* NGSPICE file created from encoder.ext - technology: gf180mcuD

.subckt Unnamed_d4602240 a_n306_n173# a_186_n173# w_n572_n603# a_n186_n382# VSUBS
X0 a_186_n173# a_n186_n382# a_n306_n173# w_n572_n603# pfet_03v3 ad=0.558p pd=3.06u as=0.558p ps=3.06u w=0.93u l=1.86u
C0 a_186_n173# w_n572_n603# 0.66931f
C1 a_n306_n173# a_n186_n382# 0.11626f
C2 w_n572_n603# a_n186_n382# 0.94238f
C3 a_186_n173# a_n186_n382# 0.05372f
C4 w_n572_n603# a_n306_n173# 0.29685f
C5 a_186_n173# a_n306_n173# 0.38397f
C6 a_186_n173# VSUBS 0.04839f
C7 a_n306_n173# VSUBS 0.04832f
C8 a_n186_n382# VSUBS 0.26326f
C9 w_n572_n603# VSUBS 5.08511f
.ends

.subckt Unnamed_c5099f02 a_n178_n131# a_n50_n339# w_n444_n560# a_28_n131# VSUBS
X0 a_28_n131# a_n50_n339# a_n178_n131# w_n444_n560# pfet_03v3 ad=0.375p pd=2.5u as=0.375p ps=2.5u w=0.5u l=0.28u
C0 a_28_n131# a_n178_n131# 0.34063f
C1 w_n444_n560# a_28_n131# 0.48499f
C2 a_n50_n339# a_28_n131# 0.01004f
C3 w_n444_n560# a_n178_n131# 0.22952f
C4 a_n50_n339# a_n178_n131# 0.02611f
C5 a_n50_n339# w_n444_n560# 0.39308f
C6 a_28_n131# VSUBS 0.04441f
C7 a_n178_n131# VSUBS 0.04328f
C8 a_n50_n339# VSUBS 0.07699f
C9 w_n444_n560# VSUBS 3.73985f
.ends

.subckt Unnamed_fd0386fc a_n1120_n131# a_n1330_n504# a_1000_n131# a_n1000_n339#
X0 a_1000_n131# a_n1000_n339# a_n1120_n131# a_n1330_n504# nfet_03v3 ad=0.3p pd=2.2u as=0.3p ps=2.2u w=0.5u l=10u
C0 a_n1000_n339# a_1000_n131# 0.06176f
C1 a_n1120_n131# a_1000_n131# 1.01551f
C2 a_n1120_n131# a_n1000_n339# 0.42273f
C3 a_1000_n131# a_n1330_n504# 1.43795f
C4 a_n1120_n131# a_n1330_n504# 0.4423f
C5 a_n1000_n339# a_n1330_n504# 5.55287f
.ends

.subckt Unnamed_c27ec396 a_n306_n173# a_186_n173# w_n572_n603# a_n186_n382# VSUBS
X0 a_186_n173# a_n186_n382# a_n306_n173# w_n572_n603# pfet_03v3 ad=0.558p pd=3.06u as=0.558p ps=3.06u w=0.93u l=1.86u
C0 a_186_n173# a_n306_n173# 0.38397f
C1 w_n572_n603# a_186_n173# 0.66931f
C2 a_n186_n382# a_186_n173# 0.05372f
C3 w_n572_n603# a_n306_n173# 0.29685f
C4 a_n186_n382# a_n306_n173# 0.11626f
C5 a_n186_n382# w_n572_n603# 0.94238f
C6 a_186_n173# VSUBS 0.04839f
C7 a_n306_n173# VSUBS 0.04832f
C8 a_n186_n382# VSUBS 0.26326f
C9 w_n572_n603# VSUBS 5.08511f
.ends

.subckt Unnamed_233cfc9d a_28_n281# a_n178_n281# w_n444_n709# a_n50_n489# VSUBS
X0 a_28_n281# a_n50_n489# a_n178_n281# w_n444_n709# pfet_03v3 ad=1.5p pd=5.5u as=1.5p ps=5.5u w=2u l=0.28u
C0 a_n178_n281# a_28_n281# 0.53377f
C1 w_n444_n709# a_n178_n281# 0.35562f
C2 a_n50_n489# a_n178_n281# 0.0391f
C3 w_n444_n709# a_28_n281# 0.6139f
C4 a_n50_n489# a_28_n281# 0.02705f
C5 a_n50_n489# w_n444_n709# 0.38939f
C6 a_28_n281# VSUBS 0.08168f
C7 a_n178_n281# VSUBS 0.08054f
C8 a_n50_n489# VSUBS 0.0768f
C9 w_n444_n709# VSUBS 4.62248f
.ends

.subckt Unnamed_89a7b3ce a_n178_n131# a_n50_n339# a_n388_n504# a_28_n131#
X0 a_28_n131# a_n50_n339# a_n178_n131# a_n388_n504# nfet_03v3 ad=0.375p pd=2.5u as=0.375p ps=2.5u w=0.5u l=0.28u
C0 a_n50_n339# a_28_n131# 0.01004f
C1 a_n178_n131# a_28_n131# 0.34063f
C2 a_n178_n131# a_n50_n339# 0.02611f
C3 a_28_n131# a_n388_n504# 0.52938f
C4 a_n178_n131# a_n388_n504# 0.27279f
C5 a_n50_n339# a_n388_n504# 0.47008f
.ends

.subckt Unnamed_dffe4b58 a_n306_n173# a_186_n173# w_n572_n603# a_n186_n382# VSUBS
X0 a_186_n173# a_n186_n382# a_n306_n173# w_n572_n603# pfet_03v3 ad=0.558p pd=3.06u as=0.558p ps=3.06u w=0.93u l=1.86u
C0 a_n306_n173# a_186_n173# 0.38397f
C1 a_186_n173# w_n572_n603# 0.66931f
C2 a_186_n173# a_n186_n382# 0.05372f
C3 a_n306_n173# w_n572_n603# 0.29685f
C4 a_n306_n173# a_n186_n382# 0.11626f
C5 a_n186_n382# w_n572_n603# 0.94238f
C6 a_186_n173# VSUBS 0.04839f
C7 a_n306_n173# VSUBS 0.04832f
C8 a_n186_n382# VSUBS 0.26326f
C9 w_n572_n603# VSUBS 5.08511f
.ends

.subckt Unnamed_399caab2 a_n306_n173# a_186_n173# w_n572_n603# a_n186_n382# VSUBS
X0 a_186_n173# a_n186_n382# a_n306_n173# w_n572_n603# pfet_03v3 ad=0.558p pd=3.06u as=0.558p ps=3.06u w=0.93u l=1.86u
C0 a_n306_n173# a_186_n173# 0.38397f
C1 a_186_n173# w_n572_n603# 0.66931f
C2 a_186_n173# a_n186_n382# 0.05372f
C3 a_n306_n173# w_n572_n603# 0.29685f
C4 a_n306_n173# a_n186_n382# 0.11626f
C5 a_n186_n382# w_n572_n603# 0.94238f
C6 a_186_n173# VSUBS 0.04839f
C7 a_n306_n173# VSUBS 0.04832f
C8 a_n186_n382# VSUBS 0.26326f
C9 w_n572_n603# VSUBS 5.08511f
.ends

.subckt Unnamed_e60251ed a_n1120_n131# a_n1330_n504# a_1000_n131# a_n1000_n339#
X0 a_1000_n131# a_n1000_n339# a_n1120_n131# a_n1330_n504# nfet_03v3 ad=0.3p pd=2.2u as=0.3p ps=2.2u w=0.5u l=10u
C0 a_1000_n131# a_n1000_n339# 0.06176f
C1 a_1000_n131# a_n1120_n131# 1.01551f
C2 a_n1120_n131# a_n1000_n339# 0.42273f
C3 a_1000_n131# a_n1330_n504# 1.43795f
C4 a_n1120_n131# a_n1330_n504# 0.4423f
C5 a_n1000_n339# a_n1330_n504# 5.55287f
.ends

.subckt Unnamed_57726a2b a_28_n281# a_n178_n281# w_n444_n709# a_n50_n489# VSUBS
X0 a_28_n281# a_n50_n489# a_n178_n281# w_n444_n709# pfet_03v3 ad=1.5p pd=5.5u as=1.5p ps=5.5u w=2u l=0.28u
C0 a_n178_n281# a_28_n281# 0.53377f
C1 a_28_n281# w_n444_n709# 0.6139f
C2 a_28_n281# a_n50_n489# 0.02705f
C3 a_n178_n281# w_n444_n709# 0.35562f
C4 a_n178_n281# a_n50_n489# 0.0391f
C5 a_n50_n489# w_n444_n709# 0.38939f
C6 a_28_n281# VSUBS 0.08168f
C7 a_n178_n281# VSUBS 0.08054f
C8 a_n50_n489# VSUBS 0.0768f
C9 w_n444_n709# VSUBS 4.62248f
.ends

.subckt Unnamed_21c496cd a_n178_n131# a_n50_n339# a_n388_n504# a_28_n131#
X0 a_28_n131# a_n50_n339# a_n178_n131# a_n388_n504# nfet_03v3 ad=0.375p pd=2.5u as=0.375p ps=2.5u w=0.5u l=0.28u
C0 a_28_n131# a_n50_n339# 0.01004f
C1 a_28_n131# a_n178_n131# 0.34063f
C2 a_n178_n131# a_n50_n339# 0.02611f
C3 a_28_n131# a_n388_n504# 0.52938f
C4 a_n178_n131# a_n388_n504# 0.27279f
C5 a_n50_n339# a_n388_n504# 0.47008f
.ends

.subckt encoder Vss Vin Vin_neg lex_1_i
XUnnamed_d4602240_0 lex_1_i lex_1_i lex_1_i Unnamed_57726a2b_0/a_28_n281# Vss Unnamed_d4602240
XUnnamed_c5099f02_0 lex_1_i Unnamed_c5099f02_0/a_28_n131# lex_1_i Unnamed_c5099f02_0/a_28_n131#
+ Vss Unnamed_c5099f02
XUnnamed_fd0386fc_0 Unnamed_89a7b3ce_0/a_28_n131# Vss Unnamed_233cfc9d_0/a_28_n281#
+ Vin_neg Unnamed_fd0386fc
XUnnamed_c27ec396_0 lex_1_i lex_1_i lex_1_i Unnamed_57726a2b_0/a_28_n281# Vss Unnamed_c27ec396
XUnnamed_233cfc9d_0 Unnamed_233cfc9d_0/a_28_n281# lex_1_i lex_1_i Unnamed_233cfc9d_0/a_28_n281#
+ Vss Unnamed_233cfc9d
XUnnamed_89a7b3ce_0 Vss Unnamed_c5099f02_0/a_28_n131# Vss Unnamed_89a7b3ce_0/a_28_n131#
+ Unnamed_89a7b3ce
XUnnamed_dffe4b58_0 lex_1_i lex_1_i lex_1_i Unnamed_233cfc9d_0/a_28_n281# Vss Unnamed_dffe4b58
XUnnamed_399caab2_0 lex_1_i lex_1_i lex_1_i Unnamed_233cfc9d_0/a_28_n281# Vss Unnamed_399caab2
XUnnamed_e60251ed_0 Unnamed_89a7b3ce_0/a_28_n131# Vss Unnamed_57726a2b_0/a_28_n281#
+ Vin Unnamed_e60251ed
XUnnamed_57726a2b_0 Unnamed_57726a2b_0/a_28_n281# lex_1_i lex_1_i Unnamed_57726a2b_0/a_28_n281#
+ Vss Unnamed_57726a2b
XUnnamed_21c496cd_0 Vss Unnamed_c5099f02_0/a_28_n131# Vss Unnamed_c5099f02_0/a_28_n131#
+ Unnamed_21c496cd
X0 Unnamed_233cfc9d_0/a_28_n281.t1 Unnamed_233cfc9d_0/a_28_n281.t0 lex_1_i lex_1_i pfet_03v3 ad=1.5p pd=5.5u as=1.5p ps=5.5u w=0 l=0
X1 lex_1_i Unnamed_57726a2b_0/a_28_n281.t3 lex_1_i lex_1_i pfet_03v3 ad=0.558p pd=3.06u as=0.558p ps=3.06u w=0 l=0
X2 lex_1_i Unnamed_57726a2b_0/a_28_n281.t2 lex_1_i lex_1_i pfet_03v3 ad=0.558p pd=3.06u as=0.558p ps=3.06u w=0 l=0
X3 lex_1_i Unnamed_233cfc9d_0/a_28_n281.t2 lex_1_i lex_1_i pfet_03v3 ad=0.558p pd=3.06u as=0.558p ps=3.06u w=0 l=0
X4 lex_1_i Unnamed_233cfc9d_0/a_28_n281.t3 lex_1_i lex_1_i pfet_03v3 ad=0.558p pd=3.06u as=0.558p ps=3.06u w=0 l=0
X5 Unnamed_57726a2b_0/a_28_n281.t1 Unnamed_57726a2b_0/a_28_n281.t0 lex_1_i lex_1_i pfet_03v3 ad=1.5p pd=5.5u as=1.5p ps=5.5u w=0 l=0
R0 Unnamed_57726a2b_0/a_28_n281.n1 Unnamed_57726a2b_0/a_28_n281.t0 56.5831
R1 Unnamed_57726a2b_0/a_28_n281.t1 Unnamed_57726a2b_0/a_28_n281.n1 18.2041
R2 Unnamed_57726a2b_0/a_28_n281.n0 Unnamed_57726a2b_0/a_28_n281.t3 10.7012
R3 Unnamed_57726a2b_0/a_28_n281.n0 Unnamed_57726a2b_0/a_28_n281.t2 9.4373
R4 Unnamed_57726a2b_0/a_28_n281.n1 Unnamed_57726a2b_0/a_28_n281.n0 0.866463
R5 lex_1_i.n106 lex_1_i.n95 696.312
R6 lex_1_i.n106 lex_1_i.n105 696.312
R7 lex_1_i.n15 lex_1_i.n4 696.312
R8 lex_1_i.n7 lex_1_i.n4 696.312
R9 lex_1_i.n200 lex_1_i.n189 528.52
R10 lex_1_i.n192 lex_1_i.n189 528.52
R11 lex_1_i.n180 lex_1_i.n151 446.678
R12 lex_1_i.n180 lex_1_i.n152 446.678
R13 lex_1_i.n142 lex_1_i.n117 446.678
R14 lex_1_i.n127 lex_1_i.n117 446.678
R15 lex_1_i.n86 lex_1_i.n61 446.678
R16 lex_1_i.n71 lex_1_i.n61 446.678
R17 lex_1_i.n50 lex_1_i.n25 446.678
R18 lex_1_i.n35 lex_1_i.n25 446.678
R19 lex_1_i.n108 lex_1_i.n107 74.638
R20 lex_1_i.n107 lex_1_i.n96 74.638
R21 lex_1_i.n104 lex_1_i.n98 74.638
R22 lex_1_i.n98 lex_1_i.n97 74.638
R23 lex_1_i.n16 lex_1_i.n3 74.638
R24 lex_1_i.n8 lex_1_i.n3 74.638
R25 lex_1_i.n13 lex_1_i.n5 74.638
R26 lex_1_i.n14 lex_1_i.n13 74.638
R27 lex_1_i.n179 lex_1_i.n153 62.563
R28 lex_1_i.n181 lex_1_i.n149 62.563
R29 lex_1_i.n179 lex_1_i.n154 62.563
R30 lex_1_i.n181 lex_1_i.n150 62.563
R31 lex_1_i.n143 lex_1_i.n116 62.563
R32 lex_1_i.n129 lex_1_i.n116 62.563
R33 lex_1_i.n123 lex_1_i.n119 62.563
R34 lex_1_i.n141 lex_1_i.n119 62.563
R35 lex_1_i.n87 lex_1_i.n60 62.563
R36 lex_1_i.n73 lex_1_i.n60 62.563
R37 lex_1_i.n67 lex_1_i.n63 62.563
R38 lex_1_i.n85 lex_1_i.n63 62.563
R39 lex_1_i.n51 lex_1_i.n24 62.563
R40 lex_1_i.n37 lex_1_i.n24 62.563
R41 lex_1_i.n31 lex_1_i.n27 62.563
R42 lex_1_i.n49 lex_1_i.n27 62.563
R43 lex_1_i.n201 lex_1_i.n188 61.6005
R44 lex_1_i.n193 lex_1_i.n188 61.6005
R45 lex_1_i.n198 lex_1_i.n190 61.6005
R46 lex_1_i.n199 lex_1_i.n198 61.6005
R47 lex_1_i.n159 lex_1_i.n157 14.0005
R48 lex_1_i.n171 lex_1_i.n169 14.0005
R49 lex_1_i.n125 lex_1_i.n124 14.0005
R50 lex_1_i.n141 lex_1_i.n120 14.0005
R51 lex_1_i.n143 lex_1_i.n115 14.0005
R52 lex_1_i.n69 lex_1_i.n68 14.0005
R53 lex_1_i.n85 lex_1_i.n64 14.0005
R54 lex_1_i.n87 lex_1_i.n59 14.0005
R55 lex_1_i.n33 lex_1_i.n32 14.0005
R56 lex_1_i.n49 lex_1_i.n28 14.0005
R57 lex_1_i.n51 lex_1_i.n23 14.0005
R58 lex_1_i.n160 lex_1_i.n149 6.3005
R59 lex_1_i.n163 lex_1_i.n159 6.3005
R60 lex_1_i.n164 lex_1_i.n157 6.3005
R61 lex_1_i.n165 lex_1_i.n153 6.3005
R62 lex_1_i.n172 lex_1_i.n150 6.3005
R63 lex_1_i.n174 lex_1_i.n171 6.3005
R64 lex_1_i.n175 lex_1_i.n169 6.3005
R65 lex_1_i.n176 lex_1_i.n154 6.3005
R66 lex_1_i.n99 lex_1_i.n96 6.3005
R67 lex_1_i.n104 lex_1_i.n103 6.3005
R68 lex_1_i.n97 lex_1_i.n94 6.3005
R69 lex_1_i.n109 lex_1_i.n108 6.3005
R70 lex_1_i.n130 lex_1_i.n129 6.3005
R71 lex_1_i.n133 lex_1_i.n125 6.3005
R72 lex_1_i.n134 lex_1_i.n124 6.3005
R73 lex_1_i.n135 lex_1_i.n123 6.3005
R74 lex_1_i.n144 lex_1_i.n143 6.3005
R75 lex_1_i.n143 lex_1_i.n142 6.3005
R76 lex_1_i.n115 lex_1_i.n114 6.3005
R77 lex_1_i.n121 lex_1_i.n120 6.3005
R78 lex_1_i.n141 lex_1_i.n140 6.3005
R79 lex_1_i.n142 lex_1_i.n141 6.3005
R80 lex_1_i.n194 lex_1_i.n193 6.3005
R81 lex_1_i.n195 lex_1_i.n190 6.3005
R82 lex_1_i.n202 lex_1_i.n201 6.3005
R83 lex_1_i.n199 lex_1_i.n187 6.3005
R84 lex_1_i.n74 lex_1_i.n73 6.3005
R85 lex_1_i.n77 lex_1_i.n69 6.3005
R86 lex_1_i.n78 lex_1_i.n68 6.3005
R87 lex_1_i.n79 lex_1_i.n67 6.3005
R88 lex_1_i.n88 lex_1_i.n87 6.3005
R89 lex_1_i.n87 lex_1_i.n86 6.3005
R90 lex_1_i.n59 lex_1_i.n58 6.3005
R91 lex_1_i.n65 lex_1_i.n64 6.3005
R92 lex_1_i.n85 lex_1_i.n84 6.3005
R93 lex_1_i.n86 lex_1_i.n85 6.3005
R94 lex_1_i.n38 lex_1_i.n37 6.3005
R95 lex_1_i.n41 lex_1_i.n33 6.3005
R96 lex_1_i.n42 lex_1_i.n32 6.3005
R97 lex_1_i.n43 lex_1_i.n31 6.3005
R98 lex_1_i.n52 lex_1_i.n51 6.3005
R99 lex_1_i.n51 lex_1_i.n50 6.3005
R100 lex_1_i.n23 lex_1_i.n22 6.3005
R101 lex_1_i.n29 lex_1_i.n28 6.3005
R102 lex_1_i.n49 lex_1_i.n48 6.3005
R103 lex_1_i.n50 lex_1_i.n49 6.3005
R104 lex_1_i.n9 lex_1_i.n8 6.3005
R105 lex_1_i.n10 lex_1_i.n5 6.3005
R106 lex_1_i.n17 lex_1_i.n16 6.3005
R107 lex_1_i.n14 lex_1_i.n2 6.3005
R108 lex_1_i.n55 lex_1_i.n19 5.85034
R109 lex_1_i.n147 lex_1_i.n111 5.73514
R110 lex_1_i.n147 lex_1_i.n146 5.58239
R111 lex_1_i.n91 lex_1_i.n90 5.58239
R112 lex_1_i.n55 lex_1_i.n54 5.58239
R113 lex_1_i.n184 lex_1_i.n183 5.58239
R114 lex_1_i.n205 lex_1_i.n204 5.51007
R115 lex_1_i.n100 lex_1_i.n93 5.34137
R116 lex_1_i.n102 lex_1_i.n100 5.34137
R117 lex_1_i.n101 lex_1_i.n92 5.34137
R118 lex_1_i.n12 lex_1_i.n1 5.34137
R119 lex_1_i.n12 lex_1_i.n11 5.34137
R120 lex_1_i.n6 lex_1_i.n0 5.34137
R121 lex_1_i.n137 lex_1_i.n136 5.20888
R122 lex_1_i.n131 lex_1_i.n112 5.20888
R123 lex_1_i.n81 lex_1_i.n80 5.20888
R124 lex_1_i.n75 lex_1_i.n56 5.20888
R125 lex_1_i.n45 lex_1_i.n44 5.20888
R126 lex_1_i.n39 lex_1_i.n20 5.20888
R127 lex_1_i.n182 lex_1_i.n148 5.20888
R128 lex_1_i.n178 lex_1_i.n177 5.20888
R129 lex_1_i.n197 lex_1_i.n186 5.19561
R130 lex_1_i.n197 lex_1_i.n196 5.19561
R131 lex_1_i.n191 lex_1_i.n185 5.19561
R132 lex_1_i.n178 lex_1_i.n166 5.17009
R133 lex_1_i.n139 lex_1_i.n137 5.17009
R134 lex_1_i.n83 lex_1_i.n81 5.17009
R135 lex_1_i.n47 lex_1_i.n45 5.17009
R136 lex_1_i.n111 lex_1_i.n110 4.7417
R137 lex_1_i.n204 lex_1_i.n203 4.7417
R138 lex_1_i.n19 lex_1_i.n18 4.7417
R139 lex_1_i.n94 lex_1_i.n93 4.5005
R140 lex_1_i.n110 lex_1_i.n109 4.5005
R141 lex_1_i.n101 lex_1_i.n99 4.5005
R142 lex_1_i.n103 lex_1_i.n102 4.5005
R143 lex_1_i.n138 lex_1_i.n121 4.5005
R144 lex_1_i.n114 lex_1_i.n113 4.5005
R145 lex_1_i.n145 lex_1_i.n144 4.5005
R146 lex_1_i.n140 lex_1_i.n139 4.5005
R147 lex_1_i.n134 lex_1_i.n122 4.5005
R148 lex_1_i.n133 lex_1_i.n132 4.5005
R149 lex_1_i.n131 lex_1_i.n130 4.5005
R150 lex_1_i.n136 lex_1_i.n135 4.5005
R151 lex_1_i.n203 lex_1_i.n202 4.5005
R152 lex_1_i.n187 lex_1_i.n186 4.5005
R153 lex_1_i.n194 lex_1_i.n191 4.5005
R154 lex_1_i.n196 lex_1_i.n195 4.5005
R155 lex_1_i.n82 lex_1_i.n65 4.5005
R156 lex_1_i.n58 lex_1_i.n57 4.5005
R157 lex_1_i.n89 lex_1_i.n88 4.5005
R158 lex_1_i.n84 lex_1_i.n83 4.5005
R159 lex_1_i.n78 lex_1_i.n66 4.5005
R160 lex_1_i.n77 lex_1_i.n76 4.5005
R161 lex_1_i.n75 lex_1_i.n74 4.5005
R162 lex_1_i.n80 lex_1_i.n79 4.5005
R163 lex_1_i.n46 lex_1_i.n29 4.5005
R164 lex_1_i.n22 lex_1_i.n21 4.5005
R165 lex_1_i.n53 lex_1_i.n52 4.5005
R166 lex_1_i.n48 lex_1_i.n47 4.5005
R167 lex_1_i.n42 lex_1_i.n30 4.5005
R168 lex_1_i.n41 lex_1_i.n40 4.5005
R169 lex_1_i.n39 lex_1_i.n38 4.5005
R170 lex_1_i.n44 lex_1_i.n43 4.5005
R171 lex_1_i.n18 lex_1_i.n17 4.5005
R172 lex_1_i.n2 lex_1_i.n1 4.5005
R173 lex_1_i.n9 lex_1_i.n6 4.5005
R174 lex_1_i.n11 lex_1_i.n10 4.5005
R175 lex_1_i.n175 lex_1_i.n167 4.5005
R176 lex_1_i.n174 lex_1_i.n173 4.5005
R177 lex_1_i.n172 lex_1_i.n148 4.5005
R178 lex_1_i.n177 lex_1_i.n176 4.5005
R179 lex_1_i.n164 lex_1_i.n155 4.5005
R180 lex_1_i.n163 lex_1_i.n162 4.5005
R181 lex_1_i.n161 lex_1_i.n160 4.5005
R182 lex_1_i.n166 lex_1_i.n165 4.5005
R183 lex_1_i.n156 lex_1_i.n153 3.31679
R184 lex_1_i.n159 lex_1_i.n158 3.31679
R185 lex_1_i.n158 lex_1_i.n149 3.31679
R186 lex_1_i.n157 lex_1_i.n156 3.31679
R187 lex_1_i.n169 lex_1_i.n168 3.31679
R188 lex_1_i.n170 lex_1_i.n150 3.31679
R189 lex_1_i.n171 lex_1_i.n170 3.31679
R190 lex_1_i.n168 lex_1_i.n154 3.31679
R191 lex_1_i.n105 lex_1_i.n104 3.31679
R192 lex_1_i.n105 lex_1_i.n96 3.31679
R193 lex_1_i.n108 lex_1_i.n95 3.31679
R194 lex_1_i.n97 lex_1_i.n95 3.31679
R195 lex_1_i.n126 lex_1_i.n123 3.31679
R196 lex_1_i.n128 lex_1_i.n125 3.31679
R197 lex_1_i.n129 lex_1_i.n128 3.31679
R198 lex_1_i.n126 lex_1_i.n124 3.31679
R199 lex_1_i.n118 lex_1_i.n115 3.31679
R200 lex_1_i.n120 lex_1_i.n118 3.31679
R201 lex_1_i.n192 lex_1_i.n190 3.31679
R202 lex_1_i.n193 lex_1_i.n192 3.31679
R203 lex_1_i.n200 lex_1_i.n199 3.31679
R204 lex_1_i.n201 lex_1_i.n200 3.31679
R205 lex_1_i.n70 lex_1_i.n67 3.31679
R206 lex_1_i.n72 lex_1_i.n69 3.31679
R207 lex_1_i.n73 lex_1_i.n72 3.31679
R208 lex_1_i.n70 lex_1_i.n68 3.31679
R209 lex_1_i.n62 lex_1_i.n59 3.31679
R210 lex_1_i.n64 lex_1_i.n62 3.31679
R211 lex_1_i.n34 lex_1_i.n31 3.31679
R212 lex_1_i.n36 lex_1_i.n33 3.31679
R213 lex_1_i.n37 lex_1_i.n36 3.31679
R214 lex_1_i.n34 lex_1_i.n32 3.31679
R215 lex_1_i.n26 lex_1_i.n23 3.31679
R216 lex_1_i.n28 lex_1_i.n26 3.31679
R217 lex_1_i.n7 lex_1_i.n5 3.31679
R218 lex_1_i.n8 lex_1_i.n7 3.31679
R219 lex_1_i.n15 lex_1_i.n14 3.31679
R220 lex_1_i.n16 lex_1_i.n15 3.31679
R221 lex_1_i.n183 lex_1_i 2.25669
R222 lex_1_i.n146 lex_1_i 2.25669
R223 lex_1_i.n90 lex_1_i 2.25669
R224 lex_1_i.n54 lex_1_i 2.25669
R225 lex_1_i.n158 lex_1_i.n151 1.49311
R226 lex_1_i.n156 lex_1_i.n151 1.49311
R227 lex_1_i.n170 lex_1_i.n152 1.49311
R228 lex_1_i.n168 lex_1_i.n152 1.49311
R229 lex_1_i.n128 lex_1_i.n127 1.49311
R230 lex_1_i.n127 lex_1_i.n126 1.49311
R231 lex_1_i.n142 lex_1_i.n118 1.49311
R232 lex_1_i.n72 lex_1_i.n71 1.49311
R233 lex_1_i.n71 lex_1_i.n70 1.49311
R234 lex_1_i.n86 lex_1_i.n62 1.49311
R235 lex_1_i.n36 lex_1_i.n35 1.49311
R236 lex_1_i.n35 lex_1_i.n34 1.49311
R237 lex_1_i.n50 lex_1_i.n26 1.49311
R238 lex_1_i.n198 lex_1_i.n197 0.9005
R239 lex_1_i.n198 lex_1_i.n189 0.9005
R240 lex_1_i.n188 lex_1_i.n185 0.9005
R241 lex_1_i.n189 lex_1_i.n188 0.9005
R242 lex_1_i.n137 lex_1_i.n119 0.788
R243 lex_1_i.n119 lex_1_i.n117 0.788
R244 lex_1_i.n116 lex_1_i.n112 0.788
R245 lex_1_i.n117 lex_1_i.n116 0.788
R246 lex_1_i.n81 lex_1_i.n63 0.788
R247 lex_1_i.n63 lex_1_i.n61 0.788
R248 lex_1_i.n60 lex_1_i.n56 0.788
R249 lex_1_i.n61 lex_1_i.n60 0.788
R250 lex_1_i.n45 lex_1_i.n27 0.788
R251 lex_1_i.n27 lex_1_i.n25 0.788
R252 lex_1_i.n24 lex_1_i.n20 0.788
R253 lex_1_i.n25 lex_1_i.n24 0.788
R254 lex_1_i.n182 lex_1_i.n181 0.788
R255 lex_1_i.n181 lex_1_i.n180 0.788
R256 lex_1_i.n179 lex_1_i.n178 0.788
R257 lex_1_i.n180 lex_1_i.n179 0.788
R258 lex_1_i.n91 lex_1_i.n55 0.6323
R259 lex_1_i.n205 lex_1_i.n184 0.6323
R260 lex_1_i.n184 lex_1_i.n147 0.6323
R261 lex_1_i.n100 lex_1_i.n98 0.6305
R262 lex_1_i.n106 lex_1_i.n98 0.6305
R263 lex_1_i.n107 lex_1_i.n92 0.6305
R264 lex_1_i.n107 lex_1_i.n106 0.6305
R265 lex_1_i.n13 lex_1_i.n12 0.6305
R266 lex_1_i.n13 lex_1_i.n4 0.6305
R267 lex_1_i.n3 lex_1_i.n0 0.6305
R268 lex_1_i.n4 lex_1_i.n3 0.6305
R269 lex_1_i.n111 lex_1_i.n92 0.592348
R270 lex_1_i.n19 lex_1_i.n0 0.592348
R271 lex_1_i.n204 lex_1_i.n185 0.446587
R272 lex_1_i lex_1_i.n91 0.3569
R273 lex_1_i.n146 lex_1_i.n112 0.322404
R274 lex_1_i.n90 lex_1_i.n56 0.322404
R275 lex_1_i.n54 lex_1_i.n20 0.322404
R276 lex_1_i.n183 lex_1_i.n182 0.322404
R277 lex_1_i lex_1_i.n205 0.1571
R278 lex_1_i.n176 lex_1_i.n175 0.1445
R279 lex_1_i.n175 lex_1_i.n174 0.1445
R280 lex_1_i.n174 lex_1_i.n172 0.1445
R281 lex_1_i.n165 lex_1_i.n164 0.1445
R282 lex_1_i.n164 lex_1_i.n163 0.1445
R283 lex_1_i.n163 lex_1_i.n160 0.1445
R284 lex_1_i.n103 lex_1_i.n99 0.1445
R285 lex_1_i.n109 lex_1_i.n94 0.1445
R286 lex_1_i.n110 lex_1_i.n93 0.1445
R287 lex_1_i.n102 lex_1_i.n101 0.1445
R288 lex_1_i.n135 lex_1_i.n134 0.1445
R289 lex_1_i.n134 lex_1_i.n133 0.1445
R290 lex_1_i.n133 lex_1_i.n130 0.1445
R291 lex_1_i.n140 lex_1_i.n121 0.1445
R292 lex_1_i.n121 lex_1_i.n114 0.1445
R293 lex_1_i.n144 lex_1_i.n114 0.1445
R294 lex_1_i.n136 lex_1_i.n122 0.1445
R295 lex_1_i.n132 lex_1_i.n122 0.1445
R296 lex_1_i.n132 lex_1_i.n131 0.1445
R297 lex_1_i.n195 lex_1_i.n194 0.1445
R298 lex_1_i.n202 lex_1_i.n187 0.1445
R299 lex_1_i.n203 lex_1_i.n186 0.1445
R300 lex_1_i.n196 lex_1_i.n191 0.1445
R301 lex_1_i.n79 lex_1_i.n78 0.1445
R302 lex_1_i.n78 lex_1_i.n77 0.1445
R303 lex_1_i.n77 lex_1_i.n74 0.1445
R304 lex_1_i.n84 lex_1_i.n65 0.1445
R305 lex_1_i.n65 lex_1_i.n58 0.1445
R306 lex_1_i.n88 lex_1_i.n58 0.1445
R307 lex_1_i.n80 lex_1_i.n66 0.1445
R308 lex_1_i.n76 lex_1_i.n66 0.1445
R309 lex_1_i.n76 lex_1_i.n75 0.1445
R310 lex_1_i.n43 lex_1_i.n42 0.1445
R311 lex_1_i.n42 lex_1_i.n41 0.1445
R312 lex_1_i.n41 lex_1_i.n38 0.1445
R313 lex_1_i.n48 lex_1_i.n29 0.1445
R314 lex_1_i.n29 lex_1_i.n22 0.1445
R315 lex_1_i.n52 lex_1_i.n22 0.1445
R316 lex_1_i.n44 lex_1_i.n30 0.1445
R317 lex_1_i.n40 lex_1_i.n30 0.1445
R318 lex_1_i.n40 lex_1_i.n39 0.1445
R319 lex_1_i.n10 lex_1_i.n9 0.1445
R320 lex_1_i.n17 lex_1_i.n2 0.1445
R321 lex_1_i.n18 lex_1_i.n1 0.1445
R322 lex_1_i.n11 lex_1_i.n6 0.1445
R323 lex_1_i.n177 lex_1_i.n167 0.1445
R324 lex_1_i.n173 lex_1_i.n167 0.1445
R325 lex_1_i.n173 lex_1_i.n148 0.1445
R326 lex_1_i.n139 lex_1_i.n138 0.0251575
R327 lex_1_i.n138 lex_1_i.n113 0.0251575
R328 lex_1_i.n145 lex_1_i.n113 0.0251575
R329 lex_1_i.n83 lex_1_i.n82 0.0251575
R330 lex_1_i.n82 lex_1_i.n57 0.0251575
R331 lex_1_i.n89 lex_1_i.n57 0.0251575
R332 lex_1_i.n47 lex_1_i.n46 0.0251575
R333 lex_1_i.n46 lex_1_i.n21 0.0251575
R334 lex_1_i.n53 lex_1_i.n21 0.0251575
R335 lex_1_i.n166 lex_1_i.n155 0.0251575
R336 lex_1_i.n162 lex_1_i.n155 0.0251575
R337 lex_1_i.n162 lex_1_i.n161 0.0251575
R338 lex_1_i lex_1_i.n145 0.0085137
R339 lex_1_i lex_1_i.n89 0.0085137
R340 lex_1_i lex_1_i.n53 0.0085137
R341 lex_1_i.n161 lex_1_i 0.0085137
R342 Vin_neg Vin_neg.t0 5.29737
R343 Unnamed_233cfc9d_0/a_28_n281.n1 Unnamed_233cfc9d_0/a_28_n281.t0 56.5807
R344 Unnamed_233cfc9d_0/a_28_n281.t1 Unnamed_233cfc9d_0/a_28_n281.n1 18.4093
R345 Unnamed_233cfc9d_0/a_28_n281.n0 Unnamed_233cfc9d_0/a_28_n281.t3 10.7012
R346 Unnamed_233cfc9d_0/a_28_n281.n0 Unnamed_233cfc9d_0/a_28_n281.t2 9.4373
R347 Unnamed_233cfc9d_0/a_28_n281.n1 Unnamed_233cfc9d_0/a_28_n281.n0 0.866017
R348 Vss.n86 Vss.n85 248.151
R349 Vss.n245 Vss.n6 158.439
R350 Vss.n245 Vss.n8 158.439
R351 Vss.n115 Vss.n83 158.439
R352 Vss.n115 Vss.n86 158.439
R353 Vss.n83 Vss.n8 150.312
R354 Vss.n117 Vss.n116 68.4449
R355 Vss.n116 Vss.n82 68.4449
R356 Vss.n96 Vss.n89 68.4449
R357 Vss.n96 Vss.n87 68.4449
R358 Vss.n114 Vss.n97 68.4449
R359 Vss.n114 Vss.n98 68.4449
R360 Vss.n102 Vss.n84 68.4449
R361 Vss.n109 Vss.n84 68.4449
R362 Vss.n151 Vss.n9 66.6949
R363 Vss.n74 Vss.n7 66.6949
R364 Vss.n124 Vss.n7 66.6949
R365 Vss.n151 Vss.n10 66.6949
R366 Vss.n246 Vss.n5 66.6949
R367 Vss.n247 Vss.n246 66.6949
R368 Vss.n244 Vss.n153 66.6949
R369 Vss.n244 Vss.n152 66.6949
R370 Vss.n45 Vss.n41 15.5561
R371 Vss.n51 Vss.n41 15.5561
R372 Vss.n55 Vss.n53 15.5561
R373 Vss.n61 Vss.n37 15.5561
R374 Vss.n65 Vss.n63 15.5561
R375 Vss.n71 Vss.n33 15.5561
R376 Vss.n74 Vss.n73 15.5561
R377 Vss.n13 Vss.n10 15.5561
R378 Vss.n145 Vss.n143 15.5561
R379 Vss.n141 Vss.n16 15.5561
R380 Vss.n137 Vss.n135 15.5561
R381 Vss.n133 Vss.n22 15.5561
R382 Vss.n129 Vss.n127 15.5561
R383 Vss.n127 Vss.n126 15.5561
R384 Vss.n238 Vss.n203 15.5561
R385 Vss.n236 Vss.n235 15.5561
R386 Vss.n233 Vss.n207 15.5561
R387 Vss.n229 Vss.n228 15.5561
R388 Vss.n226 Vss.n215 15.5561
R389 Vss.n222 Vss.n221 15.5561
R390 Vss.n197 Vss.n196 15.5561
R391 Vss.n194 Vss.n157 15.5561
R392 Vss.n190 Vss.n189 15.5561
R393 Vss.n187 Vss.n164 15.5561
R394 Vss.n183 Vss.n182 15.5561
R395 Vss.n180 Vss.n172 15.5561
R396 Vss.n251 Vss.n250 6.37289
R397 Vss.n90 Vss.n0 5.53949
R398 Vss.n118 Vss.n117 5.2005
R399 Vss.n87 Vss.n80 5.2005
R400 Vss.n92 Vss.n82 5.2005
R401 Vss.n93 Vss.n89 5.2005
R402 Vss.n177 Vss.n5 5.2005
R403 Vss.n178 Vss.n172 5.2005
R404 Vss.n180 Vss.n179 5.2005
R405 Vss.n182 Vss.n169 5.2005
R406 Vss.n184 Vss.n183 5.2005
R407 Vss.n185 Vss.n164 5.2005
R408 Vss.n187 Vss.n186 5.2005
R409 Vss.n189 Vss.n162 5.2005
R410 Vss.n191 Vss.n190 5.2005
R411 Vss.n192 Vss.n157 5.2005
R412 Vss.n194 Vss.n193 5.2005
R413 Vss.n196 Vss.n155 5.2005
R414 Vss.n198 Vss.n197 5.2005
R415 Vss.n199 Vss.n152 5.2005
R416 Vss.n248 Vss.n247 5.2005
R417 Vss.n221 Vss.n3 5.2005
R418 Vss.n223 Vss.n222 5.2005
R419 Vss.n224 Vss.n215 5.2005
R420 Vss.n226 Vss.n225 5.2005
R421 Vss.n228 Vss.n213 5.2005
R422 Vss.n230 Vss.n229 5.2005
R423 Vss.n231 Vss.n207 5.2005
R424 Vss.n233 Vss.n232 5.2005
R425 Vss.n235 Vss.n206 5.2005
R426 Vss.n236 Vss.n205 5.2005
R427 Vss.n239 Vss.n238 5.2005
R428 Vss.n240 Vss.n203 5.2005
R429 Vss.n241 Vss.n153 5.2005
R430 Vss.n124 Vss.n123 5.2005
R431 Vss.n126 Vss.n28 5.2005
R432 Vss.n127 Vss.n27 5.2005
R433 Vss.n127 Vss.n8 5.2005
R434 Vss.n130 Vss.n129 5.2005
R435 Vss.n131 Vss.n22 5.2005
R436 Vss.n133 Vss.n132 5.2005
R437 Vss.n135 Vss.n21 5.2005
R438 Vss.n138 Vss.n137 5.2005
R439 Vss.n139 Vss.n16 5.2005
R440 Vss.n141 Vss.n140 5.2005
R441 Vss.n143 Vss.n15 5.2005
R442 Vss.n146 Vss.n145 5.2005
R443 Vss.n147 Vss.n13 5.2005
R444 Vss.n148 Vss.n10 5.2005
R445 Vss.n10 Vss.n8 5.2005
R446 Vss.n43 Vss.n9 5.2005
R447 Vss.n46 Vss.n45 5.2005
R448 Vss.n42 Vss.n41 5.2005
R449 Vss.n41 Vss.n6 5.2005
R450 Vss.n51 Vss.n50 5.2005
R451 Vss.n53 Vss.n40 5.2005
R452 Vss.n56 Vss.n55 5.2005
R453 Vss.n38 Vss.n37 5.2005
R454 Vss.n61 Vss.n60 5.2005
R455 Vss.n63 Vss.n36 5.2005
R456 Vss.n66 Vss.n65 5.2005
R457 Vss.n34 Vss.n33 5.2005
R458 Vss.n71 Vss.n70 5.2005
R459 Vss.n73 Vss.n32 5.2005
R460 Vss.n75 Vss.n74 5.2005
R461 Vss.n74 Vss.n6 5.2005
R462 Vss.n103 Vss.n102 5.2005
R463 Vss.n100 Vss.n97 5.2005
R464 Vss.n110 Vss.n109 5.2005
R465 Vss.n111 Vss.n98 5.2005
R466 Vss.n95 Vss.n94 5.19561
R467 Vss.n95 Vss.n79 5.19561
R468 Vss.n113 Vss.n112 5.19561
R469 Vss.n113 Vss.n99 5.19561
R470 Vss.n105 Vss.n104 5.18779
R471 Vss.n176 Vss.n1 5.17941
R472 Vss.n243 Vss.n242 5.17941
R473 Vss.n243 Vss.n200 5.17941
R474 Vss.n150 Vss.n149 5.17941
R475 Vss.n150 Vss.n11 5.17941
R476 Vss.n77 Vss.n76 5.17941
R477 Vss.n106 Vss.n0 5.02289
R478 Vss.n91 Vss.n90 4.7417
R479 Vss.n120 Vss.n119 4.7417
R480 Vss.n107 Vss.n106 4.7417
R481 Vss.n250 Vss.n249 4.7255
R482 Vss.n122 Vss.n121 4.7255
R483 Vss.n240 Vss.n201 4.5005
R484 Vss.n239 Vss.n204 4.5005
R485 Vss.n208 Vss.n205 4.5005
R486 Vss.n209 Vss.n206 4.5005
R487 Vss.n232 Vss.n210 4.5005
R488 Vss.n231 Vss.n211 4.5005
R489 Vss.n230 Vss.n212 4.5005
R490 Vss.n216 Vss.n213 4.5005
R491 Vss.n225 Vss.n217 4.5005
R492 Vss.n224 Vss.n218 4.5005
R493 Vss.n223 Vss.n219 4.5005
R494 Vss.n3 Vss.n2 4.5005
R495 Vss.n249 Vss.n248 4.5005
R496 Vss.n242 Vss.n241 4.5005
R497 Vss.n198 Vss.n154 4.5005
R498 Vss.n158 Vss.n155 4.5005
R499 Vss.n193 Vss.n159 4.5005
R500 Vss.n192 Vss.n160 4.5005
R501 Vss.n191 Vss.n161 4.5005
R502 Vss.n165 Vss.n162 4.5005
R503 Vss.n186 Vss.n166 4.5005
R504 Vss.n185 Vss.n167 4.5005
R505 Vss.n184 Vss.n168 4.5005
R506 Vss.n173 Vss.n169 4.5005
R507 Vss.n179 Vss.n174 4.5005
R508 Vss.n178 Vss.n175 4.5005
R509 Vss.n177 Vss.n176 4.5005
R510 Vss.n200 Vss.n199 4.5005
R511 Vss.n147 Vss.n12 4.5005
R512 Vss.n146 Vss.n14 4.5005
R513 Vss.n17 Vss.n15 4.5005
R514 Vss.n140 Vss.n18 4.5005
R515 Vss.n139 Vss.n19 4.5005
R516 Vss.n138 Vss.n20 4.5005
R517 Vss.n23 Vss.n21 4.5005
R518 Vss.n132 Vss.n24 4.5005
R519 Vss.n131 Vss.n25 4.5005
R520 Vss.n130 Vss.n26 4.5005
R521 Vss.n29 Vss.n27 4.5005
R522 Vss.n30 Vss.n28 4.5005
R523 Vss.n123 Vss.n122 4.5005
R524 Vss.n149 Vss.n148 4.5005
R525 Vss.n43 Vss.n11 4.5005
R526 Vss.n47 Vss.n46 4.5005
R527 Vss.n48 Vss.n42 4.5005
R528 Vss.n50 Vss.n49 4.5005
R529 Vss.n40 Vss.n39 4.5005
R530 Vss.n57 Vss.n56 4.5005
R531 Vss.n58 Vss.n38 4.5005
R532 Vss.n60 Vss.n59 4.5005
R533 Vss.n36 Vss.n35 4.5005
R534 Vss.n67 Vss.n66 4.5005
R535 Vss.n68 Vss.n34 4.5005
R536 Vss.n70 Vss.n69 4.5005
R537 Vss.n32 Vss.n31 4.5005
R538 Vss.n76 Vss.n75 4.5005
R539 Vss.n92 Vss.n91 4.5005
R540 Vss.n94 Vss.n93 4.5005
R541 Vss.n119 Vss.n118 4.5005
R542 Vss.n80 Vss.n79 4.5005
R543 Vss.n110 Vss.n107 4.5005
R544 Vss.n112 Vss.n111 4.5005
R545 Vss.n104 Vss.n103 4.5005
R546 Vss.n100 Vss.n99 4.5005
R547 Vss.n44 Vss.n9 3.11744
R548 Vss.n52 Vss.n51 3.11744
R549 Vss.n55 Vss.n54 3.11744
R550 Vss.n62 Vss.n61 3.11744
R551 Vss.n65 Vss.n64 3.11744
R552 Vss.n72 Vss.n71 3.11744
R553 Vss.n144 Vss.n13 3.11744
R554 Vss.n143 Vss.n142 3.11744
R555 Vss.n136 Vss.n16 3.11744
R556 Vss.n135 Vss.n134 3.11744
R557 Vss.n128 Vss.n22 3.11744
R558 Vss.n125 Vss.n124 3.11744
R559 Vss.n203 Vss.n202 3.11744
R560 Vss.n237 Vss.n236 3.11744
R561 Vss.n234 Vss.n233 3.11744
R562 Vss.n229 Vss.n214 3.11744
R563 Vss.n227 Vss.n226 3.11744
R564 Vss.n222 Vss.n220 3.11744
R565 Vss.n247 Vss.n4 3.11744
R566 Vss.n197 Vss.n156 3.11744
R567 Vss.n195 Vss.n194 3.11744
R568 Vss.n190 Vss.n163 3.11744
R569 Vss.n188 Vss.n187 3.11744
R570 Vss.n183 Vss.n170 3.11744
R571 Vss.n181 Vss.n180 3.11744
R572 Vss.n171 Vss.n5 3.11744
R573 Vss.n88 Vss.n82 3.11744
R574 Vss.n117 Vss.n81 3.11744
R575 Vss.n87 Vss.n81 3.11744
R576 Vss.n89 Vss.n88 3.11744
R577 Vss.n172 Vss.n171 3.11744
R578 Vss.n182 Vss.n181 3.11744
R579 Vss.n170 Vss.n164 3.11744
R580 Vss.n189 Vss.n188 3.11744
R581 Vss.n163 Vss.n157 3.11744
R582 Vss.n196 Vss.n195 3.11744
R583 Vss.n156 Vss.n152 3.11744
R584 Vss.n221 Vss.n4 3.11744
R585 Vss.n220 Vss.n215 3.11744
R586 Vss.n228 Vss.n227 3.11744
R587 Vss.n214 Vss.n207 3.11744
R588 Vss.n235 Vss.n234 3.11744
R589 Vss.n238 Vss.n237 3.11744
R590 Vss.n202 Vss.n153 3.11744
R591 Vss.n126 Vss.n125 3.11744
R592 Vss.n129 Vss.n128 3.11744
R593 Vss.n134 Vss.n133 3.11744
R594 Vss.n137 Vss.n136 3.11744
R595 Vss.n142 Vss.n141 3.11744
R596 Vss.n145 Vss.n144 3.11744
R597 Vss.n45 Vss.n44 3.11744
R598 Vss.n53 Vss.n52 3.11744
R599 Vss.n54 Vss.n37 3.11744
R600 Vss.n63 Vss.n62 3.11744
R601 Vss.n64 Vss.n33 3.11744
R602 Vss.n73 Vss.n72 3.11744
R603 Vss.n101 Vss.n97 3.11744
R604 Vss.n102 Vss.n101 3.11744
R605 Vss.n108 Vss.n98 3.11744
R606 Vss.n109 Vss.n108 3.11744
R607 Vss.n83 Vss.n81 1.04278
R608 Vss.n88 Vss.n86 1.04278
R609 Vss.n171 Vss.n6 1.04278
R610 Vss.n181 Vss.n6 1.04278
R611 Vss.n170 Vss.n6 1.04278
R612 Vss.n188 Vss.n6 1.04278
R613 Vss.n163 Vss.n6 1.04278
R614 Vss.n195 Vss.n6 1.04278
R615 Vss.n156 Vss.n6 1.04278
R616 Vss.n8 Vss.n4 1.04278
R617 Vss.n220 Vss.n8 1.04278
R618 Vss.n227 Vss.n8 1.04278
R619 Vss.n214 Vss.n8 1.04278
R620 Vss.n234 Vss.n8 1.04278
R621 Vss.n237 Vss.n8 1.04278
R622 Vss.n202 Vss.n8 1.04278
R623 Vss.n125 Vss.n8 1.04278
R624 Vss.n128 Vss.n8 1.04278
R625 Vss.n134 Vss.n8 1.04278
R626 Vss.n136 Vss.n8 1.04278
R627 Vss.n142 Vss.n8 1.04278
R628 Vss.n144 Vss.n8 1.04278
R629 Vss.n44 Vss.n6 1.04278
R630 Vss.n52 Vss.n6 1.04278
R631 Vss.n54 Vss.n6 1.04278
R632 Vss.n62 Vss.n6 1.04278
R633 Vss.n64 Vss.n6 1.04278
R634 Vss.n72 Vss.n6 1.04278
R635 Vss.n101 Vss.n83 1.04278
R636 Vss.n108 Vss.n86 1.04278
R637 Vss.n251 Vss.n0 0.8483
R638 Vss.n96 Vss.n95 0.743357
R639 Vss.n115 Vss.n96 0.743357
R640 Vss.n116 Vss.n78 0.743357
R641 Vss.n116 Vss.n115 0.743357
R642 Vss.n244 Vss.n243 0.743357
R643 Vss.n245 Vss.n244 0.743357
R644 Vss.n246 Vss.n1 0.743357
R645 Vss.n246 Vss.n245 0.743357
R646 Vss.n151 Vss.n150 0.743357
R647 Vss.n245 Vss.n151 0.743357
R648 Vss.n77 Vss.n7 0.743357
R649 Vss.n245 Vss.n7 0.743357
R650 Vss.n114 Vss.n113 0.743357
R651 Vss.n115 Vss.n114 0.743357
R652 Vss.n105 Vss.n84 0.743357
R653 Vss.n115 Vss.n84 0.743357
R654 Vss Vss.n251 0.5729
R655 Vss.n250 Vss.n1 0.454413
R656 Vss.n121 Vss.n77 0.454413
R657 Vss.n90 Vss.n78 0.454413
R658 Vss.n106 Vss.n105 0.454413
R659 Vss.n120 Vss.n78 0.446587
R660 Vss.n121 Vss.n120 0.427022
R661 Vss.n241 Vss.n240 0.1445
R662 Vss.n240 Vss.n239 0.1445
R663 Vss.n239 Vss.n205 0.1445
R664 Vss.n206 Vss.n205 0.1445
R665 Vss.n232 Vss.n206 0.1445
R666 Vss.n232 Vss.n231 0.1445
R667 Vss.n231 Vss.n230 0.1445
R668 Vss.n230 Vss.n213 0.1445
R669 Vss.n225 Vss.n213 0.1445
R670 Vss.n225 Vss.n224 0.1445
R671 Vss.n224 Vss.n223 0.1445
R672 Vss.n223 Vss.n3 0.1445
R673 Vss.n248 Vss.n3 0.1445
R674 Vss.n242 Vss.n201 0.1445
R675 Vss.n204 Vss.n201 0.1445
R676 Vss.n208 Vss.n204 0.1445
R677 Vss.n209 Vss.n208 0.1445
R678 Vss.n210 Vss.n209 0.1445
R679 Vss.n211 Vss.n210 0.1445
R680 Vss.n212 Vss.n211 0.1445
R681 Vss.n216 Vss.n212 0.1445
R682 Vss.n217 Vss.n216 0.1445
R683 Vss.n218 Vss.n217 0.1445
R684 Vss.n219 Vss.n218 0.1445
R685 Vss.n219 Vss.n2 0.1445
R686 Vss.n249 Vss.n2 0.1445
R687 Vss.n200 Vss.n154 0.1445
R688 Vss.n158 Vss.n154 0.1445
R689 Vss.n159 Vss.n158 0.1445
R690 Vss.n160 Vss.n159 0.1445
R691 Vss.n161 Vss.n160 0.1445
R692 Vss.n165 Vss.n161 0.1445
R693 Vss.n166 Vss.n165 0.1445
R694 Vss.n167 Vss.n166 0.1445
R695 Vss.n168 Vss.n167 0.1445
R696 Vss.n173 Vss.n168 0.1445
R697 Vss.n174 Vss.n173 0.1445
R698 Vss.n175 Vss.n174 0.1445
R699 Vss.n176 Vss.n175 0.1445
R700 Vss.n199 Vss.n198 0.1445
R701 Vss.n198 Vss.n155 0.1445
R702 Vss.n193 Vss.n155 0.1445
R703 Vss.n193 Vss.n192 0.1445
R704 Vss.n192 Vss.n191 0.1445
R705 Vss.n191 Vss.n162 0.1445
R706 Vss.n186 Vss.n162 0.1445
R707 Vss.n186 Vss.n185 0.1445
R708 Vss.n185 Vss.n184 0.1445
R709 Vss.n184 Vss.n169 0.1445
R710 Vss.n179 Vss.n169 0.1445
R711 Vss.n179 Vss.n178 0.1445
R712 Vss.n178 Vss.n177 0.1445
R713 Vss.n93 Vss.n92 0.1445
R714 Vss.n46 Vss.n43 0.1445
R715 Vss.n46 Vss.n42 0.1445
R716 Vss.n50 Vss.n42 0.1445
R717 Vss.n50 Vss.n40 0.1445
R718 Vss.n56 Vss.n40 0.1445
R719 Vss.n56 Vss.n38 0.1445
R720 Vss.n60 Vss.n38 0.1445
R721 Vss.n60 Vss.n36 0.1445
R722 Vss.n66 Vss.n36 0.1445
R723 Vss.n66 Vss.n34 0.1445
R724 Vss.n70 Vss.n34 0.1445
R725 Vss.n70 Vss.n32 0.1445
R726 Vss.n75 Vss.n32 0.1445
R727 Vss.n148 Vss.n147 0.1445
R728 Vss.n147 Vss.n146 0.1445
R729 Vss.n146 Vss.n15 0.1445
R730 Vss.n140 Vss.n15 0.1445
R731 Vss.n140 Vss.n139 0.1445
R732 Vss.n139 Vss.n138 0.1445
R733 Vss.n138 Vss.n21 0.1445
R734 Vss.n132 Vss.n21 0.1445
R735 Vss.n132 Vss.n131 0.1445
R736 Vss.n131 Vss.n130 0.1445
R737 Vss.n130 Vss.n27 0.1445
R738 Vss.n28 Vss.n27 0.1445
R739 Vss.n123 Vss.n28 0.1445
R740 Vss.n149 Vss.n12 0.1445
R741 Vss.n14 Vss.n12 0.1445
R742 Vss.n17 Vss.n14 0.1445
R743 Vss.n18 Vss.n17 0.1445
R744 Vss.n19 Vss.n18 0.1445
R745 Vss.n20 Vss.n19 0.1445
R746 Vss.n23 Vss.n20 0.1445
R747 Vss.n24 Vss.n23 0.1445
R748 Vss.n25 Vss.n24 0.1445
R749 Vss.n26 Vss.n25 0.1445
R750 Vss.n29 Vss.n26 0.1445
R751 Vss.n30 Vss.n29 0.1445
R752 Vss.n122 Vss.n30 0.1445
R753 Vss.n47 Vss.n11 0.1445
R754 Vss.n48 Vss.n47 0.1445
R755 Vss.n49 Vss.n48 0.1445
R756 Vss.n49 Vss.n39 0.1445
R757 Vss.n57 Vss.n39 0.1445
R758 Vss.n58 Vss.n57 0.1445
R759 Vss.n59 Vss.n58 0.1445
R760 Vss.n59 Vss.n35 0.1445
R761 Vss.n67 Vss.n35 0.1445
R762 Vss.n68 Vss.n67 0.1445
R763 Vss.n69 Vss.n68 0.1445
R764 Vss.n69 Vss.n31 0.1445
R765 Vss.n76 Vss.n31 0.1445
R766 Vss.n94 Vss.n91 0.1445
R767 Vss.n119 Vss.n79 0.1445
R768 Vss.n118 Vss.n80 0.1445
R769 Vss.n103 Vss.n100 0.1445
R770 Vss.n111 Vss.n110 0.1445
R771 Vss.n112 Vss.n107 0.1445
R772 Vss.n104 Vss.n99 0.1445
R773 Vin Vin.t0 5.38731
C0 Unnamed_89a7b3ce_0/a_28_n131# Unnamed_c5099f02_0/a_28_n131# 0.13108f
C1 Unnamed_89a7b3ce_0/a_28_n131# Vin_neg 0
C2 Unnamed_89a7b3ce_0/a_28_n131# lex_1_i 0.0222f
C3 Vin Unnamed_89a7b3ce_0/a_28_n131# 0.05282f
C4 Unnamed_c5099f02_0/a_28_n131# Vin_neg 0.13337f
C5 lex_1_i Unnamed_c5099f02_0/a_28_n131# 0.53051f
C6 lex_1_i Vin_neg 0.01176f
C7 Vin Unnamed_c5099f02_0/a_28_n131# 0.00627f
C8 Vin Vin_neg 0.0071f
C9 Vin lex_1_i 0.01287f
C10 Unnamed_233cfc9d_0/a_28_n281.t0 Vss 0.07879f
C11 Unnamed_233cfc9d_0/a_28_n281.t3 Vss 0.41642f
C12 Unnamed_233cfc9d_0/a_28_n281.t2 Vss 0.36326f
C13 Unnamed_233cfc9d_0/a_28_n281.n0 Vss 0.94311f
C14 Unnamed_233cfc9d_0/a_28_n281.n1 Vss 1.96663f
C15 Unnamed_233cfc9d_0/a_28_n281.t1 Vss 2.1318f
C16 lex_1_i.n0 Vss 0.08227f
C17 lex_1_i.n1 Vss 0.02646f
C18 lex_1_i.n2 Vss 0.00804f
C19 lex_1_i.n3 Vss 0.03901f
C20 lex_1_i.n4 Vss 0.33984f
C21 lex_1_i.n5 Vss 0.02365f
C22 lex_1_i.n6 Vss 0.02646f
C23 lex_1_i.n7 Vss 0.21951f
C24 lex_1_i.n8 Vss 0.02365f
C25 lex_1_i.n9 Vss 0.00804f
C26 lex_1_i.n10 Vss 0.00804f
C27 lex_1_i.n11 Vss 0.02646f
C28 lex_1_i.n12 Vss 0.07322f
C29 lex_1_i.n13 Vss 0.03901f
C30 lex_1_i.n14 Vss 0.02365f
C31 lex_1_i.n15 Vss 0.21951f
C32 lex_1_i.n16 Vss 0.02365f
C33 lex_1_i.n17 Vss 0.00804f
C34 lex_1_i.n18 Vss 0.02404f
C35 lex_1_i.n19 Vss 0.10517f
C36 lex_1_i.n20 Vss 0.0435f
C37 lex_1_i.n21 Vss 0.0578f
C38 lex_1_i.n22 Vss 0.0099f
C39 lex_1_i.n23 Vss 0.00713f
C40 lex_1_i.n24 Vss 0.03292f
C41 lex_1_i.n25 Vss 0.36159f
C42 lex_1_i.n27 Vss 0.03292f
C43 lex_1_i.n28 Vss 0.00713f
C44 lex_1_i.n29 Vss 0.0099f
C45 lex_1_i.n30 Vss 0.0099f
C46 lex_1_i.n31 Vss 0.02055f
C47 lex_1_i.n32 Vss 0.00713f
C48 lex_1_i.n33 Vss 0.00713f
C49 lex_1_i.n35 Vss 0.2459f
C50 lex_1_i.n37 Vss 0.02055f
C51 lex_1_i.n38 Vss 0.00804f
C52 lex_1_i.n39 Vss 0.02393f
C53 lex_1_i.n40 Vss 0.0099f
C54 lex_1_i.n41 Vss 0.0099f
C55 lex_1_i.n42 Vss 0.0099f
C56 lex_1_i.n43 Vss 0.00804f
C57 lex_1_i.n44 Vss 0.02393f
C58 lex_1_i.n45 Vss 0.06215f
C59 lex_1_i.n46 Vss 0.0578f
C60 lex_1_i.n47 Vss 0.08763f
C61 lex_1_i.n48 Vss 0.00804f
C62 lex_1_i.n49 Vss 0.02055f
C63 lex_1_i.n50 Vss 0.2459f
C64 lex_1_i.n51 Vss 0.02055f
C65 lex_1_i.n52 Vss 0.00804f
C66 lex_1_i.n53 Vss 0.05268f
C67 lex_1_i.n54 Vss 0.06442f
C68 lex_1_i.n55 Vss 0.39173f
C69 lex_1_i.n56 Vss 0.0435f
C70 lex_1_i.n57 Vss 0.0578f
C71 lex_1_i.n58 Vss 0.0099f
C72 lex_1_i.n59 Vss 0.00713f
C73 lex_1_i.n60 Vss 0.03292f
C74 lex_1_i.n61 Vss 0.36159f
C75 lex_1_i.n63 Vss 0.03292f
C76 lex_1_i.n64 Vss 0.00713f
C77 lex_1_i.n65 Vss 0.0099f
C78 lex_1_i.n66 Vss 0.0099f
C79 lex_1_i.n67 Vss 0.02055f
C80 lex_1_i.n68 Vss 0.00713f
C81 lex_1_i.n69 Vss 0.00713f
C82 lex_1_i.n71 Vss 0.2459f
C83 lex_1_i.n73 Vss 0.02055f
C84 lex_1_i.n74 Vss 0.00804f
C85 lex_1_i.n75 Vss 0.02393f
C86 lex_1_i.n76 Vss 0.0099f
C87 lex_1_i.n77 Vss 0.0099f
C88 lex_1_i.n78 Vss 0.0099f
C89 lex_1_i.n79 Vss 0.00804f
C90 lex_1_i.n80 Vss 0.02393f
C91 lex_1_i.n81 Vss 0.06215f
C92 lex_1_i.n82 Vss 0.0578f
C93 lex_1_i.n83 Vss 0.08763f
C94 lex_1_i.n84 Vss 0.00804f
C95 lex_1_i.n85 Vss 0.02055f
C96 lex_1_i.n86 Vss 0.2459f
C97 lex_1_i.n87 Vss 0.02055f
C98 lex_1_i.n88 Vss 0.00804f
C99 lex_1_i.n89 Vss 0.05268f
C100 lex_1_i.n90 Vss 0.06442f
C101 lex_1_i.n91 Vss 0.14169f
C102 lex_1_i.n92 Vss 0.08227f
C103 lex_1_i.n93 Vss 0.02646f
C104 lex_1_i.n94 Vss 0.00804f
C105 lex_1_i.n95 Vss 0.21951f
C106 lex_1_i.n96 Vss 0.02365f
C107 lex_1_i.n97 Vss 0.02365f
C108 lex_1_i.n98 Vss 0.03901f
C109 lex_1_i.n99 Vss 0.00804f
C110 lex_1_i.n100 Vss 0.07322f
C111 lex_1_i.n101 Vss 0.02646f
C112 lex_1_i.n102 Vss 0.02646f
C113 lex_1_i.n103 Vss 0.00804f
C114 lex_1_i.n104 Vss 0.02365f
C115 lex_1_i.n105 Vss 0.21951f
C116 lex_1_i.n106 Vss 0.33984f
C117 lex_1_i.n107 Vss 0.03901f
C118 lex_1_i.n108 Vss 0.02365f
C119 lex_1_i.n109 Vss 0.00804f
C120 lex_1_i.n110 Vss 0.02404f
C121 lex_1_i.n111 Vss 0.09164f
C122 lex_1_i.n112 Vss 0.0435f
C123 lex_1_i.n113 Vss 0.0578f
C124 lex_1_i.n114 Vss 0.0099f
C125 lex_1_i.n115 Vss 0.00713f
C126 lex_1_i.n116 Vss 0.03292f
C127 lex_1_i.n117 Vss 0.36159f
C128 lex_1_i.n119 Vss 0.03292f
C129 lex_1_i.n120 Vss 0.00713f
C130 lex_1_i.n121 Vss 0.0099f
C131 lex_1_i.n122 Vss 0.0099f
C132 lex_1_i.n123 Vss 0.02055f
C133 lex_1_i.n124 Vss 0.00713f
C134 lex_1_i.n125 Vss 0.00713f
C135 lex_1_i.n127 Vss 0.2459f
C136 lex_1_i.n129 Vss 0.02055f
C137 lex_1_i.n130 Vss 0.00804f
C138 lex_1_i.n131 Vss 0.02393f
C139 lex_1_i.n132 Vss 0.0099f
C140 lex_1_i.n133 Vss 0.0099f
C141 lex_1_i.n134 Vss 0.0099f
C142 lex_1_i.n135 Vss 0.00804f
C143 lex_1_i.n136 Vss 0.02393f
C144 lex_1_i.n137 Vss 0.06215f
C145 lex_1_i.n138 Vss 0.0578f
C146 lex_1_i.n139 Vss 0.08763f
C147 lex_1_i.n140 Vss 0.00804f
C148 lex_1_i.n141 Vss 0.02055f
C149 lex_1_i.n142 Vss 0.2459f
C150 lex_1_i.n143 Vss 0.02055f
C151 lex_1_i.n144 Vss 0.00804f
C152 lex_1_i.n145 Vss 0.05268f
C153 lex_1_i.n146 Vss 0.06442f
C154 lex_1_i.n147 Vss 0.28651f
C155 lex_1_i.n148 Vss 0.02393f
C156 lex_1_i.n149 Vss 0.02055f
C157 lex_1_i.n150 Vss 0.02055f
C158 lex_1_i.n151 Vss 0.2459f
C159 lex_1_i.n152 Vss 0.2459f
C160 lex_1_i.n153 Vss 0.02055f
C161 lex_1_i.n154 Vss 0.02055f
C162 lex_1_i.n155 Vss 0.0578f
C163 lex_1_i.n157 Vss 0.00713f
C164 lex_1_i.n159 Vss 0.00713f
C165 lex_1_i.n160 Vss 0.00804f
C166 lex_1_i.n161 Vss 0.05268f
C167 lex_1_i.n162 Vss 0.0578f
C168 lex_1_i.n163 Vss 0.0099f
C169 lex_1_i.n164 Vss 0.0099f
C170 lex_1_i.n165 Vss 0.00804f
C171 lex_1_i.n166 Vss 0.08763f
C172 lex_1_i.n167 Vss 0.0099f
C173 lex_1_i.n169 Vss 0.00713f
C174 lex_1_i.n171 Vss 0.00713f
C175 lex_1_i.n172 Vss 0.00804f
C176 lex_1_i.n173 Vss 0.0099f
C177 lex_1_i.n174 Vss 0.0099f
C178 lex_1_i.n175 Vss 0.0099f
C179 lex_1_i.n176 Vss 0.00804f
C180 lex_1_i.n177 Vss 0.02393f
C181 lex_1_i.n178 Vss 0.06215f
C182 lex_1_i.n179 Vss 0.03292f
C183 lex_1_i.n180 Vss 0.36159f
C184 lex_1_i.n181 Vss 0.03292f
C185 lex_1_i.n182 Vss 0.0435f
C186 lex_1_i.n183 Vss 0.06442f
C187 lex_1_i.n184 Vss 0.17955f
C188 lex_1_i.n185 Vss 0.07044f
C189 lex_1_i.n186 Vss 0.02555f
C190 lex_1_i.n187 Vss 0.00804f
C191 lex_1_i.n188 Vss 0.03259f
C192 lex_1_i.n189 Vss 0.25807f
C193 lex_1_i.n190 Vss 0.02022f
C194 lex_1_i.n191 Vss 0.02555f
C195 lex_1_i.n192 Vss 0.17856f
C196 lex_1_i.n193 Vss 0.02022f
C197 lex_1_i.n194 Vss 0.00804f
C198 lex_1_i.n195 Vss 0.00804f
C199 lex_1_i.n196 Vss 0.02555f
C200 lex_1_i.n197 Vss 0.05807f
C201 lex_1_i.n198 Vss 0.03259f
C202 lex_1_i.n199 Vss 0.02022f
C203 lex_1_i.n200 Vss 0.17856f
C204 lex_1_i.n201 Vss 0.02022f
C205 lex_1_i.n202 Vss 0.00804f
C206 lex_1_i.n203 Vss 0.02404f
C207 lex_1_i.n204 Vss 0.07682f
C208 lex_1_i.n205 Vss 0.11336f
C209 Unnamed_57726a2b_0/a_28_n281.t3 Vss 0.47855f
C210 Unnamed_57726a2b_0/a_28_n281.t2 Vss 0.41746f
C211 Unnamed_57726a2b_0/a_28_n281.n0 Vss 1.0839f
C212 Unnamed_57726a2b_0/a_28_n281.t0 Vss 0.09055f
C213 Unnamed_57726a2b_0/a_28_n281.n1 Vss 1.74014f
C214 Unnamed_57726a2b_0/a_28_n281.t1 Vss 1.78942f
C215 Unnamed_c5099f02_0/a_28_n131# Vss 4.5894f
C216 Vin Vss 5.56476f
C217 Unnamed_89a7b3ce_0/a_28_n131# Vss 2.4767f
C218 lex_1_i Vss 37.09105f
C219 Vin_neg Vss 5.5574f
.ends
