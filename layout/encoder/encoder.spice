* NGSPICE file created from encoder.ext - technology: gf180mcuD

.subckt xm5 a_n306_n173# a_186_n173# w_n572_n603# a_n186_n382# VSUBS
X0 a_186_n173# a_n186_n382# a_n306_n173# w_n572_n603# pfet_03v3 ad=0.558p pd=3.06u as=0.558p ps=3.06u w=0.93u l=1.86u
C0 a_n306_n173# a_n186_n382# 0.11626f
C1 a_n186_n382# w_n572_n603# 0.94238f
C2 a_n186_n382# a_186_n173# 0.05372f
C3 a_n306_n173# w_n572_n603# 0.29685f
C4 a_n306_n173# a_186_n173# 0.38397f
C5 a_186_n173# w_n572_n603# 0.66931f
C6 a_186_n173# VSUBS 0.04839f
C7 a_n306_n173# VSUBS 0.04832f
C8 a_n186_n382# VSUBS 0.26326f
C9 w_n572_n603# VSUBS 5.08511f
.ends

.subckt xm3 a_28_n281# a_n178_n281# w_n444_n709# a_n50_n489# VSUBS
X0 a_28_n281# a_n50_n489# a_n178_n281# w_n444_n709# pfet_03v3 ad=1.5p pd=5.5u as=1.5p ps=5.5u w=2u l=0.28u
C0 a_28_n281# a_n50_n489# 0.02705f
C1 a_n50_n489# w_n444_n709# 0.38939f
C2 a_n50_n489# a_n178_n281# 0.0391f
C3 a_28_n281# w_n444_n709# 0.6139f
C4 a_28_n281# a_n178_n281# 0.53377f
C5 a_n178_n281# w_n444_n709# 0.35562f
C6 a_28_n281# VSUBS 0.08168f
C7 a_n178_n281# VSUBS 0.08054f
C8 a_n50_n489# VSUBS 0.0768f
C9 w_n444_n709# VSUBS 4.62248f
.ends

.subckt xm11 a_n178_n131# a_n50_n339# w_n444_n560# a_28_n131# VSUBS
X0 a_28_n131# a_n50_n339# a_n178_n131# w_n444_n560# pfet_03v3 ad=0.375p pd=2.5u as=0.375p ps=2.5u w=0.5u l=0.28u
C0 a_28_n131# a_n50_n339# 0.01004f
C1 a_n50_n339# w_n444_n560# 0.39308f
C2 a_n50_n339# a_n178_n131# 0.02611f
C3 a_28_n131# w_n444_n560# 0.48499f
C4 a_28_n131# a_n178_n131# 0.34063f
C5 a_n178_n131# w_n444_n560# 0.22952f
C6 a_28_n131# VSUBS 0.04441f
C7 a_n178_n131# VSUBS 0.04328f
C8 a_n50_n339# VSUBS 0.07699f
C9 w_n444_n560# VSUBS 3.73985f
.ends

.subckt xm1 a_n1120_n131# a_n1330_n504# a_1000_n131# a_n1000_n339#
X0 a_1000_n131# a_n1000_n339# a_n1120_n131# a_n1330_n504# nfet_03v3 ad=0.3p pd=2.2u as=0.3p ps=2.2u w=0.5u l=10u
C0 a_n1120_n131# a_n1000_n339# 0.42273f
C1 a_n1120_n131# a_1000_n131# 1.01551f
C2 a_1000_n131# a_n1000_n339# 0.06176f
C3 a_1000_n131# a_n1330_n504# 1.43795f
C4 a_n1120_n131# a_n1330_n504# 0.4423f
C5 a_n1000_n339# a_n1330_n504# 5.55287f
.ends

.subckt xm8 a_n306_n173# a_186_n173# w_n572_n603# a_n186_n382# VSUBS
X0 a_186_n173# a_n186_n382# a_n306_n173# w_n572_n603# pfet_03v3 ad=0.558p pd=3.06u as=0.558p ps=3.06u w=0.93u l=1.86u
C0 a_186_n173# w_n572_n603# 0.66931f
C1 a_n186_n382# w_n572_n603# 0.94238f
C2 a_186_n173# a_n306_n173# 0.38397f
C3 a_n186_n382# a_n306_n173# 0.11626f
C4 a_n186_n382# a_186_n173# 0.05372f
C5 a_n306_n173# w_n572_n603# 0.29685f
C6 a_186_n173# VSUBS 0.04839f
C7 a_n306_n173# VSUBS 0.04832f
C8 a_n186_n382# VSUBS 0.26326f
C9 w_n572_n603# VSUBS 5.08511f
.ends

.subckt xm6 a_n306_n173# a_186_n173# w_n572_n603# a_n186_n382# VSUBS
X0 a_186_n173# a_n186_n382# a_n306_n173# w_n572_n603# pfet_03v3 ad=0.558p pd=3.06u as=0.558p ps=3.06u w=0.93u l=1.86u
C0 a_186_n173# w_n572_n603# 0.66931f
C1 a_n186_n382# w_n572_n603# 0.94238f
C2 a_186_n173# a_n306_n173# 0.38397f
C3 a_n186_n382# a_n306_n173# 0.11626f
C4 a_n186_n382# a_186_n173# 0.05372f
C5 a_n306_n173# w_n572_n603# 0.29685f
C6 a_186_n173# VSUBS 0.04839f
C7 a_n306_n173# VSUBS 0.04832f
C8 a_n186_n382# VSUBS 0.26326f
C9 w_n572_n603# VSUBS 5.08511f
.ends

.subckt xm4 a_28_n281# a_n178_n281# w_n444_n709# a_n50_n489# VSUBS
X0 a_28_n281# a_n50_n489# a_n178_n281# w_n444_n709# pfet_03v3 ad=1.5p pd=5.5u as=1.5p ps=5.5u w=2u l=0.28u
C0 a_28_n281# w_n444_n709# 0.6139f
C1 a_n50_n489# w_n444_n709# 0.38939f
C2 a_28_n281# a_n178_n281# 0.53377f
C3 a_n50_n489# a_n178_n281# 0.0391f
C4 a_n50_n489# a_28_n281# 0.02705f
C5 a_n178_n281# w_n444_n709# 0.35562f
C6 a_28_n281# VSUBS 0.08168f
C7 a_n178_n281# VSUBS 0.08054f
C8 a_n50_n489# VSUBS 0.0768f
C9 w_n444_n709# VSUBS 4.62248f
.ends

.subckt xm2 a_n1120_n131# a_n1330_n504# a_1000_n131# a_n1000_n339#
X0 a_1000_n131# a_n1000_n339# a_n1120_n131# a_n1330_n504# nfet_03v3 ad=0.3p pd=2.2u as=0.3p ps=2.2u w=0.5u l=10u
C0 a_1000_n131# a_n1000_n339# 0.06176f
C1 a_1000_n131# a_n1120_n131# 1.01551f
C2 a_n1120_n131# a_n1000_n339# 0.42273f
C3 a_1000_n131# a_n1330_n504# 1.43795f
C4 a_n1120_n131# a_n1330_n504# 0.4423f
C5 a_n1000_n339# a_n1330_n504# 5.55287f
.ends

.subckt xm10 a_n178_n131# a_n50_n339# a_n388_n504# a_28_n131#
X0 a_28_n131# a_n50_n339# a_n178_n131# a_n388_n504# nfet_03v3 ad=0.375p pd=2.5u as=0.375p ps=2.5u w=0.5u l=0.28u
C0 a_28_n131# a_n50_n339# 0.01004f
C1 a_28_n131# a_n178_n131# 0.34063f
C2 a_n178_n131# a_n50_n339# 0.02611f
C3 a_28_n131# a_n388_n504# 0.52938f
C4 a_n178_n131# a_n388_n504# 0.27279f
C5 a_n50_n339# a_n388_n504# 0.47008f
.ends

.subckt xm9 a_n178_n131# a_n50_n339# a_n388_n504# a_28_n131#
X0 a_28_n131# a_n50_n339# a_n178_n131# a_n388_n504# nfet_03v3 ad=0.375p pd=2.5u as=0.375p ps=2.5u w=0.5u l=0.28u
C0 a_28_n131# a_n50_n339# 0.01004f
C1 a_28_n131# a_n178_n131# 0.34063f
C2 a_n178_n131# a_n50_n339# 0.02611f
C3 a_28_n131# a_n388_n504# 0.52938f
C4 a_n178_n131# a_n388_n504# 0.27279f
C5 a_n50_n339# a_n388_n504# 0.47008f
.ends

.subckt xm7 a_n306_n173# a_186_n173# w_n572_n603# a_n186_n382# VSUBS
X0 a_186_n173# a_n186_n382# a_n306_n173# w_n572_n603# pfet_03v3 ad=0.558p pd=3.06u as=0.558p ps=3.06u w=0.93u l=1.86u
C0 a_186_n173# w_n572_n603# 0.66931f
C1 a_n306_n173# w_n572_n603# 0.29685f
C2 a_186_n173# a_n186_n382# 0.05372f
C3 a_n306_n173# a_n186_n382# 0.11626f
C4 a_n306_n173# a_186_n173# 0.38397f
C5 a_n186_n382# w_n572_n603# 0.94238f
C6 a_186_n173# VSUBS 0.04839f
C7 a_n306_n173# VSUBS 0.04832f
C8 a_n186_n382# VSUBS 0.26326f
C9 w_n572_n603# VSUBS 5.08511f
.ends

.subckt encoder Vdd Vss
Xxm5_0 Vdd xm5_0/a_186_n173# Vdd Vss Vss xm5
Xxm3_0 Vss Vdd Vdd Vss Vss xm3
Xxm11_0 Vdd xm9_0/a_n50_n339# Vdd xm9_0/a_n50_n339# Vss xm11
Xxm1_0 Vss Vss Vss xm1_0/a_n1000_n339# xm1
Xxm8_0 Vdd xm8_0/a_186_n173# Vdd Vss Vss xm8
Xxm6_0 Vdd xm6_0/a_186_n173# Vdd xm4_0/a_28_n281# Vss xm6
Xxm4_0 xm4_0/a_28_n281# Vdd Vdd xm4_0/a_28_n281# Vss xm4
Xxm2_0 Vss Vss xm4_0/a_28_n281# xm2_0/a_n1000_n339# xm2
Xxm10_0 Vss xm9_0/a_n50_n339# Vss xm9_0/a_n50_n339# xm10
Xxm9_0 Vss xm9_0/a_n50_n339# Vss Vss xm9
Xxm7_0 Vdd xm7_0/a_186_n173# Vdd xm4_0/a_28_n281# Vss xm7
X0 xm4_0/a_28_n281.t1 xm4_0/a_28_n281.t0 Vdd Vdd pfet_03v3 ad=1.5p pd=5.5u as=1.5p ps=5.5u w=0 l=0
X1 xm8_0/a_186_n173# Vss.t3 Vdd Vdd pfet_03v3 ad=0.558p pd=3.06u as=0.558p ps=3.06u w=0 l=0
X2 xm5_0/a_186_n173# Vss.t2 Vdd Vdd pfet_03v3 ad=0.558p pd=3.06u as=0.558p ps=3.06u w=0 l=0
X3 xm7_0/a_186_n173# xm4_0/a_28_n281.t3 Vdd Vdd pfet_03v3 ad=0.558p pd=3.06u as=0.558p ps=3.06u w=0 l=0
X4 Vss.t1 Vss.t0 Vdd Vdd pfet_03v3 ad=1.5p pd=5.5u as=1.5p ps=5.5u w=0 l=0
X5 xm6_0/a_186_n173# xm4_0/a_28_n281.t2 Vdd Vdd pfet_03v3 ad=0.558p pd=3.06u as=0.558p ps=3.06u w=0 l=0
R0 Vss.n219 Vss.n218 16804.5
R1 Vss.n214 Vss.n96 15075
R2 Vss.n218 Vss.n47 15075
R3 Vss.n217 Vss.n94 15075
R4 Vss.n216 Vss.n9 14000
R5 Vss.n215 Vss.n95 14000
R6 Vss.n214 Vss.n213 12601.8
R7 Vss.n218 Vss.n217 4508.89
R8 Vss.n215 Vss.n214 4476.19
R9 Vss.n217 Vss.n216 4476.19
R10 Vss.n216 Vss.n215 3398
R11 Vss.n132 Vss.n131 677.784
R12 Vss.n263 Vss.n262 677.784
R13 Vss.n254 Vss.n253 677.784
R14 Vss.n264 Vss.n263 415.219
R15 Vss.n255 Vss.n254 415.219
R16 Vss.n95 Vss.n7 412.166
R17 Vss.n15 Vss.n9 412.166
R18 Vss.n188 Vss.n132 387.741
R19 Vss.n253 Vss.n23 387.741
R20 Vss.n219 Vss.n59 387.741
R21 Vss.n153 Vss.n97 244.246
R22 Vss.n154 Vss.n153 244.246
R23 Vss.n156 Vss.n154 244.246
R24 Vss.n156 Vss.n143 244.246
R25 Vss.n164 Vss.n143 244.246
R26 Vss.n165 Vss.n164 244.246
R27 Vss.n168 Vss.n165 244.246
R28 Vss.n168 Vss.n166 244.246
R29 Vss.n177 Vss.n176 244.246
R30 Vss.n179 Vss.n177 244.246
R31 Vss.n179 Vss.n118 244.246
R32 Vss.n188 Vss.n118 244.246
R33 Vss.n264 Vss.n7 244.246
R34 Vss.n255 Vss.n15 244.246
R35 Vss.n245 Vss.n32 244.246
R36 Vss.n245 Vss.n244 244.246
R37 Vss.n244 Vss.n243 244.246
R38 Vss.n243 Vss.n36 244.246
R39 Vss.n237 Vss.n36 244.246
R40 Vss.n237 Vss.n236 244.246
R41 Vss.n236 Vss.n235 244.246
R42 Vss.n229 Vss.n55 244.246
R43 Vss.n229 Vss.n228 244.246
R44 Vss.n228 Vss.n227 244.246
R45 Vss.n227 Vss.n59 244.246
R46 Vss.n94 Vss.n32 238.141
R47 Vss.n213 Vss.n97 198.958
R48 Vss.n235 Vss.n47 195.398
R49 Vss.n213 Vss.n212 185.952
R50 Vss.n166 Vss.n96 146.548
R51 Vss.n176 Vss.n96 97.699
R52 Vss.n22 Vss.n14 68.4449
R53 Vss.n256 Vss.n14 68.4449
R54 Vss.n261 Vss.n11 68.4449
R55 Vss.n261 Vss.n10 68.4449
R56 Vss.n8 Vss.n6 68.4449
R57 Vss.n265 Vss.n6 68.4449
R58 Vss.n130 Vss.n5 68.4449
R59 Vss.n130 Vss.n119 68.4449
R60 Vss.n220 Vss.n93 66.6949
R61 Vss.n220 Vss.n60 66.6949
R62 Vss.n252 Vss.n25 66.6949
R63 Vss.n252 Vss.n24 66.6949
R64 Vss.n212 Vss.n98 66.6949
R65 Vss.n212 Vss.n99 66.6949
R66 Vss.n187 Vss.n117 66.6949
R67 Vss.n189 Vss.n117 66.6949
R68 Vss.n125 Vss.t0 56.5831
R69 Vss.n55 Vss.n47 48.8497
R70 Vss.n28 Vss.n25 15.5561
R71 Vss.n246 Vss.n28 15.5561
R72 Vss.n246 Vss.n31 15.5561
R73 Vss.n242 Vss.n31 15.5561
R74 Vss.n242 Vss.n37 15.5561
R75 Vss.n238 Vss.n37 15.5561
R76 Vss.n238 Vss.n43 15.5561
R77 Vss.n234 Vss.n43 15.5561
R78 Vss.n234 Vss.n48 15.5561
R79 Vss.n230 Vss.n48 15.5561
R80 Vss.n230 Vss.n54 15.5561
R81 Vss.n226 Vss.n54 15.5561
R82 Vss.n226 Vss.n60 15.5561
R83 Vss.n71 Vss.n24 15.5561
R84 Vss.n71 Vss.n33 15.5561
R85 Vss.n34 Vss.n33 15.5561
R86 Vss.n35 Vss.n34 15.5561
R87 Vss.n78 Vss.n35 15.5561
R88 Vss.n78 Vss.n44 15.5561
R89 Vss.n45 Vss.n44 15.5561
R90 Vss.n46 Vss.n45 15.5561
R91 Vss.n85 Vss.n46 15.5561
R92 Vss.n85 Vss.n56 15.5561
R93 Vss.n57 Vss.n56 15.5561
R94 Vss.n58 Vss.n57 15.5561
R95 Vss.n93 Vss.n58 15.5561
R96 Vss.n256 Vss.n11 15.5561
R97 Vss.n22 Vss.n10 15.5561
R98 Vss.n265 Vss.n5 15.5561
R99 Vss.n119 Vss.n8 15.5561
R100 Vss.n152 Vss.n98 15.5561
R101 Vss.n152 Vss.n148 15.5561
R102 Vss.n157 Vss.n148 15.5561
R103 Vss.n157 Vss.n144 15.5561
R104 Vss.n163 Vss.n144 15.5561
R105 Vss.n163 Vss.n142 15.5561
R106 Vss.n169 Vss.n142 15.5561
R107 Vss.n169 Vss.n138 15.5561
R108 Vss.n175 Vss.n138 15.5561
R109 Vss.n175 Vss.n137 15.5561
R110 Vss.n180 Vss.n137 15.5561
R111 Vss.n180 Vss.n133 15.5561
R112 Vss.n187 Vss.n133 15.5561
R113 Vss.n102 Vss.n99 15.5561
R114 Vss.n103 Vss.n102 15.5561
R115 Vss.n155 Vss.n103 15.5561
R116 Vss.n155 Vss.n106 15.5561
R117 Vss.n107 Vss.n106 15.5561
R118 Vss.n108 Vss.n107 15.5561
R119 Vss.n167 Vss.n108 15.5561
R120 Vss.n167 Vss.n111 15.5561
R121 Vss.n112 Vss.n111 15.5561
R122 Vss.n113 Vss.n112 15.5561
R123 Vss.n178 Vss.n113 15.5561
R124 Vss.n178 Vss.n116 15.5561
R125 Vss.n189 Vss.n116 15.5561
R126 Vss.n127 Vss.n126 14.4995
R127 Vss.n124 Vss.t3 10.7012
R128 Vss.n126 Vss.n125 9.9707
R129 Vss.n124 Vss.t2 9.4373
R130 Vss.n126 Vss.t1 8.23389
R131 Vss.n222 Vss.n1 6.38729
R132 Vss.n94 Vss.n23 6.10665
R133 Vss.n128 Vss.n127 5.5337
R134 Vss Vss.n0 5.48009
R135 Vss.n121 Vss.n8 5.2005
R136 Vss.n264 Vss.n8 5.2005
R137 Vss.n122 Vss.n119 5.2005
R138 Vss.n119 Vss.n7 5.2005
R139 Vss.n266 Vss.n265 5.2005
R140 Vss.n265 Vss.n264 5.2005
R141 Vss.n5 Vss.n4 5.2005
R142 Vss.n7 Vss.n5 5.2005
R143 Vss.n22 Vss.n21 5.2005
R144 Vss.n255 Vss.n22 5.2005
R145 Vss.n16 Vss.n10 5.2005
R146 Vss.n15 Vss.n10 5.2005
R147 Vss.n257 Vss.n256 5.2005
R148 Vss.n256 Vss.n255 5.2005
R149 Vss.n258 Vss.n11 5.2005
R150 Vss.n15 Vss.n11 5.2005
R151 Vss.n93 Vss.n92 5.2005
R152 Vss.n93 Vss.n59 5.2005
R153 Vss.n91 Vss.n58 5.2005
R154 Vss.n227 Vss.n58 5.2005
R155 Vss.n64 Vss.n57 5.2005
R156 Vss.n228 Vss.n57 5.2005
R157 Vss.n87 Vss.n56 5.2005
R158 Vss.n229 Vss.n56 5.2005
R159 Vss.n86 Vss.n85 5.2005
R160 Vss.n85 Vss.n55 5.2005
R161 Vss.n84 Vss.n46 5.2005
R162 Vss.n235 Vss.n46 5.2005
R163 Vss.n66 Vss.n45 5.2005
R164 Vss.n236 Vss.n45 5.2005
R165 Vss.n80 Vss.n44 5.2005
R166 Vss.n237 Vss.n44 5.2005
R167 Vss.n79 Vss.n78 5.2005
R168 Vss.n78 Vss.n36 5.2005
R169 Vss.n77 Vss.n35 5.2005
R170 Vss.n243 Vss.n35 5.2005
R171 Vss.n68 Vss.n34 5.2005
R172 Vss.n244 Vss.n34 5.2005
R173 Vss.n73 Vss.n33 5.2005
R174 Vss.n245 Vss.n33 5.2005
R175 Vss.n72 Vss.n71 5.2005
R176 Vss.n71 Vss.n32 5.2005
R177 Vss.n70 Vss.n24 5.2005
R178 Vss.n24 Vss.n23 5.2005
R179 Vss.n224 Vss.n60 5.2005
R180 Vss.n60 Vss.n59 5.2005
R181 Vss.n226 Vss.n225 5.2005
R182 Vss.n227 Vss.n226 5.2005
R183 Vss.n54 Vss.n53 5.2005
R184 Vss.n228 Vss.n54 5.2005
R185 Vss.n231 Vss.n230 5.2005
R186 Vss.n230 Vss.n229 5.2005
R187 Vss.n232 Vss.n48 5.2005
R188 Vss.n55 Vss.n48 5.2005
R189 Vss.n234 Vss.n233 5.2005
R190 Vss.n235 Vss.n234 5.2005
R191 Vss.n43 Vss.n42 5.2005
R192 Vss.n236 Vss.n43 5.2005
R193 Vss.n239 Vss.n238 5.2005
R194 Vss.n238 Vss.n237 5.2005
R195 Vss.n240 Vss.n37 5.2005
R196 Vss.n37 Vss.n36 5.2005
R197 Vss.n242 Vss.n241 5.2005
R198 Vss.n243 Vss.n242 5.2005
R199 Vss.n31 Vss.n30 5.2005
R200 Vss.n244 Vss.n31 5.2005
R201 Vss.n247 Vss.n246 5.2005
R202 Vss.n246 Vss.n245 5.2005
R203 Vss.n248 Vss.n28 5.2005
R204 Vss.n32 Vss.n28 5.2005
R205 Vss.n249 Vss.n25 5.2005
R206 Vss.n25 Vss.n23 5.2005
R207 Vss.n187 Vss.n186 5.2005
R208 Vss.n188 Vss.n187 5.2005
R209 Vss.n134 Vss.n133 5.2005
R210 Vss.n133 Vss.n118 5.2005
R211 Vss.n181 Vss.n180 5.2005
R212 Vss.n180 Vss.n179 5.2005
R213 Vss.n137 Vss.n136 5.2005
R214 Vss.n177 Vss.n137 5.2005
R215 Vss.n175 Vss.n174 5.2005
R216 Vss.n176 Vss.n175 5.2005
R217 Vss.n139 Vss.n138 5.2005
R218 Vss.n166 Vss.n138 5.2005
R219 Vss.n170 Vss.n169 5.2005
R220 Vss.n169 Vss.n168 5.2005
R221 Vss.n142 Vss.n141 5.2005
R222 Vss.n165 Vss.n142 5.2005
R223 Vss.n163 Vss.n162 5.2005
R224 Vss.n164 Vss.n163 5.2005
R225 Vss.n145 Vss.n144 5.2005
R226 Vss.n144 Vss.n143 5.2005
R227 Vss.n158 Vss.n157 5.2005
R228 Vss.n157 Vss.n156 5.2005
R229 Vss.n148 Vss.n147 5.2005
R230 Vss.n154 Vss.n148 5.2005
R231 Vss.n152 Vss.n151 5.2005
R232 Vss.n153 Vss.n152 5.2005
R233 Vss.n149 Vss.n98 5.2005
R234 Vss.n98 Vss.n97 5.2005
R235 Vss.n190 Vss.n189 5.2005
R236 Vss.n189 Vss.n188 5.2005
R237 Vss.n191 Vss.n116 5.2005
R238 Vss.n118 Vss.n116 5.2005
R239 Vss.n178 Vss.n114 5.2005
R240 Vss.n179 Vss.n178 5.2005
R241 Vss.n195 Vss.n113 5.2005
R242 Vss.n177 Vss.n113 5.2005
R243 Vss.n196 Vss.n112 5.2005
R244 Vss.n176 Vss.n112 5.2005
R245 Vss.n197 Vss.n111 5.2005
R246 Vss.n166 Vss.n111 5.2005
R247 Vss.n167 Vss.n109 5.2005
R248 Vss.n168 Vss.n167 5.2005
R249 Vss.n201 Vss.n108 5.2005
R250 Vss.n165 Vss.n108 5.2005
R251 Vss.n202 Vss.n107 5.2005
R252 Vss.n164 Vss.n107 5.2005
R253 Vss.n203 Vss.n106 5.2005
R254 Vss.n143 Vss.n106 5.2005
R255 Vss.n155 Vss.n104 5.2005
R256 Vss.n156 Vss.n155 5.2005
R257 Vss.n207 Vss.n103 5.2005
R258 Vss.n154 Vss.n103 5.2005
R259 Vss.n208 Vss.n102 5.2005
R260 Vss.n153 Vss.n102 5.2005
R261 Vss.n209 Vss.n99 5.2005
R262 Vss.n99 Vss.n97 5.2005
R263 Vss.n20 Vss.n19 5.19561
R264 Vss.n260 Vss.n259 5.19561
R265 Vss.n120 Vss.n2 5.19561
R266 Vss.n129 Vss.n3 5.19561
R267 Vss.n221 Vss.n63 5.17941
R268 Vss.n251 Vss.n250 5.17941
R269 Vss.n251 Vss.n26 5.17941
R270 Vss.n211 Vss.n210 5.17941
R271 Vss.n211 Vss.n100 5.17941
R272 Vss.n185 Vss.n184 5.17941
R273 Vss.n17 Vss.n12 5.0655
R274 Vss.n128 Vss.n123 5.0655
R275 Vss.n18 Vss.n1 5.02289
R276 Vss.n269 Vss.n268 5.02289
R277 Vss.n18 Vss.n13 4.7417
R278 Vss.n268 Vss.n267 4.7417
R279 Vss.n223 Vss.n222 4.7255
R280 Vss.n115 Vss.n0 4.7255
R281 Vss.n248 Vss.n27 4.5005
R282 Vss.n247 Vss.n29 4.5005
R283 Vss.n38 Vss.n30 4.5005
R284 Vss.n241 Vss.n39 4.5005
R285 Vss.n240 Vss.n40 4.5005
R286 Vss.n239 Vss.n41 4.5005
R287 Vss.n49 Vss.n42 4.5005
R288 Vss.n233 Vss.n50 4.5005
R289 Vss.n232 Vss.n51 4.5005
R290 Vss.n231 Vss.n52 4.5005
R291 Vss.n61 Vss.n53 4.5005
R292 Vss.n225 Vss.n62 4.5005
R293 Vss.n224 Vss.n223 4.5005
R294 Vss.n250 Vss.n249 4.5005
R295 Vss.n72 Vss.n69 4.5005
R296 Vss.n74 Vss.n73 4.5005
R297 Vss.n75 Vss.n68 4.5005
R298 Vss.n77 Vss.n76 4.5005
R299 Vss.n79 Vss.n67 4.5005
R300 Vss.n81 Vss.n80 4.5005
R301 Vss.n82 Vss.n66 4.5005
R302 Vss.n84 Vss.n83 4.5005
R303 Vss.n86 Vss.n65 4.5005
R304 Vss.n88 Vss.n87 4.5005
R305 Vss.n89 Vss.n64 4.5005
R306 Vss.n91 Vss.n90 4.5005
R307 Vss.n92 Vss.n63 4.5005
R308 Vss.n70 Vss.n26 4.5005
R309 Vss.n21 Vss.n20 4.5005
R310 Vss.n17 Vss.n16 4.5005
R311 Vss.n257 Vss.n13 4.5005
R312 Vss.n259 Vss.n258 4.5005
R313 Vss.n127 Vss.n12 4.5005
R314 Vss.n267 Vss.n266 4.5005
R315 Vss.n4 Vss.n3 4.5005
R316 Vss.n121 Vss.n120 4.5005
R317 Vss.n123 Vss.n122 4.5005
R318 Vss.n208 Vss.n101 4.5005
R319 Vss.n207 Vss.n206 4.5005
R320 Vss.n205 Vss.n104 4.5005
R321 Vss.n204 Vss.n203 4.5005
R322 Vss.n202 Vss.n105 4.5005
R323 Vss.n201 Vss.n200 4.5005
R324 Vss.n199 Vss.n109 4.5005
R325 Vss.n198 Vss.n197 4.5005
R326 Vss.n196 Vss.n110 4.5005
R327 Vss.n195 Vss.n194 4.5005
R328 Vss.n193 Vss.n114 4.5005
R329 Vss.n192 Vss.n191 4.5005
R330 Vss.n190 Vss.n115 4.5005
R331 Vss.n210 Vss.n209 4.5005
R332 Vss.n151 Vss.n150 4.5005
R333 Vss.n147 Vss.n146 4.5005
R334 Vss.n159 Vss.n158 4.5005
R335 Vss.n160 Vss.n145 4.5005
R336 Vss.n162 Vss.n161 4.5005
R337 Vss.n141 Vss.n140 4.5005
R338 Vss.n171 Vss.n170 4.5005
R339 Vss.n172 Vss.n139 4.5005
R340 Vss.n174 Vss.n173 4.5005
R341 Vss.n136 Vss.n135 4.5005
R342 Vss.n182 Vss.n181 4.5005
R343 Vss.n183 Vss.n134 4.5005
R344 Vss.n186 Vss.n185 4.5005
R345 Vss.n149 Vss.n100 4.5005
R346 Vss.n131 Vss.n95 3.05358
R347 Vss.n262 Vss.n9 3.05358
R348 Vss.n125 Vss.n124 0.866463
R349 Vss.n130 Vss.n129 0.743357
R350 Vss.n131 Vss.n130 0.743357
R351 Vss.n6 Vss.n2 0.743357
R352 Vss.n263 Vss.n6 0.743357
R353 Vss.n261 Vss.n260 0.743357
R354 Vss.n262 Vss.n261 0.743357
R355 Vss.n19 Vss.n14 0.743357
R356 Vss.n254 Vss.n14 0.743357
R357 Vss.n252 Vss.n251 0.743357
R358 Vss.n253 Vss.n252 0.743357
R359 Vss.n221 Vss.n220 0.743357
R360 Vss.n220 Vss.n219 0.743357
R361 Vss.n212 Vss.n211 0.743357
R362 Vss.n184 Vss.n117 0.743357
R363 Vss.n132 Vss.n117 0.743357
R364 Vss.n269 Vss.n1 0.5171
R365 Vss.n222 Vss.n221 0.454413
R366 Vss.n19 Vss.n18 0.454413
R367 Vss.n268 Vss.n2 0.454413
R368 Vss.n184 Vss.n0 0.454413
R369 Vss.n249 Vss.n248 0.1445
R370 Vss.n248 Vss.n247 0.1445
R371 Vss.n247 Vss.n30 0.1445
R372 Vss.n241 Vss.n30 0.1445
R373 Vss.n241 Vss.n240 0.1445
R374 Vss.n240 Vss.n239 0.1445
R375 Vss.n239 Vss.n42 0.1445
R376 Vss.n233 Vss.n42 0.1445
R377 Vss.n233 Vss.n232 0.1445
R378 Vss.n232 Vss.n231 0.1445
R379 Vss.n231 Vss.n53 0.1445
R380 Vss.n225 Vss.n53 0.1445
R381 Vss.n225 Vss.n224 0.1445
R382 Vss.n250 Vss.n27 0.1445
R383 Vss.n29 Vss.n27 0.1445
R384 Vss.n38 Vss.n29 0.1445
R385 Vss.n39 Vss.n38 0.1445
R386 Vss.n40 Vss.n39 0.1445
R387 Vss.n41 Vss.n40 0.1445
R388 Vss.n49 Vss.n41 0.1445
R389 Vss.n50 Vss.n49 0.1445
R390 Vss.n51 Vss.n50 0.1445
R391 Vss.n52 Vss.n51 0.1445
R392 Vss.n61 Vss.n52 0.1445
R393 Vss.n62 Vss.n61 0.1445
R394 Vss.n223 Vss.n62 0.1445
R395 Vss.n69 Vss.n26 0.1445
R396 Vss.n74 Vss.n69 0.1445
R397 Vss.n75 Vss.n74 0.1445
R398 Vss.n76 Vss.n75 0.1445
R399 Vss.n76 Vss.n67 0.1445
R400 Vss.n81 Vss.n67 0.1445
R401 Vss.n82 Vss.n81 0.1445
R402 Vss.n83 Vss.n82 0.1445
R403 Vss.n83 Vss.n65 0.1445
R404 Vss.n88 Vss.n65 0.1445
R405 Vss.n89 Vss.n88 0.1445
R406 Vss.n90 Vss.n89 0.1445
R407 Vss.n90 Vss.n63 0.1445
R408 Vss.n72 Vss.n70 0.1445
R409 Vss.n73 Vss.n72 0.1445
R410 Vss.n73 Vss.n68 0.1445
R411 Vss.n77 Vss.n68 0.1445
R412 Vss.n79 Vss.n77 0.1445
R413 Vss.n80 Vss.n79 0.1445
R414 Vss.n80 Vss.n66 0.1445
R415 Vss.n84 Vss.n66 0.1445
R416 Vss.n86 Vss.n84 0.1445
R417 Vss.n87 Vss.n86 0.1445
R418 Vss.n87 Vss.n64 0.1445
R419 Vss.n91 Vss.n64 0.1445
R420 Vss.n92 Vss.n91 0.1445
R421 Vss.n258 Vss.n257 0.1445
R422 Vss.n21 Vss.n16 0.1445
R423 Vss.n20 Vss.n17 0.1445
R424 Vss.n259 Vss.n13 0.1445
R425 Vss.n266 Vss.n4 0.1445
R426 Vss.n267 Vss.n3 0.1445
R427 Vss.n123 Vss.n120 0.1445
R428 Vss.n122 Vss.n121 0.1445
R429 Vss.n151 Vss.n149 0.1445
R430 Vss.n151 Vss.n147 0.1445
R431 Vss.n158 Vss.n147 0.1445
R432 Vss.n158 Vss.n145 0.1445
R433 Vss.n162 Vss.n145 0.1445
R434 Vss.n162 Vss.n141 0.1445
R435 Vss.n170 Vss.n141 0.1445
R436 Vss.n170 Vss.n139 0.1445
R437 Vss.n174 Vss.n139 0.1445
R438 Vss.n174 Vss.n136 0.1445
R439 Vss.n181 Vss.n136 0.1445
R440 Vss.n181 Vss.n134 0.1445
R441 Vss.n186 Vss.n134 0.1445
R442 Vss.n209 Vss.n208 0.1445
R443 Vss.n208 Vss.n207 0.1445
R444 Vss.n207 Vss.n104 0.1445
R445 Vss.n203 Vss.n104 0.1445
R446 Vss.n203 Vss.n202 0.1445
R447 Vss.n202 Vss.n201 0.1445
R448 Vss.n201 Vss.n109 0.1445
R449 Vss.n197 Vss.n109 0.1445
R450 Vss.n197 Vss.n196 0.1445
R451 Vss.n196 Vss.n195 0.1445
R452 Vss.n195 Vss.n114 0.1445
R453 Vss.n191 Vss.n114 0.1445
R454 Vss.n191 Vss.n190 0.1445
R455 Vss.n210 Vss.n101 0.1445
R456 Vss.n206 Vss.n101 0.1445
R457 Vss.n206 Vss.n205 0.1445
R458 Vss.n205 Vss.n204 0.1445
R459 Vss.n204 Vss.n105 0.1445
R460 Vss.n200 Vss.n105 0.1445
R461 Vss.n200 Vss.n199 0.1445
R462 Vss.n199 Vss.n198 0.1445
R463 Vss.n198 Vss.n110 0.1445
R464 Vss.n194 Vss.n110 0.1445
R465 Vss.n194 Vss.n193 0.1445
R466 Vss.n193 Vss.n192 0.1445
R467 Vss.n192 Vss.n115 0.1445
R468 Vss.n150 Vss.n100 0.1445
R469 Vss.n150 Vss.n146 0.1445
R470 Vss.n159 Vss.n146 0.1445
R471 Vss.n160 Vss.n159 0.1445
R472 Vss.n161 Vss.n160 0.1445
R473 Vss.n161 Vss.n140 0.1445
R474 Vss.n171 Vss.n140 0.1445
R475 Vss.n172 Vss.n171 0.1445
R476 Vss.n173 Vss.n172 0.1445
R477 Vss.n173 Vss.n135 0.1445
R478 Vss.n182 Vss.n135 0.1445
R479 Vss.n183 Vss.n182 0.1445
R480 Vss.n185 Vss.n183 0.1445
R481 Vss.n260 Vss.n12 0.122783
R482 Vss.n129 Vss.n128 0.122783
R483 Vss Vss.n269 0.0563
R484 Vdd.n106 Vdd.n95 696.312
R485 Vdd.n106 Vdd.n105 696.312
R486 Vdd.n15 Vdd.n4 696.312
R487 Vdd.n7 Vdd.n4 696.312
R488 Vdd.n199 Vdd.n188 528.52
R489 Vdd.n191 Vdd.n188 528.52
R490 Vdd.n142 Vdd.n117 446.678
R491 Vdd.n127 Vdd.n117 446.678
R492 Vdd.n178 Vdd.n153 446.678
R493 Vdd.n163 Vdd.n153 446.678
R494 Vdd.n86 Vdd.n61 446.678
R495 Vdd.n71 Vdd.n61 446.678
R496 Vdd.n50 Vdd.n25 446.678
R497 Vdd.n35 Vdd.n25 446.678
R498 Vdd.n108 Vdd.n107 74.638
R499 Vdd.n107 Vdd.n96 74.638
R500 Vdd.n104 Vdd.n98 74.638
R501 Vdd.n98 Vdd.n97 74.638
R502 Vdd.n16 Vdd.n3 74.638
R503 Vdd.n8 Vdd.n3 74.638
R504 Vdd.n13 Vdd.n5 74.638
R505 Vdd.n14 Vdd.n13 74.638
R506 Vdd.n143 Vdd.n116 62.563
R507 Vdd.n129 Vdd.n116 62.563
R508 Vdd.n123 Vdd.n119 62.563
R509 Vdd.n141 Vdd.n119 62.563
R510 Vdd.n179 Vdd.n152 62.563
R511 Vdd.n165 Vdd.n152 62.563
R512 Vdd.n159 Vdd.n155 62.563
R513 Vdd.n177 Vdd.n155 62.563
R514 Vdd.n87 Vdd.n60 62.563
R515 Vdd.n73 Vdd.n60 62.563
R516 Vdd.n67 Vdd.n63 62.563
R517 Vdd.n85 Vdd.n63 62.563
R518 Vdd.n51 Vdd.n24 62.563
R519 Vdd.n37 Vdd.n24 62.563
R520 Vdd.n31 Vdd.n27 62.563
R521 Vdd.n49 Vdd.n27 62.563
R522 Vdd.n200 Vdd.n187 61.6005
R523 Vdd.n192 Vdd.n187 61.6005
R524 Vdd.n197 Vdd.n189 61.6005
R525 Vdd.n198 Vdd.n197 61.6005
R526 Vdd.n125 Vdd.n124 14.0005
R527 Vdd.n141 Vdd.n120 14.0005
R528 Vdd.n143 Vdd.n115 14.0005
R529 Vdd.n161 Vdd.n160 14.0005
R530 Vdd.n177 Vdd.n156 14.0005
R531 Vdd.n179 Vdd.n151 14.0005
R532 Vdd.n69 Vdd.n68 14.0005
R533 Vdd.n85 Vdd.n64 14.0005
R534 Vdd.n87 Vdd.n59 14.0005
R535 Vdd.n33 Vdd.n32 14.0005
R536 Vdd.n49 Vdd.n28 14.0005
R537 Vdd.n51 Vdd.n23 14.0005
R538 Vdd.n99 Vdd.n96 6.3005
R539 Vdd.n104 Vdd.n103 6.3005
R540 Vdd.n97 Vdd.n94 6.3005
R541 Vdd.n109 Vdd.n108 6.3005
R542 Vdd.n130 Vdd.n129 6.3005
R543 Vdd.n133 Vdd.n125 6.3005
R544 Vdd.n134 Vdd.n124 6.3005
R545 Vdd.n135 Vdd.n123 6.3005
R546 Vdd.n144 Vdd.n143 6.3005
R547 Vdd.n143 Vdd.n142 6.3005
R548 Vdd.n115 Vdd.n114 6.3005
R549 Vdd.n121 Vdd.n120 6.3005
R550 Vdd.n141 Vdd.n140 6.3005
R551 Vdd.n142 Vdd.n141 6.3005
R552 Vdd.n166 Vdd.n165 6.3005
R553 Vdd.n169 Vdd.n161 6.3005
R554 Vdd.n170 Vdd.n160 6.3005
R555 Vdd.n171 Vdd.n159 6.3005
R556 Vdd.n180 Vdd.n179 6.3005
R557 Vdd.n179 Vdd.n178 6.3005
R558 Vdd.n151 Vdd.n150 6.3005
R559 Vdd.n157 Vdd.n156 6.3005
R560 Vdd.n177 Vdd.n176 6.3005
R561 Vdd.n178 Vdd.n177 6.3005
R562 Vdd.n193 Vdd.n192 6.3005
R563 Vdd.n194 Vdd.n189 6.3005
R564 Vdd.n201 Vdd.n200 6.3005
R565 Vdd.n198 Vdd.n186 6.3005
R566 Vdd.n74 Vdd.n73 6.3005
R567 Vdd.n77 Vdd.n69 6.3005
R568 Vdd.n78 Vdd.n68 6.3005
R569 Vdd.n79 Vdd.n67 6.3005
R570 Vdd.n88 Vdd.n87 6.3005
R571 Vdd.n87 Vdd.n86 6.3005
R572 Vdd.n59 Vdd.n58 6.3005
R573 Vdd.n65 Vdd.n64 6.3005
R574 Vdd.n85 Vdd.n84 6.3005
R575 Vdd.n86 Vdd.n85 6.3005
R576 Vdd.n38 Vdd.n37 6.3005
R577 Vdd.n41 Vdd.n33 6.3005
R578 Vdd.n42 Vdd.n32 6.3005
R579 Vdd.n43 Vdd.n31 6.3005
R580 Vdd.n52 Vdd.n51 6.3005
R581 Vdd.n51 Vdd.n50 6.3005
R582 Vdd.n23 Vdd.n22 6.3005
R583 Vdd.n29 Vdd.n28 6.3005
R584 Vdd.n49 Vdd.n48 6.3005
R585 Vdd.n50 Vdd.n49 6.3005
R586 Vdd.n9 Vdd.n8 6.3005
R587 Vdd.n10 Vdd.n5 6.3005
R588 Vdd.n17 Vdd.n16 6.3005
R589 Vdd.n14 Vdd.n2 6.3005
R590 Vdd.n55 Vdd.n19 5.85034
R591 Vdd.n147 Vdd.n111 5.73514
R592 Vdd.n204 Vdd.n203 5.51007
R593 Vdd.n147 Vdd.n146 5.42593
R594 Vdd.n183 Vdd.n182 5.42593
R595 Vdd.n91 Vdd.n90 5.42593
R596 Vdd.n55 Vdd.n54 5.42593
R597 Vdd.n102 Vdd.n100 5.34137
R598 Vdd.n101 Vdd.n92 5.34137
R599 Vdd.n12 Vdd.n11 5.34137
R600 Vdd.n6 Vdd.n0 5.34137
R601 Vdd.n100 Vdd.n93 5.33355
R602 Vdd.n12 Vdd.n1 5.33355
R603 Vdd.n137 Vdd.n136 5.20888
R604 Vdd.n131 Vdd.n112 5.20888
R605 Vdd.n173 Vdd.n172 5.20888
R606 Vdd.n167 Vdd.n148 5.20888
R607 Vdd.n81 Vdd.n80 5.20888
R608 Vdd.n75 Vdd.n56 5.20888
R609 Vdd.n45 Vdd.n44 5.20888
R610 Vdd.n39 Vdd.n20 5.20888
R611 Vdd.n139 Vdd.n137 5.20105
R612 Vdd.n175 Vdd.n173 5.20105
R613 Vdd.n83 Vdd.n81 5.20105
R614 Vdd.n47 Vdd.n45 5.20105
R615 Vdd.n196 Vdd.n195 5.19561
R616 Vdd.n190 Vdd.n184 5.19561
R617 Vdd.n196 Vdd.n185 5.18779
R618 Vdd.n111 Vdd.n110 4.7417
R619 Vdd.n203 Vdd.n202 4.7417
R620 Vdd.n19 Vdd.n18 4.7417
R621 Vdd.n146 Vdd.n145 4.7129
R622 Vdd.n182 Vdd.n181 4.7129
R623 Vdd.n90 Vdd.n89 4.7129
R624 Vdd.n54 Vdd.n53 4.7129
R625 Vdd.n94 Vdd.n93 4.5005
R626 Vdd.n110 Vdd.n109 4.5005
R627 Vdd.n101 Vdd.n99 4.5005
R628 Vdd.n103 Vdd.n102 4.5005
R629 Vdd.n138 Vdd.n121 4.5005
R630 Vdd.n114 Vdd.n113 4.5005
R631 Vdd.n145 Vdd.n144 4.5005
R632 Vdd.n140 Vdd.n139 4.5005
R633 Vdd.n134 Vdd.n122 4.5005
R634 Vdd.n133 Vdd.n132 4.5005
R635 Vdd.n131 Vdd.n130 4.5005
R636 Vdd.n136 Vdd.n135 4.5005
R637 Vdd.n174 Vdd.n157 4.5005
R638 Vdd.n150 Vdd.n149 4.5005
R639 Vdd.n181 Vdd.n180 4.5005
R640 Vdd.n176 Vdd.n175 4.5005
R641 Vdd.n170 Vdd.n158 4.5005
R642 Vdd.n169 Vdd.n168 4.5005
R643 Vdd.n167 Vdd.n166 4.5005
R644 Vdd.n172 Vdd.n171 4.5005
R645 Vdd.n202 Vdd.n201 4.5005
R646 Vdd.n186 Vdd.n185 4.5005
R647 Vdd.n193 Vdd.n190 4.5005
R648 Vdd.n195 Vdd.n194 4.5005
R649 Vdd.n82 Vdd.n65 4.5005
R650 Vdd.n58 Vdd.n57 4.5005
R651 Vdd.n89 Vdd.n88 4.5005
R652 Vdd.n84 Vdd.n83 4.5005
R653 Vdd.n78 Vdd.n66 4.5005
R654 Vdd.n77 Vdd.n76 4.5005
R655 Vdd.n75 Vdd.n74 4.5005
R656 Vdd.n80 Vdd.n79 4.5005
R657 Vdd.n46 Vdd.n29 4.5005
R658 Vdd.n22 Vdd.n21 4.5005
R659 Vdd.n53 Vdd.n52 4.5005
R660 Vdd.n48 Vdd.n47 4.5005
R661 Vdd.n42 Vdd.n30 4.5005
R662 Vdd.n41 Vdd.n40 4.5005
R663 Vdd.n39 Vdd.n38 4.5005
R664 Vdd.n44 Vdd.n43 4.5005
R665 Vdd.n18 Vdd.n17 4.5005
R666 Vdd.n2 Vdd.n1 4.5005
R667 Vdd.n9 Vdd.n6 4.5005
R668 Vdd.n11 Vdd.n10 4.5005
R669 Vdd.n105 Vdd.n104 3.31679
R670 Vdd.n105 Vdd.n96 3.31679
R671 Vdd.n108 Vdd.n95 3.31679
R672 Vdd.n97 Vdd.n95 3.31679
R673 Vdd.n126 Vdd.n123 3.31679
R674 Vdd.n128 Vdd.n125 3.31679
R675 Vdd.n129 Vdd.n128 3.31679
R676 Vdd.n126 Vdd.n124 3.31679
R677 Vdd.n118 Vdd.n115 3.31679
R678 Vdd.n120 Vdd.n118 3.31679
R679 Vdd.n162 Vdd.n159 3.31679
R680 Vdd.n164 Vdd.n161 3.31679
R681 Vdd.n165 Vdd.n164 3.31679
R682 Vdd.n162 Vdd.n160 3.31679
R683 Vdd.n154 Vdd.n151 3.31679
R684 Vdd.n156 Vdd.n154 3.31679
R685 Vdd.n191 Vdd.n189 3.31679
R686 Vdd.n192 Vdd.n191 3.31679
R687 Vdd.n199 Vdd.n198 3.31679
R688 Vdd.n200 Vdd.n199 3.31679
R689 Vdd.n70 Vdd.n67 3.31679
R690 Vdd.n72 Vdd.n69 3.31679
R691 Vdd.n73 Vdd.n72 3.31679
R692 Vdd.n70 Vdd.n68 3.31679
R693 Vdd.n62 Vdd.n59 3.31679
R694 Vdd.n64 Vdd.n62 3.31679
R695 Vdd.n34 Vdd.n31 3.31679
R696 Vdd.n36 Vdd.n33 3.31679
R697 Vdd.n37 Vdd.n36 3.31679
R698 Vdd.n34 Vdd.n32 3.31679
R699 Vdd.n26 Vdd.n23 3.31679
R700 Vdd.n28 Vdd.n26 3.31679
R701 Vdd.n7 Vdd.n5 3.31679
R702 Vdd.n8 Vdd.n7 3.31679
R703 Vdd.n15 Vdd.n14 3.31679
R704 Vdd.n16 Vdd.n15 3.31679
R705 Vdd.n128 Vdd.n127 1.49311
R706 Vdd.n127 Vdd.n126 1.49311
R707 Vdd.n142 Vdd.n118 1.49311
R708 Vdd.n164 Vdd.n163 1.49311
R709 Vdd.n163 Vdd.n162 1.49311
R710 Vdd.n178 Vdd.n154 1.49311
R711 Vdd.n72 Vdd.n71 1.49311
R712 Vdd.n71 Vdd.n70 1.49311
R713 Vdd.n86 Vdd.n62 1.49311
R714 Vdd.n36 Vdd.n35 1.49311
R715 Vdd.n35 Vdd.n34 1.49311
R716 Vdd.n50 Vdd.n26 1.49311
R717 Vdd.n197 Vdd.n196 0.9005
R718 Vdd.n197 Vdd.n188 0.9005
R719 Vdd.n187 Vdd.n184 0.9005
R720 Vdd.n188 Vdd.n187 0.9005
R721 Vdd.n137 Vdd.n119 0.788
R722 Vdd.n119 Vdd.n117 0.788
R723 Vdd.n116 Vdd.n112 0.788
R724 Vdd.n117 Vdd.n116 0.788
R725 Vdd.n173 Vdd.n155 0.788
R726 Vdd.n155 Vdd.n153 0.788
R727 Vdd.n152 Vdd.n148 0.788
R728 Vdd.n153 Vdd.n152 0.788
R729 Vdd.n81 Vdd.n63 0.788
R730 Vdd.n63 Vdd.n61 0.788
R731 Vdd.n60 Vdd.n56 0.788
R732 Vdd.n61 Vdd.n60 0.788
R733 Vdd.n45 Vdd.n27 0.788
R734 Vdd.n27 Vdd.n25 0.788
R735 Vdd.n24 Vdd.n20 0.788
R736 Vdd.n25 Vdd.n24 0.788
R737 Vdd.n91 Vdd.n55 0.6323
R738 Vdd.n204 Vdd.n183 0.6323
R739 Vdd.n183 Vdd.n147 0.6323
R740 Vdd.n100 Vdd.n98 0.6305
R741 Vdd.n106 Vdd.n98 0.6305
R742 Vdd.n107 Vdd.n92 0.6305
R743 Vdd.n107 Vdd.n106 0.6305
R744 Vdd.n13 Vdd.n12 0.6305
R745 Vdd.n13 Vdd.n4 0.6305
R746 Vdd.n3 Vdd.n0 0.6305
R747 Vdd.n4 Vdd.n3 0.6305
R748 Vdd.n111 Vdd.n92 0.600174
R749 Vdd.n19 Vdd.n0 0.600174
R750 Vdd.n146 Vdd.n112 0.496478
R751 Vdd.n182 Vdd.n148 0.496478
R752 Vdd.n90 Vdd.n56 0.496478
R753 Vdd.n54 Vdd.n20 0.496478
R754 Vdd.n203 Vdd.n184 0.454413
R755 Vdd Vdd.n91 0.3569
R756 Vdd Vdd.n204 0.1571
R757 Vdd.n103 Vdd.n99 0.1445
R758 Vdd.n109 Vdd.n94 0.1445
R759 Vdd.n110 Vdd.n93 0.1445
R760 Vdd.n102 Vdd.n101 0.1445
R761 Vdd.n135 Vdd.n134 0.1445
R762 Vdd.n134 Vdd.n133 0.1445
R763 Vdd.n133 Vdd.n130 0.1445
R764 Vdd.n140 Vdd.n121 0.1445
R765 Vdd.n121 Vdd.n114 0.1445
R766 Vdd.n144 Vdd.n114 0.1445
R767 Vdd.n139 Vdd.n138 0.1445
R768 Vdd.n138 Vdd.n113 0.1445
R769 Vdd.n145 Vdd.n113 0.1445
R770 Vdd.n136 Vdd.n122 0.1445
R771 Vdd.n132 Vdd.n122 0.1445
R772 Vdd.n132 Vdd.n131 0.1445
R773 Vdd.n171 Vdd.n170 0.1445
R774 Vdd.n170 Vdd.n169 0.1445
R775 Vdd.n169 Vdd.n166 0.1445
R776 Vdd.n176 Vdd.n157 0.1445
R777 Vdd.n157 Vdd.n150 0.1445
R778 Vdd.n180 Vdd.n150 0.1445
R779 Vdd.n175 Vdd.n174 0.1445
R780 Vdd.n174 Vdd.n149 0.1445
R781 Vdd.n181 Vdd.n149 0.1445
R782 Vdd.n172 Vdd.n158 0.1445
R783 Vdd.n168 Vdd.n158 0.1445
R784 Vdd.n168 Vdd.n167 0.1445
R785 Vdd.n194 Vdd.n193 0.1445
R786 Vdd.n201 Vdd.n186 0.1445
R787 Vdd.n202 Vdd.n185 0.1445
R788 Vdd.n195 Vdd.n190 0.1445
R789 Vdd.n79 Vdd.n78 0.1445
R790 Vdd.n78 Vdd.n77 0.1445
R791 Vdd.n77 Vdd.n74 0.1445
R792 Vdd.n84 Vdd.n65 0.1445
R793 Vdd.n65 Vdd.n58 0.1445
R794 Vdd.n88 Vdd.n58 0.1445
R795 Vdd.n83 Vdd.n82 0.1445
R796 Vdd.n82 Vdd.n57 0.1445
R797 Vdd.n89 Vdd.n57 0.1445
R798 Vdd.n80 Vdd.n66 0.1445
R799 Vdd.n76 Vdd.n66 0.1445
R800 Vdd.n76 Vdd.n75 0.1445
R801 Vdd.n43 Vdd.n42 0.1445
R802 Vdd.n42 Vdd.n41 0.1445
R803 Vdd.n41 Vdd.n38 0.1445
R804 Vdd.n48 Vdd.n29 0.1445
R805 Vdd.n29 Vdd.n22 0.1445
R806 Vdd.n52 Vdd.n22 0.1445
R807 Vdd.n47 Vdd.n46 0.1445
R808 Vdd.n46 Vdd.n21 0.1445
R809 Vdd.n53 Vdd.n21 0.1445
R810 Vdd.n44 Vdd.n30 0.1445
R811 Vdd.n40 Vdd.n30 0.1445
R812 Vdd.n40 Vdd.n39 0.1445
R813 Vdd.n10 Vdd.n9 0.1445
R814 Vdd.n17 Vdd.n2 0.1445
R815 Vdd.n18 Vdd.n1 0.1445
R816 Vdd.n11 Vdd.n6 0.1445
R817 xm4_0/a_28_n281.n1 xm4_0/a_28_n281.t0 56.5807
R818 xm4_0/a_28_n281.t1 xm4_0/a_28_n281.n1 18.4093
R819 xm4_0/a_28_n281.n0 xm4_0/a_28_n281.t2 10.7012
R820 xm4_0/a_28_n281.n0 xm4_0/a_28_n281.t3 9.4373
R821 xm4_0/a_28_n281.n1 xm4_0/a_28_n281.n0 0.866017
C0 xm7_0/a_186_n173# Vdd 0.01325f
C1 xm1_0/a_n1000_n339# xm5_0/a_186_n173# 0
C2 xm6_0/a_186_n173# xm2_0/a_n1000_n339# 0
C3 xm7_0/a_186_n173# xm2_0/a_n1000_n339# 0
C4 xm8_0/a_186_n173# xm5_0/a_186_n173# 0.00537f
C5 xm9_0/a_n50_n339# Vdd 0.73377f
C6 xm9_0/a_n50_n339# xm2_0/a_n1000_n339# 0.0209f
C7 Vdd xm2_0/a_n1000_n339# 0.01288f
C8 xm9_0/a_n50_n339# xm1_0/a_n1000_n339# 0.00701f
C9 xm1_0/a_n1000_n339# Vdd 0.01265f
C10 xm9_0/a_n50_n339# xm8_0/a_186_n173# 0.00235f
C11 xm7_0/a_186_n173# xm6_0/a_186_n173# 0.00537f
C12 xm8_0/a_186_n173# Vdd 0.02568f
C13 xm5_0/a_186_n173# Vdd 0.01306f
C14 xm9_0/a_n50_n339# xm6_0/a_186_n173# 0.00358f
C15 xm6_0/a_186_n173# Vdd 0.01169f
C16 xm4_0/a_28_n281.t0 Vss 0.08474f
C17 xm4_0/a_28_n281.t2 Vss 0.44787f
C18 xm4_0/a_28_n281.t3 Vss 0.3907f
C19 xm4_0/a_28_n281.n0 Vss 1.01433f
C20 xm4_0/a_28_n281.n1 Vss 1.73696f
C21 xm4_0/a_28_n281.t1 Vss 1.8254f
C22 xm9_0/a_n50_n339# Vss 3.28381f
C23 xm2_0/a_n1000_n339# Vss 5.56475f
C24 xm1_0/a_n1000_n339# Vss 5.58608f
C25 xm8_0/a_186_n173# Vss 0.0198f
C26 Vdd Vss 38.90519f
C27 xm7_0/a_186_n173# Vss 0.01452f
C28 xm5_0/a_186_n173# Vss 0.05146f
C29 xm6_0/a_186_n173# Vss 0.01557f
.ends
