* NGSPICE file created from stdp.ext - technology: gf180mcuD

.subckt xm5 a_n1500_n339# a_n1620_n131# w_n1886_n560# a_1500_n131# VSUBS
X0 a_1500_n131# a_n1500_n339# a_n1620_n131# w_n1886_n560# pfet_03v3 ad=0.3p pd=2.2u as=0.3p ps=2.2u w=0.5u l=15u
C0 a_n1620_n131# a_1500_n131# 1.44038f
C1 a_n1500_n339# a_n1620_n131# 0.6108f
C2 a_n1620_n131# w_n1886_n560# 0.45972f
C3 a_n1500_n339# a_1500_n131# 0.06934f
C4 a_1500_n131# w_n1886_n560# 1.82938f
C5 a_n1500_n339# w_n1886_n560# 6.38155f
C6 a_1500_n131# VSUBS 0.06141f
C7 a_n1620_n131# VSUBS 0.05599f
C8 a_n1500_n339# VSUBS 0.30906f
C9 w_n1886_n560# VSUBS 15.2029f
.ends

.subckt xm3 a_63_n131# a_n393_n504# a_n63_n339# a_n183_n131#
X0 a_63_n131# a_n63_n339# a_n183_n131# a_n393_n504# nfet_03v3 ad=0.3p pd=2.2u as=0.3p ps=2.2u w=0.5u l=0.63u
C0 a_n183_n131# a_63_n131# 0.33209f
C1 a_63_n131# a_n63_n339# 0.01741f
C2 a_n183_n131# a_n63_n339# 0.04027f
C3 a_63_n131# a_n393_n504# 0.53054f
C4 a_n183_n131# a_n393_n504# 0.26905f
C5 a_n63_n339# a_n393_n504# 0.50927f
.ends

.subckt xm1 a_63_n131# a_n63_n339# w_n449_n560# a_n183_n131# VSUBS
X0 a_63_n131# a_n63_n339# a_n183_n131# w_n449_n560# pfet_03v3 ad=0.3p pd=2.2u as=0.3p ps=2.2u w=0.5u l=0.63u
C0 a_n183_n131# a_63_n131# 0.33209f
C1 a_n63_n339# a_n183_n131# 0.04027f
C2 a_n183_n131# w_n449_n560# 0.2249f
C3 a_n63_n339# a_63_n131# 0.01741f
C4 a_63_n131# w_n449_n560# 0.48511f
C5 a_n63_n339# w_n449_n560# 0.45684f
C6 a_63_n131# VSUBS 0.04546f
C7 a_n183_n131# VSUBS 0.04416f
C8 a_n63_n339# VSUBS 0.05243f
C9 w_n449_n560# VSUBS 3.76898f
.ends

.subckt xmcm_chain_4 a_n1120_n131# a_n1330_n504# a_1000_n131# a_n1000_n339#
X0 a_1000_n131# a_n1000_n339# a_n1120_n131# a_n1330_n504# nfet_03v3 ad=0.3p pd=2.2u as=0.3p ps=2.2u w=0.5u l=10u
C0 a_n1120_n131# a_1000_n131# 1.01551f
C1 a_1000_n131# a_n1000_n339# 0.06176f
C2 a_n1120_n131# a_n1000_n339# 0.42273f
C3 a_1000_n131# a_n1330_n504# 1.43795f
C4 a_n1120_n131# a_n1330_n504# 0.4423f
C5 a_n1000_n339# a_n1330_n504# 4.53847f
.ends

.subckt cpot m4_n700_n700# m4_n500_n500# VSUBS
X0 m4_n500_n500# m4_n700_n700# cap_mim_2f0_m4m5_noshield c_width=5u c_length=5u
X1 m4_n500_n500# m4_n700_n700# cap_mim_2f0_m4m5_noshield c_width=5u c_length=5u
C0 m4_n500_n500# m4_n700_n700# 1.99903f
C1 m4_n500_n500# VSUBS 1.68062f
C2 m4_n700_n700# VSUBS 1.59113f
.ends

.subckt xm8 a_63_n131# a_n63_n339# w_n449_n560# a_n183_n131# VSUBS
X0 a_63_n131# a_n63_n339# a_n183_n131# w_n449_n560# pfet_03v3 ad=0.3p pd=2.2u as=0.3p ps=2.2u w=0.5u l=0.63u
C0 a_n183_n131# a_63_n131# 0.33209f
C1 a_n63_n339# a_n183_n131# 0.04027f
C2 a_n183_n131# w_n449_n560# 0.2249f
C3 a_n63_n339# a_63_n131# 0.01741f
C4 a_63_n131# w_n449_n560# 0.48511f
C5 a_n63_n339# w_n449_n560# 0.45684f
C6 a_63_n131# VSUBS 0.04546f
C7 a_n183_n131# VSUBS 0.04416f
C8 a_n63_n339# VSUBS 0.05243f
C9 w_n449_n560# VSUBS 3.76898f
.ends

.subckt xmcm_chain_2 a_n1120_n131# a_n1330_n504# a_1000_n131# a_n1000_n339#
X0 a_1000_n131# a_n1000_n339# a_n1120_n131# a_n1330_n504# nfet_03v3 ad=0.3p pd=2.2u as=0.3p ps=2.2u w=0.5u l=10u
C0 a_n1120_n131# a_1000_n131# 1.01551f
C1 a_1000_n131# a_n1000_n339# 0.06176f
C2 a_n1120_n131# a_n1000_n339# 0.42273f
C3 a_1000_n131# a_n1330_n504# 1.43795f
C4 a_n1120_n131# a_n1330_n504# 0.4423f
C5 a_n1000_n339# a_n1330_n504# 4.53847f
.ends

.subckt xm16 a_n400_n1101# a_n280_n1309# w_n666_n1529# a_280_n1101# VSUBS
X0 a_280_n1101# a_n280_n1309# a_n400_n1101# w_n666_n1529# pfet_03v3 ad=6.12p pd=21.6u as=6.12p ps=21.6u w=10.2u l=2.8u
C0 a_n400_n1101# a_280_n1101# 0.72266f
C1 a_n280_n1309# a_n400_n1101# 0.64393f
C2 a_n400_n1101# w_n666_n1529# 1.08957f
C3 a_n280_n1309# a_280_n1101# 0.57005f
C4 a_280_n1101# w_n666_n1529# 1.53123f
C5 a_n280_n1309# w_n666_n1529# 1.30956f
C6 a_280_n1101# VSUBS 0.28176f
C7 a_n400_n1101# VSUBS 0.30514f
C8 a_n280_n1309# VSUBS 0.12268f
C9 w_n666_n1529# VSUBS 13.9301f
.ends

.subckt xmcm_chain_0 a_n1120_n131# a_n1330_n504# a_1000_n131# a_n1000_n339#
X0 a_1000_n131# a_n1000_n339# a_n1120_n131# a_n1330_n504# nfet_03v3 ad=0.3p pd=2.2u as=0.3p ps=2.2u w=0.5u l=10u
C0 a_n1120_n131# a_1000_n131# 1.01551f
C1 a_1000_n131# a_n1000_n339# 0.06176f
C2 a_n1120_n131# a_n1000_n339# 0.42273f
C3 a_1000_n131# a_n1330_n504# 1.43795f
C4 a_n1120_n131# a_n1330_n504# 0.4423f
C5 a_n1000_n339# a_n1330_n504# 4.53847f
.ends

.subckt cw m4_n700_n700# m4_n500_n500# VSUBS
X0 m4_n500_n500# m4_n700_n700# cap_mim_2f0_m4m5_noshield c_width=5u c_length=5u
X1 m4_n500_n500# m4_n700_n700# cap_mim_2f0_m4m5_noshield c_width=5u c_length=5u
X2 m4_n500_n500# m4_n700_n700# cap_mim_2f0_m4m5_noshield c_width=5u c_length=5u
X3 m4_n500_n500# m4_n700_n700# cap_mim_2f0_m4m5_noshield c_width=5u c_length=5u
X4 m4_n500_n500# m4_n700_n700# cap_mim_2f0_m4m5_noshield c_width=5u c_length=5u
X5 m4_n500_n500# m4_n700_n700# cap_mim_2f0_m4m5_noshield c_width=5u c_length=5u
X6 m4_n500_n500# m4_n700_n700# cap_mim_2f0_m4m5_noshield c_width=5u c_length=5u
X7 m4_n500_n500# m4_n700_n700# cap_mim_2f0_m4m5_noshield c_width=5u c_length=5u
X8 m4_n500_n500# m4_n700_n700# cap_mim_2f0_m4m5_noshield c_width=5u c_length=5u
X9 m4_n500_n500# m4_n700_n700# cap_mim_2f0_m4m5_noshield c_width=5u c_length=5u
C0 m4_n500_n500# m4_n700_n700# 10.9018f
C1 m4_n500_n500# VSUBS 4.99987f
C2 m4_n700_n700# VSUBS 4.97766f
.ends

.subckt xm4 a_63_n131# a_n393_n504# a_n63_n339# a_n183_n131#
X0 a_63_n131# a_n63_n339# a_n183_n131# a_n393_n504# nfet_03v3 ad=0.3p pd=2.2u as=0.3p ps=2.2u w=0.5u l=0.63u
C0 a_n183_n131# a_63_n131# 0.33209f
C1 a_63_n131# a_n63_n339# 0.01741f
C2 a_n183_n131# a_n63_n339# 0.04027f
C3 a_63_n131# a_n393_n504# 0.53054f
C4 a_n183_n131# a_n393_n504# 0.26905f
C5 a_n63_n339# a_n393_n504# 0.50927f
.ends

.subckt xm12 a_63_n131# a_n393_n504# a_n63_n339# a_n183_n131#
X0 a_63_n131# a_n63_n339# a_n183_n131# a_n393_n504# nfet_03v3 ad=0.3p pd=2.2u as=0.3p ps=2.2u w=0.5u l=0.63u
C0 a_n183_n131# a_63_n131# 0.33209f
C1 a_63_n131# a_n63_n339# 0.01741f
C2 a_n183_n131# a_n63_n339# 0.04027f
C3 a_63_n131# a_n393_n504# 0.53054f
C4 a_n183_n131# a_n393_n504# 0.26905f
C5 a_n63_n339# a_n393_n504# 0.50927f
.ends

.subckt xm2 a_63_n131# a_n63_n339# w_n449_n560# a_n183_n131# VSUBS
X0 a_63_n131# a_n63_n339# a_n183_n131# w_n449_n560# pfet_03v3 ad=0.3p pd=2.2u as=0.3p ps=2.2u w=0.5u l=0.63u
C0 a_n183_n131# a_63_n131# 0.33209f
C1 a_n63_n339# a_n183_n131# 0.04027f
C2 a_n183_n131# w_n449_n560# 0.2249f
C3 a_n63_n339# a_63_n131# 0.01741f
C4 a_63_n131# w_n449_n560# 0.48511f
C5 a_n63_n339# w_n449_n560# 0.45684f
C6 a_63_n131# VSUBS 0.04546f
C7 a_n183_n131# VSUBS 0.04416f
C8 a_n63_n339# VSUBS 0.05243f
C9 w_n449_n560# VSUBS 3.76898f
.ends

.subckt cdep m4_n700_n700# m4_n500_n500# VSUBS
X0 m4_n500_n500# m4_n700_n700# cap_mim_2f0_m4m5_noshield c_width=5u c_length=5u
X1 m4_n500_n500# m4_n700_n700# cap_mim_2f0_m4m5_noshield c_width=5u c_length=5u
C0 m4_n500_n500# m4_n700_n700# 1.99903f
C1 m4_n500_n500# VSUBS 1.68062f
C2 m4_n700_n700# VSUBS 1.59113f
.ends

.subckt xmcm_1 a_n280_n350# a_n400_n141# a_280_n141# a_n610_n515#
X0 a_280_n141# a_n280_n350# a_n400_n141# a_n610_n515# nfet_03v3 ad=0.366p pd=2.42u as=0.366p ps=2.42u w=0.61u l=2.8u
C0 a_n400_n141# a_280_n141# 0.4351f
C1 a_280_n141# a_n280_n350# 0.04694f
C2 a_n400_n141# a_n280_n350# 0.1455f
C3 a_280_n141# a_n610_n515# 0.76826f
C4 a_n400_n141# a_n610_n515# 0.3279f
C5 a_n280_n350# a_n610_n515# 1.4155f
.ends

.subckt xm9 a_63_n131# a_n393_n504# a_n63_n339# a_n183_n131#
X0 a_63_n131# a_n63_n339# a_n183_n131# a_n393_n504# nfet_03v3 ad=0.3p pd=2.2u as=0.3p ps=2.2u w=0.5u l=0.63u
C0 a_n183_n131# a_63_n131# 0.33209f
C1 a_63_n131# a_n63_n339# 0.01741f
C2 a_n183_n131# a_n63_n339# 0.04027f
C3 a_63_n131# a_n393_n504# 0.53054f
C4 a_n183_n131# a_n393_n504# 0.26905f
C5 a_n63_n339# a_n393_n504# 0.50927f
.ends

.subckt xmcm_chain_3 a_n1120_n131# a_n1330_n504# a_1000_n131# a_n1000_n339#
X0 a_1000_n131# a_n1000_n339# a_n1120_n131# a_n1330_n504# nfet_03v3 ad=0.3p pd=2.2u as=0.3p ps=2.2u w=0.5u l=10u
C0 a_n1120_n131# a_1000_n131# 1.01551f
C1 a_1000_n131# a_n1000_n339# 0.06176f
C2 a_n1120_n131# a_n1000_n339# 0.42273f
C3 a_1000_n131# a_n1330_n504# 1.43795f
C4 a_n1120_n131# a_n1330_n504# 0.4423f
C5 a_n1000_n339# a_n1330_n504# 4.53847f
.ends

.subckt xm17 a_n460_n339# w_n846_n560# a_n580_n131# a_460_n131# VSUBS
X0 a_460_n131# a_n460_n339# a_n580_n131# w_n846_n560# pfet_03v3 ad=0.3p pd=2.2u as=0.3p ps=2.2u w=0.5u l=4.6u
C0 a_n580_n131# a_460_n131# 0.57434f
C1 a_n460_n339# a_n580_n131# 0.21491f
C2 a_n580_n131# w_n846_n560# 0.30191f
C3 a_n460_n339# a_460_n131# 0.04912f
C4 a_460_n131# w_n846_n560# 0.87034f
C5 a_n460_n339# w_n846_n560# 2.05763f
C6 a_460_n131# VSUBS 0.04483f
C7 a_n580_n131# VSUBS 0.04363f
C8 a_n460_n339# VSUBS 0.12333f
C9 w_n846_n560# VSUBS 6.90762f
.ends

.subckt xm7 a_63_n131# a_n63_n339# w_n449_n560# a_n183_n131# VSUBS
X0 a_63_n131# a_n63_n339# a_n183_n131# w_n449_n560# pfet_03v3 ad=0.3p pd=2.2u as=0.3p ps=2.2u w=0.5u l=0.63u
C0 a_n183_n131# a_63_n131# 0.33209f
C1 a_n63_n339# a_n183_n131# 0.04027f
C2 a_n183_n131# w_n449_n560# 0.2249f
C3 a_n63_n339# a_63_n131# 0.01741f
C4 a_63_n131# w_n449_n560# 0.48511f
C5 a_n63_n339# w_n449_n560# 0.45684f
C6 a_63_n131# VSUBS 0.04546f
C7 a_n183_n131# VSUBS 0.04416f
C8 a_n63_n339# VSUBS 0.05243f
C9 w_n449_n560# VSUBS 3.76898f
.ends

.subckt xmcm_chain_1 a_n1120_n131# a_n1330_n504# a_1000_n131# a_n1000_n339#
X0 a_1000_n131# a_n1000_n339# a_n1120_n131# a_n1330_n504# nfet_03v3 ad=0.3p pd=2.2u as=0.3p ps=2.2u w=0.5u l=10u
C0 a_n1120_n131# a_1000_n131# 1.01551f
C1 a_1000_n131# a_n1000_n339# 0.06176f
C2 a_n1120_n131# a_n1000_n339# 0.42273f
C3 a_1000_n131# a_n1330_n504# 1.43795f
C4 a_n1120_n131# a_n1330_n504# 0.4423f
C5 a_n1000_n339# a_n1330_n504# 4.53847f
.ends

.subckt stdp avdd nvpost nvpre vpost vpre vb_idep vb_itd vb_itp vw Iout
Xxm5_0 vw avdd avdd Iout vw xm5
Xxm3_0 vw vw vpre xm4_0/a_63_n131# xm3
Xxm1_0 xm1_0/a_63_n131# xm1_0/a_n63_n339# avdd avdd vw xm1
Xxmcm_chain_4_0 vw vw xmcm_chain_4_0/a_1000_n131# xmcm_chain_4_0/a_n1000_n339# xmcm_chain_4
Xcpot_0 xm1_0/a_n63_n339# avdd vw cpot
Xxm8_0 xm8_0/a_63_n131# nvpre avdd xm1_0/a_n63_n339# vw xm8
Xxmcm_chain_2_0 xmcm_chain_3_0/a_1000_n131# vw xmcm_chain_2_0/a_1000_n131# xmcm_chain_4_0/a_n1000_n339#
+ xmcm_chain_2
Xxm16_0 avdd vb_idep avdd xm9_0/a_63_n131# vw xm16
Xxmcm_chain_0_0 xmcm_chain_1_0/a_1000_n131# vw vw vb_itd xmcm_chain_0
Xcw_0 cw_0/m4_n700_n700# vw vw cw
Xxm4_0 xm4_0/a_63_n131# vw vw vw xm4
Xxm12_0 xm9_0/a_63_n131# vw vpost vw xm12
Xxm2_0 vw nvpost avdd xm1_0/a_63_n131# vw xm2
Xcdep_0 cdep_0/m4_n700_n700# vw vw cdep
Xxmcm_1_0 vw vw vw vw xmcm_1
Xxm9_0 xm9_0/a_63_n131# vw xm9_0/a_63_n131# vw xm9
Xxmcm_chain_3_0 xmcm_chain_4_0/a_1000_n131# vw xmcm_chain_3_0/a_1000_n131# xmcm_chain_4_0/a_n1000_n339#
+ xmcm_chain_3
Xxm17_0 vb_itp avdd avdd xm1_0/a_n63_n339# vw xm17
Xxm7_0 vw xm8_0/a_63_n131# avdd avdd vw xm7
Xxmcm_chain_1_0 xmcm_chain_2_0/a_1000_n131# vw xmcm_chain_1_0/a_1000_n131# xmcm_chain_4_0/a_n1000_n339#
+ xmcm_chain_1
R0 vw.n695 vw.n694 27273.1
R1 vw.n694 vw.n693 16706
R2 vw.n325 vw.n270 14475
R3 vw.n326 vw.n325 14475
R4 vw.n692 vw.n237 14000
R5 vw.n325 vw.n302 14000
R6 vw.n799 vw.n270 14000
R7 vw.n725 vw.n326 14000
R8 vw.n691 vw.n179 14000
R9 vw.n694 vw.n326 12850
R10 vw.n693 vw.n270 5350
R11 vw.n691 vw.n690 4051.72
R12 vw.n651 vw.n650 2283.78
R13 vw.n579 vw.n451 2283.78
R14 vw.n692 vw.n691 1970.19
R15 vw.n650 vw.n649 1051.61
R16 vw.n693 vw.n692 736.802
R17 vw.n836 vw.n181 203.708
R18 vw.n690 vw.n390 203.343
R19 vw.n450 vw.n390 203.343
R20 vw.n467 vw.n405 203.343
R21 vw.n570 vw.n467 203.343
R22 vw.n758 vw.n271 198.688
R23 vw.n649 vw.n450 187.267
R24 vw.n749 vw.n293 182.19
R25 vw.n695 vw.n340 182.19
R26 vw.n799 vw.n798 157.803
R27 vw.n841 vw.n181 114.766
R28 vw.n836 vw.n835 114.766
R29 vw.n226 vw.n188 114.766
R30 vw.n226 vw.n197 114.766
R31 vw.n827 vw.n197 114.766
R32 vw.n827 vw.n200 114.766
R33 vw.n235 vw.n200 114.766
R34 vw.n812 vw.n248 114.766
R35 vw.n254 vw.n250 114.766
R36 vw.n801 vw.n800 114.766
R37 vw.n750 vw.n271 114.766
R38 vw.n366 vw.n304 114.766
R39 vw.n732 vw.n314 114.766
R40 vw.n724 vw.n723 114.766
R41 vw.n818 vw.n237 111.897
R42 vw.n808 vw.n807 104.007
R43 vw.n788 vw.n256 104.007
R44 vw.n352 vw.n351 101.855
R45 vw.n741 vw.n740 101.855
R46 vw.n380 vw.n329 100.419
R47 vw.n380 vw.n337 98.268
R48 vw.n717 vw.n716 98.268
R49 vw.n788 vw.n267 94.6816
R50 vw.n726 vw.n725 84.6397
R51 vw.n648 vw.n179 83.2051
R52 vw.n726 vw.n323 74.5977
R53 vw.n811 vw.n250 73.1632
R54 vw.n366 vw.n360 71.0113
R55 vw.n733 vw.n311 71.0113
R56 vw.n696 vw.n339 68.9311
R57 vw.n715 vw.n696 68.9311
R58 vw.n707 vw.n341 68.9311
R59 vw.n708 vw.n707 68.9311
R60 vw.n312 vw.n310 68.9311
R61 vw.n734 vw.n310 68.9311
R62 vw.n739 vw.n306 68.9311
R63 vw.n739 vw.n305 68.9311
R64 vw.n292 vw.n286 68.9311
R65 vw.n751 vw.n286 68.9311
R66 vw.n757 vw.n273 68.9311
R67 vw.n757 vw.n272 68.9311
R68 vw.n277 vw.n275 68.9311
R69 vw.n275 vw.n252 68.9311
R70 vw.n810 vw.n809 68.9311
R71 vw.n810 vw.n251 68.9311
R72 vw.n820 vw.n234 67.7644
R73 vw.n820 vw.n202 67.7644
R74 vw.n837 vw.n187 67.7644
R75 vw.n837 vw.n186 67.7644
R76 vw.n842 vw.n841 67.4249
R77 vw.n835 vw.n188 67.4249
R78 vw.n819 vw.n235 67.4249
R79 vw.n389 vw.n342 66.6949
R80 vw.n389 vw.n336 66.6949
R81 vw.n748 vw.n295 66.6949
R82 vw.n748 vw.n294 66.6949
R83 vw.n797 vw.n269 66.6949
R84 vw.n797 vw.n266 66.6949
R85 vw.n834 vw.n190 66.6949
R86 vw.n834 vw.n189 66.6949
R87 vw.n840 vw.n182 66.6949
R88 vw.n840 vw.n183 66.6949
R89 vw.n449 vw.n393 66.6949
R90 vw.n689 vw.n393 66.6949
R91 vw.n180 vw.n178 66.6949
R92 vw.n843 vw.n178 66.6949
R93 vw.n609 vw.n464 66.6949
R94 vw.n615 vw.n464 66.6949
R95 vw.n512 vw.n475 66.6949
R96 vw.n569 vw.n475 66.6949
R97 vw.n545 vw.n544 66.6949
R98 vw.n545 vw.n468 66.6949
R99 vw.n352 vw.n302 57.383
R100 vw.n741 vw.n302 57.383
R101 vw.n819 vw.n818 47.341
R102 vw.n115 vw.n114 45.5355
R103 vw.n360 vw.n311 43.7546
R104 vw.n733 vw.n732 43.7546
R105 vw.n812 vw.n811 41.6028
R106 vw.n323 vw.n314 40.1682
R107 vw.n649 vw.n451 31.7197
R108 vw.n842 vw.n179 31.5609
R109 vw.n725 vw.n724 30.1263
R110 vw.n800 vw.n799 24.3881
R111 vw.n801 vw.n267 20.0844
R112 vw.n308 vw.n307 19.4509
R113 vw.n51 vw.n50 17.8359
R114 vw.n51 vw 16.6847
R115 vw.n717 vw.n337 16.498
R116 vw.n716 vw.n340 16.498
R117 vw.n715 vw.n341 15.5561
R118 vw.n708 vw.n339 15.5561
R119 vw.n734 vw.n306 15.5561
R120 vw.n312 vw.n305 15.5561
R121 vw.n751 vw.n273 15.5561
R122 vw.n292 vw.n272 15.5561
R123 vw.n809 vw.n252 15.5561
R124 vw.n277 vw.n251 15.5561
R125 vw.n225 vw.n187 15.5561
R126 vw.n225 vw.n201 15.5561
R127 vw.n826 vw.n201 15.5561
R128 vw.n826 vw.n202 15.5561
R129 vw.n227 vw.n186 15.5561
R130 vw.n227 vw.n219 15.5561
R131 vw.n219 vw.n198 15.5561
R132 vw.n234 vw.n198 15.5561
R133 vw.n298 vw.n295 15.5561
R134 vw.n742 vw.n298 15.5561
R135 vw.n742 vw.n301 15.5561
R136 vw.n365 vw.n301 15.5561
R137 vw.n365 vw.n315 15.5561
R138 vw.n731 vw.n315 15.5561
R139 vw.n731 vw.n316 15.5561
R140 vw.n727 vw.n316 15.5561
R141 vw.n727 vw.n322 15.5561
R142 vw.n722 vw.n322 15.5561
R143 vw.n722 vw.n330 15.5561
R144 vw.n718 vw.n330 15.5561
R145 vw.n718 vw.n336 15.5561
R146 vw.n353 vw.n294 15.5561
R147 vw.n353 vw.n303 15.5561
R148 vw.n359 vw.n303 15.5561
R149 vw.n367 vw.n359 15.5561
R150 vw.n368 vw.n367 15.5561
R151 vw.n368 vw.n313 15.5561
R152 vw.n373 vw.n313 15.5561
R153 vw.n373 vw.n324 15.5561
R154 vw.n327 vw.n324 15.5561
R155 vw.n328 vw.n327 15.5561
R156 vw.n381 vw.n328 15.5561
R157 vw.n381 vw.n338 15.5561
R158 vw.n342 vw.n338 15.5561
R159 vw.n193 vw.n190 15.5561
R160 vw.n828 vw.n193 15.5561
R161 vw.n828 vw.n196 15.5561
R162 vw.n238 vw.n196 15.5561
R163 vw.n817 vw.n238 15.5561
R164 vw.n817 vw.n239 15.5561
R165 vw.n813 vw.n239 15.5561
R166 vw.n813 vw.n247 15.5561
R167 vw.n257 vw.n247 15.5561
R168 vw.n806 vw.n257 15.5561
R169 vw.n806 vw.n258 15.5561
R170 vw.n802 vw.n258 15.5561
R171 vw.n802 vw.n266 15.5561
R172 vw.n767 vw.n189 15.5561
R173 vw.n767 vw.n199 15.5561
R174 vw.n773 vw.n199 15.5561
R175 vw.n774 vw.n773 15.5561
R176 vw.n774 vw.n236 15.5561
R177 vw.n762 vw.n236 15.5561
R178 vw.n762 vw.n249 15.5561
R179 vw.n782 vw.n249 15.5561
R180 vw.n783 vw.n782 15.5561
R181 vw.n783 vw.n255 15.5561
R182 vw.n789 vw.n255 15.5561
R183 vw.n789 vw.n268 15.5561
R184 vw.n269 vw.n268 15.5561
R185 vw.n449 vw.n408 15.5561
R186 vw.n442 vw.n441 15.5561
R187 vw.n439 vw.n438 15.5561
R188 vw.n435 vw.n434 15.5561
R189 vw.n431 vw.n430 15.5561
R190 vw.n427 vw.n426 15.5561
R191 vw.n423 vw.n183 15.5561
R192 vw.n689 vw.n394 15.5561
R193 vw.n685 vw.n684 15.5561
R194 vw.n681 vw.n680 15.5561
R195 vw.n678 vw.n652 15.5561
R196 vw.n674 vw.n673 15.5561
R197 vw.n671 vw.n659 15.5561
R198 vw.n667 vw.n182 15.5561
R199 vw.n607 vw.n606 15.5561
R200 vw.n604 vw.n572 15.5561
R201 vw.n600 vw.n599 15.5561
R202 vw.n597 vw.n580 15.5561
R203 vw.n593 vw.n592 15.5561
R204 vw.n590 vw.n177 15.5561
R205 vw.n843 vw.n177 15.5561
R206 vw.n619 vw.n617 15.5561
R207 vw.n625 vw.n460 15.5561
R208 vw.n629 vw.n627 15.5561
R209 vw.n635 vw.n456 15.5561
R210 vw.n639 vw.n637 15.5561
R211 vw.n647 vw.n452 15.5561
R212 vw.n647 vw.n180 15.5561
R213 vw.n516 vw.n514 15.5561
R214 vw.n522 vw.n506 15.5561
R215 vw.n526 vw.n524 15.5561
R216 vw.n532 vw.n502 15.5561
R217 vw.n536 vw.n534 15.5561
R218 vw.n542 vw.n498 15.5561
R219 vw.n569 vw.n476 15.5561
R220 vw.n481 vw.n480 15.5561
R221 vw.n483 vw.n482 15.5561
R222 vw.n487 vw.n486 15.5561
R223 vw.n489 vw.n488 15.5561
R224 vw.n493 vw.n492 15.5561
R225 vw.n494 vw.n468 15.5561
R226 vw.n723 vw.n329 14.3461
R227 vw.n212 vw.n209 13.589
R228 vw.n52 vw.n51 13.1978
R229 vw.n351 vw.n293 12.9116
R230 vw.n740 vw.n304 12.9116
R231 vw.n808 vw.n254 10.7597
R232 vw.n807 vw.n256 10.7597
R233 vw.n649 vw.n648 10.0424
R234 vw.n215 vw.n185 9.8159
R235 vw.n215 vw.n214 9.1923
R236 vw.n214 vw.n213 9.1923
R237 vw.n387 vw.n173 6.57316
R238 vw.n649 vw.n405 5.6489
R239 vw.n795 vw.n173 5.20876
R240 vw.n847 vw.n846 5.20876
R241 vw.n547 vw.n172 5.20876
R242 vw.n453 vw.n452 5.2005
R243 vw.n640 vw.n639 5.2005
R244 vw.n637 vw.n455 5.2005
R245 vw.n635 vw.n634 5.2005
R246 vw.n457 vw.n456 5.2005
R247 vw.n630 vw.n629 5.2005
R248 vw.n627 vw.n459 5.2005
R249 vw.n625 vw.n624 5.2005
R250 vw.n590 vw.n589 5.2005
R251 vw.n592 vw.n585 5.2005
R252 vw.n594 vw.n593 5.2005
R253 vw.n595 vw.n580 5.2005
R254 vw.n597 vw.n596 5.2005
R255 vw.n599 vw.n577 5.2005
R256 vw.n601 vw.n600 5.2005
R257 vw.n602 vw.n572 5.2005
R258 vw.n668 vw.n667 5.2005
R259 vw.n669 vw.n659 5.2005
R260 vw.n671 vw.n670 5.2005
R261 vw.n673 vw.n657 5.2005
R262 vw.n675 vw.n674 5.2005
R263 vw.n676 vw.n652 5.2005
R264 vw.n678 vw.n677 5.2005
R265 vw.n680 vw.n400 5.2005
R266 vw.n424 vw.n423 5.2005
R267 vw.n426 vw.n425 5.2005
R268 vw.n428 vw.n427 5.2005
R269 vw.n430 vw.n429 5.2005
R270 vw.n432 vw.n431 5.2005
R271 vw.n434 vw.n433 5.2005
R272 vw.n436 vw.n435 5.2005
R273 vw.n438 vw.n437 5.2005
R274 vw.n645 vw.n180 5.2005
R275 vw.n842 vw.n180 5.2005
R276 vw.n647 vw.n646 5.2005
R277 vw.n648 vw.n647 5.2005
R278 vw.n844 vw.n843 5.2005
R279 vw.n843 vw.n842 5.2005
R280 vw.n177 vw.n176 5.2005
R281 vw.n648 vw.n177 5.2005
R282 vw.n792 vw.n269 5.2005
R283 vw.n800 vw.n269 5.2005
R284 vw.n791 vw.n268 5.2005
R285 vw.n801 vw.n268 5.2005
R286 vw.n790 vw.n789 5.2005
R287 vw.n789 vw.n788 5.2005
R288 vw.n760 vw.n255 5.2005
R289 vw.n807 vw.n255 5.2005
R290 vw.n784 vw.n783 5.2005
R291 vw.n783 vw.n254 5.2005
R292 vw.n782 vw.n781 5.2005
R293 vw.n782 vw.n250 5.2005
R294 vw.n780 vw.n249 5.2005
R295 vw.n812 vw.n249 5.2005
R296 vw.n763 vw.n762 5.2005
R297 vw.n762 vw.n248 5.2005
R298 vw.n776 vw.n236 5.2005
R299 vw.n818 vw.n236 5.2005
R300 vw.n775 vw.n774 5.2005
R301 vw.n774 vw.n235 5.2005
R302 vw.n773 vw.n772 5.2005
R303 vw.n773 vw.n200 5.2005
R304 vw.n765 vw.n199 5.2005
R305 vw.n827 vw.n199 5.2005
R306 vw.n768 vw.n767 5.2005
R307 vw.n767 vw.n197 5.2005
R308 vw.n766 vw.n189 5.2005
R309 vw.n226 vw.n189 5.2005
R310 vw.n266 vw.n265 5.2005
R311 vw.n800 vw.n266 5.2005
R312 vw.n803 vw.n802 5.2005
R313 vw.n802 vw.n801 5.2005
R314 vw.n804 vw.n258 5.2005
R315 vw.n788 vw.n258 5.2005
R316 vw.n806 vw.n805 5.2005
R317 vw.n807 vw.n806 5.2005
R318 vw.n259 vw.n257 5.2005
R319 vw.n257 vw.n254 5.2005
R320 vw.n247 vw.n246 5.2005
R321 vw.n250 vw.n247 5.2005
R322 vw.n814 vw.n813 5.2005
R323 vw.n813 vw.n812 5.2005
R324 vw.n815 vw.n239 5.2005
R325 vw.n248 vw.n239 5.2005
R326 vw.n817 vw.n816 5.2005
R327 vw.n818 vw.n817 5.2005
R328 vw.n240 vw.n238 5.2005
R329 vw.n238 vw.n235 5.2005
R330 vw.n196 vw.n195 5.2005
R331 vw.n200 vw.n196 5.2005
R332 vw.n829 vw.n828 5.2005
R333 vw.n828 vw.n827 5.2005
R334 vw.n830 vw.n193 5.2005
R335 vw.n197 vw.n193 5.2005
R336 vw.n831 vw.n190 5.2005
R337 vw.n226 vw.n190 5.2005
R338 vw.n384 vw.n342 5.2005
R339 vw.n342 vw.n340 5.2005
R340 vw.n383 vw.n338 5.2005
R341 vw.n717 vw.n338 5.2005
R342 vw.n382 vw.n381 5.2005
R343 vw.n381 vw.n380 5.2005
R344 vw.n344 vw.n328 5.2005
R345 vw.n723 vw.n328 5.2005
R346 vw.n376 vw.n327 5.2005
R347 vw.n724 vw.n327 5.2005
R348 vw.n375 vw.n324 5.2005
R349 vw.n726 vw.n324 5.2005
R350 vw.n374 vw.n373 5.2005
R351 vw.n373 vw.n314 5.2005
R352 vw.n346 vw.n313 5.2005
R353 vw.n732 vw.n313 5.2005
R354 vw.n369 vw.n368 5.2005
R355 vw.n368 vw.n311 5.2005
R356 vw.n367 vw.n348 5.2005
R357 vw.n367 vw.n366 5.2005
R358 vw.n359 vw.n358 5.2005
R359 vw.n359 vw.n304 5.2005
R360 vw.n349 vw.n303 5.2005
R361 vw.n741 vw.n303 5.2005
R362 vw.n354 vw.n353 5.2005
R363 vw.n353 vw.n352 5.2005
R364 vw.n350 vw.n294 5.2005
R365 vw.n294 vw.n293 5.2005
R366 vw.n336 vw.n335 5.2005
R367 vw.n340 vw.n336 5.2005
R368 vw.n719 vw.n718 5.2005
R369 vw.n718 vw.n717 5.2005
R370 vw.n720 vw.n330 5.2005
R371 vw.n380 vw.n330 5.2005
R372 vw.n722 vw.n721 5.2005
R373 vw.n723 vw.n722 5.2005
R374 vw.n322 vw.n321 5.2005
R375 vw.n724 vw.n322 5.2005
R376 vw.n728 vw.n727 5.2005
R377 vw.n727 vw.n726 5.2005
R378 vw.n729 vw.n316 5.2005
R379 vw.n316 vw.n314 5.2005
R380 vw.n731 vw.n730 5.2005
R381 vw.n732 vw.n731 5.2005
R382 vw.n317 vw.n315 5.2005
R383 vw.n315 vw.n311 5.2005
R384 vw.n365 vw.n364 5.2005
R385 vw.n366 vw.n365 5.2005
R386 vw.n301 vw.n300 5.2005
R387 vw.n304 vw.n301 5.2005
R388 vw.n743 vw.n742 5.2005
R389 vw.n742 vw.n741 5.2005
R390 vw.n744 vw.n298 5.2005
R391 vw.n352 vw.n298 5.2005
R392 vw.n745 vw.n295 5.2005
R393 vw.n295 vw.n293 5.2005
R394 vw.n665 vw.n182 5.2005
R395 vw.n648 vw.n182 5.2005
R396 vw.n422 vw.n183 5.2005
R397 vw.n648 vw.n183 5.2005
R398 vw.n234 vw.n233 5.2005
R399 vw.n234 vw.n200 5.2005
R400 vw.n232 vw.n198 5.2005
R401 vw.n827 vw.n198 5.2005
R402 vw.n219 vw.n203 5.2005
R403 vw.n219 vw.n197 5.2005
R404 vw.n228 vw.n227 5.2005
R405 vw.n227 vw.n226 5.2005
R406 vw.n218 vw.n186 5.2005
R407 vw.n188 vw.n186 5.2005
R408 vw.n824 vw.n202 5.2005
R409 vw.n202 vw.n200 5.2005
R410 vw.n826 vw.n825 5.2005
R411 vw.n827 vw.n826 5.2005
R412 vw.n203 vw.n201 5.2005
R413 vw.n201 vw.n197 5.2005
R414 vw.n225 vw.n224 5.2005
R415 vw.n226 vw.n225 5.2005
R416 vw.n220 vw.n187 5.2005
R417 vw.n188 vw.n187 5.2005
R418 vw.n278 vw.n277 5.2005
R419 vw.n277 vw.n256 5.2005
R420 vw.n279 vw.n251 5.2005
R421 vw.n808 vw.n251 5.2005
R422 vw.n283 vw.n252 5.2005
R423 vw.n256 vw.n252 5.2005
R424 vw.n809 vw.n253 5.2005
R425 vw.n809 vw.n808 5.2005
R426 vw.n292 vw.n291 5.2005
R427 vw.n750 vw.n292 5.2005
R428 vw.n287 vw.n272 5.2005
R429 vw.n272 vw.n271 5.2005
R430 vw.n752 vw.n751 5.2005
R431 vw.n751 vw.n750 5.2005
R432 vw.n753 vw.n273 5.2005
R433 vw.n273 vw.n271 5.2005
R434 vw.n702 vw.n312 5.2005
R435 vw.n733 vw.n312 5.2005
R436 vw.n701 vw.n305 5.2005
R437 vw.n360 vw.n305 5.2005
R438 vw.n735 vw.n734 5.2005
R439 vw.n734 vw.n733 5.2005
R440 vw.n736 vw.n306 5.2005
R441 vw.n360 vw.n306 5.2005
R442 vw.n710 vw.n339 5.2005
R443 vw.n716 vw.n339 5.2005
R444 vw.n709 vw.n708 5.2005
R445 vw.n708 vw.n337 5.2005
R446 vw.n715 vw.n714 5.2005
R447 vw.n716 vw.n715 5.2005
R448 vw.n697 vw.n341 5.2005
R449 vw.n341 vw.n337 5.2005
R450 vw.n461 vw.n460 5.2005
R451 vw.n620 vw.n619 5.2005
R452 vw.n617 vw.n463 5.2005
R453 vw.n615 vw.n614 5.2005
R454 vw.n604 vw.n603 5.2005
R455 vw.n606 vw.n571 5.2005
R456 vw.n607 vw.n466 5.2005
R457 vw.n610 vw.n609 5.2005
R458 vw.n682 vw.n681 5.2005
R459 vw.n684 vw.n683 5.2005
R460 vw.n686 vw.n685 5.2005
R461 vw.n687 vw.n394 5.2005
R462 vw.n689 vw.n688 5.2005
R463 vw.n690 vw.n689 5.2005
R464 vw.n440 vw.n439 5.2005
R465 vw.n443 vw.n442 5.2005
R466 vw.n441 vw.n411 5.2005
R467 vw.n447 vw.n408 5.2005
R468 vw.n449 vw.n448 5.2005
R469 vw.n450 vw.n449 5.2005
R470 vw.n544 vw.n497 5.2005
R471 vw.n542 vw.n541 5.2005
R472 vw.n499 vw.n498 5.2005
R473 vw.n537 vw.n536 5.2005
R474 vw.n534 vw.n501 5.2005
R475 vw.n532 vw.n531 5.2005
R476 vw.n503 vw.n502 5.2005
R477 vw.n527 vw.n526 5.2005
R478 vw.n524 vw.n505 5.2005
R479 vw.n522 vw.n521 5.2005
R480 vw.n507 vw.n506 5.2005
R481 vw.n517 vw.n516 5.2005
R482 vw.n514 vw.n509 5.2005
R483 vw.n512 vw.n511 5.2005
R484 vw.n495 vw.n468 5.2005
R485 vw.n570 vw.n468 5.2005
R486 vw.n550 vw.n494 5.2005
R487 vw.n551 vw.n493 5.2005
R488 vw.n552 vw.n492 5.2005
R489 vw.n490 vw.n489 5.2005
R490 vw.n556 vw.n488 5.2005
R491 vw.n557 vw.n487 5.2005
R492 vw.n558 vw.n486 5.2005
R493 vw.n484 vw.n483 5.2005
R494 vw.n562 vw.n482 5.2005
R495 vw.n563 vw.n481 5.2005
R496 vw.n564 vw.n480 5.2005
R497 vw.n477 vw.n476 5.2005
R498 vw.n569 vw.n568 5.2005
R499 vw.n570 vw.n569 5.2005
R500 vw.n713 vw.n712 5.20011
R501 vw.n712 vw.n711 5.20011
R502 vw.n738 vw.n737 5.20011
R503 vw.n289 vw.n285 5.20011
R504 vw.n290 vw.n289 5.20011
R505 vw.n388 vw.n385 5.17941
R506 vw.n747 vw.n746 5.17941
R507 vw.n747 vw.n296 5.17941
R508 vw.n796 vw.n793 5.17941
R509 vw.n833 vw.n832 5.17941
R510 vw.n833 vw.n191 5.17941
R511 vw.n410 vw.n409 5.17941
R512 vw.n409 vw.n395 5.17941
R513 vw.n644 vw.n174 5.17941
R514 vw.n612 vw.n611 5.17941
R515 vw.n613 vw.n612 5.17941
R516 vw.n567 vw.n478 5.17941
R517 vw.n546 vw.n496 5.17941
R518 vw.n510 vw.n478 5.17159
R519 vw.n700 vw.n308 5.07
R520 vw.n209 vw.n208 5.03258
R521 vw.n172 vw.n171 4.95416
R522 vw.n221 vw.n185 4.7678
R523 vw.n217 vw.n185 4.7678
R524 vw.n822 vw.n205 4.7678
R525 vw.n823 vw.n822 4.7678
R526 vw.n282 vw.n281 4.75185
R527 vw.n705 vw.n698 4.75136
R528 vw.n704 vw.n699 4.75136
R529 vw.n755 vw.n754 4.75136
R530 vw.n276 vw.n274 4.75136
R531 vw.n704 vw.n703 4.75135
R532 vw.n705 vw.n309 4.75135
R533 vw.n288 vw.n274 4.75135
R534 vw.n755 vw.n284 4.75135
R535 vw.n281 vw.n280 4.75085
R536 vw.n664 vw.n184 4.73115
R537 vw.n421 vw.n184 4.73015
R538 vw.n387 vw.n386 4.7255
R539 vw.n795 vw.n794 4.7255
R540 vw.n846 vw.n845 4.7255
R541 vw.n548 vw.n547 4.7255
R542 vw.n210 vw.n206 4.6445
R543 vw.n211 vw 4.6085
R544 vw.n120 vw.n110 4.5005
R545 vw.n110 vw.n88 4.5005
R546 vw.n116 vw.n88 4.5005
R547 vw.n121 vw.n120 4.5005
R548 vw.n121 vw.n89 4.5005
R549 vw.n121 vw.n88 4.5005
R550 vw.n120 vw.n92 4.5005
R551 vw.n92 vw.n89 4.5005
R552 vw.n92 vw.n88 4.5005
R553 vw.n115 vw.n89 4.5005
R554 vw.n115 vw.n88 4.5005
R555 vw.n103 vw.n100 4.5005
R556 vw.n108 vw.n100 4.5005
R557 vw.n108 vw.n97 4.5005
R558 vw.n107 vw.n103 4.5005
R559 vw.n107 vw.n95 4.5005
R560 vw.n108 vw.n107 4.5005
R561 vw.n103 vw.n96 4.5005
R562 vw.n96 vw.n95 4.5005
R563 vw.n108 vw.n96 4.5005
R564 vw.n109 vw.n95 4.5005
R565 vw.n109 vw.n108 4.5005
R566 vw.n714 vw.n713 4.5005
R567 vw.n698 vw.n697 4.5005
R568 vw.n711 vw.n710 4.5005
R569 vw.n709 vw.n699 4.5005
R570 vw.n735 vw.n309 4.5005
R571 vw.n737 vw.n736 4.5005
R572 vw.n703 vw.n702 4.5005
R573 vw.n701 vw.n700 4.5005
R574 vw.n744 vw.n297 4.5005
R575 vw.n743 vw.n299 4.5005
R576 vw.n361 vw.n300 4.5005
R577 vw.n364 vw.n363 4.5005
R578 vw.n362 vw.n317 4.5005
R579 vw.n730 vw.n318 4.5005
R580 vw.n729 vw.n319 4.5005
R581 vw.n728 vw.n320 4.5005
R582 vw.n331 vw.n321 4.5005
R583 vw.n721 vw.n332 4.5005
R584 vw.n720 vw.n333 4.5005
R585 vw.n719 vw.n334 4.5005
R586 vw.n386 vw.n335 4.5005
R587 vw.n746 vw.n745 4.5005
R588 vw.n355 vw.n354 4.5005
R589 vw.n356 vw.n349 4.5005
R590 vw.n358 vw.n357 4.5005
R591 vw.n348 vw.n347 4.5005
R592 vw.n370 vw.n369 4.5005
R593 vw.n371 vw.n346 4.5005
R594 vw.n374 vw.n372 4.5005
R595 vw.n375 vw.n345 4.5005
R596 vw.n377 vw.n376 4.5005
R597 vw.n378 vw.n344 4.5005
R598 vw.n382 vw.n379 4.5005
R599 vw.n383 vw.n343 4.5005
R600 vw.n385 vw.n384 4.5005
R601 vw.n350 vw.n296 4.5005
R602 vw.n830 vw.n192 4.5005
R603 vw.n829 vw.n194 4.5005
R604 vw.n241 vw.n195 4.5005
R605 vw.n242 vw.n240 4.5005
R606 vw.n816 vw.n243 4.5005
R607 vw.n815 vw.n244 4.5005
R608 vw.n814 vw.n245 4.5005
R609 vw.n260 vw.n246 4.5005
R610 vw.n261 vw.n259 4.5005
R611 vw.n805 vw.n262 4.5005
R612 vw.n804 vw.n263 4.5005
R613 vw.n803 vw.n264 4.5005
R614 vw.n794 vw.n265 4.5005
R615 vw.n832 vw.n831 4.5005
R616 vw.n769 vw.n768 4.5005
R617 vw.n770 vw.n765 4.5005
R618 vw.n772 vw.n771 4.5005
R619 vw.n775 vw.n764 4.5005
R620 vw.n777 vw.n776 4.5005
R621 vw.n778 vw.n763 4.5005
R622 vw.n780 vw.n779 4.5005
R623 vw.n781 vw.n761 4.5005
R624 vw.n785 vw.n784 4.5005
R625 vw.n786 vw.n760 4.5005
R626 vw.n790 vw.n787 4.5005
R627 vw.n791 vw.n759 4.5005
R628 vw.n793 vw.n792 4.5005
R629 vw.n766 vw.n191 4.5005
R630 vw.n752 vw.n285 4.5005
R631 vw.n754 vw.n753 4.5005
R632 vw.n291 vw.n290 4.5005
R633 vw.n288 vw.n287 4.5005
R634 vw.n278 vw.n276 4.5005
R635 vw.n280 vw.n279 4.5005
R636 vw.n284 vw.n283 4.5005
R637 vw.n282 vw.n253 4.5005
R638 vw.n224 vw.n223 4.5005
R639 vw.n222 vw.n203 4.5005
R640 vw.n825 vw.n204 4.5005
R641 vw.n824 vw.n823 4.5005
R642 vw.n221 vw.n220 4.5005
R643 vw.n218 vw.n217 4.5005
R644 vw.n229 vw.n228 4.5005
R645 vw.n230 vw.n203 4.5005
R646 vw.n232 vw.n231 4.5005
R647 vw.n233 vw.n205 4.5005
R648 vw.n212 vw.n211 4.5005
R649 vw.n210 vw.n203 4.5005
R650 vw.n447 vw.n446 4.5005
R651 vw.n445 vw.n411 4.5005
R652 vw.n444 vw.n443 4.5005
R653 vw.n440 vw.n412 4.5005
R654 vw.n437 vw.n413 4.5005
R655 vw.n436 vw.n414 4.5005
R656 vw.n433 vw.n415 4.5005
R657 vw.n432 vw.n416 4.5005
R658 vw.n429 vw.n417 4.5005
R659 vw.n428 vw.n418 4.5005
R660 vw.n425 vw.n419 4.5005
R661 vw.n424 vw.n420 4.5005
R662 vw.n422 vw.n421 4.5005
R663 vw.n448 vw.n410 4.5005
R664 vw.n687 vw.n396 4.5005
R665 vw.n686 vw.n397 4.5005
R666 vw.n683 vw.n398 4.5005
R667 vw.n682 vw.n399 4.5005
R668 vw.n653 vw.n400 4.5005
R669 vw.n677 vw.n654 4.5005
R670 vw.n676 vw.n655 4.5005
R671 vw.n675 vw.n656 4.5005
R672 vw.n660 vw.n657 4.5005
R673 vw.n670 vw.n661 4.5005
R674 vw.n669 vw.n662 4.5005
R675 vw.n668 vw.n663 4.5005
R676 vw.n665 vw.n664 4.5005
R677 vw.n688 vw.n395 4.5005
R678 vw.n466 vw.n465 4.5005
R679 vw.n573 vw.n571 4.5005
R680 vw.n603 vw.n574 4.5005
R681 vw.n602 vw.n575 4.5005
R682 vw.n601 vw.n576 4.5005
R683 vw.n581 vw.n577 4.5005
R684 vw.n596 vw.n582 4.5005
R685 vw.n595 vw.n583 4.5005
R686 vw.n594 vw.n584 4.5005
R687 vw.n587 vw.n585 4.5005
R688 vw.n589 vw.n588 4.5005
R689 vw.n176 vw.n175 4.5005
R690 vw.n845 vw.n844 4.5005
R691 vw.n611 vw.n610 4.5005
R692 vw.n463 vw.n462 4.5005
R693 vw.n621 vw.n620 4.5005
R694 vw.n622 vw.n461 4.5005
R695 vw.n624 vw.n623 4.5005
R696 vw.n459 vw.n458 4.5005
R697 vw.n631 vw.n630 4.5005
R698 vw.n632 vw.n457 4.5005
R699 vw.n634 vw.n633 4.5005
R700 vw.n455 vw.n454 4.5005
R701 vw.n641 vw.n640 4.5005
R702 vw.n642 vw.n453 4.5005
R703 vw.n646 vw.n643 4.5005
R704 vw.n645 vw.n644 4.5005
R705 vw.n614 vw.n613 4.5005
R706 vw.n566 vw.n477 4.5005
R707 vw.n565 vw.n564 4.5005
R708 vw.n563 vw.n479 4.5005
R709 vw.n562 vw.n561 4.5005
R710 vw.n560 vw.n484 4.5005
R711 vw.n559 vw.n558 4.5005
R712 vw.n557 vw.n485 4.5005
R713 vw.n556 vw.n555 4.5005
R714 vw.n554 vw.n490 4.5005
R715 vw.n553 vw.n552 4.5005
R716 vw.n551 vw.n491 4.5005
R717 vw.n550 vw.n549 4.5005
R718 vw.n548 vw.n495 4.5005
R719 vw.n568 vw.n567 4.5005
R720 vw.n509 vw.n508 4.5005
R721 vw.n518 vw.n517 4.5005
R722 vw.n519 vw.n507 4.5005
R723 vw.n521 vw.n520 4.5005
R724 vw.n505 vw.n504 4.5005
R725 vw.n528 vw.n527 4.5005
R726 vw.n529 vw.n503 4.5005
R727 vw.n531 vw.n530 4.5005
R728 vw.n501 vw.n500 4.5005
R729 vw.n538 vw.n537 4.5005
R730 vw.n539 vw.n499 4.5005
R731 vw.n541 vw.n540 4.5005
R732 vw.n497 vw.n496 4.5005
R733 vw.n511 vw.n510 4.5005
R734 vw vw.n848 4.5005
R735 vw.n161 vw.n155 4.5005
R736 vw.n155 vw.n2 4.5005
R737 vw.n155 vw.n4 4.5005
R738 vw.n155 vw.n1 4.5005
R739 vw.n167 vw.n1 4.5005
R740 vw.n169 vw.n2 4.5005
R741 vw.n169 vw.n4 4.5005
R742 vw.n169 vw.n1 4.5005
R743 vw.n171 vw.n2 4.5005
R744 vw.n171 vw.n4 4.5005
R745 vw.n171 vw.n1 4.5005
R746 vw.n168 vw.n155 4.5005
R747 vw.n158 vw.n155 4.5005
R748 vw.n170 vw.n155 4.5005
R749 vw.n168 vw.n167 4.5005
R750 vw.n169 vw.n168 4.5005
R751 vw.n169 vw.n158 4.5005
R752 vw.n169 vw.n6 4.5005
R753 vw.n169 vw.n157 4.5005
R754 vw.n170 vw.n169 4.5005
R755 vw.n168 vw.n8 4.5005
R756 vw.n158 vw.n8 4.5005
R757 vw.n8 vw.n6 4.5005
R758 vw.n170 vw.n8 4.5005
R759 vw.n171 vw.n6 4.5005
R760 vw.n171 vw.n170 4.5005
R761 vw.n144 vw.n138 4.5005
R762 vw.n138 vw.n12 4.5005
R763 vw.n138 vw.n14 4.5005
R764 vw.n138 vw.n11 4.5005
R765 vw.n150 vw.n11 4.5005
R766 vw.n152 vw.n12 4.5005
R767 vw.n152 vw.n14 4.5005
R768 vw.n152 vw.n11 4.5005
R769 vw.n154 vw.n12 4.5005
R770 vw.n154 vw.n14 4.5005
R771 vw.n154 vw.n11 4.5005
R772 vw.n151 vw.n138 4.5005
R773 vw.n141 vw.n138 4.5005
R774 vw.n153 vw.n138 4.5005
R775 vw.n151 vw.n150 4.5005
R776 vw.n152 vw.n151 4.5005
R777 vw.n152 vw.n141 4.5005
R778 vw.n152 vw.n16 4.5005
R779 vw.n152 vw.n140 4.5005
R780 vw.n153 vw.n152 4.5005
R781 vw.n151 vw.n18 4.5005
R782 vw.n141 vw.n18 4.5005
R783 vw.n18 vw.n16 4.5005
R784 vw.n153 vw.n18 4.5005
R785 vw.n154 vw.n16 4.5005
R786 vw.n154 vw.n153 4.5005
R787 vw.n128 vw.n86 4.5005
R788 vw.n86 vw.n22 4.5005
R789 vw.n86 vw.n24 4.5005
R790 vw.n86 vw.n21 4.5005
R791 vw.n133 vw.n128 4.5005
R792 vw.n133 vw.n21 4.5005
R793 vw.n135 vw.n128 4.5005
R794 vw.n135 vw.n22 4.5005
R795 vw.n135 vw.n24 4.5005
R796 vw.n135 vw.n21 4.5005
R797 vw.n137 vw.n22 4.5005
R798 vw.n137 vw.n24 4.5005
R799 vw.n137 vw.n21 4.5005
R800 vw.n134 vw.n86 4.5005
R801 vw.n125 vw.n86 4.5005
R802 vw.n136 vw.n86 4.5005
R803 vw.n134 vw.n133 4.5005
R804 vw.n135 vw.n134 4.5005
R805 vw.n135 vw.n125 4.5005
R806 vw.n135 vw.n26 4.5005
R807 vw.n135 vw.n124 4.5005
R808 vw.n136 vw.n135 4.5005
R809 vw.n134 vw.n28 4.5005
R810 vw.n125 vw.n28 4.5005
R811 vw.n28 vw.n26 4.5005
R812 vw.n136 vw.n28 4.5005
R813 vw.n137 vw.n26 4.5005
R814 vw.n137 vw.n136 4.5005
R815 vw.n75 vw.n69 4.5005
R816 vw.n69 vw.n32 4.5005
R817 vw.n69 vw.n34 4.5005
R818 vw.n69 vw.n31 4.5005
R819 vw.n81 vw.n31 4.5005
R820 vw.n83 vw.n32 4.5005
R821 vw.n83 vw.n34 4.5005
R822 vw.n83 vw.n31 4.5005
R823 vw.n85 vw.n32 4.5005
R824 vw.n85 vw.n34 4.5005
R825 vw.n85 vw.n31 4.5005
R826 vw.n82 vw.n69 4.5005
R827 vw.n72 vw.n69 4.5005
R828 vw.n84 vw.n69 4.5005
R829 vw.n82 vw.n81 4.5005
R830 vw.n83 vw.n82 4.5005
R831 vw.n83 vw.n72 4.5005
R832 vw.n83 vw.n36 4.5005
R833 vw.n83 vw.n71 4.5005
R834 vw.n84 vw.n83 4.5005
R835 vw.n82 vw.n38 4.5005
R836 vw.n72 vw.n38 4.5005
R837 vw.n38 vw.n36 4.5005
R838 vw.n84 vw.n38 4.5005
R839 vw.n85 vw.n36 4.5005
R840 vw.n85 vw.n84 4.5005
R841 vw.n58 vw.n52 4.5005
R842 vw.n52 vw.n42 4.5005
R843 vw.n52 vw.n44 4.5005
R844 vw.n52 vw.n41 4.5005
R845 vw.n64 vw.n41 4.5005
R846 vw.n66 vw.n42 4.5005
R847 vw.n66 vw.n44 4.5005
R848 vw.n66 vw.n41 4.5005
R849 vw.n68 vw.n42 4.5005
R850 vw.n68 vw.n44 4.5005
R851 vw.n68 vw.n41 4.5005
R852 vw.n65 vw.n52 4.5005
R853 vw.n55 vw.n52 4.5005
R854 vw.n67 vw.n52 4.5005
R855 vw.n65 vw.n64 4.5005
R856 vw.n66 vw.n65 4.5005
R857 vw.n66 vw.n55 4.5005
R858 vw.n66 vw.n46 4.5005
R859 vw.n66 vw.n54 4.5005
R860 vw.n67 vw.n66 4.5005
R861 vw.n65 vw.n48 4.5005
R862 vw.n55 vw.n48 4.5005
R863 vw.n48 vw.n46 4.5005
R864 vw.n67 vw.n48 4.5005
R865 vw.n68 vw.n46 4.5005
R866 vw.n68 vw.n67 4.5005
R867 vw.n750 vw.n749 3.5869
R868 vw.n441 vw.n407 3.11744
R869 vw.n439 vw.n406 3.11744
R870 vw.n435 vw.n401 3.11744
R871 vw.n431 vw.n402 3.11744
R872 vw.n427 vw.n403 3.11744
R873 vw.n423 vw.n404 3.11744
R874 vw.n685 vw.n392 3.11744
R875 vw.n681 vw.n391 3.11744
R876 vw.n679 vw.n678 3.11744
R877 vw.n674 vw.n658 3.11744
R878 vw.n672 vw.n671 3.11744
R879 vw.n667 vw.n666 3.11744
R880 vw.n608 vw.n607 3.11744
R881 vw.n605 vw.n604 3.11744
R882 vw.n600 vw.n578 3.11744
R883 vw.n598 vw.n597 3.11744
R884 vw.n593 vw.n586 3.11744
R885 vw.n591 vw.n590 3.11744
R886 vw.n617 vw.n616 3.11744
R887 vw.n618 vw.n460 3.11744
R888 vw.n627 vw.n626 3.11744
R889 vw.n628 vw.n456 3.11744
R890 vw.n637 vw.n636 3.11744
R891 vw.n638 vw.n452 3.11744
R892 vw.n639 vw.n638 3.11744
R893 vw.n636 vw.n635 3.11744
R894 vw.n629 vw.n628 3.11744
R895 vw.n626 vw.n625 3.11744
R896 vw.n592 vw.n591 3.11744
R897 vw.n586 vw.n580 3.11744
R898 vw.n599 vw.n598 3.11744
R899 vw.n578 vw.n572 3.11744
R900 vw.n666 vw.n659 3.11744
R901 vw.n673 vw.n672 3.11744
R902 vw.n658 vw.n652 3.11744
R903 vw.n680 vw.n679 3.11744
R904 vw.n426 vw.n404 3.11744
R905 vw.n430 vw.n403 3.11744
R906 vw.n434 vw.n402 3.11744
R907 vw.n438 vw.n401 3.11744
R908 vw.n619 vw.n618 3.11744
R909 vw.n616 vw.n615 3.11744
R910 vw.n606 vw.n605 3.11744
R911 vw.n609 vw.n608 3.11744
R912 vw.n684 vw.n391 3.11744
R913 vw.n394 vw.n392 3.11744
R914 vw.n442 vw.n406 3.11744
R915 vw.n408 vw.n407 3.11744
R916 vw.n513 vw.n512 3.11744
R917 vw.n516 vw.n515 3.11744
R918 vw.n523 vw.n522 3.11744
R919 vw.n526 vw.n525 3.11744
R920 vw.n533 vw.n532 3.11744
R921 vw.n536 vw.n535 3.11744
R922 vw.n543 vw.n542 3.11744
R923 vw.n544 vw.n543 3.11744
R924 vw.n535 vw.n498 3.11744
R925 vw.n534 vw.n533 3.11744
R926 vw.n525 vw.n502 3.11744
R927 vw.n524 vw.n523 3.11744
R928 vw.n515 vw.n506 3.11744
R929 vw.n514 vw.n513 3.11744
R930 vw.n480 vw.n474 3.11744
R931 vw.n482 vw.n473 3.11744
R932 vw.n486 vw.n472 3.11744
R933 vw.n488 vw.n471 3.11744
R934 vw.n492 vw.n470 3.11744
R935 vw.n494 vw.n469 3.11744
R936 vw.n493 vw.n469 3.11744
R937 vw.n489 vw.n470 3.11744
R938 vw.n487 vw.n471 3.11744
R939 vw.n483 vw.n472 3.11744
R940 vw.n481 vw.n473 3.11744
R941 vw.n476 vw.n474 3.11744
R942 vw.n248 vw.n237 2.86962
R943 vw.n164 vw.n163 2.25044
R944 vw.n162 vw.n161 2.25044
R945 vw.n163 vw.n159 2.25044
R946 vw.n157 vw.n0 2.25044
R947 vw.n147 vw.n146 2.25044
R948 vw.n145 vw.n144 2.25044
R949 vw.n146 vw.n142 2.25044
R950 vw.n140 vw.n10 2.25044
R951 vw.n130 vw.n129 2.25044
R952 vw.n129 vw.n126 2.25044
R953 vw.n124 vw.n20 2.25044
R954 vw.n78 vw.n77 2.25044
R955 vw.n76 vw.n75 2.25044
R956 vw.n77 vw.n73 2.25044
R957 vw.n71 vw.n30 2.25044
R958 vw.n61 vw.n60 2.25044
R959 vw.n59 vw.n58 2.25044
R960 vw.n60 vw.n56 2.25044
R961 vw.n54 vw.n40 2.25044
R962 vw.n118 vw.n117 2.24986
R963 vw.n112 vw.n87 2.24986
R964 vw.n118 vw.n90 2.24986
R965 vw.n113 vw.n112 2.24986
R966 vw.n105 vw.n104 2.24986
R967 vw.n101 vw.n98 2.24986
R968 vw.n106 vw.n105 2.24986
R969 vw.n98 vw.n93 2.24986
R970 vw.n111 vw.n110 2.24741
R971 vw.n116 vw.n91 2.24741
R972 vw.n119 vw.n115 2.24741
R973 vw.n100 vw.n99 2.24741
R974 vw.n102 vw.n97 2.24741
R975 vw.n109 vw.n94 2.24741
R976 vw.n167 vw.n166 2.24741
R977 vw.n160 vw.n8 2.24741
R978 vw.n8 vw.n7 2.24741
R979 vw.n171 vw.n3 2.24741
R980 vw.n156 vw.n155 2.24741
R981 vw.n167 vw.n165 2.24741
R982 vw.n167 vw.n9 2.24741
R983 vw.n171 vw.n5 2.24741
R984 vw.n150 vw.n149 2.24741
R985 vw.n143 vw.n18 2.24741
R986 vw.n18 vw.n17 2.24741
R987 vw.n154 vw.n13 2.24741
R988 vw.n139 vw.n138 2.24741
R989 vw.n150 vw.n148 2.24741
R990 vw.n150 vw.n19 2.24741
R991 vw.n154 vw.n15 2.24741
R992 vw.n133 vw.n132 2.24741
R993 vw.n127 vw.n28 2.24741
R994 vw.n28 vw.n27 2.24741
R995 vw.n137 vw.n23 2.24741
R996 vw.n123 vw.n86 2.24741
R997 vw.n133 vw.n131 2.24741
R998 vw.n133 vw.n29 2.24741
R999 vw.n137 vw.n25 2.24741
R1000 vw.n81 vw.n80 2.24741
R1001 vw.n74 vw.n38 2.24741
R1002 vw.n38 vw.n37 2.24741
R1003 vw.n85 vw.n33 2.24741
R1004 vw.n70 vw.n69 2.24741
R1005 vw.n81 vw.n79 2.24741
R1006 vw.n81 vw.n39 2.24741
R1007 vw.n85 vw.n35 2.24741
R1008 vw.n64 vw.n63 2.24741
R1009 vw.n57 vw.n48 2.24741
R1010 vw.n48 vw.n47 2.24741
R1011 vw.n68 vw.n43 2.24741
R1012 vw.n53 vw.n52 2.24741
R1013 vw.n64 vw.n62 2.24741
R1014 vw.n64 vw.n49 2.24741
R1015 vw.n68 vw.n45 2.24741
R1016 vw.n798 vw.n758 1.43506
R1017 vw.n847 vw.n173 1.3649
R1018 vw.n638 vw.n451 1.04278
R1019 vw.n636 vw.n451 1.04278
R1020 vw.n628 vw.n451 1.04278
R1021 vw.n626 vw.n451 1.04278
R1022 vw.n591 vw.n579 1.04278
R1023 vw.n586 vw.n579 1.04278
R1024 vw.n598 vw.n579 1.04278
R1025 vw.n579 vw.n578 1.04278
R1026 vw.n666 vw.n651 1.04278
R1027 vw.n672 vw.n651 1.04278
R1028 vw.n658 vw.n651 1.04278
R1029 vw.n679 vw.n651 1.04278
R1030 vw.n650 vw.n404 1.04278
R1031 vw.n650 vw.n403 1.04278
R1032 vw.n650 vw.n402 1.04278
R1033 vw.n650 vw.n401 1.04278
R1034 vw.n618 vw.n405 1.04278
R1035 vw.n616 vw.n405 1.04278
R1036 vw.n605 vw.n570 1.04278
R1037 vw.n608 vw.n570 1.04278
R1038 vw.n690 vw.n391 1.04278
R1039 vw.n690 vw.n392 1.04278
R1040 vw.n450 vw.n406 1.04278
R1041 vw.n450 vw.n407 1.04278
R1042 vw.n543 vw.n405 1.04278
R1043 vw.n535 vw.n405 1.04278
R1044 vw.n533 vw.n405 1.04278
R1045 vw.n525 vw.n405 1.04278
R1046 vw.n523 vw.n405 1.04278
R1047 vw.n515 vw.n405 1.04278
R1048 vw.n513 vw.n405 1.04278
R1049 vw.n570 vw.n469 1.04278
R1050 vw.n570 vw.n470 1.04278
R1051 vw.n570 vw.n471 1.04278
R1052 vw.n570 vw.n472 1.04278
R1053 vw.n570 vw.n473 1.04278
R1054 vw.n570 vw.n474 1.04278
R1055 vw.n209 vw.n207 0.795679
R1056 vw.n848 vw.n172 0.7592
R1057 vw.n178 vw.n174 0.743357
R1058 vw.n181 vw.n178 0.743357
R1059 vw.n834 vw.n833 0.743357
R1060 vw.n835 vw.n834 0.743357
R1061 vw.n797 vw.n796 0.743357
R1062 vw.n798 vw.n797 0.743357
R1063 vw.n748 vw.n747 0.743357
R1064 vw.n749 vw.n748 0.743357
R1065 vw.n389 vw.n388 0.743357
R1066 vw.n695 vw.n389 0.743357
R1067 vw.n840 vw.n839 0.743357
R1068 vw.n841 vw.n840 0.743357
R1069 vw.n838 vw.n837 0.743357
R1070 vw.n837 vw.n836 0.743357
R1071 vw.n821 vw.n820 0.743357
R1072 vw.n820 vw.n819 0.743357
R1073 vw.n810 vw.n216 0.743357
R1074 vw.n811 vw.n810 0.743357
R1075 vw.n756 vw.n275 0.743357
R1076 vw.n275 vw.n267 0.743357
R1077 vw.n757 vw.n756 0.743357
R1078 vw.n758 vw.n757 0.743357
R1079 vw.n289 vw.n286 0.743357
R1080 vw.n351 vw.n286 0.743357
R1081 vw.n739 vw.n738 0.743357
R1082 vw.n740 vw.n739 0.743357
R1083 vw.n706 vw.n310 0.743357
R1084 vw.n323 vw.n310 0.743357
R1085 vw.n707 vw.n706 0.743357
R1086 vw.n707 vw.n329 0.743357
R1087 vw.n712 vw.n696 0.743357
R1088 vw.n696 vw.n695 0.743357
R1089 vw.n612 vw.n464 0.743357
R1090 vw.n467 vw.n464 0.743357
R1091 vw.n409 vw.n393 0.743357
R1092 vw.n393 vw.n390 0.743357
R1093 vw.n478 vw.n475 0.743357
R1094 vw.n475 vw.n467 0.743357
R1095 vw.n546 vw.n545 0.743357
R1096 vw.n545 vw.n467 0.743357
R1097 vw.n848 vw.n847 0.6026
R1098 vw.n388 vw.n387 0.454413
R1099 vw.n796 vw.n795 0.454413
R1100 vw.n846 vw.n174 0.454413
R1101 vw.n547 vw.n546 0.454413
R1102 vw.n224 vw.n220 0.148954
R1103 vw.n224 vw.n203 0.148954
R1104 vw.n825 vw.n203 0.148954
R1105 vw.n825 vw.n824 0.148954
R1106 vw.n228 vw.n218 0.148954
R1107 vw.n228 vw.n203 0.148954
R1108 vw.n232 vw.n203 0.148954
R1109 vw.n233 vw.n232 0.148954
R1110 vw.n736 vw.n735 0.1445
R1111 vw.n710 vw.n709 0.1445
R1112 vw.n714 vw.n697 0.1445
R1113 vw.n713 vw.n698 0.1445
R1114 vw.n711 vw.n699 0.1445
R1115 vw.n737 vw.n309 0.1445
R1116 vw.n703 vw.n700 0.1445
R1117 vw.n702 vw.n701 0.1445
R1118 vw.n745 vw.n744 0.1445
R1119 vw.n744 vw.n743 0.1445
R1120 vw.n743 vw.n300 0.1445
R1121 vw.n364 vw.n300 0.1445
R1122 vw.n364 vw.n317 0.1445
R1123 vw.n730 vw.n317 0.1445
R1124 vw.n730 vw.n729 0.1445
R1125 vw.n729 vw.n728 0.1445
R1126 vw.n728 vw.n321 0.1445
R1127 vw.n721 vw.n321 0.1445
R1128 vw.n721 vw.n720 0.1445
R1129 vw.n720 vw.n719 0.1445
R1130 vw.n719 vw.n335 0.1445
R1131 vw.n746 vw.n297 0.1445
R1132 vw.n299 vw.n297 0.1445
R1133 vw.n361 vw.n299 0.1445
R1134 vw.n363 vw.n361 0.1445
R1135 vw.n363 vw.n362 0.1445
R1136 vw.n362 vw.n318 0.1445
R1137 vw.n319 vw.n318 0.1445
R1138 vw.n320 vw.n319 0.1445
R1139 vw.n331 vw.n320 0.1445
R1140 vw.n332 vw.n331 0.1445
R1141 vw.n333 vw.n332 0.1445
R1142 vw.n334 vw.n333 0.1445
R1143 vw.n386 vw.n334 0.1445
R1144 vw.n355 vw.n296 0.1445
R1145 vw.n356 vw.n355 0.1445
R1146 vw.n357 vw.n356 0.1445
R1147 vw.n357 vw.n347 0.1445
R1148 vw.n370 vw.n347 0.1445
R1149 vw.n371 vw.n370 0.1445
R1150 vw.n372 vw.n371 0.1445
R1151 vw.n372 vw.n345 0.1445
R1152 vw.n377 vw.n345 0.1445
R1153 vw.n378 vw.n377 0.1445
R1154 vw.n379 vw.n378 0.1445
R1155 vw.n379 vw.n343 0.1445
R1156 vw.n385 vw.n343 0.1445
R1157 vw.n354 vw.n350 0.1445
R1158 vw.n354 vw.n349 0.1445
R1159 vw.n358 vw.n349 0.1445
R1160 vw.n358 vw.n348 0.1445
R1161 vw.n369 vw.n348 0.1445
R1162 vw.n369 vw.n346 0.1445
R1163 vw.n374 vw.n346 0.1445
R1164 vw.n375 vw.n374 0.1445
R1165 vw.n376 vw.n375 0.1445
R1166 vw.n376 vw.n344 0.1445
R1167 vw.n382 vw.n344 0.1445
R1168 vw.n383 vw.n382 0.1445
R1169 vw.n384 vw.n383 0.1445
R1170 vw.n831 vw.n830 0.1445
R1171 vw.n830 vw.n829 0.1445
R1172 vw.n829 vw.n195 0.1445
R1173 vw.n240 vw.n195 0.1445
R1174 vw.n816 vw.n240 0.1445
R1175 vw.n816 vw.n815 0.1445
R1176 vw.n815 vw.n814 0.1445
R1177 vw.n814 vw.n246 0.1445
R1178 vw.n259 vw.n246 0.1445
R1179 vw.n805 vw.n259 0.1445
R1180 vw.n805 vw.n804 0.1445
R1181 vw.n804 vw.n803 0.1445
R1182 vw.n803 vw.n265 0.1445
R1183 vw.n832 vw.n192 0.1445
R1184 vw.n194 vw.n192 0.1445
R1185 vw.n241 vw.n194 0.1445
R1186 vw.n242 vw.n241 0.1445
R1187 vw.n243 vw.n242 0.1445
R1188 vw.n244 vw.n243 0.1445
R1189 vw.n245 vw.n244 0.1445
R1190 vw.n260 vw.n245 0.1445
R1191 vw.n261 vw.n260 0.1445
R1192 vw.n262 vw.n261 0.1445
R1193 vw.n263 vw.n262 0.1445
R1194 vw.n264 vw.n263 0.1445
R1195 vw.n794 vw.n264 0.1445
R1196 vw.n769 vw.n191 0.1445
R1197 vw.n770 vw.n769 0.1445
R1198 vw.n771 vw.n770 0.1445
R1199 vw.n771 vw.n764 0.1445
R1200 vw.n777 vw.n764 0.1445
R1201 vw.n778 vw.n777 0.1445
R1202 vw.n779 vw.n778 0.1445
R1203 vw.n779 vw.n761 0.1445
R1204 vw.n785 vw.n761 0.1445
R1205 vw.n786 vw.n785 0.1445
R1206 vw.n787 vw.n786 0.1445
R1207 vw.n787 vw.n759 0.1445
R1208 vw.n793 vw.n759 0.1445
R1209 vw.n768 vw.n766 0.1445
R1210 vw.n768 vw.n765 0.1445
R1211 vw.n772 vw.n765 0.1445
R1212 vw.n775 vw.n772 0.1445
R1213 vw.n776 vw.n775 0.1445
R1214 vw.n776 vw.n763 0.1445
R1215 vw.n780 vw.n763 0.1445
R1216 vw.n781 vw.n780 0.1445
R1217 vw.n784 vw.n781 0.1445
R1218 vw.n784 vw.n760 0.1445
R1219 vw.n790 vw.n760 0.1445
R1220 vw.n791 vw.n790 0.1445
R1221 vw.n792 vw.n791 0.1445
R1222 vw.n211 vw.n210 0.1445
R1223 vw.n283 vw.n253 0.1445
R1224 vw.n291 vw.n287 0.1445
R1225 vw.n753 vw.n752 0.1445
R1226 vw.n754 vw.n285 0.1445
R1227 vw.n290 vw.n288 0.1445
R1228 vw.n279 vw.n278 0.1445
R1229 vw.n280 vw.n276 0.1445
R1230 vw.n284 vw.n282 0.1445
R1231 vw.n223 vw.n221 0.1445
R1232 vw.n223 vw.n222 0.1445
R1233 vw.n222 vw.n204 0.1445
R1234 vw.n823 vw.n204 0.1445
R1235 vw.n229 vw.n217 0.1445
R1236 vw.n230 vw.n229 0.1445
R1237 vw.n231 vw.n230 0.1445
R1238 vw.n231 vw.n205 0.1445
R1239 vw.n448 vw.n447 0.1445
R1240 vw.n447 vw.n411 0.1445
R1241 vw.n443 vw.n411 0.1445
R1242 vw.n443 vw.n440 0.1445
R1243 vw.n440 vw.n437 0.1445
R1244 vw.n437 vw.n436 0.1445
R1245 vw.n436 vw.n433 0.1445
R1246 vw.n433 vw.n432 0.1445
R1247 vw.n432 vw.n429 0.1445
R1248 vw.n429 vw.n428 0.1445
R1249 vw.n428 vw.n425 0.1445
R1250 vw.n425 vw.n424 0.1445
R1251 vw.n424 vw.n422 0.1445
R1252 vw.n446 vw.n410 0.1445
R1253 vw.n446 vw.n445 0.1445
R1254 vw.n445 vw.n444 0.1445
R1255 vw.n444 vw.n412 0.1445
R1256 vw.n413 vw.n412 0.1445
R1257 vw.n414 vw.n413 0.1445
R1258 vw.n415 vw.n414 0.1445
R1259 vw.n416 vw.n415 0.1445
R1260 vw.n417 vw.n416 0.1445
R1261 vw.n418 vw.n417 0.1445
R1262 vw.n419 vw.n418 0.1445
R1263 vw.n420 vw.n419 0.1445
R1264 vw.n421 vw.n420 0.1445
R1265 vw.n396 vw.n395 0.1445
R1266 vw.n397 vw.n396 0.1445
R1267 vw.n398 vw.n397 0.1445
R1268 vw.n399 vw.n398 0.1445
R1269 vw.n653 vw.n399 0.1445
R1270 vw.n654 vw.n653 0.1445
R1271 vw.n655 vw.n654 0.1445
R1272 vw.n656 vw.n655 0.1445
R1273 vw.n660 vw.n656 0.1445
R1274 vw.n661 vw.n660 0.1445
R1275 vw.n662 vw.n661 0.1445
R1276 vw.n663 vw.n662 0.1445
R1277 vw.n664 vw.n663 0.1445
R1278 vw.n688 vw.n687 0.1445
R1279 vw.n687 vw.n686 0.1445
R1280 vw.n686 vw.n683 0.1445
R1281 vw.n683 vw.n682 0.1445
R1282 vw.n682 vw.n400 0.1445
R1283 vw.n677 vw.n400 0.1445
R1284 vw.n677 vw.n676 0.1445
R1285 vw.n676 vw.n675 0.1445
R1286 vw.n675 vw.n657 0.1445
R1287 vw.n670 vw.n657 0.1445
R1288 vw.n670 vw.n669 0.1445
R1289 vw.n669 vw.n668 0.1445
R1290 vw.n668 vw.n665 0.1445
R1291 vw.n610 vw.n466 0.1445
R1292 vw.n571 vw.n466 0.1445
R1293 vw.n603 vw.n571 0.1445
R1294 vw.n603 vw.n602 0.1445
R1295 vw.n602 vw.n601 0.1445
R1296 vw.n601 vw.n577 0.1445
R1297 vw.n596 vw.n577 0.1445
R1298 vw.n596 vw.n595 0.1445
R1299 vw.n595 vw.n594 0.1445
R1300 vw.n594 vw.n585 0.1445
R1301 vw.n589 vw.n585 0.1445
R1302 vw.n589 vw.n176 0.1445
R1303 vw.n844 vw.n176 0.1445
R1304 vw.n611 vw.n465 0.1445
R1305 vw.n573 vw.n465 0.1445
R1306 vw.n574 vw.n573 0.1445
R1307 vw.n575 vw.n574 0.1445
R1308 vw.n576 vw.n575 0.1445
R1309 vw.n581 vw.n576 0.1445
R1310 vw.n582 vw.n581 0.1445
R1311 vw.n583 vw.n582 0.1445
R1312 vw.n584 vw.n583 0.1445
R1313 vw.n587 vw.n584 0.1445
R1314 vw.n588 vw.n587 0.1445
R1315 vw.n588 vw.n175 0.1445
R1316 vw.n845 vw.n175 0.1445
R1317 vw.n613 vw.n462 0.1445
R1318 vw.n621 vw.n462 0.1445
R1319 vw.n622 vw.n621 0.1445
R1320 vw.n623 vw.n622 0.1445
R1321 vw.n623 vw.n458 0.1445
R1322 vw.n631 vw.n458 0.1445
R1323 vw.n632 vw.n631 0.1445
R1324 vw.n633 vw.n632 0.1445
R1325 vw.n633 vw.n454 0.1445
R1326 vw.n641 vw.n454 0.1445
R1327 vw.n642 vw.n641 0.1445
R1328 vw.n643 vw.n642 0.1445
R1329 vw.n644 vw.n643 0.1445
R1330 vw.n614 vw.n463 0.1445
R1331 vw.n620 vw.n463 0.1445
R1332 vw.n620 vw.n461 0.1445
R1333 vw.n624 vw.n461 0.1445
R1334 vw.n624 vw.n459 0.1445
R1335 vw.n630 vw.n459 0.1445
R1336 vw.n630 vw.n457 0.1445
R1337 vw.n634 vw.n457 0.1445
R1338 vw.n634 vw.n455 0.1445
R1339 vw.n640 vw.n455 0.1445
R1340 vw.n640 vw.n453 0.1445
R1341 vw.n646 vw.n453 0.1445
R1342 vw.n646 vw.n645 0.1445
R1343 vw.n511 vw.n509 0.1445
R1344 vw.n517 vw.n509 0.1445
R1345 vw.n517 vw.n507 0.1445
R1346 vw.n521 vw.n507 0.1445
R1347 vw.n521 vw.n505 0.1445
R1348 vw.n527 vw.n505 0.1445
R1349 vw.n527 vw.n503 0.1445
R1350 vw.n531 vw.n503 0.1445
R1351 vw.n531 vw.n501 0.1445
R1352 vw.n537 vw.n501 0.1445
R1353 vw.n537 vw.n499 0.1445
R1354 vw.n541 vw.n499 0.1445
R1355 vw.n541 vw.n497 0.1445
R1356 vw.n568 vw.n477 0.1445
R1357 vw.n564 vw.n477 0.1445
R1358 vw.n564 vw.n563 0.1445
R1359 vw.n563 vw.n562 0.1445
R1360 vw.n562 vw.n484 0.1445
R1361 vw.n558 vw.n484 0.1445
R1362 vw.n558 vw.n557 0.1445
R1363 vw.n557 vw.n556 0.1445
R1364 vw.n556 vw.n490 0.1445
R1365 vw.n552 vw.n490 0.1445
R1366 vw.n552 vw.n551 0.1445
R1367 vw.n551 vw.n550 0.1445
R1368 vw.n550 vw.n495 0.1445
R1369 vw.n567 vw.n566 0.1445
R1370 vw.n566 vw.n565 0.1445
R1371 vw.n565 vw.n479 0.1445
R1372 vw.n561 vw.n479 0.1445
R1373 vw.n561 vw.n560 0.1445
R1374 vw.n560 vw.n559 0.1445
R1375 vw.n559 vw.n485 0.1445
R1376 vw.n555 vw.n485 0.1445
R1377 vw.n555 vw.n554 0.1445
R1378 vw.n554 vw.n553 0.1445
R1379 vw.n553 vw.n491 0.1445
R1380 vw.n549 vw.n491 0.1445
R1381 vw.n549 vw.n548 0.1445
R1382 vw.n510 vw.n508 0.1445
R1383 vw.n518 vw.n508 0.1445
R1384 vw.n519 vw.n518 0.1445
R1385 vw.n520 vw.n519 0.1445
R1386 vw.n520 vw.n504 0.1445
R1387 vw.n528 vw.n504 0.1445
R1388 vw.n529 vw.n528 0.1445
R1389 vw.n530 vw.n529 0.1445
R1390 vw.n530 vw.n500 0.1445
R1391 vw.n538 vw.n500 0.1445
R1392 vw.n539 vw.n538 0.1445
R1393 vw.n540 vw.n539 0.1445
R1394 vw.n540 vw.n496 0.1445
R1395 vw.n738 vw.n308 0.122783
R1396 vw.n706 vw.n705 0.0740097
R1397 vw.n706 vw.n704 0.0740097
R1398 vw.n756 vw.n755 0.0740097
R1399 vw.n756 vw.n274 0.0740097
R1400 vw.n839 vw.n838 0.04675
R1401 vw.n821 vw.n216 0.04675
R1402 vw.n122 vw.n121 0.0325
R1403 vw.n213 vw.n185 0.024875
R1404 vw.n822 vw.n215 0.024875
R1405 vw.n110 vw.n109 0.0245
R1406 vw.n213 vw.n212 0.0188333
R1407 vw.n215 vw.n206 0.0188333
R1408 vw.n212 vw.n203 0.0171667
R1409 vw.n108 vw.n98 0.0149
R1410 vw.n112 vw.n88 0.0149
R1411 vw.n69 vw.n68 0.0121667
R1412 vw.n86 vw.n85 0.0121667
R1413 vw.n138 vw.n137 0.0121667
R1414 vw.n155 vw.n154 0.0121667
R1415 vw.n208 vw.n206 0.0114825
R1416 vw.n54 vw.n49 0.0081885
R1417 vw.n54 vw.n53 0.0081885
R1418 vw.n62 vw.n55 0.0081885
R1419 vw.n65 vw.n45 0.0081885
R1420 vw.n47 vw.n44 0.0081885
R1421 vw.n63 vw.n42 0.0081885
R1422 vw.n58 vw.n57 0.0081885
R1423 vw.n60 vw.n43 0.0081885
R1424 vw.n71 vw.n39 0.0081885
R1425 vw.n71 vw.n70 0.0081885
R1426 vw.n79 vw.n72 0.0081885
R1427 vw.n82 vw.n35 0.0081885
R1428 vw.n37 vw.n34 0.0081885
R1429 vw.n80 vw.n32 0.0081885
R1430 vw.n75 vw.n74 0.0081885
R1431 vw.n77 vw.n33 0.0081885
R1432 vw.n124 vw.n29 0.0081885
R1433 vw.n124 vw.n123 0.0081885
R1434 vw.n131 vw.n125 0.0081885
R1435 vw.n134 vw.n25 0.0081885
R1436 vw.n27 vw.n24 0.0081885
R1437 vw.n132 vw.n22 0.0081885
R1438 vw.n128 vw.n127 0.0081885
R1439 vw.n129 vw.n23 0.0081885
R1440 vw.n140 vw.n19 0.0081885
R1441 vw.n140 vw.n139 0.0081885
R1442 vw.n148 vw.n141 0.0081885
R1443 vw.n151 vw.n15 0.0081885
R1444 vw.n17 vw.n14 0.0081885
R1445 vw.n149 vw.n12 0.0081885
R1446 vw.n144 vw.n143 0.0081885
R1447 vw.n146 vw.n13 0.0081885
R1448 vw.n157 vw.n9 0.0081885
R1449 vw.n157 vw.n156 0.0081885
R1450 vw.n165 vw.n158 0.0081885
R1451 vw.n168 vw.n5 0.0081885
R1452 vw.n7 vw.n4 0.0081885
R1453 vw.n166 vw.n2 0.0081885
R1454 vw.n161 vw.n160 0.0081885
R1455 vw.n163 vw.n3 0.0081885
R1456 vw.n99 vw.n98 0.0081885
R1457 vw.n103 vw.n102 0.0081885
R1458 vw.n105 vw.n94 0.0081885
R1459 vw.n112 vw.n111 0.0081885
R1460 vw.n120 vw.n91 0.0081885
R1461 vw.n119 vw.n118 0.0081885
R1462 vw.n111 vw.n89 0.0081885
R1463 vw.n91 vw.n89 0.0081885
R1464 vw.n120 vw.n119 0.0081885
R1465 vw.n99 vw.n95 0.0081885
R1466 vw.n102 vw.n95 0.0081885
R1467 vw.n103 vw.n94 0.0081885
R1468 vw.n166 vw.n4 0.0081885
R1469 vw.n160 vw.n2 0.0081885
R1470 vw.n7 vw.n1 0.0081885
R1471 vw.n161 vw.n3 0.0081885
R1472 vw.n156 vw.n6 0.0081885
R1473 vw.n165 vw.n6 0.0081885
R1474 vw.n170 vw.n9 0.0081885
R1475 vw.n158 vw.n5 0.0081885
R1476 vw.n149 vw.n14 0.0081885
R1477 vw.n143 vw.n12 0.0081885
R1478 vw.n17 vw.n11 0.0081885
R1479 vw.n144 vw.n13 0.0081885
R1480 vw.n139 vw.n16 0.0081885
R1481 vw.n148 vw.n16 0.0081885
R1482 vw.n153 vw.n19 0.0081885
R1483 vw.n141 vw.n15 0.0081885
R1484 vw.n132 vw.n24 0.0081885
R1485 vw.n127 vw.n22 0.0081885
R1486 vw.n27 vw.n21 0.0081885
R1487 vw.n128 vw.n23 0.0081885
R1488 vw.n123 vw.n26 0.0081885
R1489 vw.n131 vw.n26 0.0081885
R1490 vw.n136 vw.n29 0.0081885
R1491 vw.n125 vw.n25 0.0081885
R1492 vw.n80 vw.n34 0.0081885
R1493 vw.n74 vw.n32 0.0081885
R1494 vw.n37 vw.n31 0.0081885
R1495 vw.n75 vw.n33 0.0081885
R1496 vw.n70 vw.n36 0.0081885
R1497 vw.n79 vw.n36 0.0081885
R1498 vw.n84 vw.n39 0.0081885
R1499 vw.n72 vw.n35 0.0081885
R1500 vw.n63 vw.n44 0.0081885
R1501 vw.n57 vw.n42 0.0081885
R1502 vw.n47 vw.n41 0.0081885
R1503 vw.n58 vw.n43 0.0081885
R1504 vw.n53 vw.n46 0.0081885
R1505 vw.n62 vw.n46 0.0081885
R1506 vw.n67 vw.n49 0.0081885
R1507 vw.n55 vw.n45 0.0081885
R1508 vw.n208 vw.n203 0.00717136
R1509 vw.n104 vw.n97 0.00328455
R1510 vw.n107 vw.n101 0.00328455
R1511 vw.n106 vw.n96 0.00328455
R1512 vw.n109 vw.n93 0.00328455
R1513 vw.n117 vw.n116 0.00328455
R1514 vw.n121 vw.n87 0.00328455
R1515 vw.n92 vw.n90 0.00328455
R1516 vw.n115 vw.n113 0.00328455
R1517 vw.n117 vw.n110 0.00328455
R1518 vw.n116 vw.n87 0.00328455
R1519 vw.n121 vw.n90 0.00328455
R1520 vw.n113 vw.n92 0.00328455
R1521 vw.n104 vw.n100 0.00328455
R1522 vw.n101 vw.n97 0.00328455
R1523 vw.n107 vw.n106 0.00328455
R1524 vw.n96 vw.n93 0.00328455
R1525 vw.n133 vw.n122 0.00229167
R1526 vw.n64 vw.n61 0.00211084
R1527 vw.n64 vw.n59 0.00211084
R1528 vw.n56 vw.n48 0.00211084
R1529 vw.n68 vw.n40 0.00211084
R1530 vw.n81 vw.n78 0.00211084
R1531 vw.n81 vw.n76 0.00211084
R1532 vw.n73 vw.n38 0.00211084
R1533 vw.n85 vw.n30 0.00211084
R1534 vw.n133 vw.n130 0.00211084
R1535 vw.n126 vw.n28 0.00211084
R1536 vw.n137 vw.n20 0.00211084
R1537 vw.n150 vw.n147 0.00211084
R1538 vw.n150 vw.n145 0.00211084
R1539 vw.n142 vw.n18 0.00211084
R1540 vw.n154 vw.n10 0.00211084
R1541 vw.n167 vw.n164 0.00211084
R1542 vw.n167 vw.n162 0.00211084
R1543 vw.n159 vw.n8 0.00211084
R1544 vw.n171 vw.n0 0.00211084
R1545 vw.n164 vw.n155 0.00211084
R1546 vw.n169 vw.n159 0.00211084
R1547 vw.n169 vw.n162 0.00211084
R1548 vw.n8 vw.n0 0.00211084
R1549 vw.n147 vw.n138 0.00211084
R1550 vw.n152 vw.n142 0.00211084
R1551 vw.n152 vw.n145 0.00211084
R1552 vw.n18 vw.n10 0.00211084
R1553 vw.n130 vw.n86 0.00211084
R1554 vw.n135 vw.n126 0.00211084
R1555 vw.n28 vw.n20 0.00211084
R1556 vw.n78 vw.n69 0.00211084
R1557 vw.n83 vw.n73 0.00211084
R1558 vw.n83 vw.n76 0.00211084
R1559 vw.n38 vw.n30 0.00211084
R1560 vw.n61 vw.n52 0.00211084
R1561 vw.n66 vw.n56 0.00211084
R1562 vw.n66 vw.n59 0.00211084
R1563 vw.n48 vw.n40 0.00211084
R1564 vw.n839 vw.n184 0.00100362
R1565 vw.n281 vw.n216 0.00100362
R1566 vw.n135 vw.n122 0.000930556
R1567 vw.n838 vw.n185 0.000916667
R1568 vw.n822 vw.n821 0.000916667
R1569 vb_pot.n687 vb_pot.n686 27273.1
R1570 vb_pot.n686 vb_pot.n685 16706
R1571 vb_pot.n316 vb_pot.n270 14475
R1572 vb_pot.n317 vb_pot.n316 14475
R1573 vb_pot.n684 vb_pot.n237 14000
R1574 vb_pot.n683 vb_pot.n179 14000
R1575 vb_pot.n316 vb_pot.n293 14000
R1576 vb_pot.n800 vb_pot.n270 14000
R1577 vb_pot.n717 vb_pot.n317 14000
R1578 vb_pot.n686 vb_pot.n317 12850
R1579 vb_pot.n685 vb_pot.n270 5350
R1580 vb_pot.n683 vb_pot.n682 4051.72
R1581 vb_pot.n643 vb_pot.n642 2283.78
R1582 vb_pot.n601 vb_pot.n397 2283.78
R1583 vb_pot.n684 vb_pot.n683 1970.19
R1584 vb_pot.n642 vb_pot.n641 1051.61
R1585 vb_pot.n685 vb_pot.n684 736.802
R1586 vb_pot.n837 vb_pot.n181 203.708
R1587 vb_pot.n682 vb_pot.n381 203.343
R1588 vb_pot.n442 vb_pot.n381 203.343
R1589 vb_pot.n640 vb_pot.n639 203.343
R1590 vb_pot.n639 vb_pot.n453 203.343
R1591 vb_pot.n759 vb_pot.n271 198.688
R1592 vb_pot.n641 vb_pot.n442 187.267
R1593 vb_pot.n741 vb_pot.n284 182.19
R1594 vb_pot.n687 vb_pot.n331 182.19
R1595 vb_pot.n800 vb_pot.n799 157.803
R1596 vb_pot.n842 vb_pot.n181 114.766
R1597 vb_pot.n837 vb_pot.n836 114.766
R1598 vb_pot.n226 vb_pot.n188 114.766
R1599 vb_pot.n226 vb_pot.n197 114.766
R1600 vb_pot.n828 vb_pot.n197 114.766
R1601 vb_pot.n828 vb_pot.n200 114.766
R1602 vb_pot.n235 vb_pot.n200 114.766
R1603 vb_pot.n813 vb_pot.n248 114.766
R1604 vb_pot.n254 vb_pot.n250 114.766
R1605 vb_pot.n802 vb_pot.n801 114.766
R1606 vb_pot.n742 vb_pot.n271 114.766
R1607 vb_pot.n357 vb_pot.n295 114.766
R1608 vb_pot.n724 vb_pot.n305 114.766
R1609 vb_pot.n716 vb_pot.n715 114.766
R1610 vb_pot.n819 vb_pot.n237 111.897
R1611 vb_pot.n809 vb_pot.n808 104.007
R1612 vb_pot.n789 vb_pot.n256 104.007
R1613 vb_pot.n343 vb_pot.n342 101.855
R1614 vb_pot.n733 vb_pot.n732 101.855
R1615 vb_pot.n371 vb_pot.n320 100.419
R1616 vb_pot.n371 vb_pot.n328 98.268
R1617 vb_pot.n709 vb_pot.n708 98.268
R1618 vb_pot.n789 vb_pot.n267 94.6816
R1619 vb_pot.n718 vb_pot.n717 84.6397
R1620 vb_pot.n396 vb_pot.n179 83.2051
R1621 vb_pot.n718 vb_pot.n314 74.5977
R1622 vb_pot.n812 vb_pot.n250 73.1632
R1623 vb_pot.n357 vb_pot.n351 71.0113
R1624 vb_pot.n725 vb_pot.n302 71.0113
R1625 vb_pot.n688 vb_pot.n330 68.9311
R1626 vb_pot.n707 vb_pot.n688 68.9311
R1627 vb_pot.n699 vb_pot.n332 68.9311
R1628 vb_pot.n700 vb_pot.n699 68.9311
R1629 vb_pot.n303 vb_pot.n301 68.9311
R1630 vb_pot.n726 vb_pot.n301 68.9311
R1631 vb_pot.n731 vb_pot.n297 68.9311
R1632 vb_pot.n731 vb_pot.n296 68.9311
R1633 vb_pot.n283 vb_pot.n277 68.9311
R1634 vb_pot.n743 vb_pot.n277 68.9311
R1635 vb_pot.n758 vb_pot.n273 68.9311
R1636 vb_pot.n758 vb_pot.n272 68.9311
R1637 vb_pot.n748 vb_pot.n275 68.9311
R1638 vb_pot.n275 vb_pot.n252 68.9311
R1639 vb_pot.n811 vb_pot.n810 68.9311
R1640 vb_pot.n811 vb_pot.n251 68.9311
R1641 vb_pot.n821 vb_pot.n202 67.7644
R1642 vb_pot.n821 vb_pot.n234 67.7644
R1643 vb_pot.n838 vb_pot.n187 67.7644
R1644 vb_pot.n838 vb_pot.n186 67.7644
R1645 vb_pot.n843 vb_pot.n842 67.4249
R1646 vb_pot.n836 vb_pot.n188 67.4249
R1647 vb_pot.n820 vb_pot.n235 67.4249
R1648 vb_pot.n380 vb_pot.n333 66.6949
R1649 vb_pot.n380 vb_pot.n327 66.6949
R1650 vb_pot.n740 vb_pot.n286 66.6949
R1651 vb_pot.n740 vb_pot.n285 66.6949
R1652 vb_pot.n798 vb_pot.n269 66.6949
R1653 vb_pot.n798 vb_pot.n266 66.6949
R1654 vb_pot.n835 vb_pot.n190 66.6949
R1655 vb_pot.n835 vb_pot.n189 66.6949
R1656 vb_pot.n516 vb_pot.n452 66.6949
R1657 vb_pot.n523 vb_pot.n452 66.6949
R1658 vb_pot.n548 vb_pot.n455 66.6949
R1659 vb_pot.n548 vb_pot.n454 66.6949
R1660 vb_pot.n841 vb_pot.n182 66.6949
R1661 vb_pot.n841 vb_pot.n183 66.6949
R1662 vb_pot.n441 vb_pot.n384 66.6949
R1663 vb_pot.n681 vb_pot.n384 66.6949
R1664 vb_pot.n180 vb_pot.n178 66.6949
R1665 vb_pot.n844 vb_pot.n178 66.6949
R1666 vb_pot.n638 vb_pot.n550 66.6949
R1667 vb_pot.n638 vb_pot.n549 66.6949
R1668 vb_pot.n343 vb_pot.n293 57.383
R1669 vb_pot.n733 vb_pot.n293 57.383
R1670 vb_pot.n820 vb_pot.n819 47.341
R1671 vb_pot.n115 vb_pot.n114 45.5355
R1672 vb_pot.n351 vb_pot.n302 43.7546
R1673 vb_pot.n725 vb_pot.n724 43.7546
R1674 vb_pot.n813 vb_pot.n812 41.6028
R1675 vb_pot.n314 vb_pot.n305 40.1682
R1676 vb_pot.n641 vb_pot.n397 31.7197
R1677 vb_pot.n843 vb_pot.n179 31.5609
R1678 vb_pot.n717 vb_pot.n716 30.1263
R1679 vb_pot.n801 vb_pot.n800 24.3881
R1680 vb_pot.n802 vb_pot.n267 20.0844
R1681 vb_pot.n299 vb_pot.n298 19.4509
R1682 vb_pot.n51 vb_pot.n50 17.8359
R1683 vb_pot.n51 vw 16.6847
R1684 vb_pot.n709 vb_pot.n328 16.498
R1685 vb_pot.n708 vb_pot.n331 16.498
R1686 vb_pot.n707 vb_pot.n332 15.5561
R1687 vb_pot.n700 vb_pot.n330 15.5561
R1688 vb_pot.n726 vb_pot.n297 15.5561
R1689 vb_pot.n303 vb_pot.n296 15.5561
R1690 vb_pot.n743 vb_pot.n273 15.5561
R1691 vb_pot.n283 vb_pot.n272 15.5561
R1692 vb_pot.n810 vb_pot.n252 15.5561
R1693 vb_pot.n748 vb_pot.n251 15.5561
R1694 vb_pot.n289 vb_pot.n286 15.5561
R1695 vb_pot.n734 vb_pot.n289 15.5561
R1696 vb_pot.n734 vb_pot.n292 15.5561
R1697 vb_pot.n356 vb_pot.n292 15.5561
R1698 vb_pot.n356 vb_pot.n306 15.5561
R1699 vb_pot.n723 vb_pot.n306 15.5561
R1700 vb_pot.n723 vb_pot.n307 15.5561
R1701 vb_pot.n719 vb_pot.n307 15.5561
R1702 vb_pot.n719 vb_pot.n313 15.5561
R1703 vb_pot.n714 vb_pot.n313 15.5561
R1704 vb_pot.n714 vb_pot.n321 15.5561
R1705 vb_pot.n710 vb_pot.n321 15.5561
R1706 vb_pot.n710 vb_pot.n327 15.5561
R1707 vb_pot.n344 vb_pot.n285 15.5561
R1708 vb_pot.n344 vb_pot.n294 15.5561
R1709 vb_pot.n350 vb_pot.n294 15.5561
R1710 vb_pot.n358 vb_pot.n350 15.5561
R1711 vb_pot.n359 vb_pot.n358 15.5561
R1712 vb_pot.n359 vb_pot.n304 15.5561
R1713 vb_pot.n364 vb_pot.n304 15.5561
R1714 vb_pot.n364 vb_pot.n315 15.5561
R1715 vb_pot.n318 vb_pot.n315 15.5561
R1716 vb_pot.n319 vb_pot.n318 15.5561
R1717 vb_pot.n372 vb_pot.n319 15.5561
R1718 vb_pot.n372 vb_pot.n329 15.5561
R1719 vb_pot.n333 vb_pot.n329 15.5561
R1720 vb_pot.n193 vb_pot.n190 15.5561
R1721 vb_pot.n829 vb_pot.n193 15.5561
R1722 vb_pot.n829 vb_pot.n196 15.5561
R1723 vb_pot.n238 vb_pot.n196 15.5561
R1724 vb_pot.n818 vb_pot.n238 15.5561
R1725 vb_pot.n818 vb_pot.n239 15.5561
R1726 vb_pot.n814 vb_pot.n239 15.5561
R1727 vb_pot.n814 vb_pot.n247 15.5561
R1728 vb_pot.n257 vb_pot.n247 15.5561
R1729 vb_pot.n807 vb_pot.n257 15.5561
R1730 vb_pot.n807 vb_pot.n258 15.5561
R1731 vb_pot.n803 vb_pot.n258 15.5561
R1732 vb_pot.n803 vb_pot.n266 15.5561
R1733 vb_pot.n768 vb_pot.n189 15.5561
R1734 vb_pot.n768 vb_pot.n199 15.5561
R1735 vb_pot.n774 vb_pot.n199 15.5561
R1736 vb_pot.n775 vb_pot.n774 15.5561
R1737 vb_pot.n775 vb_pot.n236 15.5561
R1738 vb_pot.n763 vb_pot.n236 15.5561
R1739 vb_pot.n763 vb_pot.n249 15.5561
R1740 vb_pot.n783 vb_pot.n249 15.5561
R1741 vb_pot.n784 vb_pot.n783 15.5561
R1742 vb_pot.n784 vb_pot.n255 15.5561
R1743 vb_pot.n790 vb_pot.n255 15.5561
R1744 vb_pot.n790 vb_pot.n268 15.5561
R1745 vb_pot.n269 vb_pot.n268 15.5561
R1746 vb_pot.n542 vb_pot.n459 15.5561
R1747 vb_pot.n540 vb_pot.n539 15.5561
R1748 vb_pot.n537 vb_pot.n463 15.5561
R1749 vb_pot.n533 vb_pot.n532 15.5561
R1750 vb_pot.n530 vb_pot.n471 15.5561
R1751 vb_pot.n526 vb_pot.n525 15.5561
R1752 vb_pot.n487 vb_pot.n486 15.5561
R1753 vb_pot.n494 vb_pot.n493 15.5561
R1754 vb_pot.n497 vb_pot.n496 15.5561
R1755 vb_pot.n504 vb_pot.n503 15.5561
R1756 vb_pot.n507 vb_pot.n506 15.5561
R1757 vb_pot.n514 vb_pot.n513 15.5561
R1758 vb_pot.n441 vb_pot.n400 15.5561
R1759 vb_pot.n434 vb_pot.n433 15.5561
R1760 vb_pot.n431 vb_pot.n430 15.5561
R1761 vb_pot.n427 vb_pot.n426 15.5561
R1762 vb_pot.n423 vb_pot.n422 15.5561
R1763 vb_pot.n419 vb_pot.n418 15.5561
R1764 vb_pot.n415 vb_pot.n183 15.5561
R1765 vb_pot.n681 vb_pot.n385 15.5561
R1766 vb_pot.n677 vb_pot.n676 15.5561
R1767 vb_pot.n673 vb_pot.n672 15.5561
R1768 vb_pot.n670 vb_pot.n644 15.5561
R1769 vb_pot.n666 vb_pot.n665 15.5561
R1770 vb_pot.n663 vb_pot.n651 15.5561
R1771 vb_pot.n659 vb_pot.n182 15.5561
R1772 vb_pot.n632 vb_pot.n597 15.5561
R1773 vb_pot.n630 vb_pot.n629 15.5561
R1774 vb_pot.n627 vb_pot.n602 15.5561
R1775 vb_pot.n623 vb_pot.n622 15.5561
R1776 vb_pot.n620 vb_pot.n610 15.5561
R1777 vb_pot.n616 vb_pot.n177 15.5561
R1778 vb_pot.n844 vb_pot.n177 15.5561
R1779 vb_pot.n591 vb_pot.n590 15.5561
R1780 vb_pot.n587 vb_pot.n586 15.5561
R1781 vb_pot.n584 vb_pot.n555 15.5561
R1782 vb_pot.n580 vb_pot.n579 15.5561
R1783 vb_pot.n577 vb_pot.n562 15.5561
R1784 vb_pot.n573 vb_pot.n572 15.5561
R1785 vb_pot.n572 vb_pot.n180 15.5561
R1786 vb_pot.n227 vb_pot.n187 15.5561
R1787 vb_pot.n227 vb_pot.n220 15.5561
R1788 vb_pot.n220 vb_pot.n198 15.5561
R1789 vb_pot.n234 vb_pot.n198 15.5561
R1790 vb_pot.n225 vb_pot.n186 15.5561
R1791 vb_pot.n225 vb_pot.n201 15.5561
R1792 vb_pot.n827 vb_pot.n201 15.5561
R1793 vb_pot.n827 vb_pot.n202 15.5561
R1794 vb_pot.n715 vb_pot.n320 14.3461
R1795 vb_pot.n213 vb_pot.n210 13.589
R1796 vb_pot.n52 vb_pot.n51 13.1971
R1797 vb_pot.n342 vb_pot.n284 12.9116
R1798 vb_pot.n732 vb_pot.n295 12.9116
R1799 vb_pot.n809 vb_pot.n254 10.7597
R1800 vb_pot.n808 vb_pot.n256 10.7597
R1801 vb_pot.n641 vb_pot.n396 10.0424
R1802 vb_pot.n216 vb_pot.n185 9.8159
R1803 vb_pot.n216 vb_pot.n215 9.1923
R1804 vb_pot.n215 vb_pot.n214 9.1923
R1805 vb_pot.n378 vb_pot.n173 6.57316
R1806 vb_pot.n641 vb_pot.n640 5.6489
R1807 vb_pot.n796 vb_pot.n173 5.20876
R1808 vb_pot.n520 vb_pot.n172 5.20876
R1809 vb_pot.n848 vb_pot.n847 5.20876
R1810 vb_pot.n574 vb_pot.n573 5.2005
R1811 vb_pot.n575 vb_pot.n562 5.2005
R1812 vb_pot.n577 vb_pot.n576 5.2005
R1813 vb_pot.n579 vb_pot.n560 5.2005
R1814 vb_pot.n581 vb_pot.n580 5.2005
R1815 vb_pot.n582 vb_pot.n555 5.2005
R1816 vb_pot.n584 vb_pot.n583 5.2005
R1817 vb_pot.n586 vb_pot.n554 5.2005
R1818 vb_pot.n617 vb_pot.n616 5.2005
R1819 vb_pot.n618 vb_pot.n610 5.2005
R1820 vb_pot.n620 vb_pot.n619 5.2005
R1821 vb_pot.n622 vb_pot.n608 5.2005
R1822 vb_pot.n624 vb_pot.n623 5.2005
R1823 vb_pot.n625 vb_pot.n602 5.2005
R1824 vb_pot.n627 vb_pot.n626 5.2005
R1825 vb_pot.n629 vb_pot.n600 5.2005
R1826 vb_pot.n660 vb_pot.n659 5.2005
R1827 vb_pot.n661 vb_pot.n651 5.2005
R1828 vb_pot.n663 vb_pot.n662 5.2005
R1829 vb_pot.n665 vb_pot.n649 5.2005
R1830 vb_pot.n667 vb_pot.n666 5.2005
R1831 vb_pot.n668 vb_pot.n644 5.2005
R1832 vb_pot.n670 vb_pot.n669 5.2005
R1833 vb_pot.n672 vb_pot.n391 5.2005
R1834 vb_pot.n416 vb_pot.n415 5.2005
R1835 vb_pot.n418 vb_pot.n417 5.2005
R1836 vb_pot.n420 vb_pot.n419 5.2005
R1837 vb_pot.n422 vb_pot.n421 5.2005
R1838 vb_pot.n424 vb_pot.n423 5.2005
R1839 vb_pot.n426 vb_pot.n425 5.2005
R1840 vb_pot.n428 vb_pot.n427 5.2005
R1841 vb_pot.n430 vb_pot.n429 5.2005
R1842 vb_pot.n517 vb_pot.n516 5.2005
R1843 vb_pot.n515 vb_pot.n514 5.2005
R1844 vb_pot.n513 vb_pot.n512 5.2005
R1845 vb_pot.n506 vb_pot.n480 5.2005
R1846 vb_pot.n508 vb_pot.n507 5.2005
R1847 vb_pot.n505 vb_pot.n504 5.2005
R1848 vb_pot.n503 vb_pot.n502 5.2005
R1849 vb_pot.n496 vb_pot.n482 5.2005
R1850 vb_pot.n498 vb_pot.n497 5.2005
R1851 vb_pot.n495 vb_pot.n494 5.2005
R1852 vb_pot.n493 vb_pot.n492 5.2005
R1853 vb_pot.n486 vb_pot.n484 5.2005
R1854 vb_pot.n488 vb_pot.n487 5.2005
R1855 vb_pot.n485 vb_pot.n454 5.2005
R1856 vb_pot.n523 vb_pot.n522 5.2005
R1857 vb_pot.n525 vb_pot.n476 5.2005
R1858 vb_pot.n527 vb_pot.n526 5.2005
R1859 vb_pot.n528 vb_pot.n471 5.2005
R1860 vb_pot.n530 vb_pot.n529 5.2005
R1861 vb_pot.n532 vb_pot.n469 5.2005
R1862 vb_pot.n534 vb_pot.n533 5.2005
R1863 vb_pot.n535 vb_pot.n463 5.2005
R1864 vb_pot.n537 vb_pot.n536 5.2005
R1865 vb_pot.n539 vb_pot.n462 5.2005
R1866 vb_pot.n540 vb_pot.n461 5.2005
R1867 vb_pot.n543 vb_pot.n542 5.2005
R1868 vb_pot.n544 vb_pot.n459 5.2005
R1869 vb_pot.n545 vb_pot.n455 5.2005
R1870 vb_pot.n588 vb_pot.n587 5.2005
R1871 vb_pot.n590 vb_pot.n589 5.2005
R1872 vb_pot.n592 vb_pot.n591 5.2005
R1873 vb_pot.n593 vb_pot.n549 5.2005
R1874 vb_pot.n630 vb_pot.n599 5.2005
R1875 vb_pot.n633 vb_pot.n632 5.2005
R1876 vb_pot.n634 vb_pot.n597 5.2005
R1877 vb_pot.n635 vb_pot.n550 5.2005
R1878 vb_pot.n674 vb_pot.n673 5.2005
R1879 vb_pot.n676 vb_pot.n675 5.2005
R1880 vb_pot.n678 vb_pot.n677 5.2005
R1881 vb_pot.n679 vb_pot.n385 5.2005
R1882 vb_pot.n681 vb_pot.n680 5.2005
R1883 vb_pot.n682 vb_pot.n681 5.2005
R1884 vb_pot.n432 vb_pot.n431 5.2005
R1885 vb_pot.n435 vb_pot.n434 5.2005
R1886 vb_pot.n433 vb_pot.n403 5.2005
R1887 vb_pot.n439 vb_pot.n400 5.2005
R1888 vb_pot.n441 vb_pot.n440 5.2005
R1889 vb_pot.n442 vb_pot.n441 5.2005
R1890 vb_pot.n569 vb_pot.n180 5.2005
R1891 vb_pot.n843 vb_pot.n180 5.2005
R1892 vb_pot.n572 vb_pot.n570 5.2005
R1893 vb_pot.n572 vb_pot.n396 5.2005
R1894 vb_pot.n845 vb_pot.n844 5.2005
R1895 vb_pot.n844 vb_pot.n843 5.2005
R1896 vb_pot.n177 vb_pot.n176 5.2005
R1897 vb_pot.n396 vb_pot.n177 5.2005
R1898 vb_pot.n793 vb_pot.n269 5.2005
R1899 vb_pot.n801 vb_pot.n269 5.2005
R1900 vb_pot.n792 vb_pot.n268 5.2005
R1901 vb_pot.n802 vb_pot.n268 5.2005
R1902 vb_pot.n791 vb_pot.n790 5.2005
R1903 vb_pot.n790 vb_pot.n789 5.2005
R1904 vb_pot.n761 vb_pot.n255 5.2005
R1905 vb_pot.n808 vb_pot.n255 5.2005
R1906 vb_pot.n785 vb_pot.n784 5.2005
R1907 vb_pot.n784 vb_pot.n254 5.2005
R1908 vb_pot.n783 vb_pot.n782 5.2005
R1909 vb_pot.n783 vb_pot.n250 5.2005
R1910 vb_pot.n781 vb_pot.n249 5.2005
R1911 vb_pot.n813 vb_pot.n249 5.2005
R1912 vb_pot.n764 vb_pot.n763 5.2005
R1913 vb_pot.n763 vb_pot.n248 5.2005
R1914 vb_pot.n777 vb_pot.n236 5.2005
R1915 vb_pot.n819 vb_pot.n236 5.2005
R1916 vb_pot.n776 vb_pot.n775 5.2005
R1917 vb_pot.n775 vb_pot.n235 5.2005
R1918 vb_pot.n774 vb_pot.n773 5.2005
R1919 vb_pot.n774 vb_pot.n200 5.2005
R1920 vb_pot.n766 vb_pot.n199 5.2005
R1921 vb_pot.n828 vb_pot.n199 5.2005
R1922 vb_pot.n769 vb_pot.n768 5.2005
R1923 vb_pot.n768 vb_pot.n197 5.2005
R1924 vb_pot.n767 vb_pot.n189 5.2005
R1925 vb_pot.n226 vb_pot.n189 5.2005
R1926 vb_pot.n266 vb_pot.n265 5.2005
R1927 vb_pot.n801 vb_pot.n266 5.2005
R1928 vb_pot.n804 vb_pot.n803 5.2005
R1929 vb_pot.n803 vb_pot.n802 5.2005
R1930 vb_pot.n805 vb_pot.n258 5.2005
R1931 vb_pot.n789 vb_pot.n258 5.2005
R1932 vb_pot.n807 vb_pot.n806 5.2005
R1933 vb_pot.n808 vb_pot.n807 5.2005
R1934 vb_pot.n259 vb_pot.n257 5.2005
R1935 vb_pot.n257 vb_pot.n254 5.2005
R1936 vb_pot.n247 vb_pot.n246 5.2005
R1937 vb_pot.n250 vb_pot.n247 5.2005
R1938 vb_pot.n815 vb_pot.n814 5.2005
R1939 vb_pot.n814 vb_pot.n813 5.2005
R1940 vb_pot.n816 vb_pot.n239 5.2005
R1941 vb_pot.n248 vb_pot.n239 5.2005
R1942 vb_pot.n818 vb_pot.n817 5.2005
R1943 vb_pot.n819 vb_pot.n818 5.2005
R1944 vb_pot.n240 vb_pot.n238 5.2005
R1945 vb_pot.n238 vb_pot.n235 5.2005
R1946 vb_pot.n196 vb_pot.n195 5.2005
R1947 vb_pot.n200 vb_pot.n196 5.2005
R1948 vb_pot.n830 vb_pot.n829 5.2005
R1949 vb_pot.n829 vb_pot.n828 5.2005
R1950 vb_pot.n831 vb_pot.n193 5.2005
R1951 vb_pot.n197 vb_pot.n193 5.2005
R1952 vb_pot.n832 vb_pot.n190 5.2005
R1953 vb_pot.n226 vb_pot.n190 5.2005
R1954 vb_pot.n375 vb_pot.n333 5.2005
R1955 vb_pot.n333 vb_pot.n331 5.2005
R1956 vb_pot.n374 vb_pot.n329 5.2005
R1957 vb_pot.n709 vb_pot.n329 5.2005
R1958 vb_pot.n373 vb_pot.n372 5.2005
R1959 vb_pot.n372 vb_pot.n371 5.2005
R1960 vb_pot.n335 vb_pot.n319 5.2005
R1961 vb_pot.n715 vb_pot.n319 5.2005
R1962 vb_pot.n367 vb_pot.n318 5.2005
R1963 vb_pot.n716 vb_pot.n318 5.2005
R1964 vb_pot.n366 vb_pot.n315 5.2005
R1965 vb_pot.n718 vb_pot.n315 5.2005
R1966 vb_pot.n365 vb_pot.n364 5.2005
R1967 vb_pot.n364 vb_pot.n305 5.2005
R1968 vb_pot.n337 vb_pot.n304 5.2005
R1969 vb_pot.n724 vb_pot.n304 5.2005
R1970 vb_pot.n360 vb_pot.n359 5.2005
R1971 vb_pot.n359 vb_pot.n302 5.2005
R1972 vb_pot.n358 vb_pot.n339 5.2005
R1973 vb_pot.n358 vb_pot.n357 5.2005
R1974 vb_pot.n350 vb_pot.n349 5.2005
R1975 vb_pot.n350 vb_pot.n295 5.2005
R1976 vb_pot.n340 vb_pot.n294 5.2005
R1977 vb_pot.n733 vb_pot.n294 5.2005
R1978 vb_pot.n345 vb_pot.n344 5.2005
R1979 vb_pot.n344 vb_pot.n343 5.2005
R1980 vb_pot.n341 vb_pot.n285 5.2005
R1981 vb_pot.n285 vb_pot.n284 5.2005
R1982 vb_pot.n327 vb_pot.n326 5.2005
R1983 vb_pot.n331 vb_pot.n327 5.2005
R1984 vb_pot.n711 vb_pot.n710 5.2005
R1985 vb_pot.n710 vb_pot.n709 5.2005
R1986 vb_pot.n712 vb_pot.n321 5.2005
R1987 vb_pot.n371 vb_pot.n321 5.2005
R1988 vb_pot.n714 vb_pot.n713 5.2005
R1989 vb_pot.n715 vb_pot.n714 5.2005
R1990 vb_pot.n313 vb_pot.n312 5.2005
R1991 vb_pot.n716 vb_pot.n313 5.2005
R1992 vb_pot.n720 vb_pot.n719 5.2005
R1993 vb_pot.n719 vb_pot.n718 5.2005
R1994 vb_pot.n721 vb_pot.n307 5.2005
R1995 vb_pot.n307 vb_pot.n305 5.2005
R1996 vb_pot.n723 vb_pot.n722 5.2005
R1997 vb_pot.n724 vb_pot.n723 5.2005
R1998 vb_pot.n308 vb_pot.n306 5.2005
R1999 vb_pot.n306 vb_pot.n302 5.2005
R2000 vb_pot.n356 vb_pot.n355 5.2005
R2001 vb_pot.n357 vb_pot.n356 5.2005
R2002 vb_pot.n292 vb_pot.n291 5.2005
R2003 vb_pot.n295 vb_pot.n292 5.2005
R2004 vb_pot.n735 vb_pot.n734 5.2005
R2005 vb_pot.n734 vb_pot.n733 5.2005
R2006 vb_pot.n736 vb_pot.n289 5.2005
R2007 vb_pot.n343 vb_pot.n289 5.2005
R2008 vb_pot.n737 vb_pot.n286 5.2005
R2009 vb_pot.n286 vb_pot.n284 5.2005
R2010 vb_pot.n657 vb_pot.n182 5.2005
R2011 vb_pot.n396 vb_pot.n182 5.2005
R2012 vb_pot.n414 vb_pot.n183 5.2005
R2013 vb_pot.n396 vb_pot.n183 5.2005
R2014 vb_pot.n749 vb_pot.n748 5.2005
R2015 vb_pot.n748 vb_pot.n256 5.2005
R2016 vb_pot.n750 vb_pot.n251 5.2005
R2017 vb_pot.n809 vb_pot.n251 5.2005
R2018 vb_pot.n754 vb_pot.n252 5.2005
R2019 vb_pot.n256 vb_pot.n252 5.2005
R2020 vb_pot.n810 vb_pot.n253 5.2005
R2021 vb_pot.n810 vb_pot.n809 5.2005
R2022 vb_pot.n283 vb_pot.n282 5.2005
R2023 vb_pot.n742 vb_pot.n283 5.2005
R2024 vb_pot.n278 vb_pot.n272 5.2005
R2025 vb_pot.n272 vb_pot.n271 5.2005
R2026 vb_pot.n744 vb_pot.n743 5.2005
R2027 vb_pot.n743 vb_pot.n742 5.2005
R2028 vb_pot.n745 vb_pot.n273 5.2005
R2029 vb_pot.n273 vb_pot.n271 5.2005
R2030 vb_pot.n694 vb_pot.n303 5.2005
R2031 vb_pot.n725 vb_pot.n303 5.2005
R2032 vb_pot.n693 vb_pot.n296 5.2005
R2033 vb_pot.n351 vb_pot.n296 5.2005
R2034 vb_pot.n727 vb_pot.n726 5.2005
R2035 vb_pot.n726 vb_pot.n725 5.2005
R2036 vb_pot.n728 vb_pot.n297 5.2005
R2037 vb_pot.n351 vb_pot.n297 5.2005
R2038 vb_pot.n702 vb_pot.n330 5.2005
R2039 vb_pot.n708 vb_pot.n330 5.2005
R2040 vb_pot.n701 vb_pot.n700 5.2005
R2041 vb_pot.n700 vb_pot.n328 5.2005
R2042 vb_pot.n707 vb_pot.n706 5.2005
R2043 vb_pot.n708 vb_pot.n707 5.2005
R2044 vb_pot.n689 vb_pot.n332 5.2005
R2045 vb_pot.n332 vb_pot.n328 5.2005
R2046 vb_pot.n234 vb_pot.n233 5.2005
R2047 vb_pot.n234 vb_pot.n200 5.2005
R2048 vb_pot.n232 vb_pot.n198 5.2005
R2049 vb_pot.n828 vb_pot.n198 5.2005
R2050 vb_pot.n220 vb_pot.n203 5.2005
R2051 vb_pot.n220 vb_pot.n197 5.2005
R2052 vb_pot.n228 vb_pot.n227 5.2005
R2053 vb_pot.n227 vb_pot.n226 5.2005
R2054 vb_pot.n219 vb_pot.n187 5.2005
R2055 vb_pot.n188 vb_pot.n187 5.2005
R2056 vb_pot.n204 vb_pot.n202 5.2005
R2057 vb_pot.n202 vb_pot.n200 5.2005
R2058 vb_pot.n827 vb_pot.n826 5.2005
R2059 vb_pot.n828 vb_pot.n827 5.2005
R2060 vb_pot.n203 vb_pot.n201 5.2005
R2061 vb_pot.n201 vb_pot.n197 5.2005
R2062 vb_pot.n225 vb_pot.n224 5.2005
R2063 vb_pot.n226 vb_pot.n225 5.2005
R2064 vb_pot.n221 vb_pot.n186 5.2005
R2065 vb_pot.n188 vb_pot.n186 5.2005
R2066 vb_pot.n705 vb_pot.n704 5.20011
R2067 vb_pot.n704 vb_pot.n703 5.20011
R2068 vb_pot.n730 vb_pot.n729 5.20011
R2069 vb_pot.n281 vb_pot.n280 5.20011
R2070 vb_pot.n280 vb_pot.n276 5.20011
R2071 vb_pot.n402 vb_pot.n401 5.17941
R2072 vb_pot.n401 vb_pot.n386 5.17941
R2073 vb_pot.n568 vb_pot.n174 5.17941
R2074 vb_pot.n739 vb_pot.n738 5.17941
R2075 vb_pot.n739 vb_pot.n287 5.17941
R2076 vb_pot.n379 vb_pot.n376 5.17941
R2077 vb_pot.n834 vb_pot.n833 5.17941
R2078 vb_pot.n834 vb_pot.n191 5.17941
R2079 vb_pot.n797 vb_pot.n794 5.17941
R2080 vb_pot.n547 vb_pot.n546 5.17941
R2081 vb_pot.n519 vb_pot.n518 5.17941
R2082 vb_pot.n637 vb_pot.n636 5.17941
R2083 vb_pot.n637 vb_pot.n594 5.17941
R2084 vb_pot.n547 vb_pot.n456 5.17159
R2085 vb_pot.n692 vb_pot.n299 5.07
R2086 vb_pot.n210 vb_pot.n209 5.03258
R2087 vb_pot.n172 vb_pot.n171 4.95493
R2088 vb_pot.n218 vb_pot.n185 4.7678
R2089 vb_pot.n222 vb_pot.n185 4.7678
R2090 vb_pot.n824 vb_pot.n823 4.7678
R2091 vb_pot.n823 vb_pot.n206 4.7678
R2092 vb_pot.n752 vb_pot.n751 4.75185
R2093 vb_pot.n697 vb_pot.n690 4.75136
R2094 vb_pot.n696 vb_pot.n691 4.75136
R2095 vb_pot.n279 vb_pot.n274 4.75136
R2096 vb_pot.n756 vb_pot.n746 4.75136
R2097 vb_pot.n696 vb_pot.n695 4.75135
R2098 vb_pot.n697 vb_pot.n300 4.75135
R2099 vb_pot.n756 vb_pot.n755 4.75135
R2100 vb_pot.n747 vb_pot.n274 4.75135
R2101 vb_pot.n753 vb_pot.n752 4.75085
R2102 vb_pot.n656 vb_pot.n184 4.73115
R2103 vb_pot.n413 vb_pot.n184 4.73015
R2104 vb_pot.n378 vb_pot.n377 4.7255
R2105 vb_pot.n796 vb_pot.n795 4.7255
R2106 vb_pot.n521 vb_pot.n520 4.7255
R2107 vb_pot.n847 vb_pot.n846 4.7255
R2108 vb_pot.n211 vb_pot.n207 4.6445
R2109 vb_pot.n212 vw 4.6085
R2110 vb_pot.n706 vb_pot.n705 4.5005
R2111 vb_pot.n690 vb_pot.n689 4.5005
R2112 vb_pot.n703 vb_pot.n702 4.5005
R2113 vb_pot.n701 vb_pot.n691 4.5005
R2114 vb_pot.n727 vb_pot.n300 4.5005
R2115 vb_pot.n729 vb_pot.n728 4.5005
R2116 vb_pot.n695 vb_pot.n694 4.5005
R2117 vb_pot.n693 vb_pot.n692 4.5005
R2118 vb_pot.n755 vb_pot.n754 4.5005
R2119 vb_pot.n753 vb_pot.n253 4.5005
R2120 vb_pot.n282 vb_pot.n281 4.5005
R2121 vb_pot.n279 vb_pot.n278 4.5005
R2122 vb_pot.n744 vb_pot.n276 4.5005
R2123 vb_pot.n746 vb_pot.n745 4.5005
R2124 vb_pot.n749 vb_pot.n747 4.5005
R2125 vb_pot.n751 vb_pot.n750 4.5005
R2126 vb_pot.n439 vb_pot.n438 4.5005
R2127 vb_pot.n437 vb_pot.n403 4.5005
R2128 vb_pot.n436 vb_pot.n435 4.5005
R2129 vb_pot.n432 vb_pot.n404 4.5005
R2130 vb_pot.n429 vb_pot.n405 4.5005
R2131 vb_pot.n428 vb_pot.n406 4.5005
R2132 vb_pot.n425 vb_pot.n407 4.5005
R2133 vb_pot.n424 vb_pot.n408 4.5005
R2134 vb_pot.n421 vb_pot.n409 4.5005
R2135 vb_pot.n420 vb_pot.n410 4.5005
R2136 vb_pot.n417 vb_pot.n411 4.5005
R2137 vb_pot.n416 vb_pot.n412 4.5005
R2138 vb_pot.n414 vb_pot.n413 4.5005
R2139 vb_pot.n440 vb_pot.n402 4.5005
R2140 vb_pot.n679 vb_pot.n387 4.5005
R2141 vb_pot.n678 vb_pot.n388 4.5005
R2142 vb_pot.n675 vb_pot.n389 4.5005
R2143 vb_pot.n674 vb_pot.n390 4.5005
R2144 vb_pot.n645 vb_pot.n391 4.5005
R2145 vb_pot.n669 vb_pot.n646 4.5005
R2146 vb_pot.n668 vb_pot.n647 4.5005
R2147 vb_pot.n667 vb_pot.n648 4.5005
R2148 vb_pot.n652 vb_pot.n649 4.5005
R2149 vb_pot.n662 vb_pot.n653 4.5005
R2150 vb_pot.n661 vb_pot.n654 4.5005
R2151 vb_pot.n660 vb_pot.n655 4.5005
R2152 vb_pot.n657 vb_pot.n656 4.5005
R2153 vb_pot.n680 vb_pot.n386 4.5005
R2154 vb_pot.n736 vb_pot.n288 4.5005
R2155 vb_pot.n735 vb_pot.n290 4.5005
R2156 vb_pot.n352 vb_pot.n291 4.5005
R2157 vb_pot.n355 vb_pot.n354 4.5005
R2158 vb_pot.n353 vb_pot.n308 4.5005
R2159 vb_pot.n722 vb_pot.n309 4.5005
R2160 vb_pot.n721 vb_pot.n310 4.5005
R2161 vb_pot.n720 vb_pot.n311 4.5005
R2162 vb_pot.n322 vb_pot.n312 4.5005
R2163 vb_pot.n713 vb_pot.n323 4.5005
R2164 vb_pot.n712 vb_pot.n324 4.5005
R2165 vb_pot.n711 vb_pot.n325 4.5005
R2166 vb_pot.n377 vb_pot.n326 4.5005
R2167 vb_pot.n738 vb_pot.n737 4.5005
R2168 vb_pot.n346 vb_pot.n345 4.5005
R2169 vb_pot.n347 vb_pot.n340 4.5005
R2170 vb_pot.n349 vb_pot.n348 4.5005
R2171 vb_pot.n339 vb_pot.n338 4.5005
R2172 vb_pot.n361 vb_pot.n360 4.5005
R2173 vb_pot.n362 vb_pot.n337 4.5005
R2174 vb_pot.n365 vb_pot.n363 4.5005
R2175 vb_pot.n366 vb_pot.n336 4.5005
R2176 vb_pot.n368 vb_pot.n367 4.5005
R2177 vb_pot.n369 vb_pot.n335 4.5005
R2178 vb_pot.n373 vb_pot.n370 4.5005
R2179 vb_pot.n374 vb_pot.n334 4.5005
R2180 vb_pot.n376 vb_pot.n375 4.5005
R2181 vb_pot.n341 vb_pot.n287 4.5005
R2182 vb_pot.n831 vb_pot.n192 4.5005
R2183 vb_pot.n830 vb_pot.n194 4.5005
R2184 vb_pot.n241 vb_pot.n195 4.5005
R2185 vb_pot.n242 vb_pot.n240 4.5005
R2186 vb_pot.n817 vb_pot.n243 4.5005
R2187 vb_pot.n816 vb_pot.n244 4.5005
R2188 vb_pot.n815 vb_pot.n245 4.5005
R2189 vb_pot.n260 vb_pot.n246 4.5005
R2190 vb_pot.n261 vb_pot.n259 4.5005
R2191 vb_pot.n806 vb_pot.n262 4.5005
R2192 vb_pot.n805 vb_pot.n263 4.5005
R2193 vb_pot.n804 vb_pot.n264 4.5005
R2194 vb_pot.n795 vb_pot.n265 4.5005
R2195 vb_pot.n833 vb_pot.n832 4.5005
R2196 vb_pot.n770 vb_pot.n769 4.5005
R2197 vb_pot.n771 vb_pot.n766 4.5005
R2198 vb_pot.n773 vb_pot.n772 4.5005
R2199 vb_pot.n776 vb_pot.n765 4.5005
R2200 vb_pot.n778 vb_pot.n777 4.5005
R2201 vb_pot.n779 vb_pot.n764 4.5005
R2202 vb_pot.n781 vb_pot.n780 4.5005
R2203 vb_pot.n782 vb_pot.n762 4.5005
R2204 vb_pot.n786 vb_pot.n785 4.5005
R2205 vb_pot.n787 vb_pot.n761 4.5005
R2206 vb_pot.n791 vb_pot.n788 4.5005
R2207 vb_pot.n792 vb_pot.n760 4.5005
R2208 vb_pot.n794 vb_pot.n793 4.5005
R2209 vb_pot.n767 vb_pot.n191 4.5005
R2210 vb_pot.n544 vb_pot.n457 4.5005
R2211 vb_pot.n543 vb_pot.n460 4.5005
R2212 vb_pot.n464 vb_pot.n461 4.5005
R2213 vb_pot.n465 vb_pot.n462 4.5005
R2214 vb_pot.n536 vb_pot.n466 4.5005
R2215 vb_pot.n535 vb_pot.n467 4.5005
R2216 vb_pot.n534 vb_pot.n468 4.5005
R2217 vb_pot.n472 vb_pot.n469 4.5005
R2218 vb_pot.n529 vb_pot.n473 4.5005
R2219 vb_pot.n528 vb_pot.n474 4.5005
R2220 vb_pot.n527 vb_pot.n475 4.5005
R2221 vb_pot.n478 vb_pot.n476 4.5005
R2222 vb_pot.n522 vb_pot.n521 4.5005
R2223 vb_pot.n546 vb_pot.n545 4.5005
R2224 vb_pot.n489 vb_pot.n488 4.5005
R2225 vb_pot.n490 vb_pot.n484 4.5005
R2226 vb_pot.n492 vb_pot.n491 4.5005
R2227 vb_pot.n495 vb_pot.n483 4.5005
R2228 vb_pot.n499 vb_pot.n498 4.5005
R2229 vb_pot.n500 vb_pot.n482 4.5005
R2230 vb_pot.n502 vb_pot.n501 4.5005
R2231 vb_pot.n505 vb_pot.n481 4.5005
R2232 vb_pot.n509 vb_pot.n508 4.5005
R2233 vb_pot.n510 vb_pot.n480 4.5005
R2234 vb_pot.n512 vb_pot.n511 4.5005
R2235 vb_pot.n515 vb_pot.n479 4.5005
R2236 vb_pot.n518 vb_pot.n517 4.5005
R2237 vb_pot.n485 vb_pot.n456 4.5005
R2238 vb_pot.n120 vb_pot.n110 4.5005
R2239 vb_pot.n110 vb_pot.n88 4.5005
R2240 vb_pot.n116 vb_pot.n88 4.5005
R2241 vb_pot.n121 vb_pot.n120 4.5005
R2242 vb_pot.n121 vb_pot.n89 4.5005
R2243 vb_pot.n121 vb_pot.n88 4.5005
R2244 vb_pot.n120 vb_pot.n92 4.5005
R2245 vb_pot.n92 vb_pot.n89 4.5005
R2246 vb_pot.n92 vb_pot.n88 4.5005
R2247 vb_pot.n115 vb_pot.n89 4.5005
R2248 vb_pot.n115 vb_pot.n88 4.5005
R2249 vb_pot.n103 vb_pot.n100 4.5005
R2250 vb_pot.n108 vb_pot.n100 4.5005
R2251 vb_pot.n108 vb_pot.n97 4.5005
R2252 vb_pot.n107 vb_pot.n103 4.5005
R2253 vb_pot.n107 vb_pot.n95 4.5005
R2254 vb_pot.n108 vb_pot.n107 4.5005
R2255 vb_pot.n103 vb_pot.n96 4.5005
R2256 vb_pot.n96 vb_pot.n95 4.5005
R2257 vb_pot.n108 vb_pot.n96 4.5005
R2258 vb_pot.n109 vb_pot.n95 4.5005
R2259 vb_pot.n109 vb_pot.n108 4.5005
R2260 vb_pot.n161 vb_pot.n155 4.5005
R2261 vb_pot.n155 vb_pot.n2 4.5005
R2262 vb_pot.n155 vb_pot.n4 4.5005
R2263 vb_pot.n155 vb_pot.n1 4.5005
R2264 vb_pot.n167 vb_pot.n1 4.5005
R2265 vb_pot.n169 vb_pot.n2 4.5005
R2266 vb_pot.n169 vb_pot.n4 4.5005
R2267 vb_pot.n169 vb_pot.n1 4.5005
R2268 vb_pot.n171 vb_pot.n2 4.5005
R2269 vb_pot.n171 vb_pot.n4 4.5005
R2270 vb_pot.n171 vb_pot.n1 4.5005
R2271 vb_pot.n168 vb_pot.n155 4.5005
R2272 vb_pot.n158 vb_pot.n155 4.5005
R2273 vb_pot.n170 vb_pot.n155 4.5005
R2274 vb_pot.n168 vb_pot.n167 4.5005
R2275 vb_pot.n169 vb_pot.n168 4.5005
R2276 vb_pot.n169 vb_pot.n158 4.5005
R2277 vb_pot.n169 vb_pot.n6 4.5005
R2278 vb_pot.n169 vb_pot.n157 4.5005
R2279 vb_pot.n170 vb_pot.n169 4.5005
R2280 vb_pot.n168 vb_pot.n8 4.5005
R2281 vb_pot.n158 vb_pot.n8 4.5005
R2282 vb_pot.n8 vb_pot.n6 4.5005
R2283 vb_pot.n170 vb_pot.n8 4.5005
R2284 vb_pot.n171 vb_pot.n6 4.5005
R2285 vb_pot.n171 vb_pot.n170 4.5005
R2286 vb_pot.n144 vb_pot.n138 4.5005
R2287 vb_pot.n138 vb_pot.n12 4.5005
R2288 vb_pot.n138 vb_pot.n14 4.5005
R2289 vb_pot.n138 vb_pot.n11 4.5005
R2290 vb_pot.n150 vb_pot.n11 4.5005
R2291 vb_pot.n152 vb_pot.n12 4.5005
R2292 vb_pot.n152 vb_pot.n14 4.5005
R2293 vb_pot.n152 vb_pot.n11 4.5005
R2294 vb_pot.n154 vb_pot.n12 4.5005
R2295 vb_pot.n154 vb_pot.n14 4.5005
R2296 vb_pot.n154 vb_pot.n11 4.5005
R2297 vb_pot.n151 vb_pot.n138 4.5005
R2298 vb_pot.n141 vb_pot.n138 4.5005
R2299 vb_pot.n153 vb_pot.n138 4.5005
R2300 vb_pot.n151 vb_pot.n150 4.5005
R2301 vb_pot.n152 vb_pot.n151 4.5005
R2302 vb_pot.n152 vb_pot.n141 4.5005
R2303 vb_pot.n152 vb_pot.n16 4.5005
R2304 vb_pot.n152 vb_pot.n140 4.5005
R2305 vb_pot.n153 vb_pot.n152 4.5005
R2306 vb_pot.n151 vb_pot.n18 4.5005
R2307 vb_pot.n141 vb_pot.n18 4.5005
R2308 vb_pot.n18 vb_pot.n16 4.5005
R2309 vb_pot.n153 vb_pot.n18 4.5005
R2310 vb_pot.n154 vb_pot.n16 4.5005
R2311 vb_pot.n154 vb_pot.n153 4.5005
R2312 vb_pot.n128 vb_pot.n86 4.5005
R2313 vb_pot.n86 vb_pot.n22 4.5005
R2314 vb_pot.n86 vb_pot.n24 4.5005
R2315 vb_pot.n86 vb_pot.n21 4.5005
R2316 vb_pot.n133 vb_pot.n128 4.5005
R2317 vb_pot.n133 vb_pot.n21 4.5005
R2318 vb_pot.n135 vb_pot.n128 4.5005
R2319 vb_pot.n135 vb_pot.n22 4.5005
R2320 vb_pot.n135 vb_pot.n24 4.5005
R2321 vb_pot.n135 vb_pot.n21 4.5005
R2322 vb_pot.n137 vb_pot.n22 4.5005
R2323 vb_pot.n137 vb_pot.n24 4.5005
R2324 vb_pot.n137 vb_pot.n21 4.5005
R2325 vb_pot.n134 vb_pot.n86 4.5005
R2326 vb_pot.n125 vb_pot.n86 4.5005
R2327 vb_pot.n136 vb_pot.n86 4.5005
R2328 vb_pot.n134 vb_pot.n133 4.5005
R2329 vb_pot.n135 vb_pot.n134 4.5005
R2330 vb_pot.n135 vb_pot.n125 4.5005
R2331 vb_pot.n135 vb_pot.n26 4.5005
R2332 vb_pot.n135 vb_pot.n124 4.5005
R2333 vb_pot.n136 vb_pot.n135 4.5005
R2334 vb_pot.n134 vb_pot.n28 4.5005
R2335 vb_pot.n125 vb_pot.n28 4.5005
R2336 vb_pot.n28 vb_pot.n26 4.5005
R2337 vb_pot.n136 vb_pot.n28 4.5005
R2338 vb_pot.n137 vb_pot.n26 4.5005
R2339 vb_pot.n137 vb_pot.n136 4.5005
R2340 vb_pot.n75 vb_pot.n69 4.5005
R2341 vb_pot.n69 vb_pot.n32 4.5005
R2342 vb_pot.n69 vb_pot.n34 4.5005
R2343 vb_pot.n69 vb_pot.n31 4.5005
R2344 vb_pot.n81 vb_pot.n31 4.5005
R2345 vb_pot.n83 vb_pot.n32 4.5005
R2346 vb_pot.n83 vb_pot.n34 4.5005
R2347 vb_pot.n83 vb_pot.n31 4.5005
R2348 vb_pot.n85 vb_pot.n32 4.5005
R2349 vb_pot.n85 vb_pot.n34 4.5005
R2350 vb_pot.n85 vb_pot.n31 4.5005
R2351 vb_pot.n82 vb_pot.n69 4.5005
R2352 vb_pot.n72 vb_pot.n69 4.5005
R2353 vb_pot.n84 vb_pot.n69 4.5005
R2354 vb_pot.n82 vb_pot.n81 4.5005
R2355 vb_pot.n83 vb_pot.n82 4.5005
R2356 vb_pot.n83 vb_pot.n72 4.5005
R2357 vb_pot.n83 vb_pot.n36 4.5005
R2358 vb_pot.n83 vb_pot.n71 4.5005
R2359 vb_pot.n84 vb_pot.n83 4.5005
R2360 vb_pot.n82 vb_pot.n38 4.5005
R2361 vb_pot.n72 vb_pot.n38 4.5005
R2362 vb_pot.n38 vb_pot.n36 4.5005
R2363 vb_pot.n84 vb_pot.n38 4.5005
R2364 vb_pot.n85 vb_pot.n36 4.5005
R2365 vb_pot.n85 vb_pot.n84 4.5005
R2366 vb_pot.n58 vb_pot.n52 4.5005
R2367 vb_pot.n52 vb_pot.n42 4.5005
R2368 vb_pot.n52 vb_pot.n44 4.5005
R2369 vb_pot.n52 vb_pot.n41 4.5005
R2370 vb_pot.n64 vb_pot.n41 4.5005
R2371 vb_pot.n66 vb_pot.n42 4.5005
R2372 vb_pot.n66 vb_pot.n44 4.5005
R2373 vb_pot.n66 vb_pot.n41 4.5005
R2374 vb_pot.n68 vb_pot.n42 4.5005
R2375 vb_pot.n68 vb_pot.n44 4.5005
R2376 vb_pot.n68 vb_pot.n41 4.5005
R2377 vb_pot.n65 vb_pot.n52 4.5005
R2378 vb_pot.n55 vb_pot.n52 4.5005
R2379 vb_pot.n67 vb_pot.n52 4.5005
R2380 vb_pot.n65 vb_pot.n64 4.5005
R2381 vb_pot.n66 vb_pot.n65 4.5005
R2382 vb_pot.n66 vb_pot.n55 4.5005
R2383 vb_pot.n66 vb_pot.n46 4.5005
R2384 vb_pot.n66 vb_pot.n54 4.5005
R2385 vb_pot.n67 vb_pot.n66 4.5005
R2386 vb_pot.n65 vb_pot.n48 4.5005
R2387 vb_pot.n55 vb_pot.n48 4.5005
R2388 vb_pot.n48 vb_pot.n46 4.5005
R2389 vb_pot.n67 vb_pot.n48 4.5005
R2390 vb_pot.n68 vb_pot.n46 4.5005
R2391 vb_pot.n68 vb_pot.n67 4.5005
R2392 vw vb_pot.n849 4.5005
R2393 vb_pot.n634 vb_pot.n595 4.5005
R2394 vb_pot.n633 vb_pot.n598 4.5005
R2395 vb_pot.n603 vb_pot.n599 4.5005
R2396 vb_pot.n604 vb_pot.n600 4.5005
R2397 vb_pot.n626 vb_pot.n605 4.5005
R2398 vb_pot.n625 vb_pot.n606 4.5005
R2399 vb_pot.n624 vb_pot.n607 4.5005
R2400 vb_pot.n611 vb_pot.n608 4.5005
R2401 vb_pot.n619 vb_pot.n612 4.5005
R2402 vb_pot.n618 vb_pot.n613 4.5005
R2403 vb_pot.n617 vb_pot.n614 4.5005
R2404 vb_pot.n176 vb_pot.n175 4.5005
R2405 vb_pot.n846 vb_pot.n845 4.5005
R2406 vb_pot.n636 vb_pot.n635 4.5005
R2407 vb_pot.n592 vb_pot.n551 4.5005
R2408 vb_pot.n589 vb_pot.n552 4.5005
R2409 vb_pot.n588 vb_pot.n553 4.5005
R2410 vb_pot.n556 vb_pot.n554 4.5005
R2411 vb_pot.n583 vb_pot.n557 4.5005
R2412 vb_pot.n582 vb_pot.n558 4.5005
R2413 vb_pot.n581 vb_pot.n559 4.5005
R2414 vb_pot.n563 vb_pot.n560 4.5005
R2415 vb_pot.n576 vb_pot.n564 4.5005
R2416 vb_pot.n575 vb_pot.n565 4.5005
R2417 vb_pot.n574 vb_pot.n566 4.5005
R2418 vb_pot.n570 vb_pot.n567 4.5005
R2419 vb_pot.n569 vb_pot.n568 4.5005
R2420 vb_pot.n594 vb_pot.n593 4.5005
R2421 vb_pot.n229 vb_pot.n228 4.5005
R2422 vb_pot.n230 vb_pot.n203 4.5005
R2423 vb_pot.n232 vb_pot.n231 4.5005
R2424 vb_pot.n233 vb_pot.n206 4.5005
R2425 vb_pot.n219 vb_pot.n218 4.5005
R2426 vb_pot.n222 vb_pot.n221 4.5005
R2427 vb_pot.n224 vb_pot.n223 4.5005
R2428 vb_pot.n205 vb_pot.n203 4.5005
R2429 vb_pot.n826 vb_pot.n825 4.5005
R2430 vb_pot.n824 vb_pot.n204 4.5005
R2431 vb_pot.n213 vb_pot.n212 4.5005
R2432 vb_pot.n211 vb_pot.n203 4.5005
R2433 vb_pot.n742 vb_pot.n741 3.5869
R2434 vb_pot.n459 vb_pot.n458 3.11744
R2435 vb_pot.n541 vb_pot.n540 3.11744
R2436 vb_pot.n538 vb_pot.n537 3.11744
R2437 vb_pot.n533 vb_pot.n470 3.11744
R2438 vb_pot.n531 vb_pot.n530 3.11744
R2439 vb_pot.n526 vb_pot.n477 3.11744
R2440 vb_pot.n524 vb_pot.n523 3.11744
R2441 vb_pot.n487 vb_pot.n445 3.11744
R2442 vb_pot.n493 vb_pot.n446 3.11744
R2443 vb_pot.n497 vb_pot.n447 3.11744
R2444 vb_pot.n503 vb_pot.n448 3.11744
R2445 vb_pot.n507 vb_pot.n449 3.11744
R2446 vb_pot.n513 vb_pot.n450 3.11744
R2447 vb_pot.n516 vb_pot.n451 3.11744
R2448 vb_pot.n433 vb_pot.n399 3.11744
R2449 vb_pot.n431 vb_pot.n398 3.11744
R2450 vb_pot.n427 vb_pot.n392 3.11744
R2451 vb_pot.n423 vb_pot.n393 3.11744
R2452 vb_pot.n419 vb_pot.n394 3.11744
R2453 vb_pot.n415 vb_pot.n395 3.11744
R2454 vb_pot.n677 vb_pot.n383 3.11744
R2455 vb_pot.n673 vb_pot.n382 3.11744
R2456 vb_pot.n671 vb_pot.n670 3.11744
R2457 vb_pot.n666 vb_pot.n650 3.11744
R2458 vb_pot.n664 vb_pot.n663 3.11744
R2459 vb_pot.n659 vb_pot.n658 3.11744
R2460 vb_pot.n597 vb_pot.n596 3.11744
R2461 vb_pot.n631 vb_pot.n630 3.11744
R2462 vb_pot.n628 vb_pot.n627 3.11744
R2463 vb_pot.n623 vb_pot.n609 3.11744
R2464 vb_pot.n621 vb_pot.n620 3.11744
R2465 vb_pot.n616 vb_pot.n615 3.11744
R2466 vb_pot.n591 vb_pot.n443 3.11744
R2467 vb_pot.n587 vb_pot.n444 3.11744
R2468 vb_pot.n585 vb_pot.n584 3.11744
R2469 vb_pot.n580 vb_pot.n561 3.11744
R2470 vb_pot.n578 vb_pot.n577 3.11744
R2471 vb_pot.n573 vb_pot.n571 3.11744
R2472 vb_pot.n571 vb_pot.n562 3.11744
R2473 vb_pot.n579 vb_pot.n578 3.11744
R2474 vb_pot.n561 vb_pot.n555 3.11744
R2475 vb_pot.n586 vb_pot.n585 3.11744
R2476 vb_pot.n615 vb_pot.n610 3.11744
R2477 vb_pot.n622 vb_pot.n621 3.11744
R2478 vb_pot.n609 vb_pot.n602 3.11744
R2479 vb_pot.n629 vb_pot.n628 3.11744
R2480 vb_pot.n658 vb_pot.n651 3.11744
R2481 vb_pot.n665 vb_pot.n664 3.11744
R2482 vb_pot.n650 vb_pot.n644 3.11744
R2483 vb_pot.n672 vb_pot.n671 3.11744
R2484 vb_pot.n418 vb_pot.n395 3.11744
R2485 vb_pot.n422 vb_pot.n394 3.11744
R2486 vb_pot.n426 vb_pot.n393 3.11744
R2487 vb_pot.n430 vb_pot.n392 3.11744
R2488 vb_pot.n514 vb_pot.n451 3.11744
R2489 vb_pot.n506 vb_pot.n450 3.11744
R2490 vb_pot.n504 vb_pot.n449 3.11744
R2491 vb_pot.n496 vb_pot.n448 3.11744
R2492 vb_pot.n494 vb_pot.n447 3.11744
R2493 vb_pot.n486 vb_pot.n446 3.11744
R2494 vb_pot.n454 vb_pot.n445 3.11744
R2495 vb_pot.n525 vb_pot.n524 3.11744
R2496 vb_pot.n477 vb_pot.n471 3.11744
R2497 vb_pot.n532 vb_pot.n531 3.11744
R2498 vb_pot.n470 vb_pot.n463 3.11744
R2499 vb_pot.n539 vb_pot.n538 3.11744
R2500 vb_pot.n542 vb_pot.n541 3.11744
R2501 vb_pot.n458 vb_pot.n455 3.11744
R2502 vb_pot.n590 vb_pot.n444 3.11744
R2503 vb_pot.n549 vb_pot.n443 3.11744
R2504 vb_pot.n632 vb_pot.n631 3.11744
R2505 vb_pot.n596 vb_pot.n550 3.11744
R2506 vb_pot.n676 vb_pot.n382 3.11744
R2507 vb_pot.n385 vb_pot.n383 3.11744
R2508 vb_pot.n434 vb_pot.n398 3.11744
R2509 vb_pot.n400 vb_pot.n399 3.11744
R2510 vb_pot.n248 vb_pot.n237 2.86962
R2511 vb_pot.n164 vb_pot.n163 2.25044
R2512 vb_pot.n162 vb_pot.n161 2.25044
R2513 vb_pot.n163 vb_pot.n159 2.25044
R2514 vb_pot.n157 vb_pot.n0 2.25044
R2515 vb_pot.n147 vb_pot.n146 2.25044
R2516 vb_pot.n145 vb_pot.n144 2.25044
R2517 vb_pot.n146 vb_pot.n142 2.25044
R2518 vb_pot.n140 vb_pot.n10 2.25044
R2519 vb_pot.n130 vb_pot.n129 2.25044
R2520 vb_pot.n129 vb_pot.n126 2.25044
R2521 vb_pot.n124 vb_pot.n20 2.25044
R2522 vb_pot.n78 vb_pot.n77 2.25044
R2523 vb_pot.n76 vb_pot.n75 2.25044
R2524 vb_pot.n77 vb_pot.n73 2.25044
R2525 vb_pot.n71 vb_pot.n30 2.25044
R2526 vb_pot.n61 vb_pot.n60 2.25044
R2527 vb_pot.n59 vb_pot.n58 2.25044
R2528 vb_pot.n60 vb_pot.n56 2.25044
R2529 vb_pot.n54 vb_pot.n40 2.25044
R2530 vb_pot.n118 vb_pot.n117 2.24986
R2531 vb_pot.n112 vb_pot.n87 2.24986
R2532 vb_pot.n118 vb_pot.n90 2.24986
R2533 vb_pot.n113 vb_pot.n112 2.24986
R2534 vb_pot.n105 vb_pot.n104 2.24986
R2535 vb_pot.n101 vb_pot.n98 2.24986
R2536 vb_pot.n106 vb_pot.n105 2.24986
R2537 vb_pot.n98 vb_pot.n93 2.24986
R2538 vb_pot.n111 vb_pot.n110 2.24741
R2539 vb_pot.n116 vb_pot.n91 2.24741
R2540 vb_pot.n119 vb_pot.n115 2.24741
R2541 vb_pot.n100 vb_pot.n99 2.24741
R2542 vb_pot.n102 vb_pot.n97 2.24741
R2543 vb_pot.n109 vb_pot.n94 2.24741
R2544 vb_pot.n167 vb_pot.n166 2.24741
R2545 vb_pot.n160 vb_pot.n8 2.24741
R2546 vb_pot.n8 vb_pot.n7 2.24741
R2547 vb_pot.n171 vb_pot.n3 2.24741
R2548 vb_pot.n156 vb_pot.n155 2.24741
R2549 vb_pot.n167 vb_pot.n165 2.24741
R2550 vb_pot.n167 vb_pot.n9 2.24741
R2551 vb_pot.n171 vb_pot.n5 2.24741
R2552 vb_pot.n150 vb_pot.n149 2.24741
R2553 vb_pot.n143 vb_pot.n18 2.24741
R2554 vb_pot.n18 vb_pot.n17 2.24741
R2555 vb_pot.n154 vb_pot.n13 2.24741
R2556 vb_pot.n139 vb_pot.n138 2.24741
R2557 vb_pot.n150 vb_pot.n148 2.24741
R2558 vb_pot.n150 vb_pot.n19 2.24741
R2559 vb_pot.n154 vb_pot.n15 2.24741
R2560 vb_pot.n133 vb_pot.n132 2.24741
R2561 vb_pot.n127 vb_pot.n28 2.24741
R2562 vb_pot.n28 vb_pot.n27 2.24741
R2563 vb_pot.n137 vb_pot.n23 2.24741
R2564 vb_pot.n123 vb_pot.n86 2.24741
R2565 vb_pot.n133 vb_pot.n131 2.24741
R2566 vb_pot.n133 vb_pot.n29 2.24741
R2567 vb_pot.n137 vb_pot.n25 2.24741
R2568 vb_pot.n81 vb_pot.n80 2.24741
R2569 vb_pot.n74 vb_pot.n38 2.24741
R2570 vb_pot.n38 vb_pot.n37 2.24741
R2571 vb_pot.n85 vb_pot.n33 2.24741
R2572 vb_pot.n70 vb_pot.n69 2.24741
R2573 vb_pot.n81 vb_pot.n79 2.24741
R2574 vb_pot.n81 vb_pot.n39 2.24741
R2575 vb_pot.n85 vb_pot.n35 2.24741
R2576 vb_pot.n64 vb_pot.n63 2.24741
R2577 vb_pot.n57 vb_pot.n48 2.24741
R2578 vb_pot.n48 vb_pot.n47 2.24741
R2579 vb_pot.n68 vb_pot.n43 2.24741
R2580 vb_pot.n53 vb_pot.n52 2.24741
R2581 vb_pot.n64 vb_pot.n62 2.24741
R2582 vb_pot.n64 vb_pot.n49 2.24741
R2583 vb_pot.n68 vb_pot.n45 2.24741
R2584 vb_pot.n799 vb_pot.n759 1.43506
R2585 vb_pot.n848 vb_pot.n173 1.3649
R2586 vb_pot.n571 vb_pot.n397 1.04278
R2587 vb_pot.n578 vb_pot.n397 1.04278
R2588 vb_pot.n561 vb_pot.n397 1.04278
R2589 vb_pot.n585 vb_pot.n397 1.04278
R2590 vb_pot.n615 vb_pot.n601 1.04278
R2591 vb_pot.n621 vb_pot.n601 1.04278
R2592 vb_pot.n609 vb_pot.n601 1.04278
R2593 vb_pot.n628 vb_pot.n601 1.04278
R2594 vb_pot.n658 vb_pot.n643 1.04278
R2595 vb_pot.n664 vb_pot.n643 1.04278
R2596 vb_pot.n650 vb_pot.n643 1.04278
R2597 vb_pot.n671 vb_pot.n643 1.04278
R2598 vb_pot.n642 vb_pot.n395 1.04278
R2599 vb_pot.n642 vb_pot.n394 1.04278
R2600 vb_pot.n642 vb_pot.n393 1.04278
R2601 vb_pot.n642 vb_pot.n392 1.04278
R2602 vb_pot.n640 vb_pot.n451 1.04278
R2603 vb_pot.n640 vb_pot.n450 1.04278
R2604 vb_pot.n640 vb_pot.n449 1.04278
R2605 vb_pot.n640 vb_pot.n448 1.04278
R2606 vb_pot.n640 vb_pot.n447 1.04278
R2607 vb_pot.n640 vb_pot.n446 1.04278
R2608 vb_pot.n640 vb_pot.n445 1.04278
R2609 vb_pot.n524 vb_pot.n453 1.04278
R2610 vb_pot.n477 vb_pot.n453 1.04278
R2611 vb_pot.n531 vb_pot.n453 1.04278
R2612 vb_pot.n470 vb_pot.n453 1.04278
R2613 vb_pot.n538 vb_pot.n453 1.04278
R2614 vb_pot.n541 vb_pot.n453 1.04278
R2615 vb_pot.n458 vb_pot.n453 1.04278
R2616 vb_pot.n640 vb_pot.n444 1.04278
R2617 vb_pot.n640 vb_pot.n443 1.04278
R2618 vb_pot.n631 vb_pot.n453 1.04278
R2619 vb_pot.n596 vb_pot.n453 1.04278
R2620 vb_pot.n682 vb_pot.n382 1.04278
R2621 vb_pot.n682 vb_pot.n383 1.04278
R2622 vb_pot.n442 vb_pot.n398 1.04278
R2623 vb_pot.n442 vb_pot.n399 1.04278
R2624 vb_pot.n210 vb_pot.n208 0.795679
R2625 vb_pot.n849 vb_pot.n172 0.7592
R2626 vb_pot.n548 vb_pot.n547 0.743357
R2627 vb_pot.n639 vb_pot.n548 0.743357
R2628 vb_pot.n519 vb_pot.n452 0.743357
R2629 vb_pot.n639 vb_pot.n452 0.743357
R2630 vb_pot.n638 vb_pot.n637 0.743357
R2631 vb_pot.n639 vb_pot.n638 0.743357
R2632 vb_pot.n401 vb_pot.n384 0.743357
R2633 vb_pot.n384 vb_pot.n381 0.743357
R2634 vb_pot.n178 vb_pot.n174 0.743357
R2635 vb_pot.n181 vb_pot.n178 0.743357
R2636 vb_pot.n835 vb_pot.n834 0.743357
R2637 vb_pot.n836 vb_pot.n835 0.743357
R2638 vb_pot.n798 vb_pot.n797 0.743357
R2639 vb_pot.n799 vb_pot.n798 0.743357
R2640 vb_pot.n740 vb_pot.n739 0.743357
R2641 vb_pot.n741 vb_pot.n740 0.743357
R2642 vb_pot.n380 vb_pot.n379 0.743357
R2643 vb_pot.n687 vb_pot.n380 0.743357
R2644 vb_pot.n757 vb_pot.n275 0.743357
R2645 vb_pot.n275 vb_pot.n267 0.743357
R2646 vb_pot.n758 vb_pot.n757 0.743357
R2647 vb_pot.n759 vb_pot.n758 0.743357
R2648 vb_pot.n280 vb_pot.n277 0.743357
R2649 vb_pot.n342 vb_pot.n277 0.743357
R2650 vb_pot.n731 vb_pot.n730 0.743357
R2651 vb_pot.n732 vb_pot.n731 0.743357
R2652 vb_pot.n698 vb_pot.n301 0.743357
R2653 vb_pot.n314 vb_pot.n301 0.743357
R2654 vb_pot.n699 vb_pot.n698 0.743357
R2655 vb_pot.n699 vb_pot.n320 0.743357
R2656 vb_pot.n704 vb_pot.n688 0.743357
R2657 vb_pot.n688 vb_pot.n687 0.743357
R2658 vb_pot.n841 vb_pot.n840 0.743357
R2659 vb_pot.n842 vb_pot.n841 0.743357
R2660 vb_pot.n839 vb_pot.n838 0.743357
R2661 vb_pot.n838 vb_pot.n837 0.743357
R2662 vb_pot.n822 vb_pot.n821 0.743357
R2663 vb_pot.n821 vb_pot.n820 0.743357
R2664 vb_pot.n811 vb_pot.n217 0.743357
R2665 vb_pot.n812 vb_pot.n811 0.743357
R2666 vb_pot.n849 vb_pot.n848 0.6026
R2667 vb_pot.n847 vb_pot.n174 0.454413
R2668 vb_pot.n379 vb_pot.n378 0.454413
R2669 vb_pot.n797 vb_pot.n796 0.454413
R2670 vb_pot.n520 vb_pot.n519 0.454413
R2671 vb_pot.n228 vb_pot.n219 0.148954
R2672 vb_pot.n228 vb_pot.n203 0.148954
R2673 vb_pot.n232 vb_pot.n203 0.148954
R2674 vb_pot.n233 vb_pot.n232 0.148954
R2675 vb_pot.n224 vb_pot.n221 0.148954
R2676 vb_pot.n224 vb_pot.n203 0.148954
R2677 vb_pot.n826 vb_pot.n203 0.148954
R2678 vb_pot.n826 vb_pot.n204 0.148954
R2679 vb_pot.n728 vb_pot.n727 0.1445
R2680 vb_pot.n702 vb_pot.n701 0.1445
R2681 vb_pot.n706 vb_pot.n689 0.1445
R2682 vb_pot.n705 vb_pot.n690 0.1445
R2683 vb_pot.n703 vb_pot.n691 0.1445
R2684 vb_pot.n729 vb_pot.n300 0.1445
R2685 vb_pot.n695 vb_pot.n692 0.1445
R2686 vb_pot.n694 vb_pot.n693 0.1445
R2687 vb_pot.n754 vb_pot.n253 0.1445
R2688 vb_pot.n755 vb_pot.n753 0.1445
R2689 vb_pot.n745 vb_pot.n744 0.1445
R2690 vb_pot.n282 vb_pot.n278 0.1445
R2691 vb_pot.n281 vb_pot.n279 0.1445
R2692 vb_pot.n746 vb_pot.n276 0.1445
R2693 vb_pot.n751 vb_pot.n747 0.1445
R2694 vb_pot.n750 vb_pot.n749 0.1445
R2695 vb_pot.n440 vb_pot.n439 0.1445
R2696 vb_pot.n439 vb_pot.n403 0.1445
R2697 vb_pot.n435 vb_pot.n403 0.1445
R2698 vb_pot.n435 vb_pot.n432 0.1445
R2699 vb_pot.n432 vb_pot.n429 0.1445
R2700 vb_pot.n429 vb_pot.n428 0.1445
R2701 vb_pot.n428 vb_pot.n425 0.1445
R2702 vb_pot.n425 vb_pot.n424 0.1445
R2703 vb_pot.n424 vb_pot.n421 0.1445
R2704 vb_pot.n421 vb_pot.n420 0.1445
R2705 vb_pot.n420 vb_pot.n417 0.1445
R2706 vb_pot.n417 vb_pot.n416 0.1445
R2707 vb_pot.n416 vb_pot.n414 0.1445
R2708 vb_pot.n438 vb_pot.n402 0.1445
R2709 vb_pot.n438 vb_pot.n437 0.1445
R2710 vb_pot.n437 vb_pot.n436 0.1445
R2711 vb_pot.n436 vb_pot.n404 0.1445
R2712 vb_pot.n405 vb_pot.n404 0.1445
R2713 vb_pot.n406 vb_pot.n405 0.1445
R2714 vb_pot.n407 vb_pot.n406 0.1445
R2715 vb_pot.n408 vb_pot.n407 0.1445
R2716 vb_pot.n409 vb_pot.n408 0.1445
R2717 vb_pot.n410 vb_pot.n409 0.1445
R2718 vb_pot.n411 vb_pot.n410 0.1445
R2719 vb_pot.n412 vb_pot.n411 0.1445
R2720 vb_pot.n413 vb_pot.n412 0.1445
R2721 vb_pot.n387 vb_pot.n386 0.1445
R2722 vb_pot.n388 vb_pot.n387 0.1445
R2723 vb_pot.n389 vb_pot.n388 0.1445
R2724 vb_pot.n390 vb_pot.n389 0.1445
R2725 vb_pot.n645 vb_pot.n390 0.1445
R2726 vb_pot.n646 vb_pot.n645 0.1445
R2727 vb_pot.n647 vb_pot.n646 0.1445
R2728 vb_pot.n648 vb_pot.n647 0.1445
R2729 vb_pot.n652 vb_pot.n648 0.1445
R2730 vb_pot.n653 vb_pot.n652 0.1445
R2731 vb_pot.n654 vb_pot.n653 0.1445
R2732 vb_pot.n655 vb_pot.n654 0.1445
R2733 vb_pot.n656 vb_pot.n655 0.1445
R2734 vb_pot.n680 vb_pot.n679 0.1445
R2735 vb_pot.n679 vb_pot.n678 0.1445
R2736 vb_pot.n678 vb_pot.n675 0.1445
R2737 vb_pot.n675 vb_pot.n674 0.1445
R2738 vb_pot.n674 vb_pot.n391 0.1445
R2739 vb_pot.n669 vb_pot.n391 0.1445
R2740 vb_pot.n669 vb_pot.n668 0.1445
R2741 vb_pot.n668 vb_pot.n667 0.1445
R2742 vb_pot.n667 vb_pot.n649 0.1445
R2743 vb_pot.n662 vb_pot.n649 0.1445
R2744 vb_pot.n662 vb_pot.n661 0.1445
R2745 vb_pot.n661 vb_pot.n660 0.1445
R2746 vb_pot.n660 vb_pot.n657 0.1445
R2747 vb_pot.n635 vb_pot.n634 0.1445
R2748 vb_pot.n634 vb_pot.n633 0.1445
R2749 vb_pot.n633 vb_pot.n599 0.1445
R2750 vb_pot.n600 vb_pot.n599 0.1445
R2751 vb_pot.n626 vb_pot.n600 0.1445
R2752 vb_pot.n626 vb_pot.n625 0.1445
R2753 vb_pot.n625 vb_pot.n624 0.1445
R2754 vb_pot.n624 vb_pot.n608 0.1445
R2755 vb_pot.n619 vb_pot.n608 0.1445
R2756 vb_pot.n619 vb_pot.n618 0.1445
R2757 vb_pot.n618 vb_pot.n617 0.1445
R2758 vb_pot.n617 vb_pot.n176 0.1445
R2759 vb_pot.n845 vb_pot.n176 0.1445
R2760 vb_pot.n345 vb_pot.n341 0.1445
R2761 vb_pot.n345 vb_pot.n340 0.1445
R2762 vb_pot.n349 vb_pot.n340 0.1445
R2763 vb_pot.n349 vb_pot.n339 0.1445
R2764 vb_pot.n360 vb_pot.n339 0.1445
R2765 vb_pot.n360 vb_pot.n337 0.1445
R2766 vb_pot.n365 vb_pot.n337 0.1445
R2767 vb_pot.n366 vb_pot.n365 0.1445
R2768 vb_pot.n367 vb_pot.n366 0.1445
R2769 vb_pot.n367 vb_pot.n335 0.1445
R2770 vb_pot.n373 vb_pot.n335 0.1445
R2771 vb_pot.n374 vb_pot.n373 0.1445
R2772 vb_pot.n375 vb_pot.n374 0.1445
R2773 vb_pot.n737 vb_pot.n736 0.1445
R2774 vb_pot.n736 vb_pot.n735 0.1445
R2775 vb_pot.n735 vb_pot.n291 0.1445
R2776 vb_pot.n355 vb_pot.n291 0.1445
R2777 vb_pot.n355 vb_pot.n308 0.1445
R2778 vb_pot.n722 vb_pot.n308 0.1445
R2779 vb_pot.n722 vb_pot.n721 0.1445
R2780 vb_pot.n721 vb_pot.n720 0.1445
R2781 vb_pot.n720 vb_pot.n312 0.1445
R2782 vb_pot.n713 vb_pot.n312 0.1445
R2783 vb_pot.n713 vb_pot.n712 0.1445
R2784 vb_pot.n712 vb_pot.n711 0.1445
R2785 vb_pot.n711 vb_pot.n326 0.1445
R2786 vb_pot.n738 vb_pot.n288 0.1445
R2787 vb_pot.n290 vb_pot.n288 0.1445
R2788 vb_pot.n352 vb_pot.n290 0.1445
R2789 vb_pot.n354 vb_pot.n352 0.1445
R2790 vb_pot.n354 vb_pot.n353 0.1445
R2791 vb_pot.n353 vb_pot.n309 0.1445
R2792 vb_pot.n310 vb_pot.n309 0.1445
R2793 vb_pot.n311 vb_pot.n310 0.1445
R2794 vb_pot.n322 vb_pot.n311 0.1445
R2795 vb_pot.n323 vb_pot.n322 0.1445
R2796 vb_pot.n324 vb_pot.n323 0.1445
R2797 vb_pot.n325 vb_pot.n324 0.1445
R2798 vb_pot.n377 vb_pot.n325 0.1445
R2799 vb_pot.n346 vb_pot.n287 0.1445
R2800 vb_pot.n347 vb_pot.n346 0.1445
R2801 vb_pot.n348 vb_pot.n347 0.1445
R2802 vb_pot.n348 vb_pot.n338 0.1445
R2803 vb_pot.n361 vb_pot.n338 0.1445
R2804 vb_pot.n362 vb_pot.n361 0.1445
R2805 vb_pot.n363 vb_pot.n362 0.1445
R2806 vb_pot.n363 vb_pot.n336 0.1445
R2807 vb_pot.n368 vb_pot.n336 0.1445
R2808 vb_pot.n369 vb_pot.n368 0.1445
R2809 vb_pot.n370 vb_pot.n369 0.1445
R2810 vb_pot.n370 vb_pot.n334 0.1445
R2811 vb_pot.n376 vb_pot.n334 0.1445
R2812 vb_pot.n769 vb_pot.n767 0.1445
R2813 vb_pot.n769 vb_pot.n766 0.1445
R2814 vb_pot.n773 vb_pot.n766 0.1445
R2815 vb_pot.n776 vb_pot.n773 0.1445
R2816 vb_pot.n777 vb_pot.n776 0.1445
R2817 vb_pot.n777 vb_pot.n764 0.1445
R2818 vb_pot.n781 vb_pot.n764 0.1445
R2819 vb_pot.n782 vb_pot.n781 0.1445
R2820 vb_pot.n785 vb_pot.n782 0.1445
R2821 vb_pot.n785 vb_pot.n761 0.1445
R2822 vb_pot.n791 vb_pot.n761 0.1445
R2823 vb_pot.n792 vb_pot.n791 0.1445
R2824 vb_pot.n793 vb_pot.n792 0.1445
R2825 vb_pot.n832 vb_pot.n831 0.1445
R2826 vb_pot.n831 vb_pot.n830 0.1445
R2827 vb_pot.n830 vb_pot.n195 0.1445
R2828 vb_pot.n240 vb_pot.n195 0.1445
R2829 vb_pot.n817 vb_pot.n240 0.1445
R2830 vb_pot.n817 vb_pot.n816 0.1445
R2831 vb_pot.n816 vb_pot.n815 0.1445
R2832 vb_pot.n815 vb_pot.n246 0.1445
R2833 vb_pot.n259 vb_pot.n246 0.1445
R2834 vb_pot.n806 vb_pot.n259 0.1445
R2835 vb_pot.n806 vb_pot.n805 0.1445
R2836 vb_pot.n805 vb_pot.n804 0.1445
R2837 vb_pot.n804 vb_pot.n265 0.1445
R2838 vb_pot.n833 vb_pot.n192 0.1445
R2839 vb_pot.n194 vb_pot.n192 0.1445
R2840 vb_pot.n241 vb_pot.n194 0.1445
R2841 vb_pot.n242 vb_pot.n241 0.1445
R2842 vb_pot.n243 vb_pot.n242 0.1445
R2843 vb_pot.n244 vb_pot.n243 0.1445
R2844 vb_pot.n245 vb_pot.n244 0.1445
R2845 vb_pot.n260 vb_pot.n245 0.1445
R2846 vb_pot.n261 vb_pot.n260 0.1445
R2847 vb_pot.n262 vb_pot.n261 0.1445
R2848 vb_pot.n263 vb_pot.n262 0.1445
R2849 vb_pot.n264 vb_pot.n263 0.1445
R2850 vb_pot.n795 vb_pot.n264 0.1445
R2851 vb_pot.n770 vb_pot.n191 0.1445
R2852 vb_pot.n771 vb_pot.n770 0.1445
R2853 vb_pot.n772 vb_pot.n771 0.1445
R2854 vb_pot.n772 vb_pot.n765 0.1445
R2855 vb_pot.n778 vb_pot.n765 0.1445
R2856 vb_pot.n779 vb_pot.n778 0.1445
R2857 vb_pot.n780 vb_pot.n779 0.1445
R2858 vb_pot.n780 vb_pot.n762 0.1445
R2859 vb_pot.n786 vb_pot.n762 0.1445
R2860 vb_pot.n787 vb_pot.n786 0.1445
R2861 vb_pot.n788 vb_pot.n787 0.1445
R2862 vb_pot.n788 vb_pot.n760 0.1445
R2863 vb_pot.n794 vb_pot.n760 0.1445
R2864 vb_pot.n488 vb_pot.n485 0.1445
R2865 vb_pot.n488 vb_pot.n484 0.1445
R2866 vb_pot.n492 vb_pot.n484 0.1445
R2867 vb_pot.n495 vb_pot.n492 0.1445
R2868 vb_pot.n498 vb_pot.n495 0.1445
R2869 vb_pot.n498 vb_pot.n482 0.1445
R2870 vb_pot.n502 vb_pot.n482 0.1445
R2871 vb_pot.n505 vb_pot.n502 0.1445
R2872 vb_pot.n508 vb_pot.n505 0.1445
R2873 vb_pot.n508 vb_pot.n480 0.1445
R2874 vb_pot.n512 vb_pot.n480 0.1445
R2875 vb_pot.n515 vb_pot.n512 0.1445
R2876 vb_pot.n517 vb_pot.n515 0.1445
R2877 vb_pot.n545 vb_pot.n544 0.1445
R2878 vb_pot.n544 vb_pot.n543 0.1445
R2879 vb_pot.n543 vb_pot.n461 0.1445
R2880 vb_pot.n462 vb_pot.n461 0.1445
R2881 vb_pot.n536 vb_pot.n462 0.1445
R2882 vb_pot.n536 vb_pot.n535 0.1445
R2883 vb_pot.n535 vb_pot.n534 0.1445
R2884 vb_pot.n534 vb_pot.n469 0.1445
R2885 vb_pot.n529 vb_pot.n469 0.1445
R2886 vb_pot.n529 vb_pot.n528 0.1445
R2887 vb_pot.n528 vb_pot.n527 0.1445
R2888 vb_pot.n527 vb_pot.n476 0.1445
R2889 vb_pot.n522 vb_pot.n476 0.1445
R2890 vb_pot.n546 vb_pot.n457 0.1445
R2891 vb_pot.n460 vb_pot.n457 0.1445
R2892 vb_pot.n464 vb_pot.n460 0.1445
R2893 vb_pot.n465 vb_pot.n464 0.1445
R2894 vb_pot.n466 vb_pot.n465 0.1445
R2895 vb_pot.n467 vb_pot.n466 0.1445
R2896 vb_pot.n468 vb_pot.n467 0.1445
R2897 vb_pot.n472 vb_pot.n468 0.1445
R2898 vb_pot.n473 vb_pot.n472 0.1445
R2899 vb_pot.n474 vb_pot.n473 0.1445
R2900 vb_pot.n475 vb_pot.n474 0.1445
R2901 vb_pot.n478 vb_pot.n475 0.1445
R2902 vb_pot.n521 vb_pot.n478 0.1445
R2903 vb_pot.n489 vb_pot.n456 0.1445
R2904 vb_pot.n490 vb_pot.n489 0.1445
R2905 vb_pot.n491 vb_pot.n490 0.1445
R2906 vb_pot.n491 vb_pot.n483 0.1445
R2907 vb_pot.n499 vb_pot.n483 0.1445
R2908 vb_pot.n500 vb_pot.n499 0.1445
R2909 vb_pot.n501 vb_pot.n500 0.1445
R2910 vb_pot.n501 vb_pot.n481 0.1445
R2911 vb_pot.n509 vb_pot.n481 0.1445
R2912 vb_pot.n510 vb_pot.n509 0.1445
R2913 vb_pot.n511 vb_pot.n510 0.1445
R2914 vb_pot.n511 vb_pot.n479 0.1445
R2915 vb_pot.n518 vb_pot.n479 0.1445
R2916 vb_pot.n636 vb_pot.n595 0.1445
R2917 vb_pot.n598 vb_pot.n595 0.1445
R2918 vb_pot.n603 vb_pot.n598 0.1445
R2919 vb_pot.n604 vb_pot.n603 0.1445
R2920 vb_pot.n605 vb_pot.n604 0.1445
R2921 vb_pot.n606 vb_pot.n605 0.1445
R2922 vb_pot.n607 vb_pot.n606 0.1445
R2923 vb_pot.n611 vb_pot.n607 0.1445
R2924 vb_pot.n612 vb_pot.n611 0.1445
R2925 vb_pot.n613 vb_pot.n612 0.1445
R2926 vb_pot.n614 vb_pot.n613 0.1445
R2927 vb_pot.n614 vb_pot.n175 0.1445
R2928 vb_pot.n846 vb_pot.n175 0.1445
R2929 vb_pot.n594 vb_pot.n551 0.1445
R2930 vb_pot.n552 vb_pot.n551 0.1445
R2931 vb_pot.n553 vb_pot.n552 0.1445
R2932 vb_pot.n556 vb_pot.n553 0.1445
R2933 vb_pot.n557 vb_pot.n556 0.1445
R2934 vb_pot.n558 vb_pot.n557 0.1445
R2935 vb_pot.n559 vb_pot.n558 0.1445
R2936 vb_pot.n563 vb_pot.n559 0.1445
R2937 vb_pot.n564 vb_pot.n563 0.1445
R2938 vb_pot.n565 vb_pot.n564 0.1445
R2939 vb_pot.n566 vb_pot.n565 0.1445
R2940 vb_pot.n567 vb_pot.n566 0.1445
R2941 vb_pot.n568 vb_pot.n567 0.1445
R2942 vb_pot.n593 vb_pot.n592 0.1445
R2943 vb_pot.n592 vb_pot.n589 0.1445
R2944 vb_pot.n589 vb_pot.n588 0.1445
R2945 vb_pot.n588 vb_pot.n554 0.1445
R2946 vb_pot.n583 vb_pot.n554 0.1445
R2947 vb_pot.n583 vb_pot.n582 0.1445
R2948 vb_pot.n582 vb_pot.n581 0.1445
R2949 vb_pot.n581 vb_pot.n560 0.1445
R2950 vb_pot.n576 vb_pot.n560 0.1445
R2951 vb_pot.n576 vb_pot.n575 0.1445
R2952 vb_pot.n575 vb_pot.n574 0.1445
R2953 vb_pot.n574 vb_pot.n570 0.1445
R2954 vb_pot.n570 vb_pot.n569 0.1445
R2955 vb_pot.n229 vb_pot.n218 0.1445
R2956 vb_pot.n230 vb_pot.n229 0.1445
R2957 vb_pot.n231 vb_pot.n230 0.1445
R2958 vb_pot.n231 vb_pot.n206 0.1445
R2959 vb_pot.n223 vb_pot.n222 0.1445
R2960 vb_pot.n223 vb_pot.n205 0.1445
R2961 vb_pot.n825 vb_pot.n205 0.1445
R2962 vb_pot.n825 vb_pot.n824 0.1445
R2963 vb_pot.n212 vb_pot.n211 0.1445
R2964 vb_pot.n730 vb_pot.n299 0.122783
R2965 vb_pot.n698 vb_pot.n697 0.0740097
R2966 vb_pot.n698 vb_pot.n696 0.0740097
R2967 vb_pot.n757 vb_pot.n274 0.0740097
R2968 vb_pot.n757 vb_pot.n756 0.0740097
R2969 vb_pot.n840 vb_pot.n839 0.04675
R2970 vb_pot.n822 vb_pot.n217 0.04675
R2971 vb_pot.n122 vb_pot.n121 0.0325
R2972 vb_pot.n214 vb_pot.n185 0.024875
R2973 vb_pot.n823 vb_pot.n216 0.024875
R2974 vb_pot.n110 vb_pot.n109 0.0245
R2975 vb_pot.n214 vb_pot.n213 0.0188333
R2976 vb_pot.n216 vb_pot.n207 0.0188333
R2977 vb_pot.n213 vb_pot.n203 0.0171667
R2978 vb_pot.n108 vb_pot.n98 0.0149
R2979 vb_pot.n112 vb_pot.n88 0.0149
R2980 vb_pot.n69 vb_pot.n68 0.0121667
R2981 vb_pot.n86 vb_pot.n85 0.0121667
R2982 vb_pot.n138 vb_pot.n137 0.0121667
R2983 vb_pot.n155 vb_pot.n154 0.0121667
R2984 vb_pot.n209 vb_pot.n207 0.0114825
R2985 vb_pot.n54 vb_pot.n49 0.0081885
R2986 vb_pot.n54 vb_pot.n53 0.0081885
R2987 vb_pot.n62 vb_pot.n55 0.0081885
R2988 vb_pot.n65 vb_pot.n45 0.0081885
R2989 vb_pot.n47 vb_pot.n44 0.0081885
R2990 vb_pot.n63 vb_pot.n42 0.0081885
R2991 vb_pot.n58 vb_pot.n57 0.0081885
R2992 vb_pot.n60 vb_pot.n43 0.0081885
R2993 vb_pot.n71 vb_pot.n39 0.0081885
R2994 vb_pot.n71 vb_pot.n70 0.0081885
R2995 vb_pot.n79 vb_pot.n72 0.0081885
R2996 vb_pot.n82 vb_pot.n35 0.0081885
R2997 vb_pot.n37 vb_pot.n34 0.0081885
R2998 vb_pot.n80 vb_pot.n32 0.0081885
R2999 vb_pot.n75 vb_pot.n74 0.0081885
R3000 vb_pot.n77 vb_pot.n33 0.0081885
R3001 vb_pot.n124 vb_pot.n29 0.0081885
R3002 vb_pot.n124 vb_pot.n123 0.0081885
R3003 vb_pot.n131 vb_pot.n125 0.0081885
R3004 vb_pot.n134 vb_pot.n25 0.0081885
R3005 vb_pot.n27 vb_pot.n24 0.0081885
R3006 vb_pot.n132 vb_pot.n22 0.0081885
R3007 vb_pot.n128 vb_pot.n127 0.0081885
R3008 vb_pot.n129 vb_pot.n23 0.0081885
R3009 vb_pot.n140 vb_pot.n19 0.0081885
R3010 vb_pot.n140 vb_pot.n139 0.0081885
R3011 vb_pot.n148 vb_pot.n141 0.0081885
R3012 vb_pot.n151 vb_pot.n15 0.0081885
R3013 vb_pot.n17 vb_pot.n14 0.0081885
R3014 vb_pot.n149 vb_pot.n12 0.0081885
R3015 vb_pot.n144 vb_pot.n143 0.0081885
R3016 vb_pot.n146 vb_pot.n13 0.0081885
R3017 vb_pot.n157 vb_pot.n9 0.0081885
R3018 vb_pot.n157 vb_pot.n156 0.0081885
R3019 vb_pot.n165 vb_pot.n158 0.0081885
R3020 vb_pot.n168 vb_pot.n5 0.0081885
R3021 vb_pot.n7 vb_pot.n4 0.0081885
R3022 vb_pot.n166 vb_pot.n2 0.0081885
R3023 vb_pot.n161 vb_pot.n160 0.0081885
R3024 vb_pot.n163 vb_pot.n3 0.0081885
R3025 vb_pot.n99 vb_pot.n98 0.0081885
R3026 vb_pot.n103 vb_pot.n102 0.0081885
R3027 vb_pot.n105 vb_pot.n94 0.0081885
R3028 vb_pot.n112 vb_pot.n111 0.0081885
R3029 vb_pot.n120 vb_pot.n91 0.0081885
R3030 vb_pot.n119 vb_pot.n118 0.0081885
R3031 vb_pot.n111 vb_pot.n89 0.0081885
R3032 vb_pot.n91 vb_pot.n89 0.0081885
R3033 vb_pot.n120 vb_pot.n119 0.0081885
R3034 vb_pot.n99 vb_pot.n95 0.0081885
R3035 vb_pot.n102 vb_pot.n95 0.0081885
R3036 vb_pot.n103 vb_pot.n94 0.0081885
R3037 vb_pot.n166 vb_pot.n4 0.0081885
R3038 vb_pot.n160 vb_pot.n2 0.0081885
R3039 vb_pot.n7 vb_pot.n1 0.0081885
R3040 vb_pot.n161 vb_pot.n3 0.0081885
R3041 vb_pot.n156 vb_pot.n6 0.0081885
R3042 vb_pot.n165 vb_pot.n6 0.0081885
R3043 vb_pot.n170 vb_pot.n9 0.0081885
R3044 vb_pot.n158 vb_pot.n5 0.0081885
R3045 vb_pot.n149 vb_pot.n14 0.0081885
R3046 vb_pot.n143 vb_pot.n12 0.0081885
R3047 vb_pot.n17 vb_pot.n11 0.0081885
R3048 vb_pot.n144 vb_pot.n13 0.0081885
R3049 vb_pot.n139 vb_pot.n16 0.0081885
R3050 vb_pot.n148 vb_pot.n16 0.0081885
R3051 vb_pot.n153 vb_pot.n19 0.0081885
R3052 vb_pot.n141 vb_pot.n15 0.0081885
R3053 vb_pot.n132 vb_pot.n24 0.0081885
R3054 vb_pot.n127 vb_pot.n22 0.0081885
R3055 vb_pot.n27 vb_pot.n21 0.0081885
R3056 vb_pot.n128 vb_pot.n23 0.0081885
R3057 vb_pot.n123 vb_pot.n26 0.0081885
R3058 vb_pot.n131 vb_pot.n26 0.0081885
R3059 vb_pot.n136 vb_pot.n29 0.0081885
R3060 vb_pot.n125 vb_pot.n25 0.0081885
R3061 vb_pot.n80 vb_pot.n34 0.0081885
R3062 vb_pot.n74 vb_pot.n32 0.0081885
R3063 vb_pot.n37 vb_pot.n31 0.0081885
R3064 vb_pot.n75 vb_pot.n33 0.0081885
R3065 vb_pot.n70 vb_pot.n36 0.0081885
R3066 vb_pot.n79 vb_pot.n36 0.0081885
R3067 vb_pot.n84 vb_pot.n39 0.0081885
R3068 vb_pot.n72 vb_pot.n35 0.0081885
R3069 vb_pot.n63 vb_pot.n44 0.0081885
R3070 vb_pot.n57 vb_pot.n42 0.0081885
R3071 vb_pot.n47 vb_pot.n41 0.0081885
R3072 vb_pot.n58 vb_pot.n43 0.0081885
R3073 vb_pot.n53 vb_pot.n46 0.0081885
R3074 vb_pot.n62 vb_pot.n46 0.0081885
R3075 vb_pot.n67 vb_pot.n49 0.0081885
R3076 vb_pot.n55 vb_pot.n45 0.0081885
R3077 vb_pot.n209 vb_pot.n203 0.00717136
R3078 vb_pot.n104 vb_pot.n97 0.00328455
R3079 vb_pot.n107 vb_pot.n101 0.00328455
R3080 vb_pot.n106 vb_pot.n96 0.00328455
R3081 vb_pot.n109 vb_pot.n93 0.00328455
R3082 vb_pot.n117 vb_pot.n116 0.00328455
R3083 vb_pot.n121 vb_pot.n87 0.00328455
R3084 vb_pot.n92 vb_pot.n90 0.00328455
R3085 vb_pot.n115 vb_pot.n113 0.00328455
R3086 vb_pot.n117 vb_pot.n110 0.00328455
R3087 vb_pot.n116 vb_pot.n87 0.00328455
R3088 vb_pot.n121 vb_pot.n90 0.00328455
R3089 vb_pot.n113 vb_pot.n92 0.00328455
R3090 vb_pot.n104 vb_pot.n100 0.00328455
R3091 vb_pot.n101 vb_pot.n97 0.00328455
R3092 vb_pot.n107 vb_pot.n106 0.00328455
R3093 vb_pot.n96 vb_pot.n93 0.00328455
R3094 vb_pot.n133 vb_pot.n122 0.00229167
R3095 vb_pot.n64 vb_pot.n61 0.00211084
R3096 vb_pot.n64 vb_pot.n59 0.00211084
R3097 vb_pot.n56 vb_pot.n48 0.00211084
R3098 vb_pot.n68 vb_pot.n40 0.00211084
R3099 vb_pot.n81 vb_pot.n78 0.00211084
R3100 vb_pot.n81 vb_pot.n76 0.00211084
R3101 vb_pot.n73 vb_pot.n38 0.00211084
R3102 vb_pot.n85 vb_pot.n30 0.00211084
R3103 vb_pot.n133 vb_pot.n130 0.00211084
R3104 vb_pot.n126 vb_pot.n28 0.00211084
R3105 vb_pot.n137 vb_pot.n20 0.00211084
R3106 vb_pot.n150 vb_pot.n147 0.00211084
R3107 vb_pot.n150 vb_pot.n145 0.00211084
R3108 vb_pot.n142 vb_pot.n18 0.00211084
R3109 vb_pot.n154 vb_pot.n10 0.00211084
R3110 vb_pot.n167 vb_pot.n164 0.00211084
R3111 vb_pot.n167 vb_pot.n162 0.00211084
R3112 vb_pot.n159 vb_pot.n8 0.00211084
R3113 vb_pot.n171 vb_pot.n0 0.00211084
R3114 vb_pot.n164 vb_pot.n155 0.00211084
R3115 vb_pot.n169 vb_pot.n159 0.00211084
R3116 vb_pot.n169 vb_pot.n162 0.00211084
R3117 vb_pot.n8 vb_pot.n0 0.00211084
R3118 vb_pot.n147 vb_pot.n138 0.00211084
R3119 vb_pot.n152 vb_pot.n142 0.00211084
R3120 vb_pot.n152 vb_pot.n145 0.00211084
R3121 vb_pot.n18 vb_pot.n10 0.00211084
R3122 vb_pot.n130 vb_pot.n86 0.00211084
R3123 vb_pot.n135 vb_pot.n126 0.00211084
R3124 vb_pot.n28 vb_pot.n20 0.00211084
R3125 vb_pot.n78 vb_pot.n69 0.00211084
R3126 vb_pot.n83 vb_pot.n73 0.00211084
R3127 vb_pot.n83 vb_pot.n76 0.00211084
R3128 vb_pot.n38 vb_pot.n30 0.00211084
R3129 vb_pot.n61 vb_pot.n52 0.00211084
R3130 vb_pot.n66 vb_pot.n56 0.00211084
R3131 vb_pot.n66 vb_pot.n59 0.00211084
R3132 vb_pot.n48 vb_pot.n40 0.00211084
R3133 vb_pot.n752 vb_pot.n217 0.00100362
R3134 vb_pot.n840 vb_pot.n184 0.00100362
R3135 vb_pot.n135 vb_pot.n122 0.000930556
R3136 vb_pot.n839 vb_pot.n185 0.000916667
R3137 vb_pot.n823 vb_pot.n822 0.000916667
R3138 vb_itp vb_itp.n0 9.49353
R3139 vb_itd vb_itd.n0 9.84237
R3140 vb_idep vb_idep.n0 23.2425
R3141 vpre vpre.n0 29.108
R3142 vpost vpost.n0 29.108
R3143 nvpre nvpre.n0 29.108
R3144 nvpost nvpost.n0 29.108
R3145 avss.n581 avss.n191 27273.1
R3146 avss.n600 avss.n191 16706
R3147 avss.n599 avss.n598 14475
R3148 avss.n598 avss.n597 14475
R3149 avss.n601 avss.n190 14000
R3150 avss.n598 avss.n193 14000
R3151 avss.n599 avss.n192 14000
R3152 avss.n597 avss.n596 14000
R3153 avss.n602 avss.n160 14000
R3154 avss.n597 avss.n191 12850
R3155 avss.n600 avss.n599 5350
R3156 avss.n633 avss.n602 4051.72
R3157 avss.n670 avss.n669 2283.78
R3158 avss.n346 avss.n143 2283.78
R3159 avss.n602 avss.n601 1970.19
R3160 avss.n669 avss.n125 1051.61
R3161 avss.n601 avss.n600 736.802
R3162 avss.n357 avss.n356 203.708
R3163 avss.n633 avss.n183 203.343
R3164 avss.n648 avss.n183 203.343
R3165 avss.n702 avss.n96 203.343
R3166 avss.n761 avss.n96 203.343
R3167 avss.n544 avss.n543 198.688
R3168 avss.n648 avss.n125 187.267
R3169 avss.n431 avss.n430 182.19
R3170 avss.n581 avss.n215 182.19
R3171 avss.n428 avss.n192 157.803
R3172 avss.n356 avss.n299 114.766
R3173 avss.n368 avss.n357 114.766
R3174 avss.n374 avss.n272 114.766
R3175 avss.n385 avss.n272 114.766
R3176 avss.n385 avss.n266 114.766
R3177 avss.n394 avss.n266 114.766
R3178 avss.n394 avss.n251 114.766
R3179 avss.n409 avss.n259 114.766
R3180 avss.n553 avss.n238 114.766
R3181 avss.n569 avss.n225 114.766
R3182 avss.n543 avss.n542 114.766
R3183 avss.n522 avss.n521 114.766
R3184 avss.n511 avss.n462 114.766
R3185 avss.n595 avss.n196 114.766
R3186 avss.n415 avss.n190 111.897
R3187 avss.n552 avss.n241 104.007
R3188 avss.n561 avss.n231 104.007
R3189 avss.n531 avss.n530 101.855
R3190 avss.n467 avss.n441 101.855
R3191 avss.n589 avss.n205 100.419
R3192 avss.n589 avss.n588 98.268
R3193 avss.n214 avss.n208 98.268
R3194 avss.n561 avss.n232 94.6816
R3195 avss.n596 avss.n194 84.6397
R3196 avss.n680 avss.n160 83.2051
R3197 avss.n512 avss.n194 74.5977
R3198 avss.n408 avss.n238 73.1632
R3199 avss.n521 avss.n520 71.0113
R3200 avss.n461 avss.n445 71.0113
R3201 avss.n582 avss.n213 68.9311
R3202 avss.n582 avss.n210 68.9311
R3203 avss.n587 avss.n209 68.9311
R3204 avss.n209 avss.n207 68.9311
R3205 avss.n513 avss.n460 68.9311
R3206 avss.n513 avss.n447 68.9311
R3207 avss.n519 avss.n446 68.9311
R3208 avss.n446 avss.n444 68.9311
R3209 avss.n532 avss.n429 68.9311
R3210 avss.n541 avss.n532 68.9311
R3211 avss.n545 avss.n427 68.9311
R3212 avss.n545 avss.n426 68.9311
R3213 avss.n425 avss.n424 68.9311
R3214 avss.n425 avss.n243 68.9311
R3215 avss.n551 avss.n242 68.9311
R3216 avss.n242 avss.n240 68.9311
R3217 avss.n417 avss.n249 67.7644
R3218 avss.n417 avss.n250 67.7644
R3219 avss.n375 avss.n298 67.7644
R3220 avss.n373 avss.n298 67.7644
R3221 avss.n300 avss.n299 67.4249
R3222 avss.n374 avss.n368 67.4249
R3223 avss.n416 avss.n251 67.4249
R3224 avss.n580 avss.n216 66.6949
R3225 avss.n580 avss.n217 66.6949
R3226 avss.n472 avss.n433 66.6949
R3227 avss.n473 avss.n472 66.6949
R3228 avss.n568 avss.n224 66.6949
R3229 avss.n570 avss.n224 66.6949
R3230 avss.n367 avss.n271 66.6949
R3231 avss.n367 avss.n358 66.6949
R3232 avss.n163 avss.n159 66.6949
R3233 avss.n679 avss.n163 66.6949
R3234 avss.n647 avss.n185 66.6949
R3235 avss.n634 avss.n185 66.6949
R3236 avss.n355 avss.n158 66.6949
R3237 avss.n355 avss.n301 66.6949
R3238 avss.n319 avss.n318 66.6949
R3239 avss.n319 avss.n136 66.6949
R3240 avss.n109 avss.n105 66.6949
R3241 avss.n760 avss.n105 66.6949
R3242 avss.n704 avss.n95 66.6949
R3243 avss.n762 avss.n95 66.6949
R3244 avss.n530 avss.n193 57.383
R3245 avss.n467 avss.n193 57.383
R3246 avss.n416 avss.n415 47.341
R3247 avss.n815 avss.n814 45.5355
R3248 avss.n520 avss.n445 43.7546
R3249 avss.n462 avss.n461 43.7546
R3250 avss.n409 avss.n408 41.6028
R3251 avss.n512 avss.n511 40.1682
R3252 avss.n143 avss.n125 31.7197
R3253 avss.n300 avss.n160 31.5609
R3254 avss.n596 avss.n595 30.1263
R3255 avss.n569 avss.n192 24.3881
R3256 avss.n232 avss.n225 20.0844
R3257 avss.n456 avss.n455 19.4509
R3258 avss.n848 avss.n847 17.8359
R3259 vw avss.n848 16.6847
R3260 avss.n588 avss.n208 16.498
R3261 avss.n215 avss.n214 16.498
R3262 avss.n587 avss.n210 15.5561
R3263 avss.n213 avss.n207 15.5561
R3264 avss.n519 avss.n447 15.5561
R3265 avss.n460 avss.n444 15.5561
R3266 avss.n541 avss.n427 15.5561
R3267 avss.n429 avss.n426 15.5561
R3268 avss.n551 avss.n243 15.5561
R3269 avss.n424 avss.n240 15.5561
R3270 avss.n375 avss.n275 15.5561
R3271 avss.n384 avss.n275 15.5561
R3272 avss.n384 avss.n276 15.5561
R3273 avss.n276 avss.n250 15.5561
R3274 avss.n373 avss.n369 15.5561
R3275 avss.n369 avss.n273 15.5561
R3276 avss.n282 avss.n273 15.5561
R3277 avss.n282 avss.n249 15.5561
R3278 avss.n529 avss.n433 15.5561
R3279 avss.n529 avss.n434 15.5561
R3280 avss.n523 avss.n434 15.5561
R3281 avss.n523 avss.n440 15.5561
R3282 avss.n503 avss.n440 15.5561
R3283 avss.n503 avss.n501 15.5561
R3284 avss.n510 avss.n501 15.5561
R3285 avss.n510 avss.n197 15.5561
R3286 avss.n594 avss.n197 15.5561
R3287 avss.n594 avss.n198 15.5561
R3288 avss.n590 avss.n198 15.5561
R3289 avss.n590 avss.n204 15.5561
R3290 avss.n217 avss.n204 15.5561
R3291 avss.n473 avss.n432 15.5561
R3292 avss.n468 avss.n432 15.5561
R3293 avss.n468 avss.n442 15.5561
R3294 avss.n443 avss.n442 15.5561
R3295 avss.n481 avss.n443 15.5561
R3296 avss.n481 avss.n463 15.5561
R3297 avss.n500 avss.n463 15.5561
R3298 avss.n500 avss.n464 15.5561
R3299 avss.n464 avss.n195 15.5561
R3300 avss.n495 avss.n195 15.5561
R3301 avss.n495 avss.n206 15.5561
R3302 avss.n492 avss.n206 15.5561
R3303 avss.n492 avss.n216 15.5561
R3304 avss.n386 avss.n271 15.5561
R3305 avss.n386 avss.n267 15.5561
R3306 avss.n393 avss.n267 15.5561
R3307 avss.n393 avss.n253 15.5561
R3308 avss.n414 avss.n253 15.5561
R3309 avss.n414 avss.n254 15.5561
R3310 avss.n410 avss.n254 15.5561
R3311 avss.n410 avss.n237 15.5561
R3312 avss.n554 avss.n237 15.5561
R3313 avss.n554 avss.n233 15.5561
R3314 avss.n560 avss.n233 15.5561
R3315 avss.n560 avss.n223 15.5561
R3316 avss.n570 avss.n223 15.5561
R3317 avss.n358 avss.n274 15.5561
R3318 avss.n274 avss.n265 15.5561
R3319 avss.n395 avss.n265 15.5561
R3320 avss.n396 avss.n395 15.5561
R3321 avss.n396 avss.n252 15.5561
R3322 avss.n260 avss.n252 15.5561
R3323 avss.n407 avss.n260 15.5561
R3324 avss.n407 avss.n261 15.5561
R3325 avss.n261 avss.n239 15.5561
R3326 avss.n239 avss.n230 15.5561
R3327 avss.n562 avss.n230 15.5561
R3328 avss.n562 avss.n226 15.5561
R3329 avss.n568 avss.n226 15.5561
R3330 avss.n647 avss.n186 15.5561
R3331 avss.n639 avss.n182 15.5561
R3332 avss.n651 avss.n650 15.5561
R3333 avss.n657 avss.n656 15.5561
R3334 avss.n661 avss.n660 15.5561
R3335 avss.n667 avss.n176 15.5561
R3336 avss.n679 avss.n162 15.5561
R3337 avss.n634 avss.n189 15.5561
R3338 avss.n631 avss.n604 15.5561
R3339 avss.n627 avss.n626 15.5561
R3340 avss.n623 avss.n622 15.5561
R3341 avss.n619 avss.n618 15.5561
R3342 avss.n615 avss.n169 15.5561
R3343 avss.n672 avss.n159 15.5561
R3344 avss.n325 avss.n324 15.5561
R3345 avss.n328 avss.n327 15.5561
R3346 avss.n335 avss.n334 15.5561
R3347 avss.n337 avss.n311 15.5561
R3348 avss.n344 avss.n308 15.5561
R3349 avss.n348 avss.n161 15.5561
R3350 avss.n301 avss.n161 15.5561
R3351 avss.n700 avss.n137 15.5561
R3352 avss.n696 avss.n695 15.5561
R3353 avss.n693 avss.n144 15.5561
R3354 avss.n689 avss.n688 15.5561
R3355 avss.n686 avss.n151 15.5561
R3356 avss.n682 avss.n681 15.5561
R3357 avss.n681 avss.n158 15.5561
R3358 avss.n111 avss.n110 15.5561
R3359 avss.n127 avss.n114 15.5561
R3360 avss.n116 avss.n115 15.5561
R3361 avss.n130 avss.n119 15.5561
R3362 avss.n121 avss.n120 15.5561
R3363 avss.n133 avss.n124 15.5561
R3364 avss.n760 avss.n106 15.5561
R3365 avss.n729 avss.n728 15.5561
R3366 avss.n731 avss.n730 15.5561
R3367 avss.n735 avss.n734 15.5561
R3368 avss.n737 avss.n736 15.5561
R3369 avss.n741 avss.n740 15.5561
R3370 avss.n762 avss.n94 15.5561
R3371 avss.n205 avss.n196 14.3461
R3372 avss.n286 avss.n284 13.589
R3373 avss.n848 avss.n846 13.1971
R3374 avss.n531 avss.n431 12.9116
R3375 avss.n522 avss.n441 12.9116
R3376 avss.n553 avss.n552 10.7597
R3377 avss.n241 avss.n231 10.7597
R3378 avss.n680 avss.n125 10.0424
R3379 avss.n296 avss.n295 9.8159
R3380 avss.n295 avss.n294 9.1923
R3381 avss.n294 avss.n292 9.1923
R3382 avss.n578 avss.n574 6.57316
R3383 avss.n702 avss.n125 5.6489
R3384 avss.n574 avss.n573 5.20876
R3385 avss.n353 avss.n219 5.20876
R3386 avss.n766 avss.n765 5.20876
R3387 avss.n683 avss.n682 5.2005
R3388 avss.n684 avss.n151 5.2005
R3389 avss.n686 avss.n685 5.2005
R3390 avss.n688 avss.n149 5.2005
R3391 avss.n690 avss.n689 5.2005
R3392 avss.n691 avss.n144 5.2005
R3393 avss.n693 avss.n692 5.2005
R3394 avss.n695 avss.n142 5.2005
R3395 avss.n349 avss.n348 5.2005
R3396 avss.n308 avss.n306 5.2005
R3397 avss.n344 avss.n343 5.2005
R3398 avss.n312 avss.n311 5.2005
R3399 avss.n338 avss.n337 5.2005
R3400 avss.n336 avss.n335 5.2005
R3401 avss.n334 avss.n333 5.2005
R3402 avss.n327 avss.n314 5.2005
R3403 avss.n673 avss.n672 5.2005
R3404 avss.n169 avss.n168 5.2005
R3405 avss.n616 avss.n615 5.2005
R3406 avss.n618 avss.n617 5.2005
R3407 avss.n620 avss.n619 5.2005
R3408 avss.n622 avss.n621 5.2005
R3409 avss.n624 avss.n623 5.2005
R3410 avss.n626 avss.n625 5.2005
R3411 avss.n164 avss.n162 5.2005
R3412 avss.n667 avss.n666 5.2005
R3413 avss.n177 avss.n176 5.2005
R3414 avss.n662 avss.n661 5.2005
R3415 avss.n660 avss.n659 5.2005
R3416 avss.n658 avss.n657 5.2005
R3417 avss.n656 avss.n179 5.2005
R3418 avss.n652 avss.n651 5.2005
R3419 avss.n303 avss.n158 5.2005
R3420 avss.n300 avss.n158 5.2005
R3421 avss.n681 avss.n156 5.2005
R3422 avss.n681 avss.n680 5.2005
R3423 avss.n351 avss.n301 5.2005
R3424 avss.n301 avss.n300 5.2005
R3425 avss.n350 avss.n161 5.2005
R3426 avss.n680 avss.n161 5.2005
R3427 avss.n568 avss.n567 5.2005
R3428 avss.n569 avss.n568 5.2005
R3429 avss.n227 avss.n226 5.2005
R3430 avss.n226 avss.n225 5.2005
R3431 avss.n563 avss.n562 5.2005
R3432 avss.n562 avss.n561 5.2005
R3433 avss.n230 avss.n229 5.2005
R3434 avss.n241 avss.n230 5.2005
R3435 avss.n404 avss.n239 5.2005
R3436 avss.n553 avss.n239 5.2005
R3437 avss.n405 avss.n261 5.2005
R3438 avss.n261 avss.n238 5.2005
R3439 avss.n407 avss.n406 5.2005
R3440 avss.n409 avss.n407 5.2005
R3441 avss.n262 avss.n260 5.2005
R3442 avss.n260 avss.n259 5.2005
R3443 avss.n398 avss.n252 5.2005
R3444 avss.n415 avss.n252 5.2005
R3445 avss.n397 avss.n396 5.2005
R3446 avss.n396 avss.n251 5.2005
R3447 avss.n395 avss.n264 5.2005
R3448 avss.n395 avss.n394 5.2005
R3449 avss.n362 avss.n265 5.2005
R3450 avss.n266 avss.n265 5.2005
R3451 avss.n363 avss.n274 5.2005
R3452 avss.n385 avss.n274 5.2005
R3453 avss.n364 avss.n358 5.2005
R3454 avss.n358 avss.n272 5.2005
R3455 avss.n571 avss.n570 5.2005
R3456 avss.n570 avss.n569 5.2005
R3457 avss.n223 avss.n222 5.2005
R3458 avss.n225 avss.n223 5.2005
R3459 avss.n560 avss.n559 5.2005
R3460 avss.n561 avss.n560 5.2005
R3461 avss.n234 avss.n233 5.2005
R3462 avss.n241 avss.n233 5.2005
R3463 avss.n555 avss.n554 5.2005
R3464 avss.n554 avss.n553 5.2005
R3465 avss.n237 avss.n236 5.2005
R3466 avss.n238 avss.n237 5.2005
R3467 avss.n411 avss.n410 5.2005
R3468 avss.n410 avss.n409 5.2005
R3469 avss.n412 avss.n254 5.2005
R3470 avss.n259 avss.n254 5.2005
R3471 avss.n414 avss.n413 5.2005
R3472 avss.n415 avss.n414 5.2005
R3473 avss.n255 avss.n253 5.2005
R3474 avss.n253 avss.n251 5.2005
R3475 avss.n393 avss.n392 5.2005
R3476 avss.n394 avss.n393 5.2005
R3477 avss.n268 avss.n267 5.2005
R3478 avss.n267 avss.n266 5.2005
R3479 avss.n387 avss.n386 5.2005
R3480 avss.n386 avss.n385 5.2005
R3481 avss.n271 avss.n270 5.2005
R3482 avss.n272 avss.n271 5.2005
R3483 avss.n491 avss.n216 5.2005
R3484 avss.n216 avss.n215 5.2005
R3485 avss.n493 avss.n492 5.2005
R3486 avss.n492 avss.n208 5.2005
R3487 avss.n494 avss.n206 5.2005
R3488 avss.n589 avss.n206 5.2005
R3489 avss.n496 avss.n495 5.2005
R3490 avss.n495 avss.n196 5.2005
R3491 avss.n497 avss.n195 5.2005
R3492 avss.n595 avss.n195 5.2005
R3493 avss.n498 avss.n464 5.2005
R3494 avss.n464 avss.n194 5.2005
R3495 avss.n500 avss.n499 5.2005
R3496 avss.n511 avss.n500 5.2005
R3497 avss.n465 avss.n463 5.2005
R3498 avss.n463 avss.n462 5.2005
R3499 avss.n482 avss.n481 5.2005
R3500 avss.n481 avss.n445 5.2005
R3501 avss.n480 avss.n443 5.2005
R3502 avss.n521 avss.n443 5.2005
R3503 avss.n479 avss.n442 5.2005
R3504 avss.n522 avss.n442 5.2005
R3505 avss.n469 avss.n468 5.2005
R3506 avss.n468 avss.n467 5.2005
R3507 avss.n475 avss.n432 5.2005
R3508 avss.n530 avss.n432 5.2005
R3509 avss.n474 avss.n473 5.2005
R3510 avss.n473 avss.n431 5.2005
R3511 avss.n576 avss.n217 5.2005
R3512 avss.n217 avss.n215 5.2005
R3513 avss.n204 avss.n203 5.2005
R3514 avss.n208 avss.n204 5.2005
R3515 avss.n591 avss.n590 5.2005
R3516 avss.n590 avss.n589 5.2005
R3517 avss.n592 avss.n198 5.2005
R3518 avss.n198 avss.n196 5.2005
R3519 avss.n594 avss.n593 5.2005
R3520 avss.n595 avss.n594 5.2005
R3521 avss.n199 avss.n197 5.2005
R3522 avss.n197 avss.n194 5.2005
R3523 avss.n510 avss.n509 5.2005
R3524 avss.n511 avss.n510 5.2005
R3525 avss.n502 avss.n501 5.2005
R3526 avss.n501 avss.n462 5.2005
R3527 avss.n504 avss.n503 5.2005
R3528 avss.n503 avss.n445 5.2005
R3529 avss.n440 avss.n439 5.2005
R3530 avss.n521 avss.n440 5.2005
R3531 avss.n524 avss.n523 5.2005
R3532 avss.n523 avss.n522 5.2005
R3533 avss.n436 avss.n434 5.2005
R3534 avss.n467 avss.n434 5.2005
R3535 avss.n529 avss.n528 5.2005
R3536 avss.n530 avss.n529 5.2005
R3537 avss.n435 avss.n433 5.2005
R3538 avss.n433 avss.n431 5.2005
R3539 avss.n674 avss.n159 5.2005
R3540 avss.n680 avss.n159 5.2005
R3541 avss.n679 avss.n678 5.2005
R3542 avss.n680 avss.n679 5.2005
R3543 avss.n281 avss.n249 5.2005
R3544 avss.n394 avss.n249 5.2005
R3545 avss.n283 avss.n282 5.2005
R3546 avss.n282 avss.n266 5.2005
R3547 avss.n383 avss.n273 5.2005
R3548 avss.n385 avss.n273 5.2005
R3549 avss.n369 avss.n290 5.2005
R3550 avss.n369 avss.n272 5.2005
R3551 avss.n373 avss.n372 5.2005
R3552 avss.n374 avss.n373 5.2005
R3553 avss.n379 avss.n250 5.2005
R3554 avss.n394 avss.n250 5.2005
R3555 avss.n291 avss.n276 5.2005
R3556 avss.n276 avss.n266 5.2005
R3557 avss.n384 avss.n383 5.2005
R3558 avss.n385 avss.n384 5.2005
R3559 avss.n277 avss.n275 5.2005
R3560 avss.n275 avss.n272 5.2005
R3561 avss.n376 avss.n375 5.2005
R3562 avss.n375 avss.n374 5.2005
R3563 avss.n424 avss.n423 5.2005
R3564 avss.n424 avss.n231 5.2005
R3565 avss.n247 avss.n240 5.2005
R3566 avss.n552 avss.n240 5.2005
R3567 avss.n549 avss.n243 5.2005
R3568 avss.n243 avss.n231 5.2005
R3569 avss.n551 avss.n550 5.2005
R3570 avss.n552 avss.n551 5.2005
R3571 avss.n536 avss.n429 5.2005
R3572 avss.n542 avss.n429 5.2005
R3573 avss.n535 avss.n426 5.2005
R3574 avss.n543 avss.n426 5.2005
R3575 avss.n541 avss.n540 5.2005
R3576 avss.n542 avss.n541 5.2005
R3577 avss.n533 avss.n427 5.2005
R3578 avss.n543 avss.n427 5.2005
R3579 avss.n460 avss.n459 5.2005
R3580 avss.n461 avss.n460 5.2005
R3581 avss.n453 avss.n444 5.2005
R3582 avss.n520 avss.n444 5.2005
R3583 avss.n517 avss.n447 5.2005
R3584 avss.n461 avss.n447 5.2005
R3585 avss.n519 avss.n518 5.2005
R3586 avss.n520 avss.n519 5.2005
R3587 avss.n449 avss.n213 5.2005
R3588 avss.n214 avss.n213 5.2005
R3589 avss.n450 avss.n207 5.2005
R3590 avss.n588 avss.n207 5.2005
R3591 avss.n585 avss.n210 5.2005
R3592 avss.n214 avss.n210 5.2005
R3593 avss.n587 avss.n586 5.2005
R3594 avss.n588 avss.n587 5.2005
R3595 avss.n697 avss.n696 5.2005
R3596 avss.n698 avss.n137 5.2005
R3597 avss.n700 avss.n699 5.2005
R3598 avss.n138 avss.n136 5.2005
R3599 avss.n329 avss.n328 5.2005
R3600 avss.n326 avss.n325 5.2005
R3601 avss.n324 avss.n323 5.2005
R3602 avss.n318 avss.n316 5.2005
R3603 avss.n628 avss.n627 5.2005
R3604 avss.n629 avss.n604 5.2005
R3605 avss.n631 avss.n630 5.2005
R3606 avss.n189 avss.n188 5.2005
R3607 avss.n635 avss.n634 5.2005
R3608 avss.n634 avss.n633 5.2005
R3609 avss.n650 avss.n181 5.2005
R3610 avss.n641 avss.n182 5.2005
R3611 avss.n640 avss.n639 5.2005
R3612 avss.n645 avss.n186 5.2005
R3613 avss.n647 avss.n646 5.2005
R3614 avss.n648 avss.n647 5.2005
R3615 avss.n705 avss.n704 5.2005
R3616 avss.n706 avss.n124 5.2005
R3617 avss.n133 avss.n122 5.2005
R3618 avss.n710 avss.n121 5.2005
R3619 avss.n711 avss.n120 5.2005
R3620 avss.n712 avss.n119 5.2005
R3621 avss.n130 avss.n117 5.2005
R3622 avss.n716 avss.n116 5.2005
R3623 avss.n717 avss.n115 5.2005
R3624 avss.n718 avss.n114 5.2005
R3625 avss.n127 avss.n112 5.2005
R3626 avss.n722 avss.n111 5.2005
R3627 avss.n723 avss.n110 5.2005
R3628 avss.n724 avss.n109 5.2005
R3629 avss.n763 avss.n762 5.2005
R3630 avss.n762 avss.n761 5.2005
R3631 avss.n94 avss.n93 5.2005
R3632 avss.n742 avss.n741 5.2005
R3633 avss.n743 avss.n740 5.2005
R3634 avss.n738 avss.n737 5.2005
R3635 avss.n747 avss.n736 5.2005
R3636 avss.n748 avss.n735 5.2005
R3637 avss.n749 avss.n734 5.2005
R3638 avss.n732 avss.n731 5.2005
R3639 avss.n753 avss.n730 5.2005
R3640 avss.n754 avss.n729 5.2005
R3641 avss.n755 avss.n728 5.2005
R3642 avss.n107 avss.n106 5.2005
R3643 avss.n760 avss.n759 5.2005
R3644 avss.n761 avss.n760 5.2005
R3645 avss.n584 avss.n583 5.20011
R3646 avss.n583 avss.n212 5.20011
R3647 avss.n454 avss.n448 5.20011
R3648 avss.n539 avss.n538 5.20011
R3649 avss.n538 avss.n537 5.20011
R3650 avss.n579 avss.n218 5.17941
R3651 avss.n471 avss.n437 5.17941
R3652 avss.n471 avss.n470 5.17941
R3653 avss.n566 avss.n220 5.17941
R3654 avss.n366 avss.n269 5.17941
R3655 avss.n366 avss.n365 5.17941
R3656 avss.n638 avss.n637 5.17941
R3657 avss.n637 avss.n636 5.17941
R3658 avss.n354 avss.n304 5.17941
R3659 avss.n321 avss.n320 5.17941
R3660 avss.n320 avss.n317 5.17941
R3661 avss.n758 avss.n726 5.17941
R3662 avss.n123 avss.n91 5.17941
R3663 avss.n726 avss.n725 5.17159
R3664 avss.n457 avss.n456 5.07
R3665 avss.n287 avss.n286 5.03258
R3666 avss.n773 avss.n766 4.95493
R3667 avss.n377 avss.n296 4.7678
R3668 avss.n371 avss.n296 4.7678
R3669 avss.n280 avss.n248 4.7678
R3670 avss.n380 avss.n248 4.7678
R3671 avss.n420 avss.n244 4.75185
R3672 avss.n515 avss.n211 4.75136
R3673 avss.n452 avss.n451 4.75136
R3674 avss.n547 avss.n245 4.75136
R3675 avss.n422 avss.n246 4.75136
R3676 avss.n458 avss.n452 4.75135
R3677 avss.n516 avss.n515 4.75135
R3678 avss.n534 avss.n246 4.75135
R3679 avss.n548 avss.n547 4.75135
R3680 avss.n421 avss.n420 4.75085
R3681 avss.n676 avss.n675 4.73115
R3682 avss.n677 avss.n676 4.73015
R3683 avss.n578 avss.n577 4.7255
R3684 avss.n573 avss.n572 4.7255
R3685 avss.n353 avss.n352 4.7255
R3686 avss.n765 avss.n764 4.7255
R3687 avss.n293 avss.n289 4.6445
R3688 avss.n288 vw 4.6085
R3689 avss.n585 avss.n584 4.5005
R3690 avss.n586 avss.n211 4.5005
R3691 avss.n449 avss.n212 4.5005
R3692 avss.n451 avss.n450 4.5005
R3693 avss.n517 avss.n516 4.5005
R3694 avss.n518 avss.n448 4.5005
R3695 avss.n459 avss.n458 4.5005
R3696 avss.n457 avss.n453 4.5005
R3697 avss.n528 avss.n527 4.5005
R3698 avss.n526 avss.n436 4.5005
R3699 avss.n525 avss.n524 4.5005
R3700 avss.n439 avss.n438 4.5005
R3701 avss.n505 avss.n504 4.5005
R3702 avss.n506 avss.n502 4.5005
R3703 avss.n509 avss.n508 4.5005
R3704 avss.n507 avss.n199 4.5005
R3705 avss.n593 avss.n200 4.5005
R3706 avss.n592 avss.n201 4.5005
R3707 avss.n591 avss.n202 4.5005
R3708 avss.n575 avss.n203 4.5005
R3709 avss.n577 avss.n576 4.5005
R3710 avss.n437 avss.n435 4.5005
R3711 avss.n476 avss.n475 4.5005
R3712 avss.n477 avss.n469 4.5005
R3713 avss.n479 avss.n478 4.5005
R3714 avss.n480 avss.n466 4.5005
R3715 avss.n483 avss.n482 4.5005
R3716 avss.n484 avss.n465 4.5005
R3717 avss.n499 avss.n485 4.5005
R3718 avss.n498 avss.n486 4.5005
R3719 avss.n497 avss.n487 4.5005
R3720 avss.n496 avss.n488 4.5005
R3721 avss.n494 avss.n489 4.5005
R3722 avss.n493 avss.n490 4.5005
R3723 avss.n491 avss.n218 4.5005
R3724 avss.n474 avss.n470 4.5005
R3725 avss.n388 avss.n387 4.5005
R3726 avss.n389 avss.n268 4.5005
R3727 avss.n392 avss.n391 4.5005
R3728 avss.n390 avss.n255 4.5005
R3729 avss.n413 avss.n256 4.5005
R3730 avss.n412 avss.n257 4.5005
R3731 avss.n411 avss.n258 4.5005
R3732 avss.n236 avss.n235 4.5005
R3733 avss.n556 avss.n555 4.5005
R3734 avss.n557 avss.n234 4.5005
R3735 avss.n559 avss.n558 4.5005
R3736 avss.n222 avss.n221 4.5005
R3737 avss.n572 avss.n571 4.5005
R3738 avss.n270 avss.n269 4.5005
R3739 avss.n363 avss.n359 4.5005
R3740 avss.n362 avss.n361 4.5005
R3741 avss.n360 avss.n264 4.5005
R3742 avss.n397 avss.n263 4.5005
R3743 avss.n399 avss.n398 4.5005
R3744 avss.n400 avss.n262 4.5005
R3745 avss.n406 avss.n401 4.5005
R3746 avss.n405 avss.n402 4.5005
R3747 avss.n404 avss.n403 4.5005
R3748 avss.n229 avss.n228 4.5005
R3749 avss.n564 avss.n563 4.5005
R3750 avss.n565 avss.n227 4.5005
R3751 avss.n567 avss.n566 4.5005
R3752 avss.n365 avss.n364 4.5005
R3753 avss.n540 avss.n539 4.5005
R3754 avss.n533 avss.n245 4.5005
R3755 avss.n537 avss.n536 4.5005
R3756 avss.n535 avss.n534 4.5005
R3757 avss.n423 avss.n422 4.5005
R3758 avss.n421 avss.n247 4.5005
R3759 avss.n549 avss.n548 4.5005
R3760 avss.n550 avss.n244 4.5005
R3761 avss.n378 avss.n277 4.5005
R3762 avss.n383 avss.n382 4.5005
R3763 avss.n381 avss.n291 4.5005
R3764 avss.n380 avss.n379 4.5005
R3765 avss.n377 avss.n376 4.5005
R3766 avss.n372 avss.n371 4.5005
R3767 avss.n370 avss.n290 4.5005
R3768 avss.n383 avss.n278 4.5005
R3769 avss.n283 avss.n279 4.5005
R3770 avss.n281 avss.n280 4.5005
R3771 avss.n288 avss.n284 4.5005
R3772 avss.n383 avss.n289 4.5005
R3773 avss.n645 avss.n644 4.5005
R3774 avss.n643 avss.n640 4.5005
R3775 avss.n642 avss.n641 4.5005
R3776 avss.n181 avss.n180 4.5005
R3777 avss.n653 avss.n652 4.5005
R3778 avss.n654 avss.n179 4.5005
R3779 avss.n658 avss.n655 4.5005
R3780 avss.n659 avss.n178 4.5005
R3781 avss.n663 avss.n662 4.5005
R3782 avss.n664 avss.n177 4.5005
R3783 avss.n666 avss.n665 4.5005
R3784 avss.n165 avss.n164 4.5005
R3785 avss.n678 avss.n677 4.5005
R3786 avss.n646 avss.n638 4.5005
R3787 avss.n188 avss.n187 4.5005
R3788 avss.n630 avss.n605 4.5005
R3789 avss.n629 avss.n606 4.5005
R3790 avss.n628 avss.n607 4.5005
R3791 avss.n625 avss.n608 4.5005
R3792 avss.n624 avss.n609 4.5005
R3793 avss.n621 avss.n610 4.5005
R3794 avss.n620 avss.n611 4.5005
R3795 avss.n617 avss.n612 4.5005
R3796 avss.n616 avss.n614 4.5005
R3797 avss.n613 avss.n168 4.5005
R3798 avss.n673 avss.n167 4.5005
R3799 avss.n675 avss.n674 4.5005
R3800 avss.n636 avss.n635 4.5005
R3801 avss.n323 avss.n322 4.5005
R3802 avss.n326 avss.n315 4.5005
R3803 avss.n330 avss.n329 4.5005
R3804 avss.n331 avss.n314 4.5005
R3805 avss.n333 avss.n332 4.5005
R3806 avss.n336 avss.n313 4.5005
R3807 avss.n339 avss.n338 4.5005
R3808 avss.n340 avss.n312 4.5005
R3809 avss.n343 avss.n342 4.5005
R3810 avss.n341 avss.n306 4.5005
R3811 avss.n349 avss.n307 4.5005
R3812 avss.n350 avss.n305 4.5005
R3813 avss.n352 avss.n351 4.5005
R3814 avss.n321 avss.n316 4.5005
R3815 avss.n699 avss.n139 4.5005
R3816 avss.n698 avss.n140 4.5005
R3817 avss.n697 avss.n141 4.5005
R3818 avss.n145 avss.n142 4.5005
R3819 avss.n692 avss.n146 4.5005
R3820 avss.n691 avss.n147 4.5005
R3821 avss.n690 avss.n148 4.5005
R3822 avss.n152 avss.n149 4.5005
R3823 avss.n685 avss.n153 4.5005
R3824 avss.n684 avss.n154 4.5005
R3825 avss.n683 avss.n155 4.5005
R3826 avss.n302 avss.n156 4.5005
R3827 avss.n304 avss.n303 4.5005
R3828 avss.n317 avss.n138 4.5005
R3829 avss.n757 avss.n107 4.5005
R3830 avss.n756 avss.n755 4.5005
R3831 avss.n754 avss.n727 4.5005
R3832 avss.n753 avss.n752 4.5005
R3833 avss.n751 avss.n732 4.5005
R3834 avss.n750 avss.n749 4.5005
R3835 avss.n748 avss.n733 4.5005
R3836 avss.n747 avss.n746 4.5005
R3837 avss.n745 avss.n738 4.5005
R3838 avss.n744 avss.n743 4.5005
R3839 avss.n742 avss.n739 4.5005
R3840 avss.n93 avss.n92 4.5005
R3841 avss.n764 avss.n763 4.5005
R3842 avss.n759 avss.n758 4.5005
R3843 avss.n723 avss.n108 4.5005
R3844 avss.n722 avss.n721 4.5005
R3845 avss.n720 avss.n112 4.5005
R3846 avss.n719 avss.n718 4.5005
R3847 avss.n717 avss.n113 4.5005
R3848 avss.n716 avss.n715 4.5005
R3849 avss.n714 avss.n117 4.5005
R3850 avss.n713 avss.n712 4.5005
R3851 avss.n711 avss.n118 4.5005
R3852 avss.n710 avss.n709 4.5005
R3853 avss.n708 avss.n122 4.5005
R3854 avss.n707 avss.n706 4.5005
R3855 avss.n705 avss.n123 4.5005
R3856 avss.n725 avss.n724 4.5005
R3857 avss.n820 avss.n810 4.5005
R3858 avss.n810 avss.n788 4.5005
R3859 avss.n816 avss.n788 4.5005
R3860 avss.n821 avss.n820 4.5005
R3861 avss.n821 avss.n789 4.5005
R3862 avss.n821 avss.n788 4.5005
R3863 avss.n820 avss.n792 4.5005
R3864 avss.n792 avss.n789 4.5005
R3865 avss.n792 avss.n788 4.5005
R3866 avss.n815 avss.n789 4.5005
R3867 avss.n815 avss.n788 4.5005
R3868 avss.n803 avss.n800 4.5005
R3869 avss.n808 avss.n800 4.5005
R3870 avss.n808 avss.n797 4.5005
R3871 avss.n807 avss.n803 4.5005
R3872 avss.n807 avss.n795 4.5005
R3873 avss.n808 avss.n807 4.5005
R3874 avss.n803 avss.n796 4.5005
R3875 avss.n796 avss.n795 4.5005
R3876 avss.n808 avss.n796 4.5005
R3877 avss.n809 avss.n795 4.5005
R3878 avss.n809 avss.n808 4.5005
R3879 avss.n775 avss.n77 4.5005
R3880 avss.n775 avss.n75 4.5005
R3881 avss.n775 avss.n78 4.5005
R3882 avss.n775 avss.n74 4.5005
R3883 avss.n770 avss.n74 4.5005
R3884 avss.n84 avss.n75 4.5005
R3885 avss.n84 avss.n78 4.5005
R3886 avss.n84 avss.n74 4.5005
R3887 avss.n773 avss.n75 4.5005
R3888 avss.n773 avss.n78 4.5005
R3889 avss.n773 avss.n74 4.5005
R3890 avss.n775 avss.n79 4.5005
R3891 avss.n775 avss.n73 4.5005
R3892 avss.n775 avss.n774 4.5005
R3893 avss.n770 avss.n79 4.5005
R3894 avss.n84 avss.n79 4.5005
R3895 avss.n84 avss.n73 4.5005
R3896 avss.n772 avss.n84 4.5005
R3897 avss.n85 avss.n84 4.5005
R3898 avss.n774 avss.n84 4.5005
R3899 avss.n82 avss.n79 4.5005
R3900 avss.n82 avss.n73 4.5005
R3901 avss.n772 avss.n82 4.5005
R3902 avss.n774 avss.n82 4.5005
R3903 avss.n773 avss.n772 4.5005
R3904 avss.n774 avss.n773 4.5005
R3905 avss.n784 avss.n59 4.5005
R3906 avss.n784 avss.n57 4.5005
R3907 avss.n784 avss.n60 4.5005
R3908 avss.n784 avss.n56 4.5005
R3909 avss.n779 avss.n56 4.5005
R3910 avss.n66 avss.n57 4.5005
R3911 avss.n66 avss.n60 4.5005
R3912 avss.n66 avss.n56 4.5005
R3913 avss.n782 avss.n57 4.5005
R3914 avss.n782 avss.n60 4.5005
R3915 avss.n782 avss.n56 4.5005
R3916 avss.n784 avss.n61 4.5005
R3917 avss.n784 avss.n55 4.5005
R3918 avss.n784 avss.n783 4.5005
R3919 avss.n779 avss.n61 4.5005
R3920 avss.n66 avss.n61 4.5005
R3921 avss.n66 avss.n55 4.5005
R3922 avss.n781 avss.n66 4.5005
R3923 avss.n67 avss.n66 4.5005
R3924 avss.n783 avss.n66 4.5005
R3925 avss.n64 avss.n61 4.5005
R3926 avss.n64 avss.n55 4.5005
R3927 avss.n781 avss.n64 4.5005
R3928 avss.n783 avss.n64 4.5005
R3929 avss.n782 avss.n781 4.5005
R3930 avss.n783 avss.n782 4.5005
R3931 avss.n828 avss.n41 4.5005
R3932 avss.n828 avss.n39 4.5005
R3933 avss.n828 avss.n42 4.5005
R3934 avss.n828 avss.n38 4.5005
R3935 avss.n823 avss.n41 4.5005
R3936 avss.n823 avss.n38 4.5005
R3937 avss.n48 avss.n41 4.5005
R3938 avss.n48 avss.n39 4.5005
R3939 avss.n48 avss.n42 4.5005
R3940 avss.n48 avss.n38 4.5005
R3941 avss.n826 avss.n39 4.5005
R3942 avss.n826 avss.n42 4.5005
R3943 avss.n826 avss.n38 4.5005
R3944 avss.n828 avss.n43 4.5005
R3945 avss.n828 avss.n37 4.5005
R3946 avss.n828 avss.n827 4.5005
R3947 avss.n823 avss.n43 4.5005
R3948 avss.n48 avss.n43 4.5005
R3949 avss.n48 avss.n37 4.5005
R3950 avss.n825 avss.n48 4.5005
R3951 avss.n49 avss.n48 4.5005
R3952 avss.n827 avss.n48 4.5005
R3953 avss.n46 avss.n43 4.5005
R3954 avss.n46 avss.n37 4.5005
R3955 avss.n825 avss.n46 4.5005
R3956 avss.n827 avss.n46 4.5005
R3957 avss.n826 avss.n825 4.5005
R3958 avss.n827 avss.n826 4.5005
R3959 avss.n837 avss.n23 4.5005
R3960 avss.n837 avss.n21 4.5005
R3961 avss.n837 avss.n24 4.5005
R3962 avss.n837 avss.n20 4.5005
R3963 avss.n832 avss.n20 4.5005
R3964 avss.n30 avss.n21 4.5005
R3965 avss.n30 avss.n24 4.5005
R3966 avss.n30 avss.n20 4.5005
R3967 avss.n835 avss.n21 4.5005
R3968 avss.n835 avss.n24 4.5005
R3969 avss.n835 avss.n20 4.5005
R3970 avss.n837 avss.n25 4.5005
R3971 avss.n837 avss.n19 4.5005
R3972 avss.n837 avss.n836 4.5005
R3973 avss.n832 avss.n25 4.5005
R3974 avss.n30 avss.n25 4.5005
R3975 avss.n30 avss.n19 4.5005
R3976 avss.n834 avss.n30 4.5005
R3977 avss.n31 avss.n30 4.5005
R3978 avss.n836 avss.n30 4.5005
R3979 avss.n28 avss.n25 4.5005
R3980 avss.n28 avss.n19 4.5005
R3981 avss.n834 avss.n28 4.5005
R3982 avss.n836 avss.n28 4.5005
R3983 avss.n835 avss.n834 4.5005
R3984 avss.n836 avss.n835 4.5005
R3985 avss.n846 avss.n5 4.5005
R3986 avss.n846 avss.n3 4.5005
R3987 avss.n846 avss.n6 4.5005
R3988 avss.n846 avss.n2 4.5005
R3989 avss.n841 avss.n2 4.5005
R3990 avss.n12 avss.n3 4.5005
R3991 avss.n12 avss.n6 4.5005
R3992 avss.n12 avss.n2 4.5005
R3993 avss.n844 avss.n3 4.5005
R3994 avss.n844 avss.n6 4.5005
R3995 avss.n844 avss.n2 4.5005
R3996 avss.n846 avss.n7 4.5005
R3997 avss.n846 avss.n1 4.5005
R3998 avss.n846 avss.n845 4.5005
R3999 avss.n841 avss.n7 4.5005
R4000 avss.n12 avss.n7 4.5005
R4001 avss.n12 avss.n1 4.5005
R4002 avss.n843 avss.n12 4.5005
R4003 avss.n13 avss.n12 4.5005
R4004 avss.n845 avss.n12 4.5005
R4005 avss.n10 avss.n7 4.5005
R4006 avss.n10 avss.n1 4.5005
R4007 avss.n843 avss.n10 4.5005
R4008 avss.n845 avss.n10 4.5005
R4009 avss.n844 avss.n843 4.5005
R4010 avss.n845 avss.n844 4.5005
R4011 avss.n90 vw 4.5005
R4012 avss.n542 avss.n430 3.5869
R4013 avss.n639 avss.n184 3.11744
R4014 avss.n650 avss.n649 3.11744
R4015 avss.n656 avss.n173 3.11744
R4016 avss.n660 avss.n174 3.11744
R4017 avss.n176 avss.n175 3.11744
R4018 avss.n668 avss.n162 3.11744
R4019 avss.n632 avss.n631 3.11744
R4020 avss.n627 avss.n603 3.11744
R4021 avss.n623 avss.n170 3.11744
R4022 avss.n619 avss.n171 3.11744
R4023 avss.n615 avss.n172 3.11744
R4024 avss.n672 avss.n671 3.11744
R4025 avss.n324 avss.n97 3.11744
R4026 avss.n328 avss.n98 3.11744
R4027 avss.n334 avss.n309 3.11744
R4028 avss.n337 avss.n310 3.11744
R4029 avss.n345 avss.n344 3.11744
R4030 avss.n348 avss.n347 3.11744
R4031 avss.n701 avss.n700 3.11744
R4032 avss.n696 avss.n135 3.11744
R4033 avss.n694 avss.n693 3.11744
R4034 avss.n689 avss.n150 3.11744
R4035 avss.n687 avss.n686 3.11744
R4036 avss.n682 avss.n157 3.11744
R4037 avss.n157 avss.n151 3.11744
R4038 avss.n688 avss.n687 3.11744
R4039 avss.n150 avss.n144 3.11744
R4040 avss.n695 avss.n694 3.11744
R4041 avss.n347 avss.n308 3.11744
R4042 avss.n345 avss.n311 3.11744
R4043 avss.n335 avss.n310 3.11744
R4044 avss.n327 avss.n309 3.11744
R4045 avss.n671 avss.n169 3.11744
R4046 avss.n618 avss.n172 3.11744
R4047 avss.n622 avss.n171 3.11744
R4048 avss.n626 avss.n170 3.11744
R4049 avss.n668 avss.n667 3.11744
R4050 avss.n661 avss.n175 3.11744
R4051 avss.n657 avss.n174 3.11744
R4052 avss.n651 avss.n173 3.11744
R4053 avss.n137 avss.n135 3.11744
R4054 avss.n701 avss.n136 3.11744
R4055 avss.n325 avss.n98 3.11744
R4056 avss.n318 avss.n97 3.11744
R4057 avss.n604 avss.n603 3.11744
R4058 avss.n632 avss.n189 3.11744
R4059 avss.n649 avss.n182 3.11744
R4060 avss.n186 avss.n184 3.11744
R4061 avss.n126 avss.n109 3.11744
R4062 avss.n128 avss.n111 3.11744
R4063 avss.n129 avss.n114 3.11744
R4064 avss.n131 avss.n116 3.11744
R4065 avss.n132 avss.n119 3.11744
R4066 avss.n134 avss.n121 3.11744
R4067 avss.n703 avss.n124 3.11744
R4068 avss.n704 avss.n703 3.11744
R4069 avss.n134 avss.n133 3.11744
R4070 avss.n132 avss.n120 3.11744
R4071 avss.n131 avss.n130 3.11744
R4072 avss.n129 avss.n115 3.11744
R4073 avss.n128 avss.n127 3.11744
R4074 avss.n126 avss.n110 3.11744
R4075 avss.n728 avss.n104 3.11744
R4076 avss.n730 avss.n103 3.11744
R4077 avss.n734 avss.n102 3.11744
R4078 avss.n736 avss.n101 3.11744
R4079 avss.n740 avss.n100 3.11744
R4080 avss.n99 avss.n94 3.11744
R4081 avss.n741 avss.n99 3.11744
R4082 avss.n737 avss.n100 3.11744
R4083 avss.n735 avss.n101 3.11744
R4084 avss.n731 avss.n102 3.11744
R4085 avss.n729 avss.n103 3.11744
R4086 avss.n106 avss.n104 3.11744
R4087 avss.n259 avss.n190 2.86962
R4088 avss.n88 avss.n76 2.25044
R4089 avss.n769 avss.n77 2.25044
R4090 avss.n88 avss.n87 2.25044
R4091 avss.n86 avss.n85 2.25044
R4092 avss.n70 avss.n58 2.25044
R4093 avss.n778 avss.n59 2.25044
R4094 avss.n70 avss.n69 2.25044
R4095 avss.n68 avss.n67 2.25044
R4096 avss.n52 avss.n40 2.25044
R4097 avss.n52 avss.n51 2.25044
R4098 avss.n50 avss.n49 2.25044
R4099 avss.n34 avss.n22 2.25044
R4100 avss.n831 avss.n23 2.25044
R4101 avss.n34 avss.n33 2.25044
R4102 avss.n32 avss.n31 2.25044
R4103 avss.n16 avss.n4 2.25044
R4104 avss.n840 avss.n5 2.25044
R4105 avss.n16 avss.n15 2.25044
R4106 avss.n14 avss.n13 2.25044
R4107 avss.n818 avss.n817 2.24986
R4108 avss.n812 avss.n787 2.24986
R4109 avss.n818 avss.n790 2.24986
R4110 avss.n813 avss.n812 2.24986
R4111 avss.n805 avss.n804 2.24986
R4112 avss.n801 avss.n798 2.24986
R4113 avss.n806 avss.n805 2.24986
R4114 avss.n798 avss.n793 2.24986
R4115 avss.n811 avss.n810 2.24741
R4116 avss.n816 avss.n791 2.24741
R4117 avss.n819 avss.n815 2.24741
R4118 avss.n800 avss.n799 2.24741
R4119 avss.n802 avss.n797 2.24741
R4120 avss.n809 avss.n794 2.24741
R4121 avss.n770 avss.n768 2.24741
R4122 avss.n82 avss.n80 2.24741
R4123 avss.n82 avss.n81 2.24741
R4124 avss.n773 avss.n89 2.24741
R4125 avss.n775 avss.n72 2.24741
R4126 avss.n771 avss.n770 2.24741
R4127 avss.n770 avss.n83 2.24741
R4128 avss.n773 avss.n767 2.24741
R4129 avss.n779 avss.n777 2.24741
R4130 avss.n64 avss.n62 2.24741
R4131 avss.n64 avss.n63 2.24741
R4132 avss.n782 avss.n71 2.24741
R4133 avss.n784 avss.n54 2.24741
R4134 avss.n780 avss.n779 2.24741
R4135 avss.n779 avss.n65 2.24741
R4136 avss.n782 avss.n776 2.24741
R4137 avss.n823 avss.n786 2.24741
R4138 avss.n46 avss.n44 2.24741
R4139 avss.n46 avss.n45 2.24741
R4140 avss.n826 avss.n53 2.24741
R4141 avss.n828 avss.n36 2.24741
R4142 avss.n824 avss.n823 2.24741
R4143 avss.n823 avss.n47 2.24741
R4144 avss.n826 avss.n785 2.24741
R4145 avss.n832 avss.n830 2.24741
R4146 avss.n28 avss.n26 2.24741
R4147 avss.n28 avss.n27 2.24741
R4148 avss.n835 avss.n35 2.24741
R4149 avss.n837 avss.n18 2.24741
R4150 avss.n833 avss.n832 2.24741
R4151 avss.n832 avss.n29 2.24741
R4152 avss.n835 avss.n829 2.24741
R4153 avss.n841 avss.n839 2.24741
R4154 avss.n10 avss.n8 2.24741
R4155 avss.n10 avss.n9 2.24741
R4156 avss.n844 avss.n17 2.24741
R4157 avss.n846 avss.n0 2.24741
R4158 avss.n842 avss.n841 2.24741
R4159 avss.n841 avss.n11 2.24741
R4160 avss.n844 avss.n838 2.24741
R4161 avss.n544 avss.n428 1.43506
R4162 avss.n574 avss.n219 1.3649
R4163 avss.n157 avss.n143 1.04278
R4164 avss.n687 avss.n143 1.04278
R4165 avss.n150 avss.n143 1.04278
R4166 avss.n694 avss.n143 1.04278
R4167 avss.n347 avss.n346 1.04278
R4168 avss.n346 avss.n345 1.04278
R4169 avss.n346 avss.n310 1.04278
R4170 avss.n346 avss.n309 1.04278
R4171 avss.n671 avss.n670 1.04278
R4172 avss.n670 avss.n172 1.04278
R4173 avss.n670 avss.n171 1.04278
R4174 avss.n670 avss.n170 1.04278
R4175 avss.n669 avss.n668 1.04278
R4176 avss.n669 avss.n175 1.04278
R4177 avss.n669 avss.n174 1.04278
R4178 avss.n669 avss.n173 1.04278
R4179 avss.n702 avss.n135 1.04278
R4180 avss.n702 avss.n701 1.04278
R4181 avss.n761 avss.n98 1.04278
R4182 avss.n761 avss.n97 1.04278
R4183 avss.n633 avss.n603 1.04278
R4184 avss.n633 avss.n632 1.04278
R4185 avss.n649 avss.n648 1.04278
R4186 avss.n648 avss.n184 1.04278
R4187 avss.n703 avss.n702 1.04278
R4188 avss.n702 avss.n134 1.04278
R4189 avss.n702 avss.n132 1.04278
R4190 avss.n702 avss.n131 1.04278
R4191 avss.n702 avss.n129 1.04278
R4192 avss.n702 avss.n128 1.04278
R4193 avss.n702 avss.n126 1.04278
R4194 avss.n761 avss.n99 1.04278
R4195 avss.n761 avss.n100 1.04278
R4196 avss.n761 avss.n101 1.04278
R4197 avss.n761 avss.n102 1.04278
R4198 avss.n761 avss.n103 1.04278
R4199 avss.n761 avss.n104 1.04278
R4200 avss.n286 avss.n285 0.795679
R4201 avss.n766 avss.n90 0.7592
R4202 avss.n355 avss.n354 0.743357
R4203 avss.n356 avss.n355 0.743357
R4204 avss.n367 avss.n366 0.743357
R4205 avss.n368 avss.n367 0.743357
R4206 avss.n224 avss.n220 0.743357
R4207 avss.n428 avss.n224 0.743357
R4208 avss.n472 avss.n471 0.743357
R4209 avss.n472 avss.n430 0.743357
R4210 avss.n580 avss.n579 0.743357
R4211 avss.n581 avss.n580 0.743357
R4212 avss.n166 avss.n163 0.743357
R4213 avss.n299 avss.n163 0.743357
R4214 avss.n298 avss.n297 0.743357
R4215 avss.n357 avss.n298 0.743357
R4216 avss.n418 avss.n417 0.743357
R4217 avss.n417 avss.n416 0.743357
R4218 avss.n419 avss.n242 0.743357
R4219 avss.n408 avss.n242 0.743357
R4220 avss.n546 avss.n425 0.743357
R4221 avss.n425 avss.n232 0.743357
R4222 avss.n546 avss.n545 0.743357
R4223 avss.n545 avss.n544 0.743357
R4224 avss.n538 avss.n532 0.743357
R4225 avss.n532 avss.n531 0.743357
R4226 avss.n454 avss.n446 0.743357
R4227 avss.n446 avss.n441 0.743357
R4228 avss.n514 avss.n513 0.743357
R4229 avss.n513 avss.n512 0.743357
R4230 avss.n514 avss.n209 0.743357
R4231 avss.n209 avss.n205 0.743357
R4232 avss.n583 avss.n582 0.743357
R4233 avss.n582 avss.n581 0.743357
R4234 avss.n320 avss.n319 0.743357
R4235 avss.n319 avss.n96 0.743357
R4236 avss.n637 avss.n185 0.743357
R4237 avss.n185 avss.n183 0.743357
R4238 avss.n726 avss.n105 0.743357
R4239 avss.n105 avss.n96 0.743357
R4240 avss.n95 avss.n91 0.743357
R4241 avss.n96 avss.n95 0.743357
R4242 avss.n219 avss.n90 0.6026
R4243 avss.n579 avss.n578 0.454413
R4244 avss.n573 avss.n220 0.454413
R4245 avss.n354 avss.n353 0.454413
R4246 avss.n765 avss.n91 0.454413
R4247 avss.n376 avss.n277 0.148954
R4248 avss.n383 avss.n277 0.148954
R4249 avss.n383 avss.n291 0.148954
R4250 avss.n379 avss.n291 0.148954
R4251 avss.n372 avss.n290 0.148954
R4252 avss.n383 avss.n290 0.148954
R4253 avss.n383 avss.n283 0.148954
R4254 avss.n283 avss.n281 0.148954
R4255 avss.n518 avss.n517 0.1445
R4256 avss.n450 avss.n449 0.1445
R4257 avss.n586 avss.n585 0.1445
R4258 avss.n584 avss.n211 0.1445
R4259 avss.n451 avss.n212 0.1445
R4260 avss.n516 avss.n448 0.1445
R4261 avss.n458 avss.n457 0.1445
R4262 avss.n459 avss.n453 0.1445
R4263 avss.n528 avss.n435 0.1445
R4264 avss.n528 avss.n436 0.1445
R4265 avss.n524 avss.n436 0.1445
R4266 avss.n524 avss.n439 0.1445
R4267 avss.n504 avss.n439 0.1445
R4268 avss.n504 avss.n502 0.1445
R4269 avss.n509 avss.n502 0.1445
R4270 avss.n509 avss.n199 0.1445
R4271 avss.n593 avss.n199 0.1445
R4272 avss.n593 avss.n592 0.1445
R4273 avss.n592 avss.n591 0.1445
R4274 avss.n591 avss.n203 0.1445
R4275 avss.n576 avss.n203 0.1445
R4276 avss.n527 avss.n437 0.1445
R4277 avss.n527 avss.n526 0.1445
R4278 avss.n526 avss.n525 0.1445
R4279 avss.n525 avss.n438 0.1445
R4280 avss.n505 avss.n438 0.1445
R4281 avss.n506 avss.n505 0.1445
R4282 avss.n508 avss.n506 0.1445
R4283 avss.n508 avss.n507 0.1445
R4284 avss.n507 avss.n200 0.1445
R4285 avss.n201 avss.n200 0.1445
R4286 avss.n202 avss.n201 0.1445
R4287 avss.n575 avss.n202 0.1445
R4288 avss.n577 avss.n575 0.1445
R4289 avss.n476 avss.n470 0.1445
R4290 avss.n477 avss.n476 0.1445
R4291 avss.n478 avss.n477 0.1445
R4292 avss.n478 avss.n466 0.1445
R4293 avss.n483 avss.n466 0.1445
R4294 avss.n484 avss.n483 0.1445
R4295 avss.n485 avss.n484 0.1445
R4296 avss.n486 avss.n485 0.1445
R4297 avss.n487 avss.n486 0.1445
R4298 avss.n488 avss.n487 0.1445
R4299 avss.n489 avss.n488 0.1445
R4300 avss.n490 avss.n489 0.1445
R4301 avss.n490 avss.n218 0.1445
R4302 avss.n475 avss.n474 0.1445
R4303 avss.n475 avss.n469 0.1445
R4304 avss.n479 avss.n469 0.1445
R4305 avss.n480 avss.n479 0.1445
R4306 avss.n482 avss.n480 0.1445
R4307 avss.n482 avss.n465 0.1445
R4308 avss.n499 avss.n465 0.1445
R4309 avss.n499 avss.n498 0.1445
R4310 avss.n498 avss.n497 0.1445
R4311 avss.n497 avss.n496 0.1445
R4312 avss.n496 avss.n494 0.1445
R4313 avss.n494 avss.n493 0.1445
R4314 avss.n493 avss.n491 0.1445
R4315 avss.n387 avss.n270 0.1445
R4316 avss.n387 avss.n268 0.1445
R4317 avss.n392 avss.n268 0.1445
R4318 avss.n392 avss.n255 0.1445
R4319 avss.n413 avss.n255 0.1445
R4320 avss.n413 avss.n412 0.1445
R4321 avss.n412 avss.n411 0.1445
R4322 avss.n411 avss.n236 0.1445
R4323 avss.n555 avss.n236 0.1445
R4324 avss.n555 avss.n234 0.1445
R4325 avss.n559 avss.n234 0.1445
R4326 avss.n559 avss.n222 0.1445
R4327 avss.n571 avss.n222 0.1445
R4328 avss.n388 avss.n269 0.1445
R4329 avss.n389 avss.n388 0.1445
R4330 avss.n391 avss.n389 0.1445
R4331 avss.n391 avss.n390 0.1445
R4332 avss.n390 avss.n256 0.1445
R4333 avss.n257 avss.n256 0.1445
R4334 avss.n258 avss.n257 0.1445
R4335 avss.n258 avss.n235 0.1445
R4336 avss.n556 avss.n235 0.1445
R4337 avss.n557 avss.n556 0.1445
R4338 avss.n558 avss.n557 0.1445
R4339 avss.n558 avss.n221 0.1445
R4340 avss.n572 avss.n221 0.1445
R4341 avss.n365 avss.n359 0.1445
R4342 avss.n361 avss.n359 0.1445
R4343 avss.n361 avss.n360 0.1445
R4344 avss.n360 avss.n263 0.1445
R4345 avss.n399 avss.n263 0.1445
R4346 avss.n400 avss.n399 0.1445
R4347 avss.n401 avss.n400 0.1445
R4348 avss.n402 avss.n401 0.1445
R4349 avss.n403 avss.n402 0.1445
R4350 avss.n403 avss.n228 0.1445
R4351 avss.n564 avss.n228 0.1445
R4352 avss.n565 avss.n564 0.1445
R4353 avss.n566 avss.n565 0.1445
R4354 avss.n364 avss.n363 0.1445
R4355 avss.n363 avss.n362 0.1445
R4356 avss.n362 avss.n264 0.1445
R4357 avss.n397 avss.n264 0.1445
R4358 avss.n398 avss.n397 0.1445
R4359 avss.n398 avss.n262 0.1445
R4360 avss.n406 avss.n262 0.1445
R4361 avss.n406 avss.n405 0.1445
R4362 avss.n405 avss.n404 0.1445
R4363 avss.n404 avss.n229 0.1445
R4364 avss.n563 avss.n229 0.1445
R4365 avss.n563 avss.n227 0.1445
R4366 avss.n567 avss.n227 0.1445
R4367 avss.n289 avss.n288 0.1445
R4368 avss.n550 avss.n549 0.1445
R4369 avss.n536 avss.n535 0.1445
R4370 avss.n540 avss.n533 0.1445
R4371 avss.n539 avss.n245 0.1445
R4372 avss.n537 avss.n534 0.1445
R4373 avss.n423 avss.n247 0.1445
R4374 avss.n422 avss.n421 0.1445
R4375 avss.n548 avss.n244 0.1445
R4376 avss.n378 avss.n377 0.1445
R4377 avss.n382 avss.n378 0.1445
R4378 avss.n382 avss.n381 0.1445
R4379 avss.n381 avss.n380 0.1445
R4380 avss.n371 avss.n370 0.1445
R4381 avss.n370 avss.n278 0.1445
R4382 avss.n279 avss.n278 0.1445
R4383 avss.n280 avss.n279 0.1445
R4384 avss.n646 avss.n645 0.1445
R4385 avss.n645 avss.n640 0.1445
R4386 avss.n641 avss.n640 0.1445
R4387 avss.n641 avss.n181 0.1445
R4388 avss.n652 avss.n181 0.1445
R4389 avss.n652 avss.n179 0.1445
R4390 avss.n658 avss.n179 0.1445
R4391 avss.n659 avss.n658 0.1445
R4392 avss.n662 avss.n659 0.1445
R4393 avss.n662 avss.n177 0.1445
R4394 avss.n666 avss.n177 0.1445
R4395 avss.n666 avss.n164 0.1445
R4396 avss.n678 avss.n164 0.1445
R4397 avss.n644 avss.n638 0.1445
R4398 avss.n644 avss.n643 0.1445
R4399 avss.n643 avss.n642 0.1445
R4400 avss.n642 avss.n180 0.1445
R4401 avss.n653 avss.n180 0.1445
R4402 avss.n654 avss.n653 0.1445
R4403 avss.n655 avss.n654 0.1445
R4404 avss.n655 avss.n178 0.1445
R4405 avss.n663 avss.n178 0.1445
R4406 avss.n664 avss.n663 0.1445
R4407 avss.n665 avss.n664 0.1445
R4408 avss.n665 avss.n165 0.1445
R4409 avss.n677 avss.n165 0.1445
R4410 avss.n636 avss.n187 0.1445
R4411 avss.n605 avss.n187 0.1445
R4412 avss.n606 avss.n605 0.1445
R4413 avss.n607 avss.n606 0.1445
R4414 avss.n608 avss.n607 0.1445
R4415 avss.n609 avss.n608 0.1445
R4416 avss.n610 avss.n609 0.1445
R4417 avss.n611 avss.n610 0.1445
R4418 avss.n612 avss.n611 0.1445
R4419 avss.n614 avss.n612 0.1445
R4420 avss.n614 avss.n613 0.1445
R4421 avss.n613 avss.n167 0.1445
R4422 avss.n675 avss.n167 0.1445
R4423 avss.n635 avss.n188 0.1445
R4424 avss.n630 avss.n188 0.1445
R4425 avss.n630 avss.n629 0.1445
R4426 avss.n629 avss.n628 0.1445
R4427 avss.n628 avss.n625 0.1445
R4428 avss.n625 avss.n624 0.1445
R4429 avss.n624 avss.n621 0.1445
R4430 avss.n621 avss.n620 0.1445
R4431 avss.n620 avss.n617 0.1445
R4432 avss.n617 avss.n616 0.1445
R4433 avss.n616 avss.n168 0.1445
R4434 avss.n673 avss.n168 0.1445
R4435 avss.n674 avss.n673 0.1445
R4436 avss.n323 avss.n316 0.1445
R4437 avss.n326 avss.n323 0.1445
R4438 avss.n329 avss.n326 0.1445
R4439 avss.n329 avss.n314 0.1445
R4440 avss.n333 avss.n314 0.1445
R4441 avss.n336 avss.n333 0.1445
R4442 avss.n338 avss.n336 0.1445
R4443 avss.n338 avss.n312 0.1445
R4444 avss.n343 avss.n312 0.1445
R4445 avss.n343 avss.n306 0.1445
R4446 avss.n349 avss.n306 0.1445
R4447 avss.n350 avss.n349 0.1445
R4448 avss.n351 avss.n350 0.1445
R4449 avss.n322 avss.n321 0.1445
R4450 avss.n322 avss.n315 0.1445
R4451 avss.n330 avss.n315 0.1445
R4452 avss.n331 avss.n330 0.1445
R4453 avss.n332 avss.n331 0.1445
R4454 avss.n332 avss.n313 0.1445
R4455 avss.n339 avss.n313 0.1445
R4456 avss.n340 avss.n339 0.1445
R4457 avss.n342 avss.n340 0.1445
R4458 avss.n342 avss.n341 0.1445
R4459 avss.n341 avss.n307 0.1445
R4460 avss.n307 avss.n305 0.1445
R4461 avss.n352 avss.n305 0.1445
R4462 avss.n317 avss.n139 0.1445
R4463 avss.n140 avss.n139 0.1445
R4464 avss.n141 avss.n140 0.1445
R4465 avss.n145 avss.n141 0.1445
R4466 avss.n146 avss.n145 0.1445
R4467 avss.n147 avss.n146 0.1445
R4468 avss.n148 avss.n147 0.1445
R4469 avss.n152 avss.n148 0.1445
R4470 avss.n153 avss.n152 0.1445
R4471 avss.n154 avss.n153 0.1445
R4472 avss.n155 avss.n154 0.1445
R4473 avss.n302 avss.n155 0.1445
R4474 avss.n304 avss.n302 0.1445
R4475 avss.n699 avss.n138 0.1445
R4476 avss.n699 avss.n698 0.1445
R4477 avss.n698 avss.n697 0.1445
R4478 avss.n697 avss.n142 0.1445
R4479 avss.n692 avss.n142 0.1445
R4480 avss.n692 avss.n691 0.1445
R4481 avss.n691 avss.n690 0.1445
R4482 avss.n690 avss.n149 0.1445
R4483 avss.n685 avss.n149 0.1445
R4484 avss.n685 avss.n684 0.1445
R4485 avss.n684 avss.n683 0.1445
R4486 avss.n683 avss.n156 0.1445
R4487 avss.n303 avss.n156 0.1445
R4488 avss.n724 avss.n723 0.1445
R4489 avss.n723 avss.n722 0.1445
R4490 avss.n722 avss.n112 0.1445
R4491 avss.n718 avss.n112 0.1445
R4492 avss.n718 avss.n717 0.1445
R4493 avss.n717 avss.n716 0.1445
R4494 avss.n716 avss.n117 0.1445
R4495 avss.n712 avss.n117 0.1445
R4496 avss.n712 avss.n711 0.1445
R4497 avss.n711 avss.n710 0.1445
R4498 avss.n710 avss.n122 0.1445
R4499 avss.n706 avss.n122 0.1445
R4500 avss.n706 avss.n705 0.1445
R4501 avss.n759 avss.n107 0.1445
R4502 avss.n755 avss.n107 0.1445
R4503 avss.n755 avss.n754 0.1445
R4504 avss.n754 avss.n753 0.1445
R4505 avss.n753 avss.n732 0.1445
R4506 avss.n749 avss.n732 0.1445
R4507 avss.n749 avss.n748 0.1445
R4508 avss.n748 avss.n747 0.1445
R4509 avss.n747 avss.n738 0.1445
R4510 avss.n743 avss.n738 0.1445
R4511 avss.n743 avss.n742 0.1445
R4512 avss.n742 avss.n93 0.1445
R4513 avss.n763 avss.n93 0.1445
R4514 avss.n758 avss.n757 0.1445
R4515 avss.n757 avss.n756 0.1445
R4516 avss.n756 avss.n727 0.1445
R4517 avss.n752 avss.n727 0.1445
R4518 avss.n752 avss.n751 0.1445
R4519 avss.n751 avss.n750 0.1445
R4520 avss.n750 avss.n733 0.1445
R4521 avss.n746 avss.n733 0.1445
R4522 avss.n746 avss.n745 0.1445
R4523 avss.n745 avss.n744 0.1445
R4524 avss.n744 avss.n739 0.1445
R4525 avss.n739 avss.n92 0.1445
R4526 avss.n764 avss.n92 0.1445
R4527 avss.n725 avss.n108 0.1445
R4528 avss.n721 avss.n108 0.1445
R4529 avss.n721 avss.n720 0.1445
R4530 avss.n720 avss.n719 0.1445
R4531 avss.n719 avss.n113 0.1445
R4532 avss.n715 avss.n113 0.1445
R4533 avss.n715 avss.n714 0.1445
R4534 avss.n714 avss.n713 0.1445
R4535 avss.n713 avss.n118 0.1445
R4536 avss.n709 avss.n118 0.1445
R4537 avss.n709 avss.n708 0.1445
R4538 avss.n708 avss.n707 0.1445
R4539 avss.n707 avss.n123 0.1445
R4540 avss.n456 avss.n454 0.122783
R4541 avss.n515 avss.n514 0.0740097
R4542 avss.n514 avss.n452 0.0740097
R4543 avss.n547 avss.n546 0.0740097
R4544 avss.n546 avss.n246 0.0740097
R4545 avss.n297 avss.n166 0.04675
R4546 avss.n419 avss.n418 0.04675
R4547 avss.n822 avss.n821 0.0325
R4548 avss.n296 avss.n292 0.024875
R4549 avss.n295 avss.n248 0.024875
R4550 avss.n810 avss.n809 0.0245
R4551 avss.n292 avss.n284 0.0188333
R4552 avss.n295 avss.n293 0.0188333
R4553 avss.n383 avss.n284 0.0171667
R4554 avss.n808 avss.n798 0.0149
R4555 avss.n812 avss.n788 0.0149
R4556 avss.n844 avss.n837 0.0121667
R4557 avss.n835 avss.n828 0.0121667
R4558 avss.n826 avss.n784 0.0121667
R4559 avss.n782 avss.n775 0.0121667
R4560 avss.n293 avss.n287 0.0114825
R4561 avss.n13 avss.n11 0.0081885
R4562 avss.n13 avss.n0 0.0081885
R4563 avss.n842 avss.n1 0.0081885
R4564 avss.n838 avss.n7 0.0081885
R4565 avss.n9 avss.n6 0.0081885
R4566 avss.n839 avss.n3 0.0081885
R4567 avss.n8 avss.n5 0.0081885
R4568 avss.n17 avss.n16 0.0081885
R4569 avss.n31 avss.n29 0.0081885
R4570 avss.n31 avss.n18 0.0081885
R4571 avss.n833 avss.n19 0.0081885
R4572 avss.n829 avss.n25 0.0081885
R4573 avss.n27 avss.n24 0.0081885
R4574 avss.n830 avss.n21 0.0081885
R4575 avss.n26 avss.n23 0.0081885
R4576 avss.n35 avss.n34 0.0081885
R4577 avss.n49 avss.n47 0.0081885
R4578 avss.n49 avss.n36 0.0081885
R4579 avss.n824 avss.n37 0.0081885
R4580 avss.n785 avss.n43 0.0081885
R4581 avss.n45 avss.n42 0.0081885
R4582 avss.n786 avss.n39 0.0081885
R4583 avss.n44 avss.n41 0.0081885
R4584 avss.n53 avss.n52 0.0081885
R4585 avss.n67 avss.n65 0.0081885
R4586 avss.n67 avss.n54 0.0081885
R4587 avss.n780 avss.n55 0.0081885
R4588 avss.n776 avss.n61 0.0081885
R4589 avss.n63 avss.n60 0.0081885
R4590 avss.n777 avss.n57 0.0081885
R4591 avss.n62 avss.n59 0.0081885
R4592 avss.n71 avss.n70 0.0081885
R4593 avss.n85 avss.n83 0.0081885
R4594 avss.n85 avss.n72 0.0081885
R4595 avss.n771 avss.n73 0.0081885
R4596 avss.n767 avss.n79 0.0081885
R4597 avss.n81 avss.n78 0.0081885
R4598 avss.n768 avss.n75 0.0081885
R4599 avss.n80 avss.n77 0.0081885
R4600 avss.n89 avss.n88 0.0081885
R4601 avss.n799 avss.n798 0.0081885
R4602 avss.n803 avss.n802 0.0081885
R4603 avss.n805 avss.n794 0.0081885
R4604 avss.n812 avss.n811 0.0081885
R4605 avss.n820 avss.n791 0.0081885
R4606 avss.n819 avss.n818 0.0081885
R4607 avss.n811 avss.n789 0.0081885
R4608 avss.n791 avss.n789 0.0081885
R4609 avss.n820 avss.n819 0.0081885
R4610 avss.n799 avss.n795 0.0081885
R4611 avss.n802 avss.n795 0.0081885
R4612 avss.n803 avss.n794 0.0081885
R4613 avss.n768 avss.n78 0.0081885
R4614 avss.n80 avss.n75 0.0081885
R4615 avss.n81 avss.n74 0.0081885
R4616 avss.n89 avss.n77 0.0081885
R4617 avss.n772 avss.n72 0.0081885
R4618 avss.n772 avss.n771 0.0081885
R4619 avss.n774 avss.n83 0.0081885
R4620 avss.n767 avss.n73 0.0081885
R4621 avss.n777 avss.n60 0.0081885
R4622 avss.n62 avss.n57 0.0081885
R4623 avss.n63 avss.n56 0.0081885
R4624 avss.n71 avss.n59 0.0081885
R4625 avss.n781 avss.n54 0.0081885
R4626 avss.n781 avss.n780 0.0081885
R4627 avss.n783 avss.n65 0.0081885
R4628 avss.n776 avss.n55 0.0081885
R4629 avss.n786 avss.n42 0.0081885
R4630 avss.n44 avss.n39 0.0081885
R4631 avss.n45 avss.n38 0.0081885
R4632 avss.n53 avss.n41 0.0081885
R4633 avss.n825 avss.n36 0.0081885
R4634 avss.n825 avss.n824 0.0081885
R4635 avss.n827 avss.n47 0.0081885
R4636 avss.n785 avss.n37 0.0081885
R4637 avss.n830 avss.n24 0.0081885
R4638 avss.n26 avss.n21 0.0081885
R4639 avss.n27 avss.n20 0.0081885
R4640 avss.n35 avss.n23 0.0081885
R4641 avss.n834 avss.n18 0.0081885
R4642 avss.n834 avss.n833 0.0081885
R4643 avss.n836 avss.n29 0.0081885
R4644 avss.n829 avss.n19 0.0081885
R4645 avss.n839 avss.n6 0.0081885
R4646 avss.n8 avss.n3 0.0081885
R4647 avss.n9 avss.n2 0.0081885
R4648 avss.n17 avss.n5 0.0081885
R4649 avss.n843 avss.n0 0.0081885
R4650 avss.n843 avss.n842 0.0081885
R4651 avss.n845 avss.n11 0.0081885
R4652 avss.n838 avss.n1 0.0081885
R4653 avss.n383 avss.n287 0.00717136
R4654 avss.n804 avss.n797 0.00328455
R4655 avss.n807 avss.n801 0.00328455
R4656 avss.n806 avss.n796 0.00328455
R4657 avss.n809 avss.n793 0.00328455
R4658 avss.n817 avss.n816 0.00328455
R4659 avss.n821 avss.n787 0.00328455
R4660 avss.n792 avss.n790 0.00328455
R4661 avss.n815 avss.n813 0.00328455
R4662 avss.n817 avss.n810 0.00328455
R4663 avss.n816 avss.n787 0.00328455
R4664 avss.n821 avss.n790 0.00328455
R4665 avss.n813 avss.n792 0.00328455
R4666 avss.n804 avss.n800 0.00328455
R4667 avss.n801 avss.n797 0.00328455
R4668 avss.n807 avss.n806 0.00328455
R4669 avss.n796 avss.n793 0.00328455
R4670 avss.n823 avss.n822 0.00229167
R4671 avss.n841 avss.n4 0.00211084
R4672 avss.n841 avss.n840 0.00211084
R4673 avss.n15 avss.n10 0.00211084
R4674 avss.n844 avss.n14 0.00211084
R4675 avss.n832 avss.n22 0.00211084
R4676 avss.n832 avss.n831 0.00211084
R4677 avss.n33 avss.n28 0.00211084
R4678 avss.n835 avss.n32 0.00211084
R4679 avss.n823 avss.n40 0.00211084
R4680 avss.n51 avss.n46 0.00211084
R4681 avss.n826 avss.n50 0.00211084
R4682 avss.n779 avss.n58 0.00211084
R4683 avss.n779 avss.n778 0.00211084
R4684 avss.n69 avss.n64 0.00211084
R4685 avss.n782 avss.n68 0.00211084
R4686 avss.n770 avss.n76 0.00211084
R4687 avss.n770 avss.n769 0.00211084
R4688 avss.n87 avss.n82 0.00211084
R4689 avss.n773 avss.n86 0.00211084
R4690 avss.n775 avss.n76 0.00211084
R4691 avss.n87 avss.n84 0.00211084
R4692 avss.n769 avss.n84 0.00211084
R4693 avss.n86 avss.n82 0.00211084
R4694 avss.n784 avss.n58 0.00211084
R4695 avss.n69 avss.n66 0.00211084
R4696 avss.n778 avss.n66 0.00211084
R4697 avss.n68 avss.n64 0.00211084
R4698 avss.n828 avss.n40 0.00211084
R4699 avss.n51 avss.n48 0.00211084
R4700 avss.n50 avss.n46 0.00211084
R4701 avss.n837 avss.n22 0.00211084
R4702 avss.n33 avss.n30 0.00211084
R4703 avss.n831 avss.n30 0.00211084
R4704 avss.n32 avss.n28 0.00211084
R4705 avss.n846 avss.n4 0.00211084
R4706 avss.n15 avss.n12 0.00211084
R4707 avss.n840 avss.n12 0.00211084
R4708 avss.n14 avss.n10 0.00211084
R4709 avss.n676 avss.n166 0.00100362
R4710 avss.n420 avss.n419 0.00100362
R4711 avss.n822 avss.n48 0.000930556
R4712 avss.n297 avss.n296 0.000916667
R4713 avss.n418 avss.n248 0.000916667
R4714 avdd.n357 avdd.n356 1078.83
R4715 avdd.n356 avdd.n355 1078.83
R4716 avdd.n207 avdd.n176 522.652
R4717 avdd.n181 avdd.n176 522.652
R4718 avdd.n199 avdd.n188 522.652
R4719 avdd.n191 avdd.n188 522.652
R4720 avdd.n246 avdd.n245 522.652
R4721 avdd.n246 avdd.n233 522.652
R4722 avdd.n256 avdd.n255 522.652
R4723 avdd.n255 avdd.n226 522.652
R4724 avdd.n358 avdd.n324 144.812
R4725 avdd.n354 avdd.n324 144.812
R4726 avdd.n333 avdd.n327 144.812
R4727 avdd.n335 avdd.n327 144.812
R4728 avdd.n103 avdd.n93 142.857
R4729 avdd.n103 avdd.n87 142.857
R4730 avdd.n111 avdd.n87 142.857
R4731 avdd.n111 avdd.n81 142.857
R4732 avdd.n119 avdd.n81 142.857
R4733 avdd.n119 avdd.n75 142.857
R4734 avdd.n127 avdd.n75 142.857
R4735 avdd.n127 avdd.n69 142.857
R4736 avdd.n135 avdd.n69 142.857
R4737 avdd.n135 avdd.n63 142.857
R4738 avdd.n143 avdd.n63 142.857
R4739 avdd.n143 avdd.n57 142.857
R4740 avdd.n151 avdd.n57 142.857
R4741 avdd.n151 avdd.n51 142.857
R4742 avdd.n159 avdd.n51 142.857
R4743 avdd.n159 avdd.n45 142.857
R4744 avdd.n167 avdd.n45 142.857
R4745 avdd.n167 avdd.n39 142.857
R4746 avdd.n216 avdd.n39 142.857
R4747 avdd.n288 avdd.n280 142.857
R4748 avdd.n297 avdd.n280 142.857
R4749 avdd.n297 avdd.n274 142.857
R4750 avdd.n305 avdd.n274 142.857
R4751 avdd.n305 avdd.n268 142.857
R4752 avdd.n313 avdd.n268 142.857
R4753 avdd.n208 avdd.n175 62.038
R4754 avdd.n182 avdd.n175 62.038
R4755 avdd.n205 avdd.n177 62.038
R4756 avdd.n206 avdd.n205 62.038
R4757 avdd.n197 avdd.n189 62.038
R4758 avdd.n198 avdd.n197 62.038
R4759 avdd.n192 avdd.n179 62.038
R4760 avdd.n200 avdd.n179 62.038
R4761 avdd.n247 avdd.n231 62.038
R4762 avdd.n247 avdd.n232 62.038
R4763 avdd.n238 avdd.n234 62.038
R4764 avdd.n244 avdd.n234 62.038
R4765 avdd.n257 avdd.n225 62.038
R4766 avdd.n227 avdd.n225 62.038
R4767 avdd.n254 avdd.n253 62.038
R4768 avdd.n254 avdd.n224 62.038
R4769 avdd.n215 avdd.n38 61.7755
R4770 avdd.n97 avdd.n94 61.7755
R4771 avdd.n312 avdd.n267 61.7755
R4772 avdd.n287 avdd.n284 61.7755
R4773 avdd.n217 avdd.n38 48.3669
R4774 avdd.n97 avdd.n96 48.3669
R4775 avdd.n314 avdd.n267 48.3669
R4776 avdd.n289 avdd.n284 48.3669
R4777 avdd.n104 avdd.n92 14.0005
R4778 avdd.n104 avdd.n88 14.0005
R4779 avdd.n110 avdd.n88 14.0005
R4780 avdd.n110 avdd.n80 14.0005
R4781 avdd.n120 avdd.n80 14.0005
R4782 avdd.n120 avdd.n76 14.0005
R4783 avdd.n126 avdd.n76 14.0005
R4784 avdd.n126 avdd.n68 14.0005
R4785 avdd.n136 avdd.n68 14.0005
R4786 avdd.n136 avdd.n64 14.0005
R4787 avdd.n142 avdd.n64 14.0005
R4788 avdd.n142 avdd.n56 14.0005
R4789 avdd.n152 avdd.n56 14.0005
R4790 avdd.n152 avdd.n52 14.0005
R4791 avdd.n158 avdd.n52 14.0005
R4792 avdd.n158 avdd.n44 14.0005
R4793 avdd.n168 avdd.n44 14.0005
R4794 avdd.n168 avdd.n40 14.0005
R4795 avdd.n215 avdd.n40 14.0005
R4796 avdd.n102 avdd.n94 14.0005
R4797 avdd.n102 avdd.n86 14.0005
R4798 avdd.n112 avdd.n86 14.0005
R4799 avdd.n112 avdd.n82 14.0005
R4800 avdd.n118 avdd.n82 14.0005
R4801 avdd.n118 avdd.n74 14.0005
R4802 avdd.n128 avdd.n74 14.0005
R4803 avdd.n128 avdd.n70 14.0005
R4804 avdd.n134 avdd.n70 14.0005
R4805 avdd.n134 avdd.n62 14.0005
R4806 avdd.n144 avdd.n62 14.0005
R4807 avdd.n144 avdd.n58 14.0005
R4808 avdd.n150 avdd.n58 14.0005
R4809 avdd.n150 avdd.n50 14.0005
R4810 avdd.n160 avdd.n50 14.0005
R4811 avdd.n160 avdd.n46 14.0005
R4812 avdd.n166 avdd.n46 14.0005
R4813 avdd.n166 avdd.n37 14.0005
R4814 avdd.n218 avdd.n37 14.0005
R4815 avdd.n290 avdd.n281 14.0005
R4816 avdd.n296 avdd.n281 14.0005
R4817 avdd.n296 avdd.n273 14.0005
R4818 avdd.n306 avdd.n273 14.0005
R4819 avdd.n306 avdd.n269 14.0005
R4820 avdd.n312 avdd.n269 14.0005
R4821 avdd.n287 avdd.n279 14.0005
R4822 avdd.n298 avdd.n279 14.0005
R4823 avdd.n298 avdd.n275 14.0005
R4824 avdd.n304 avdd.n275 14.0005
R4825 avdd.n304 avdd.n266 14.0005
R4826 avdd.n315 avdd.n266 14.0005
R4827 avdd.n348 avdd.n347 14.0005
R4828 avdd.n354 avdd.n330 14.0005
R4829 avdd.n337 avdd.n336 14.0005
R4830 avdd.n358 avdd.n323 14.0005
R4831 avdd.n262 avdd.n221 8.16945
R4832 avdd.n262 avdd.n261 7.63485
R4833 avdd.n319 avdd.n318 7.63485
R4834 avdd.n362 avdd.n361 6.68691
R4835 avdd.n215 avdd.n214 6.3005
R4836 avdd.n216 avdd.n215 6.3005
R4837 avdd.n41 avdd.n40 6.3005
R4838 avdd.n40 avdd.n39 6.3005
R4839 avdd.n169 avdd.n168 6.3005
R4840 avdd.n168 avdd.n167 6.3005
R4841 avdd.n44 avdd.n43 6.3005
R4842 avdd.n45 avdd.n44 6.3005
R4843 avdd.n158 avdd.n157 6.3005
R4844 avdd.n159 avdd.n158 6.3005
R4845 avdd.n53 avdd.n52 6.3005
R4846 avdd.n52 avdd.n51 6.3005
R4847 avdd.n153 avdd.n152 6.3005
R4848 avdd.n152 avdd.n151 6.3005
R4849 avdd.n56 avdd.n55 6.3005
R4850 avdd.n57 avdd.n56 6.3005
R4851 avdd.n142 avdd.n141 6.3005
R4852 avdd.n143 avdd.n142 6.3005
R4853 avdd.n65 avdd.n64 6.3005
R4854 avdd.n64 avdd.n63 6.3005
R4855 avdd.n137 avdd.n136 6.3005
R4856 avdd.n136 avdd.n135 6.3005
R4857 avdd.n68 avdd.n67 6.3005
R4858 avdd.n69 avdd.n68 6.3005
R4859 avdd.n126 avdd.n125 6.3005
R4860 avdd.n127 avdd.n126 6.3005
R4861 avdd.n77 avdd.n76 6.3005
R4862 avdd.n76 avdd.n75 6.3005
R4863 avdd.n121 avdd.n120 6.3005
R4864 avdd.n120 avdd.n119 6.3005
R4865 avdd.n80 avdd.n79 6.3005
R4866 avdd.n81 avdd.n80 6.3005
R4867 avdd.n110 avdd.n109 6.3005
R4868 avdd.n111 avdd.n110 6.3005
R4869 avdd.n89 avdd.n88 6.3005
R4870 avdd.n88 avdd.n87 6.3005
R4871 avdd.n105 avdd.n104 6.3005
R4872 avdd.n104 avdd.n103 6.3005
R4873 avdd.n92 avdd.n91 6.3005
R4874 avdd.n95 avdd.n94 6.3005
R4875 avdd.n94 avdd.n93 6.3005
R4876 avdd.n102 avdd.n101 6.3005
R4877 avdd.n103 avdd.n102 6.3005
R4878 avdd.n86 avdd.n85 6.3005
R4879 avdd.n87 avdd.n86 6.3005
R4880 avdd.n113 avdd.n112 6.3005
R4881 avdd.n112 avdd.n111 6.3005
R4882 avdd.n83 avdd.n82 6.3005
R4883 avdd.n82 avdd.n81 6.3005
R4884 avdd.n118 avdd.n117 6.3005
R4885 avdd.n119 avdd.n118 6.3005
R4886 avdd.n74 avdd.n73 6.3005
R4887 avdd.n75 avdd.n74 6.3005
R4888 avdd.n129 avdd.n128 6.3005
R4889 avdd.n128 avdd.n127 6.3005
R4890 avdd.n71 avdd.n70 6.3005
R4891 avdd.n70 avdd.n69 6.3005
R4892 avdd.n134 avdd.n133 6.3005
R4893 avdd.n135 avdd.n134 6.3005
R4894 avdd.n62 avdd.n61 6.3005
R4895 avdd.n63 avdd.n62 6.3005
R4896 avdd.n145 avdd.n144 6.3005
R4897 avdd.n144 avdd.n143 6.3005
R4898 avdd.n59 avdd.n58 6.3005
R4899 avdd.n58 avdd.n57 6.3005
R4900 avdd.n150 avdd.n149 6.3005
R4901 avdd.n151 avdd.n150 6.3005
R4902 avdd.n50 avdd.n49 6.3005
R4903 avdd.n51 avdd.n50 6.3005
R4904 avdd.n161 avdd.n160 6.3005
R4905 avdd.n160 avdd.n159 6.3005
R4906 avdd.n47 avdd.n46 6.3005
R4907 avdd.n46 avdd.n45 6.3005
R4908 avdd.n166 avdd.n165 6.3005
R4909 avdd.n167 avdd.n166 6.3005
R4910 avdd.n37 avdd.n36 6.3005
R4911 avdd.n39 avdd.n37 6.3005
R4912 avdd.n219 avdd.n218 6.3005
R4913 avdd.n183 avdd.n182 6.3005
R4914 avdd.n184 avdd.n177 6.3005
R4915 avdd.n209 avdd.n208 6.3005
R4916 avdd.n206 avdd.n174 6.3005
R4917 avdd.n193 avdd.n192 6.3005
R4918 avdd.n194 avdd.n189 6.3005
R4919 avdd.n201 avdd.n200 6.3005
R4920 avdd.n198 avdd.n187 6.3005
R4921 avdd.n239 avdd.n238 6.3005
R4922 avdd.n237 avdd.n231 6.3005
R4923 avdd.n244 avdd.n243 6.3005
R4924 avdd.n235 avdd.n232 6.3005
R4925 avdd.n228 avdd.n227 6.3005
R4926 avdd.n253 avdd.n252 6.3005
R4927 avdd.n258 avdd.n257 6.3005
R4928 avdd.n259 avdd.n224 6.3005
R4929 avdd.n312 avdd.n311 6.3005
R4930 avdd.n313 avdd.n312 6.3005
R4931 avdd.n270 avdd.n269 6.3005
R4932 avdd.n269 avdd.n268 6.3005
R4933 avdd.n307 avdd.n306 6.3005
R4934 avdd.n306 avdd.n305 6.3005
R4935 avdd.n273 avdd.n272 6.3005
R4936 avdd.n274 avdd.n273 6.3005
R4937 avdd.n296 avdd.n295 6.3005
R4938 avdd.n297 avdd.n296 6.3005
R4939 avdd.n282 avdd.n281 6.3005
R4940 avdd.n281 avdd.n280 6.3005
R4941 avdd.n291 avdd.n290 6.3005
R4942 avdd.n316 avdd.n315 6.3005
R4943 avdd.n266 avdd.n265 6.3005
R4944 avdd.n268 avdd.n266 6.3005
R4945 avdd.n304 avdd.n303 6.3005
R4946 avdd.n305 avdd.n304 6.3005
R4947 avdd.n276 avdd.n275 6.3005
R4948 avdd.n275 avdd.n274 6.3005
R4949 avdd.n299 avdd.n298 6.3005
R4950 avdd.n298 avdd.n297 6.3005
R4951 avdd.n279 avdd.n278 6.3005
R4952 avdd.n280 avdd.n279 6.3005
R4953 avdd.n287 avdd.n286 6.3005
R4954 avdd.n288 avdd.n287 6.3005
R4955 avdd.n354 avdd.n353 6.3005
R4956 avdd.n355 avdd.n354 6.3005
R4957 avdd.n331 avdd.n330 6.3005
R4958 avdd.n349 avdd.n348 6.3005
R4959 avdd.n347 avdd.n346 6.3005
R4960 avdd.n345 avdd.n333 6.3005
R4961 avdd.n359 avdd.n358 6.3005
R4962 avdd.n358 avdd.n357 6.3005
R4963 avdd.n323 avdd.n322 6.3005
R4964 avdd.n339 avdd.n337 6.3005
R4965 avdd.n340 avdd.n336 6.3005
R4966 avdd.n341 avdd.n335 6.3005
R4967 avdd.n344 avdd.n343 6.12735
R4968 avdd.n352 avdd.n320 6.12735
R4969 avdd.n343 avdd.n342 6.11952
R4970 avdd.n196 avdd.n186 5.20011
R4971 avdd.n196 avdd.n195 5.20011
R4972 avdd.n180 avdd.n172 5.20011
R4973 avdd.n242 avdd.n241 5.20011
R4974 avdd.n241 avdd.n240 5.20011
R4975 avdd.n251 avdd.n222 5.20011
R4976 avdd.n98 avdd.n90 5.19741
R4977 avdd.n292 avdd.n283 5.19741
R4978 avdd.n310 avdd.n263 5.19741
R4979 avdd.n99 avdd.n98 5.18959
R4980 avdd.n285 avdd.n283 5.18959
R4981 avdd.n96 avdd.n93 4.9335
R4982 avdd.n217 avdd.n216 4.9335
R4983 avdd.n289 avdd.n288 4.9335
R4984 avdd.n314 avdd.n313 4.9335
R4985 avdd.n203 avdd.n202 4.75136
R4986 avdd.n190 avdd.n178 4.75136
R4987 avdd.n249 avdd.n229 4.75136
R4988 avdd.n230 avdd.n223 4.75136
R4989 avdd.n178 avdd.n173 4.75135
R4990 avdd.n203 avdd.n185 4.75135
R4991 avdd.n236 avdd.n230 4.75135
R4992 avdd.n250 avdd.n249 4.75135
R4993 avdd.n211 avdd.n210 4.7462
R4994 avdd.n261 avdd.n260 4.7462
R4995 avdd.n221 avdd.n220 4.7435
R4996 avdd.n213 avdd.n212 4.7435
R4997 avdd.n318 avdd.n317 4.7435
R4998 avdd.n361 avdd.n360 4.7255
R4999 avdd.n99 avdd.n95 4.5005
R5000 avdd.n101 avdd.n100 4.5005
R5001 avdd.n85 avdd.n84 4.5005
R5002 avdd.n114 avdd.n113 4.5005
R5003 avdd.n115 avdd.n83 4.5005
R5004 avdd.n117 avdd.n116 4.5005
R5005 avdd.n73 avdd.n72 4.5005
R5006 avdd.n130 avdd.n129 4.5005
R5007 avdd.n131 avdd.n71 4.5005
R5008 avdd.n133 avdd.n132 4.5005
R5009 avdd.n61 avdd.n60 4.5005
R5010 avdd.n146 avdd.n145 4.5005
R5011 avdd.n147 avdd.n59 4.5005
R5012 avdd.n149 avdd.n148 4.5005
R5013 avdd.n49 avdd.n48 4.5005
R5014 avdd.n162 avdd.n161 4.5005
R5015 avdd.n163 avdd.n47 4.5005
R5016 avdd.n165 avdd.n164 4.5005
R5017 avdd.n36 avdd.n35 4.5005
R5018 avdd.n220 avdd.n219 4.5005
R5019 avdd.n106 avdd.n105 4.5005
R5020 avdd.n107 avdd.n89 4.5005
R5021 avdd.n109 avdd.n108 4.5005
R5022 avdd.n79 avdd.n78 4.5005
R5023 avdd.n122 avdd.n121 4.5005
R5024 avdd.n123 avdd.n77 4.5005
R5025 avdd.n125 avdd.n124 4.5005
R5026 avdd.n67 avdd.n66 4.5005
R5027 avdd.n138 avdd.n137 4.5005
R5028 avdd.n139 avdd.n65 4.5005
R5029 avdd.n141 avdd.n140 4.5005
R5030 avdd.n55 avdd.n54 4.5005
R5031 avdd.n154 avdd.n153 4.5005
R5032 avdd.n155 avdd.n53 4.5005
R5033 avdd.n157 avdd.n156 4.5005
R5034 avdd.n43 avdd.n42 4.5005
R5035 avdd.n170 avdd.n169 4.5005
R5036 avdd.n171 avdd.n41 4.5005
R5037 avdd.n214 avdd.n213 4.5005
R5038 avdd.n91 avdd.n90 4.5005
R5039 avdd.n210 avdd.n209 4.5005
R5040 avdd.n174 avdd.n173 4.5005
R5041 avdd.n202 avdd.n201 4.5005
R5042 avdd.n187 avdd.n186 4.5005
R5043 avdd.n193 avdd.n190 4.5005
R5044 avdd.n195 avdd.n194 4.5005
R5045 avdd.n183 avdd.n180 4.5005
R5046 avdd.n185 avdd.n184 4.5005
R5047 avdd.n243 avdd.n242 4.5005
R5048 avdd.n235 avdd.n229 4.5005
R5049 avdd.n240 avdd.n239 4.5005
R5050 avdd.n237 avdd.n236 4.5005
R5051 avdd.n258 avdd.n223 4.5005
R5052 avdd.n260 avdd.n259 4.5005
R5053 avdd.n250 avdd.n228 4.5005
R5054 avdd.n252 avdd.n251 4.5005
R5055 avdd.n278 avdd.n277 4.5005
R5056 avdd.n300 avdd.n299 4.5005
R5057 avdd.n301 avdd.n276 4.5005
R5058 avdd.n303 avdd.n302 4.5005
R5059 avdd.n265 avdd.n264 4.5005
R5060 avdd.n317 avdd.n316 4.5005
R5061 avdd.n286 avdd.n285 4.5005
R5062 avdd.n293 avdd.n282 4.5005
R5063 avdd.n295 avdd.n294 4.5005
R5064 avdd.n272 avdd.n271 4.5005
R5065 avdd.n308 avdd.n307 4.5005
R5066 avdd.n309 avdd.n270 4.5005
R5067 avdd.n311 avdd.n310 4.5005
R5068 avdd.n292 avdd.n291 4.5005
R5069 avdd.n340 avdd.n334 4.5005
R5070 avdd.n339 avdd.n338 4.5005
R5071 avdd.n322 avdd.n321 4.5005
R5072 avdd.n360 avdd.n359 4.5005
R5073 avdd.n342 avdd.n341 4.5005
R5074 avdd.n346 avdd.n332 4.5005
R5075 avdd.n350 avdd.n349 4.5005
R5076 avdd.n351 avdd.n331 4.5005
R5077 avdd.n353 avdd.n352 4.5005
R5078 avdd.n345 avdd.n344 4.5005
R5079 avdd.n25 avdd.n10 4.5005
R5080 avdd.n25 avdd.n24 4.5005
R5081 avdd.n24 avdd.n13 4.5005
R5082 avdd.n16 avdd.n10 4.5005
R5083 avdd.n22 avdd.n16 4.5005
R5084 avdd.n24 avdd.n16 4.5005
R5085 avdd.n12 avdd.n10 4.5005
R5086 avdd.n22 avdd.n12 4.5005
R5087 avdd.n24 avdd.n12 4.5005
R5088 avdd.n23 avdd.n22 4.5005
R5089 avdd.n24 avdd.n23 4.5005
R5090 avdd.n33 avdd.n1 4.5005
R5091 avdd.n33 avdd.n32 4.5005
R5092 avdd.n32 avdd.n4 4.5005
R5093 avdd.n7 avdd.n1 4.5005
R5094 avdd.n30 avdd.n7 4.5005
R5095 avdd.n32 avdd.n7 4.5005
R5096 avdd.n3 avdd.n1 4.5005
R5097 avdd.n30 avdd.n3 4.5005
R5098 avdd.n32 avdd.n3 4.5005
R5099 avdd.n31 avdd.n30 4.5005
R5100 avdd.n32 avdd.n31 4.5005
R5101 avdd avdd.n363 4.5005
R5102 avdd.n363 avdd.n33 3.32124
R5103 avdd.n181 avdd.n177 3.31679
R5104 avdd.n182 avdd.n181 3.31679
R5105 avdd.n207 avdd.n206 3.31679
R5106 avdd.n208 avdd.n207 3.31679
R5107 avdd.n191 avdd.n189 3.31679
R5108 avdd.n192 avdd.n191 3.31679
R5109 avdd.n199 avdd.n198 3.31679
R5110 avdd.n200 avdd.n199 3.31679
R5111 avdd.n233 avdd.n231 3.31679
R5112 avdd.n238 avdd.n233 3.31679
R5113 avdd.n245 avdd.n232 3.31679
R5114 avdd.n245 avdd.n244 3.31679
R5115 avdd.n253 avdd.n226 3.31679
R5116 avdd.n227 avdd.n226 3.31679
R5117 avdd.n256 avdd.n224 3.31679
R5118 avdd.n257 avdd.n256 3.31679
R5119 avdd.n333 avdd.n328 3.31679
R5120 avdd.n348 avdd.n329 3.31679
R5121 avdd.n330 avdd.n329 3.31679
R5122 avdd.n347 avdd.n328 3.31679
R5123 avdd.n336 avdd.n325 3.31679
R5124 avdd.n326 avdd.n323 3.31679
R5125 avdd.n337 avdd.n326 3.31679
R5126 avdd.n335 avdd.n325 3.31679
R5127 avdd.n19 avdd.n11 2.24986
R5128 avdd.n15 avdd.n14 2.24986
R5129 avdd.n19 avdd.n18 2.24986
R5130 avdd.n17 avdd.n14 2.24986
R5131 avdd.n27 avdd.n2 2.24986
R5132 avdd.n6 avdd.n5 2.24986
R5133 avdd.n27 avdd.n26 2.24986
R5134 avdd.n8 avdd.n5 2.24986
R5135 avdd.n25 avdd.n9 2.24741
R5136 avdd.n21 avdd.n13 2.24741
R5137 avdd.n23 avdd.n20 2.24741
R5138 avdd.n33 avdd.n0 2.24741
R5139 avdd.n29 avdd.n4 2.24741
R5140 avdd.n31 avdd.n28 2.24741
R5141 avdd.n355 avdd.n329 1.49311
R5142 avdd.n355 avdd.n328 1.49311
R5143 avdd.n357 avdd.n326 1.49311
R5144 avdd.n357 avdd.n325 1.49311
R5145 avdd.n361 avdd.n320 1.40235
R5146 avdd.n218 avdd.n217 1.24194
R5147 avdd.n96 avdd.n92 1.24194
R5148 avdd.n315 avdd.n314 1.24194
R5149 avdd.n290 avdd.n289 1.24194
R5150 avdd.n98 avdd.n97 0.9005
R5151 avdd.n197 avdd.n196 0.9005
R5152 avdd.n197 avdd.n188 0.9005
R5153 avdd.n204 avdd.n179 0.9005
R5154 avdd.n188 avdd.n179 0.9005
R5155 avdd.n205 avdd.n204 0.9005
R5156 avdd.n205 avdd.n176 0.9005
R5157 avdd.n175 avdd.n172 0.9005
R5158 avdd.n176 avdd.n175 0.9005
R5159 avdd.n38 avdd.n34 0.9005
R5160 avdd.n241 avdd.n234 0.9005
R5161 avdd.n246 avdd.n234 0.9005
R5162 avdd.n248 avdd.n225 0.9005
R5163 avdd.n255 avdd.n225 0.9005
R5164 avdd.n248 avdd.n247 0.9005
R5165 avdd.n247 avdd.n246 0.9005
R5166 avdd.n254 avdd.n222 0.9005
R5167 avdd.n255 avdd.n254 0.9005
R5168 avdd.n284 avdd.n283 0.9005
R5169 avdd.n267 avdd.n263 0.9005
R5170 avdd.n362 avdd.n319 0.8789
R5171 avdd.n211 avdd.n172 0.454413
R5172 avdd.n212 avdd.n34 0.454413
R5173 avdd.n221 avdd.n34 0.454413
R5174 avdd.n261 avdd.n222 0.454413
R5175 avdd.n318 avdd.n263 0.454413
R5176 avdd.n212 avdd.n211 0.427022
R5177 avdd.n363 avdd.n362 0.3686
R5178 avdd.n343 avdd.n327 0.2255
R5179 avdd.n356 avdd.n327 0.2255
R5180 avdd.n324 avdd.n320 0.2255
R5181 avdd.n356 avdd.n324 0.2255
R5182 avdd.n319 avdd.n262 0.2003
R5183 avdd.n105 avdd.n91 0.1445
R5184 avdd.n105 avdd.n89 0.1445
R5185 avdd.n109 avdd.n89 0.1445
R5186 avdd.n109 avdd.n79 0.1445
R5187 avdd.n121 avdd.n79 0.1445
R5188 avdd.n121 avdd.n77 0.1445
R5189 avdd.n125 avdd.n77 0.1445
R5190 avdd.n125 avdd.n67 0.1445
R5191 avdd.n137 avdd.n67 0.1445
R5192 avdd.n137 avdd.n65 0.1445
R5193 avdd.n141 avdd.n65 0.1445
R5194 avdd.n141 avdd.n55 0.1445
R5195 avdd.n153 avdd.n55 0.1445
R5196 avdd.n153 avdd.n53 0.1445
R5197 avdd.n157 avdd.n53 0.1445
R5198 avdd.n157 avdd.n43 0.1445
R5199 avdd.n169 avdd.n43 0.1445
R5200 avdd.n169 avdd.n41 0.1445
R5201 avdd.n214 avdd.n41 0.1445
R5202 avdd.n101 avdd.n95 0.1445
R5203 avdd.n101 avdd.n85 0.1445
R5204 avdd.n113 avdd.n85 0.1445
R5205 avdd.n113 avdd.n83 0.1445
R5206 avdd.n117 avdd.n83 0.1445
R5207 avdd.n117 avdd.n73 0.1445
R5208 avdd.n129 avdd.n73 0.1445
R5209 avdd.n129 avdd.n71 0.1445
R5210 avdd.n133 avdd.n71 0.1445
R5211 avdd.n133 avdd.n61 0.1445
R5212 avdd.n145 avdd.n61 0.1445
R5213 avdd.n145 avdd.n59 0.1445
R5214 avdd.n149 avdd.n59 0.1445
R5215 avdd.n149 avdd.n49 0.1445
R5216 avdd.n161 avdd.n49 0.1445
R5217 avdd.n161 avdd.n47 0.1445
R5218 avdd.n165 avdd.n47 0.1445
R5219 avdd.n165 avdd.n36 0.1445
R5220 avdd.n219 avdd.n36 0.1445
R5221 avdd.n100 avdd.n99 0.1445
R5222 avdd.n100 avdd.n84 0.1445
R5223 avdd.n114 avdd.n84 0.1445
R5224 avdd.n115 avdd.n114 0.1445
R5225 avdd.n116 avdd.n115 0.1445
R5226 avdd.n116 avdd.n72 0.1445
R5227 avdd.n130 avdd.n72 0.1445
R5228 avdd.n131 avdd.n130 0.1445
R5229 avdd.n132 avdd.n131 0.1445
R5230 avdd.n132 avdd.n60 0.1445
R5231 avdd.n146 avdd.n60 0.1445
R5232 avdd.n147 avdd.n146 0.1445
R5233 avdd.n148 avdd.n147 0.1445
R5234 avdd.n148 avdd.n48 0.1445
R5235 avdd.n162 avdd.n48 0.1445
R5236 avdd.n163 avdd.n162 0.1445
R5237 avdd.n164 avdd.n163 0.1445
R5238 avdd.n164 avdd.n35 0.1445
R5239 avdd.n220 avdd.n35 0.1445
R5240 avdd.n106 avdd.n90 0.1445
R5241 avdd.n107 avdd.n106 0.1445
R5242 avdd.n108 avdd.n107 0.1445
R5243 avdd.n108 avdd.n78 0.1445
R5244 avdd.n122 avdd.n78 0.1445
R5245 avdd.n123 avdd.n122 0.1445
R5246 avdd.n124 avdd.n123 0.1445
R5247 avdd.n124 avdd.n66 0.1445
R5248 avdd.n138 avdd.n66 0.1445
R5249 avdd.n139 avdd.n138 0.1445
R5250 avdd.n140 avdd.n139 0.1445
R5251 avdd.n140 avdd.n54 0.1445
R5252 avdd.n154 avdd.n54 0.1445
R5253 avdd.n155 avdd.n154 0.1445
R5254 avdd.n156 avdd.n155 0.1445
R5255 avdd.n156 avdd.n42 0.1445
R5256 avdd.n170 avdd.n42 0.1445
R5257 avdd.n171 avdd.n170 0.1445
R5258 avdd.n213 avdd.n171 0.1445
R5259 avdd.n184 avdd.n183 0.1445
R5260 avdd.n209 avdd.n174 0.1445
R5261 avdd.n210 avdd.n173 0.1445
R5262 avdd.n194 avdd.n193 0.1445
R5263 avdd.n201 avdd.n187 0.1445
R5264 avdd.n202 avdd.n186 0.1445
R5265 avdd.n195 avdd.n190 0.1445
R5266 avdd.n185 avdd.n180 0.1445
R5267 avdd.n239 avdd.n237 0.1445
R5268 avdd.n243 avdd.n235 0.1445
R5269 avdd.n242 avdd.n229 0.1445
R5270 avdd.n240 avdd.n236 0.1445
R5271 avdd.n252 avdd.n228 0.1445
R5272 avdd.n259 avdd.n258 0.1445
R5273 avdd.n260 avdd.n223 0.1445
R5274 avdd.n251 avdd.n250 0.1445
R5275 avdd.n291 avdd.n282 0.1445
R5276 avdd.n295 avdd.n282 0.1445
R5277 avdd.n295 avdd.n272 0.1445
R5278 avdd.n307 avdd.n272 0.1445
R5279 avdd.n307 avdd.n270 0.1445
R5280 avdd.n311 avdd.n270 0.1445
R5281 avdd.n286 avdd.n278 0.1445
R5282 avdd.n299 avdd.n278 0.1445
R5283 avdd.n299 avdd.n276 0.1445
R5284 avdd.n303 avdd.n276 0.1445
R5285 avdd.n303 avdd.n265 0.1445
R5286 avdd.n316 avdd.n265 0.1445
R5287 avdd.n285 avdd.n277 0.1445
R5288 avdd.n300 avdd.n277 0.1445
R5289 avdd.n301 avdd.n300 0.1445
R5290 avdd.n302 avdd.n301 0.1445
R5291 avdd.n302 avdd.n264 0.1445
R5292 avdd.n317 avdd.n264 0.1445
R5293 avdd.n293 avdd.n292 0.1445
R5294 avdd.n294 avdd.n293 0.1445
R5295 avdd.n294 avdd.n271 0.1445
R5296 avdd.n308 avdd.n271 0.1445
R5297 avdd.n309 avdd.n308 0.1445
R5298 avdd.n310 avdd.n309 0.1445
R5299 avdd.n346 avdd.n345 0.1445
R5300 avdd.n349 avdd.n346 0.1445
R5301 avdd.n349 avdd.n331 0.1445
R5302 avdd.n353 avdd.n331 0.1445
R5303 avdd.n341 avdd.n340 0.1445
R5304 avdd.n340 avdd.n339 0.1445
R5305 avdd.n339 avdd.n322 0.1445
R5306 avdd.n359 avdd.n322 0.1445
R5307 avdd.n342 avdd.n334 0.1445
R5308 avdd.n338 avdd.n334 0.1445
R5309 avdd.n338 avdd.n321 0.1445
R5310 avdd.n360 avdd.n321 0.1445
R5311 avdd.n344 avdd.n332 0.1445
R5312 avdd.n350 avdd.n332 0.1445
R5313 avdd.n351 avdd.n350 0.1445
R5314 avdd.n352 avdd.n351 0.1445
R5315 avdd.n204 avdd.n203 0.0740097
R5316 avdd.n204 avdd.n178 0.0740097
R5317 avdd.n249 avdd.n248 0.0740097
R5318 avdd.n248 avdd.n230 0.0740097
R5319 avdd.n31 avdd.n25 0.0245
R5320 avdd.n32 avdd.n5 0.0149
R5321 avdd.n24 avdd.n14 0.0149
R5322 avdd.n5 avdd.n0 0.0081885
R5323 avdd.n29 avdd.n1 0.0081885
R5324 avdd.n28 avdd.n27 0.0081885
R5325 avdd.n14 avdd.n9 0.0081885
R5326 avdd.n21 avdd.n10 0.0081885
R5327 avdd.n20 avdd.n19 0.0081885
R5328 avdd.n22 avdd.n9 0.0081885
R5329 avdd.n22 avdd.n21 0.0081885
R5330 avdd.n20 avdd.n10 0.0081885
R5331 avdd.n30 avdd.n0 0.0081885
R5332 avdd.n30 avdd.n29 0.0081885
R5333 avdd.n28 avdd.n1 0.0081885
R5334 avdd.n4 avdd.n2 0.00328455
R5335 avdd.n7 avdd.n6 0.00328455
R5336 avdd.n26 avdd.n3 0.00328455
R5337 avdd.n31 avdd.n8 0.00328455
R5338 avdd.n13 avdd.n11 0.00328455
R5339 avdd.n16 avdd.n15 0.00328455
R5340 avdd.n18 avdd.n12 0.00328455
R5341 avdd.n23 avdd.n17 0.00328455
R5342 avdd.n25 avdd.n11 0.00328455
R5343 avdd.n15 avdd.n13 0.00328455
R5344 avdd.n18 avdd.n16 0.00328455
R5345 avdd.n17 avdd.n12 0.00328455
R5346 avdd.n33 avdd.n2 0.00328455
R5347 avdd.n6 avdd.n4 0.00328455
R5348 avdd.n26 avdd.n7 0.00328455
R5349 avdd.n8 avdd.n3 0.00328455
C0 avdd xm8_0/a_63_n131# 0.78052f
C1 avdd Iout 0.03304f
C2 xmcm_chain_2_0/a_1000_n131# xm4_0/a_63_n131# 0
C3 vpost xmcm_chain_1_0/a_1000_n131# 0.00231f
C4 vb_itd xmcm_chain_1_0/a_1000_n131# 0.05873f
C5 xmcm_chain_4_0/a_n1000_n339# xm9_0/a_63_n131# 0.00198f
C6 xmcm_chain_4_0/a_n1000_n339# cw_0/m4_n700_n700# 0.01659f
C7 xmcm_chain_2_0/a_1000_n131# xmcm_chain_1_0/a_1000_n131# 0.07902f
C8 xmcm_chain_3_0/a_1000_n131# vpost 0
C9 vb_idep xm9_0/a_63_n131# 0.08994f
C10 xmcm_chain_3_0/a_1000_n131# vb_itd 0.00449f
C11 xmcm_chain_4_0/a_1000_n131# xmcm_chain_4_0/a_n1000_n339# 0.12631f
C12 nvpre xm8_0/a_63_n131# 0.03001f
C13 vb_idep avdd 0.0374f
C14 Iout xm1_0/a_63_n131# 0
C15 xm9_0/a_63_n131# avdd 0.69134f
C16 xmcm_chain_2_0/a_1000_n131# xmcm_chain_3_0/a_1000_n131# 0.04151f
C17 cw_0/m4_n700_n700# avdd 0.04948f
C18 xm1_0/a_n63_n339# xm8_0/a_63_n131# 0.04832f
C19 xm1_0/a_n63_n339# Iout 0.03718f
C20 xmcm_chain_4_0/a_1000_n131# cw_0/m4_n700_n700# 0.00992f
C21 xmcm_chain_4_0/a_n1000_n339# xm4_0/a_63_n131# 0
C22 vb_itp xm8_0/a_63_n131# 0
C23 xm9_0/a_63_n131# xm4_0/a_63_n131# 0.0142f
C24 xmcm_chain_4_0/a_n1000_n339# xmcm_chain_1_0/a_1000_n131# 0.04758f
C25 xm9_0/a_63_n131# nvpre 0
C26 avdd xm4_0/a_63_n131# 0
C27 avdd nvpre 0.03262f
C28 vb_idep xmcm_chain_1_0/a_1000_n131# 0
C29 avdd xm1_0/a_63_n131# 0.87307f
C30 xm9_0/a_63_n131# xmcm_chain_1_0/a_1000_n131# 0.02631f
C31 xmcm_chain_4_0/a_n1000_n339# xmcm_chain_3_0/a_1000_n131# 0.15956f
C32 xm1_0/a_n63_n339# vb_idep 0.02469f
C33 xm1_0/a_n63_n339# xm9_0/a_63_n131# 0.05011f
C34 xm9_0/a_63_n131# vb_itp 0.02854f
C35 cdep_0/m4_n700_n700# cw_0/m4_n700_n700# 0.24226f
C36 xm1_0/a_n63_n339# avdd 2.3363f
C37 avdd vb_itp 0.03631f
C38 xmcm_chain_4_0/a_1000_n131# xmcm_chain_1_0/a_1000_n131# 0.01434f
C39 xm9_0/a_63_n131# xmcm_chain_3_0/a_1000_n131# 0
C40 xmcm_chain_2_0/a_1000_n131# vpre 0
C41 xm4_0/a_63_n131# xm1_0/a_63_n131# 0.01204f
C42 xmcm_chain_4_0/a_1000_n131# xmcm_chain_3_0/a_1000_n131# 0.04151f
C43 xm4_0/a_63_n131# xmcm_chain_1_0/a_1000_n131# 0
C44 xm1_0/a_n63_n339# nvpre 0.00163f
C45 nvpre vb_itp 0.00799f
C46 xm1_0/a_n63_n339# xm1_0/a_63_n131# 0.29212f
C47 cdep_0/m4_n700_n700# xm1_0/a_n63_n339# 0.23585f
C48 xmcm_chain_2_0/a_1000_n131# vpost 0
C49 xmcm_chain_4_0/a_n1000_n339# vpre 0.00204f
C50 nvpost xm8_0/a_63_n131# 0.0071f
C51 xm1_0/a_n63_n339# vb_itp 0
C52 xmcm_chain_3_0/a_1000_n131# xmcm_chain_1_0/a_1000_n131# 0.04858f
C53 xmcm_chain_4_0/a_n1000_n339# vpost 0.00204f
C54 xmcm_chain_4_0/a_n1000_n339# vb_itd 0.0204f
C55 avdd nvpost 0.03628f
C56 xm4_0/a_63_n131# vpre 0.00163f
C57 vb_idep vb_itd 0.00453f
C58 Iout xm8_0/a_63_n131# 0.00295f
C59 xm9_0/a_63_n131# vpost 0.01355f
C60 xmcm_chain_4_0/a_n1000_n339# xmcm_chain_2_0/a_1000_n131# 0.12554f
C61 xm9_0/a_63_n131# vb_itd 0
C62 avdd vb_itd 0.01241f
C63 vpre xmcm_chain_1_0/a_1000_n131# 0
C64 xm9_0/a_63_n131# xmcm_chain_2_0/a_1000_n131# 0.00189f
C65 xmcm_chain_4_0/a_1000_n131# vb_itd 0.0028f
C66 nvpost xm1_0/a_63_n131# 0.01709f
C67 xmcm_chain_4_0/a_1000_n131# xmcm_chain_2_0/a_1000_n131# 0.00555f
C68 xm9_0/a_63_n131# xm8_0/a_63_n131# 0
C69 xm1_0/a_n63_n339# nvpost 0.0071f
C70 Iout vw 0.07222f
C71 vb_itp vw -0.11537f
C72 vb_itd vw -0.08164f
C73 vpre vw -0.04241f
C74 vpost vw -0.04428f
C75 nvpre vw -0.0917f
C76 nvpost vw -0.07664f
C77 avdd.n1 vw 0.00451f
C78 avdd.n3 vw 0.00632f
C79 avdd.n4 vw 0.00632f
C80 avdd.n5 vw 0.00451f
C81 avdd.n7 vw 0.00632f
C82 avdd.n10 vw 0.00451f
C83 avdd.n12 vw 0.00632f
C84 avdd.n13 vw 0.00632f
C85 avdd.n14 vw 0.00451f
C86 avdd.n16 vw 0.00632f
C87 avdd.n19 vw 0.00734f
C88 avdd.n22 vw 0.00451f
C89 avdd.n23 vw 0.01817f
C90 avdd.n24 vw 0.00734f
C91 avdd.n25 vw 0.01975f
C92 avdd.n27 vw 0.00734f
C93 avdd.n30 vw 0.00451f
C94 avdd.n31 vw 0.01975f
C95 avdd.n32 vw 0.00734f
C96 avdd.n33 vw 0.04855f
C97 avdd.n34 vw 0.00121f
C98 avdd.n35 vw 0
C99 avdd.n36 vw 0
C100 avdd.n37 vw 0
C101 avdd.n38 vw 0.0087f
C102 avdd.n39 vw 0.00506f
C103 avdd.n40 vw 0
C104 avdd.n41 vw 0
C105 avdd.n42 vw 0
C106 avdd.n43 vw 0
C107 avdd.n44 vw 0
C108 avdd.n45 vw 0.00506f
C109 avdd.n46 vw 0
C110 avdd.n47 vw 0
C111 avdd.n48 vw 0
C112 avdd.n49 vw 0
C113 avdd.n50 vw 0
C114 avdd.n51 vw 0.00506f
C115 avdd.n52 vw 0
C116 avdd.n53 vw 0
C117 avdd.n54 vw 0
C118 avdd.n55 vw 0
C119 avdd.n56 vw 0
C120 avdd.n57 vw 0.00506f
C121 avdd.n58 vw 0
C122 avdd.n59 vw 0
C123 avdd.n60 vw 0
C124 avdd.n61 vw 0
C125 avdd.n62 vw 0
C126 avdd.n63 vw 0.00506f
C127 avdd.n64 vw 0
C128 avdd.n65 vw 0
C129 avdd.n66 vw 0
C130 avdd.n67 vw 0
C131 avdd.n68 vw 0
C132 avdd.n69 vw 0.00506f
C133 avdd.n70 vw 0
C134 avdd.n71 vw 0
C135 avdd.n72 vw 0
C136 avdd.n73 vw 0
C137 avdd.n74 vw 0
C138 avdd.n75 vw 0.00506f
C139 avdd.n76 vw 0
C140 avdd.n77 vw 0
C141 avdd.n78 vw 0
C142 avdd.n79 vw 0
C143 avdd.n80 vw 0
C144 avdd.n81 vw 0.00506f
C145 avdd.n82 vw 0
C146 avdd.n83 vw 0
C147 avdd.n84 vw 0
C148 avdd.n85 vw 0
C149 avdd.n86 vw 0
C150 avdd.n87 vw 0.00506f
C151 avdd.n88 vw 0
C152 avdd.n89 vw 0
C153 avdd.n90 vw 0.00117f
C154 avdd.n91 vw 0
C155 avdd.n92 vw 0
C156 avdd.n93 vw 0.00688f
C157 avdd.n94 vw 0
C158 avdd.n95 vw 0
C159 avdd.n97 vw 0.0087f
C160 avdd.n98 vw 0.01239f
C161 avdd.n99 vw 0.0014f
C162 avdd.n100 vw 0
C163 avdd.n101 vw 0
C164 avdd.n102 vw 0
C165 avdd.n103 vw 0.00506f
C166 avdd.n104 vw 0
C167 avdd.n105 vw 0
C168 avdd.n106 vw 0
C169 avdd.n107 vw 0
C170 avdd.n108 vw 0
C171 avdd.n109 vw 0
C172 avdd.n110 vw 0
C173 avdd.n111 vw 0.00506f
C174 avdd.n112 vw 0
C175 avdd.n113 vw 0
C176 avdd.n114 vw 0
C177 avdd.n115 vw 0
C178 avdd.n116 vw 0
C179 avdd.n117 vw 0
C180 avdd.n118 vw 0
C181 avdd.n119 vw 0.00506f
C182 avdd.n120 vw 0
C183 avdd.n121 vw 0
C184 avdd.n122 vw 0
C185 avdd.n123 vw 0
C186 avdd.n124 vw 0
C187 avdd.n125 vw 0
C188 avdd.n126 vw 0
C189 avdd.n127 vw 0.00506f
C190 avdd.n128 vw 0
C191 avdd.n129 vw 0
C192 avdd.n130 vw 0
C193 avdd.n131 vw 0
C194 avdd.n132 vw 0
C195 avdd.n133 vw 0
C196 avdd.n134 vw 0
C197 avdd.n135 vw 0.00506f
C198 avdd.n136 vw 0
C199 avdd.n137 vw 0
C200 avdd.n138 vw 0
C201 avdd.n139 vw 0
C202 avdd.n140 vw 0
C203 avdd.n141 vw 0
C204 avdd.n142 vw 0
C205 avdd.n143 vw 0.00506f
C206 avdd.n144 vw 0
C207 avdd.n145 vw 0
C208 avdd.n146 vw 0
C209 avdd.n147 vw 0
C210 avdd.n148 vw 0
C211 avdd.n149 vw 0
C212 avdd.n150 vw 0
C213 avdd.n151 vw 0.00506f
C214 avdd.n152 vw 0
C215 avdd.n153 vw 0
C216 avdd.n154 vw 0
C217 avdd.n155 vw 0
C218 avdd.n156 vw 0
C219 avdd.n157 vw 0
C220 avdd.n158 vw 0
C221 avdd.n159 vw 0.00506f
C222 avdd.n160 vw 0
C223 avdd.n161 vw 0
C224 avdd.n162 vw 0
C225 avdd.n163 vw 0
C226 avdd.n164 vw 0
C227 avdd.n165 vw 0
C228 avdd.n166 vw 0
C229 avdd.n167 vw 0.00506f
C230 avdd.n168 vw 0
C231 avdd.n169 vw 0
C232 avdd.n170 vw 0
C233 avdd.n171 vw 0
C234 avdd.n172 vw 0.00193f
C235 avdd.n173 vw 0.00111f
C236 avdd.n174 vw 0
C237 avdd.n175 vw 0.0015f
C238 avdd.n176 vw 0.0119f
C239 avdd.n177 vw 0
C240 avdd.n178 vw 0.00431f
C241 avdd.n179 vw 0.0015f
C242 avdd.n180 vw 0.00118f
C243 avdd.n181 vw 0.00824f
C244 avdd.n182 vw 0
C245 avdd.n183 vw 0
C246 avdd.n184 vw 0
C247 avdd.n185 vw 0.00111f
C248 avdd.n186 vw 0.00118f
C249 avdd.n187 vw 0
C250 avdd.n188 vw 0.0119f
C251 avdd.n189 vw 0
C252 avdd.n190 vw 0.00111f
C253 avdd.n191 vw 0.00824f
C254 avdd.n192 vw 0
C255 avdd.n193 vw 0
C256 avdd.n194 vw 0
C257 avdd.n195 vw 0.00118f
C258 avdd.n196 vw 0.00265f
C259 avdd.n197 vw 0.0015f
C260 avdd.n198 vw 0
C261 avdd.n199 vw 0.00824f
C262 avdd.n200 vw 0
C263 avdd.n201 vw 0
C264 avdd.n202 vw 0.00111f
C265 avdd.n203 vw 0.00377f
C266 avdd.n204 vw 0.0079f
C267 avdd.n205 vw 0.0015f
C268 avdd.n206 vw 0
C269 avdd.n207 vw 0.00824f
C270 avdd.n208 vw 0
C271 avdd.n209 vw 0
C272 avdd.n210 vw 0.00111f
C273 avdd.n211 vw 0.00124f
C274 avdd.n212 vw 0.00124f
C275 avdd.n213 vw 0.0011f
C276 avdd.n214 vw 0
C277 avdd.n215 vw 0
C278 avdd.n216 vw 0.00688f
C279 avdd.n218 vw 0
C280 avdd.n219 vw 0
C281 avdd.n220 vw 0.0011f
C282 avdd.n221 vw 0.00839f
C283 avdd.n222 vw 0.00193f
C284 avdd.n223 vw 0.00111f
C285 avdd.n224 vw 0
C286 avdd.n225 vw 0.0015f
C287 avdd.n226 vw 0.00824f
C288 avdd.n227 vw 0
C289 avdd.n228 vw 0
C290 avdd.n229 vw 0.00111f
C291 avdd.n230 vw 0.00431f
C292 avdd.n231 vw 0
C293 avdd.n232 vw 0
C294 avdd.n233 vw 0.00824f
C295 avdd.n234 vw 0.0015f
C296 avdd.n235 vw 0
C297 avdd.n236 vw 0.00111f
C298 avdd.n237 vw 0
C299 avdd.n238 vw 0
C300 avdd.n239 vw 0
C301 avdd.n240 vw 0.00118f
C302 avdd.n241 vw 0.00265f
C303 avdd.n242 vw 0.00118f
C304 avdd.n243 vw 0
C305 avdd.n244 vw 0
C306 avdd.n245 vw 0.00824f
C307 avdd.n246 vw 0.0119f
C308 avdd.n247 vw 0.0015f
C309 avdd.n248 vw 0.0079f
C310 avdd.n249 vw 0.00377f
C311 avdd.n250 vw 0.00111f
C312 avdd.n251 vw 0.00118f
C313 avdd.n252 vw 0
C314 avdd.n253 vw 0
C315 avdd.n254 vw 0.0015f
C316 avdd.n255 vw 0.0119f
C317 avdd.n256 vw 0.00824f
C318 avdd.n257 vw 0
C319 avdd.n258 vw 0
C320 avdd.n259 vw 0
C321 avdd.n260 vw 0.00111f
C322 avdd.n261 vw 0.00738f
C323 avdd.n262 vw 0.02664f
C324 avdd.n263 vw 0.00193f
C325 avdd.n264 vw 0
C326 avdd.n265 vw 0
C327 avdd.n266 vw 0
C328 avdd.n267 vw 0.0087f
C329 avdd.n268 vw 0.00506f
C330 avdd.n269 vw 0
C331 avdd.n270 vw 0
C332 avdd.n271 vw 0
C333 avdd.n272 vw 0
C334 avdd.n273 vw 0
C335 avdd.n274 vw 0.00506f
C336 avdd.n275 vw 0
C337 avdd.n276 vw 0
C338 avdd.n277 vw 0
C339 avdd.n278 vw 0
C340 avdd.n279 vw 0
C341 avdd.n280 vw 0.00506f
C342 avdd.n281 vw 0
C343 avdd.n282 vw 0
C344 avdd.n283 vw 0.00666f
C345 avdd.n284 vw 0.0087f
C346 avdd.n285 vw 0.00127f
C347 avdd.n286 vw 0
C348 avdd.n287 vw 0
C349 avdd.n288 vw 0.00688f
C350 avdd.n290 vw 0
C351 avdd.n291 vw 0
C352 avdd.n292 vw 0.00117f
C353 avdd.n293 vw 0
C354 avdd.n294 vw 0
C355 avdd.n295 vw 0
C356 avdd.n296 vw 0
C357 avdd.n297 vw 0.00506f
C358 avdd.n298 vw 0
C359 avdd.n299 vw 0
C360 avdd.n300 vw 0
C361 avdd.n301 vw 0
C362 avdd.n302 vw 0
C363 avdd.n303 vw 0
C364 avdd.n304 vw 0
C365 avdd.n305 vw 0.00506f
C366 avdd.n306 vw 0
C367 avdd.n307 vw 0
C368 avdd.n308 vw 0
C369 avdd.n309 vw 0
C370 avdd.n310 vw 0.00117f
C371 avdd.n311 vw 0
C372 avdd.n312 vw 0
C373 avdd.n313 vw 0.00688f
C374 avdd.n315 vw 0
C375 avdd.n316 vw 0
C376 avdd.n317 vw 0.0011f
C377 avdd.n318 vw 0.00738f
C378 avdd.n319 vw 0.00853f
C379 avdd.n320 vw 0.0053f
C380 avdd.n321 vw 0
C381 avdd.n322 vw 0
C382 avdd.n323 vw 0
C383 avdd.n324 vw 0.00338f
C384 avdd.n327 vw 0.00338f
C385 avdd.n330 vw 0
C386 avdd.n331 vw 0
C387 avdd.n332 vw 0
C388 avdd.n333 vw 0.00191f
C389 avdd.n334 vw 0
C390 avdd.n335 vw 0.00191f
C391 avdd.n336 vw 0
C392 avdd.n337 vw 0
C393 avdd.n338 vw 0
C394 avdd.n339 vw 0
C395 avdd.n340 vw 0
C396 avdd.n341 vw 0
C397 avdd.n342 vw 0.00283f
C398 avdd.n343 vw 0.01308f
C399 avdd.n344 vw 0.00152f
C400 avdd.n345 vw 0
C401 avdd.n346 vw 0
C402 avdd.n347 vw 0
C403 avdd.n348 vw 0
C404 avdd.n349 vw 0
C405 avdd.n350 vw 0
C406 avdd.n351 vw 0
C407 avdd.n352 vw 0.00152f
C408 avdd.n353 vw 0
C409 avdd.n354 vw 0.00191f
C410 avdd.n355 vw 0.03046f
C411 avdd.n356 vw 0.054f
C412 avdd.n357 vw 0.03046f
C413 avdd.n358 vw 0.00191f
C414 avdd.n359 vw 0
C415 avdd.n360 vw 0.00105f
C416 avdd.n361 vw 0.00689f
C417 avdd.n362 vw 0.00882f
C418 avdd.n363 vw 0.04046f
C419 avss.n1 vw 0.00291f
C420 avss.n2 vw 0.00473f
C421 avss.n3 vw 0.00291f
C422 avss.n5 vw 0.00291f
C423 avss.n6 vw 0.00291f
C424 avss.n7 vw 0.00473f
C425 avss.n10 vw 0.00838f
C426 avss.n12 vw 0.00838f
C427 avss.n13 vw 0.00291f
C428 avss.n16 vw 0.00473f
C429 avss.n19 vw 0.00291f
C430 avss.n20 vw 0.00473f
C431 avss.n21 vw 0.00291f
C432 avss.n23 vw 0.00291f
C433 avss.n24 vw 0.00291f
C434 avss.n25 vw 0.00473f
C435 avss.n28 vw 0.00838f
C436 avss.n30 vw 0.00838f
C437 avss.n31 vw 0.00291f
C438 avss.n34 vw 0.00473f
C439 avss.n37 vw 0.00291f
C440 avss.n38 vw 0.00473f
C441 avss.n39 vw 0.00291f
C442 avss.n41 vw 0.00291f
C443 avss.n42 vw 0.00291f
C444 avss.n43 vw 0.00473f
C445 avss.n46 vw 0.00838f
C446 avss.n48 vw 0.005f
C447 avss.n49 vw 0.00291f
C448 avss.n52 vw 0.00473f
C449 avss.n55 vw 0.00291f
C450 avss.n56 vw 0.00473f
C451 avss.n57 vw 0.00291f
C452 avss.n59 vw 0.00291f
C453 avss.n60 vw 0.00291f
C454 avss.n61 vw 0.00473f
C455 avss.n64 vw 0.00838f
C456 avss.n66 vw 0.00838f
C457 avss.n67 vw 0.00291f
C458 avss.n70 vw 0.00473f
C459 avss.n73 vw 0.00291f
C460 avss.n74 vw 0.00473f
C461 avss.n75 vw 0.00291f
C462 avss.n77 vw 0.00291f
C463 avss.n78 vw 0.00291f
C464 avss.n79 vw 0.00473f
C465 avss.n82 vw 0.00838f
C466 avss.n84 vw 0.00838f
C467 avss.n85 vw 0.00291f
C468 avss.n88 vw 0.00473f
C469 avss.n90 vw 0.0055f
C470 avss.n91 vw 0.00124f
C471 avss.n92 vw 0
C472 avss.n93 vw 0
C473 avss.n94 vw 0
C474 avss.n95 vw 0
C475 avss.n96 vw 0.0637f
C476 avss.n105 vw 0
C477 avss.n106 vw 0
C478 avss.n107 vw 0
C479 avss.n108 vw 0
C480 avss.n109 vw 0
C481 avss.n110 vw 0
C482 avss.n111 vw 0
C483 avss.n112 vw 0
C484 avss.n113 vw 0
C485 avss.n114 vw 0
C486 avss.n115 vw 0
C487 avss.n116 vw 0
C488 avss.n117 vw 0
C489 avss.n118 vw 0
C490 avss.n119 vw 0
C491 avss.n120 vw 0
C492 avss.n121 vw 0
C493 avss.n122 vw 0
C494 avss.n123 vw 0
C495 avss.n124 vw 0
C496 avss.n125 vw 0.03617f
C497 avss.n127 vw 0
C498 avss.n130 vw 0
C499 avss.n133 vw 0
C500 avss.n136 vw 0
C501 avss.n137 vw 0
C502 avss.n138 vw 0
C503 avss.n139 vw 0
C504 avss.n140 vw 0
C505 avss.n141 vw 0
C506 avss.n142 vw 0
C507 avss.n143 vw 0.0115f
C508 avss.n144 vw 0
C509 avss.n145 vw 0
C510 avss.n146 vw 0
C511 avss.n147 vw 0
C512 avss.n148 vw 0
C513 avss.n149 vw 0
C514 avss.n151 vw 0
C515 avss.n152 vw 0
C516 avss.n153 vw 0
C517 avss.n154 vw 0
C518 avss.n155 vw 0
C519 avss.n156 vw 0
C520 avss.n158 vw 0
C521 avss.n159 vw 0
C522 avss.n160 vw 0.00925f
C523 avss.n161 vw 0
C524 avss.n162 vw 0
C525 avss.n163 vw 0
C526 avss.n164 vw 0
C527 avss.n165 vw 0
C528 avss.n166 vw 0.004f
C529 avss.n167 vw 0
C530 avss.n168 vw 0
C531 avss.n169 vw 0
C532 avss.n176 vw 0
C533 avss.n177 vw 0
C534 avss.n178 vw 0
C535 avss.n179 vw 0
C536 avss.n180 vw 0
C537 avss.n181 vw 0
C538 avss.n182 vw 0
C539 avss.n183 vw 0.0637f
C540 avss.n185 vw 0
C541 avss.n186 vw 0
C542 avss.n187 vw 0
C543 avss.n188 vw 0
C544 avss.n189 vw 0
C545 avss.n190 vw 0.00925f
C546 avss.n191 vw 0.05376f
C547 avss.n192 vw 0.01312f
C548 avss.n193 vw 0.00925f
C549 avss.n194 vw 0.00915f
C550 avss.n195 vw 0
C551 avss.n196 vw 0.00742f
C552 avss.n197 vw 0
C553 avss.n198 vw 0
C554 avss.n199 vw 0
C555 avss.n200 vw 0
C556 avss.n201 vw 0
C557 avss.n202 vw 0
C558 avss.n203 vw 0
C559 avss.n204 vw 0
C560 avss.n205 vw 0.0066f
C561 avss.n206 vw 0
C562 avss.n207 vw 0
C563 avss.n208 vw 0.0066f
C564 avss.n209 vw 0
C565 avss.n210 vw 0
C566 avss.n211 vw 0
C567 avss.n212 vw 0
C568 avss.n213 vw 0
C569 avss.n214 vw 0.0066f
C570 avss.n215 vw 0.01142f
C571 avss.n216 vw 0
C572 avss.n217 vw 0
C573 avss.n218 vw 0
C574 avss.n219 vw 0.00805f
C575 avss.n220 vw 0.00124f
C576 avss.n221 vw 0
C577 avss.n222 vw 0
C578 avss.n223 vw 0
C579 avss.n224 vw 0
C580 avss.n225 vw 0.00775f
C581 avss.n226 vw 0
C582 avss.n227 vw 0
C583 avss.n228 vw 0
C584 avss.n229 vw 0
C585 avss.n230 vw 0
C586 avss.n231 vw 0.0066f
C587 avss.n232 vw 0.0066f
C588 avss.n233 vw 0
C589 avss.n234 vw 0
C590 avss.n235 vw 0
C591 avss.n236 vw 0
C592 avss.n237 vw 0
C593 avss.n238 vw 0.0108f
C594 avss.n239 vw 0
C595 avss.n240 vw 0
C596 avss.n241 vw 0.0066f
C597 avss.n242 vw 0
C598 avss.n243 vw 0
C599 avss.n244 vw 0
C600 avss.n245 vw 0
C601 avss.n246 vw 0.00278f
C602 avss.n247 vw 0
C603 avss.n248 vw 0.00225f
C604 avss.n249 vw 0
C605 avss.n250 vw 0
C606 avss.n251 vw 0.01047f
C607 avss.n252 vw 0
C608 avss.n253 vw 0
C609 avss.n254 vw 0
C610 avss.n255 vw 0
C611 avss.n256 vw 0
C612 avss.n257 vw 0
C613 avss.n258 vw 0
C614 avss.n259 vw 0.00676f
C615 avss.n260 vw 0
C616 avss.n261 vw 0
C617 avss.n262 vw 0
C618 avss.n263 vw 0
C619 avss.n264 vw 0
C620 avss.n265 vw 0
C621 avss.n266 vw 0.01319f
C622 avss.n267 vw 0
C623 avss.n268 vw 0
C624 avss.n269 vw 0
C625 avss.n270 vw 0
C626 avss.n271 vw 0
C627 avss.n272 vw 0.01319f
C628 avss.n273 vw 0
C629 avss.n274 vw 0
C630 avss.n275 vw 0
C631 avss.n276 vw 0
C632 avss.n277 vw 0
C633 avss.n278 vw 0
C634 avss.n279 vw 0
C635 avss.n280 vw 0
C636 avss.n281 vw 0
C637 avss.n282 vw 0
C638 avss.n283 vw 0
C639 avss.n284 vw 0.00295f
C640 avss.n285 vw 0
C641 avss.n286 vw 0.00181f
C642 avss.n288 vw 0
C643 avss.n289 vw 0
C644 avss.n290 vw 0
C645 avss.n291 vw 0
C646 avss.n292 vw 0.01645f
C647 avss.n293 vw 0.00297f
C648 avss.n294 vw 0
C649 avss.n295 vw 0.00398f
C650 avss.n296 vw 0.00317f
C651 avss.n297 vw 0.00352f
C652 avss.n298 vw 0
C653 avss.n299 vw 0.01047f
C654 avss.n300 vw 0.00569f
C655 avss.n301 vw 0
C656 avss.n302 vw 0
C657 avss.n303 vw 0
C658 avss.n304 vw 0
C659 avss.n305 vw 0
C660 avss.n306 vw 0
C661 avss.n307 vw 0
C662 avss.n308 vw 0
C663 avss.n311 vw 0
C664 avss.n312 vw 0
C665 avss.n313 vw 0
C666 avss.n314 vw 0
C667 avss.n315 vw 0
C668 avss.n316 vw 0
C669 avss.n317 vw 0
C670 avss.n318 vw 0
C671 avss.n319 vw 0
C672 avss.n320 vw 0.0017f
C673 avss.n321 vw 0
C674 avss.n322 vw 0
C675 avss.n323 vw 0
C676 avss.n324 vw 0
C677 avss.n325 vw 0
C678 avss.n326 vw 0
C679 avss.n327 vw 0
C680 avss.n328 vw 0
C681 avss.n329 vw 0
C682 avss.n330 vw 0
C683 avss.n331 vw 0
C684 avss.n332 vw 0
C685 avss.n333 vw 0
C686 avss.n334 vw 0
C687 avss.n335 vw 0
C688 avss.n336 vw 0
C689 avss.n337 vw 0
C690 avss.n338 vw 0
C691 avss.n339 vw 0
C692 avss.n340 vw 0
C693 avss.n341 vw 0
C694 avss.n342 vw 0
C695 avss.n343 vw 0
C696 avss.n344 vw 0
C697 avss.n346 vw 0.03151f
C698 avss.n348 vw 0
C699 avss.n349 vw 0
C700 avss.n350 vw 0
C701 avss.n351 vw 0
C702 avss.n352 vw 0
C703 avss.n353 vw 0.00165f
C704 avss.n354 vw 0.00124f
C705 avss.n355 vw 0
C706 avss.n356 vw 0.0183f
C707 avss.n357 vw 0.0183f
C708 avss.n358 vw 0
C709 avss.n359 vw 0
C710 avss.n360 vw 0
C711 avss.n361 vw 0
C712 avss.n362 vw 0
C713 avss.n363 vw 0
C714 avss.n364 vw 0
C715 avss.n365 vw 0
C716 avss.n366 vw 0.0017f
C717 avss.n367 vw 0
C718 avss.n368 vw 0.01047f
C719 avss.n369 vw 0
C720 avss.n370 vw 0
C721 avss.n371 vw 0
C722 avss.n372 vw 0
C723 avss.n373 vw 0
C724 avss.n374 vw 0.01047f
C725 avss.n375 vw 0
C726 avss.n376 vw 0
C727 avss.n377 vw 0
C728 avss.n378 vw 0
C729 avss.n379 vw 0
C730 avss.n380 vw 0
C731 avss.n381 vw 0
C732 avss.n382 vw 0
C733 avss.n383 vw 0.00308f
C734 avss.n384 vw 0
C735 avss.n385 vw 0.01319f
C736 avss.n386 vw 0
C737 avss.n387 vw 0
C738 avss.n388 vw 0
C739 avss.n389 vw 0
C740 avss.n390 vw 0
C741 avss.n391 vw 0
C742 avss.n392 vw 0
C743 avss.n393 vw 0
C744 avss.n394 vw 0.01319f
C745 avss.n395 vw 0
C746 avss.n396 vw 0
C747 avss.n397 vw 0
C748 avss.n398 vw 0
C749 avss.n399 vw 0
C750 avss.n400 vw 0
C751 avss.n401 vw 0
C752 avss.n402 vw 0
C753 avss.n403 vw 0
C754 avss.n404 vw 0
C755 avss.n405 vw 0
C756 avss.n406 vw 0
C757 avss.n407 vw 0
C758 avss.n408 vw 0.0066f
C759 avss.n409 vw 0.00899f
C760 avss.n410 vw 0
C761 avss.n411 vw 0
C762 avss.n412 vw 0
C763 avss.n413 vw 0
C764 avss.n414 vw 0
C765 avss.n415 vw 0.00915f
C766 avss.n416 vw 0.0066f
C767 avss.n417 vw 0
C768 avss.n418 vw 0.00352f
C769 avss.n419 vw 0.004f
C770 avss.n420 vw 0
C771 avss.n421 vw 0
C772 avss.n422 vw 0
C773 avss.n423 vw 0
C774 avss.n424 vw 0
C775 avss.n425 vw 0
C776 avss.n426 vw 0
C777 avss.n427 vw 0
C778 avss.n428 vw 0.00915f
C779 avss.n429 vw 0
C780 avss.n430 vw 0.01068f
C781 avss.n431 vw 0.01121f
C782 avss.n432 vw 0
C783 avss.n433 vw 0
C784 avss.n434 vw 0
C785 avss.n435 vw 0
C786 avss.n436 vw 0
C787 avss.n437 vw 0
C788 avss.n438 vw 0
C789 avss.n439 vw 0
C790 avss.n440 vw 0
C791 avss.n441 vw 0.0066f
C792 avss.n442 vw 0
C793 avss.n443 vw 0
C794 avss.n444 vw 0
C795 avss.n445 vw 0.0066f
C796 avss.n446 vw 0
C797 avss.n447 vw 0
C798 avss.n448 vw 0
C799 avss.n449 vw 0
C800 avss.n450 vw 0
C801 avss.n451 vw 0
C802 avss.n452 vw 0.00243f
C803 avss.n453 vw 0
C804 avss.n454 vw 0
C805 avss.n455 vw 0
C806 avss.n456 vw 0.00179f
C807 avss.n457 vw 0
C808 avss.n458 vw 0
C809 avss.n459 vw 0
C810 avss.n460 vw 0
C811 avss.n461 vw 0.0066f
C812 avss.n462 vw 0.00911f
C813 avss.n463 vw 0
C814 avss.n464 vw 0
C815 avss.n465 vw 0
C816 avss.n466 vw 0
C817 avss.n467 vw 0.00915f
C818 avss.n468 vw 0
C819 avss.n469 vw 0
C820 avss.n470 vw 0
C821 avss.n471 vw 0.0017f
C822 avss.n472 vw 0
C823 avss.n473 vw 0
C824 avss.n474 vw 0
C825 avss.n475 vw 0
C826 avss.n476 vw 0
C827 avss.n477 vw 0
C828 avss.n478 vw 0
C829 avss.n479 vw 0
C830 avss.n480 vw 0
C831 avss.n481 vw 0
C832 avss.n482 vw 0
C833 avss.n483 vw 0
C834 avss.n484 vw 0
C835 avss.n485 vw 0
C836 avss.n486 vw 0
C837 avss.n487 vw 0
C838 avss.n488 vw 0
C839 avss.n489 vw 0
C840 avss.n490 vw 0
C841 avss.n491 vw 0
C842 avss.n492 vw 0
C843 avss.n493 vw 0
C844 avss.n494 vw 0
C845 avss.n495 vw 0
C846 avss.n496 vw 0
C847 avss.n497 vw 0
C848 avss.n498 vw 0
C849 avss.n499 vw 0
C850 avss.n500 vw 0
C851 avss.n501 vw 0
C852 avss.n502 vw 0
C853 avss.n503 vw 0
C854 avss.n504 vw 0
C855 avss.n505 vw 0
C856 avss.n506 vw 0
C857 avss.n507 vw 0
C858 avss.n508 vw 0
C859 avss.n509 vw 0
C860 avss.n510 vw 0
C861 avss.n511 vw 0.0089f
C862 avss.n512 vw 0.0066f
C863 avss.n513 vw 0
C864 avss.n514 vw 0.00427f
C865 avss.n515 vw 0.00243f
C866 avss.n516 vw 0
C867 avss.n517 vw 0
C868 avss.n518 vw 0
C869 avss.n519 vw 0
C870 avss.n520 vw 0.0066f
C871 avss.n521 vw 0.01068f
C872 avss.n522 vw 0.00734f
C873 avss.n523 vw 0
C874 avss.n524 vw 0
C875 avss.n525 vw 0
C876 avss.n526 vw 0
C877 avss.n527 vw 0
C878 avss.n528 vw 0
C879 avss.n529 vw 0
C880 avss.n530 vw 0.00915f
C881 avss.n531 vw 0.0066f
C882 avss.n532 vw 0
C883 avss.n533 vw 0
C884 avss.n534 vw 0
C885 avss.n535 vw 0
C886 avss.n536 vw 0
C887 avss.n537 vw 0
C888 avss.n538 vw 0.00171f
C889 avss.n539 vw 0
C890 avss.n540 vw 0
C891 avss.n541 vw 0
C892 avss.n542 vw 0.0068f
C893 avss.n543 vw 0.01801f
C894 avss.n544 vw 0.0115f
C895 avss.n545 vw 0
C896 avss.n546 vw 0.0051f
C897 avss.n547 vw 0.00243f
C898 avss.n548 vw 0
C899 avss.n549 vw 0
C900 avss.n550 vw 0
C901 avss.n551 vw 0
C902 avss.n552 vw 0.0066f
C903 avss.n553 vw 0.00721f
C904 avss.n554 vw 0
C905 avss.n555 vw 0
C906 avss.n556 vw 0
C907 avss.n557 vw 0
C908 avss.n558 vw 0
C909 avss.n559 vw 0
C910 avss.n560 vw 0
C911 avss.n561 vw 0.01142f
C912 avss.n562 vw 0
C913 avss.n563 vw 0
C914 avss.n564 vw 0
C915 avss.n565 vw 0
C916 avss.n566 vw 0
C917 avss.n567 vw 0
C918 avss.n568 vw 0
C919 avss.n569 vw 0.008f
C920 avss.n570 vw 0
C921 avss.n571 vw 0
C922 avss.n572 vw 0
C923 avss.n573 vw 0.00165f
C924 avss.n574 vw 0.01701f
C925 avss.n575 vw 0
C926 avss.n576 vw 0
C927 avss.n577 vw 0
C928 avss.n578 vw 0.00319f
C929 avss.n579 vw 0.00124f
C930 avss.n580 vw 0
C931 avss.n581 vw 0.04872f
C932 avss.n582 vw 0
C933 avss.n583 vw 0.00171f
C934 avss.n584 vw 0
C935 avss.n585 vw 0
C936 avss.n586 vw 0
C937 avss.n587 vw 0
C938 avss.n588 vw 0.0066f
C939 avss.n589 vw 0.01142f
C940 avss.n590 vw 0
C941 avss.n591 vw 0
C942 avss.n592 vw 0
C943 avss.n593 vw 0
C944 avss.n594 vw 0
C945 avss.n595 vw 0.00833f
C946 avss.n596 vw 0.00925f
C947 avss.n597 vw 0.00782f
C948 avss.n598 vw 0.00813f
C949 avss.n599 vw 0.0064f
C950 avss.n600 vw 0.13449f
C951 avss.n601 vw 0.08122f
C952 avss.n602 vw 0.33695f
C953 avss.n604 vw 0
C954 avss.n605 vw 0
C955 avss.n606 vw 0
C956 avss.n607 vw 0
C957 avss.n608 vw 0
C958 avss.n609 vw 0
C959 avss.n610 vw 0
C960 avss.n611 vw 0
C961 avss.n612 vw 0
C962 avss.n613 vw 0
C963 avss.n614 vw 0
C964 avss.n615 vw 0
C965 avss.n616 vw 0
C966 avss.n617 vw 0
C967 avss.n618 vw 0
C968 avss.n619 vw 0
C969 avss.n620 vw 0
C970 avss.n621 vw 0
C971 avss.n622 vw 0
C972 avss.n623 vw 0
C973 avss.n624 vw 0
C974 avss.n625 vw 0
C975 avss.n626 vw 0
C976 avss.n627 vw 0
C977 avss.n628 vw 0
C978 avss.n629 vw 0
C979 avss.n630 vw 0
C980 avss.n631 vw 0
C981 avss.n633 vw 0.59587f
C982 avss.n634 vw 0
C983 avss.n635 vw 0
C984 avss.n636 vw 0
C985 avss.n637 vw 0.0017f
C986 avss.n638 vw 0
C987 avss.n639 vw 0
C988 avss.n640 vw 0
C989 avss.n641 vw 0
C990 avss.n642 vw 0
C991 avss.n643 vw 0
C992 avss.n644 vw 0
C993 avss.n645 vw 0
C994 avss.n646 vw 0
C995 avss.n647 vw 0
C996 avss.n648 vw 0.06118f
C997 avss.n650 vw 0
C998 avss.n651 vw 0
C999 avss.n652 vw 0
C1000 avss.n653 vw 0
C1001 avss.n654 vw 0
C1002 avss.n655 vw 0
C1003 avss.n656 vw 0
C1004 avss.n657 vw 0
C1005 avss.n658 vw 0
C1006 avss.n659 vw 0
C1007 avss.n660 vw 0
C1008 avss.n661 vw 0
C1009 avss.n662 vw 0
C1010 avss.n663 vw 0
C1011 avss.n664 vw 0
C1012 avss.n665 vw 0
C1013 avss.n666 vw 0
C1014 avss.n667 vw 0
C1015 avss.n669 vw 0.01657f
C1016 avss.n670 vw 0.02138f
C1017 avss.n672 vw 0
C1018 avss.n673 vw 0
C1019 avss.n674 vw 0
C1020 avss.n675 vw 0
C1021 avss.n676 vw 0
C1022 avss.n677 vw 0
C1023 avss.n678 vw 0
C1024 avss.n679 vw 0
C1025 avss.n680 vw 0.00536f
C1026 avss.n681 vw 0
C1027 avss.n682 vw 0
C1028 avss.n683 vw 0
C1029 avss.n684 vw 0
C1030 avss.n685 vw 0
C1031 avss.n686 vw 0
C1032 avss.n688 vw 0
C1033 avss.n689 vw 0
C1034 avss.n690 vw 0
C1035 avss.n691 vw 0
C1036 avss.n692 vw 0
C1037 avss.n693 vw 0
C1038 avss.n695 vw 0
C1039 avss.n696 vw 0
C1040 avss.n697 vw 0
C1041 avss.n698 vw 0
C1042 avss.n699 vw 0
C1043 avss.n700 vw 0
C1044 avss.n702 vw 0.03273f
C1045 avss.n704 vw 0
C1046 avss.n705 vw 0
C1047 avss.n706 vw 0
C1048 avss.n707 vw 0
C1049 avss.n708 vw 0
C1050 avss.n709 vw 0
C1051 avss.n710 vw 0
C1052 avss.n711 vw 0
C1053 avss.n712 vw 0
C1054 avss.n713 vw 0
C1055 avss.n714 vw 0
C1056 avss.n715 vw 0
C1057 avss.n716 vw 0
C1058 avss.n717 vw 0
C1059 avss.n718 vw 0
C1060 avss.n719 vw 0
C1061 avss.n720 vw 0
C1062 avss.n721 vw 0
C1063 avss.n722 vw 0
C1064 avss.n723 vw 0
C1065 avss.n724 vw 0
C1066 avss.n725 vw 0
C1067 avss.n726 vw 0.00621f
C1068 avss.n727 vw 0
C1069 avss.n728 vw 0
C1070 avss.n729 vw 0
C1071 avss.n730 vw 0
C1072 avss.n731 vw 0
C1073 avss.n732 vw 0
C1074 avss.n733 vw 0
C1075 avss.n734 vw 0
C1076 avss.n735 vw 0
C1077 avss.n736 vw 0
C1078 avss.n737 vw 0
C1079 avss.n738 vw 0
C1080 avss.n739 vw 0
C1081 avss.n740 vw 0
C1082 avss.n741 vw 0
C1083 avss.n742 vw 0
C1084 avss.n743 vw 0
C1085 avss.n744 vw 0
C1086 avss.n745 vw 0
C1087 avss.n746 vw 0
C1088 avss.n747 vw 0
C1089 avss.n748 vw 0
C1090 avss.n749 vw 0
C1091 avss.n750 vw 0
C1092 avss.n751 vw 0
C1093 avss.n752 vw 0
C1094 avss.n753 vw 0
C1095 avss.n754 vw 0
C1096 avss.n755 vw 0
C1097 avss.n756 vw 0
C1098 avss.n757 vw 0
C1099 avss.n758 vw 0
C1100 avss.n759 vw 0
C1101 avss.n760 vw 0
C1102 avss.n761 vw 0.14509f
C1103 avss.n762 vw 0
C1104 avss.n763 vw 0
C1105 avss.n764 vw 0
C1106 avss.n765 vw 0.00165f
C1107 avss.n766 vw 0.02013f
C1108 avss.n770 vw 0.00838f
C1109 avss.n772 vw 0.00291f
C1110 avss.n773 vw 0.04157f
C1111 avss.n774 vw 0.00473f
C1112 avss.n775 vw 0.0262f
C1113 avss.n779 vw 0.00838f
C1114 avss.n781 vw 0.00291f
C1115 avss.n782 vw 0.0262f
C1116 avss.n783 vw 0.00473f
C1117 avss.n784 vw 0.0262f
C1118 avss.n788 vw 0.00473f
C1119 avss.n789 vw 0.00291f
C1120 avss.n792 vw 0.00408f
C1121 avss.n795 vw 0.00291f
C1122 avss.n796 vw 0.00408f
C1123 avss.n797 vw 0.00408f
C1124 avss.n798 vw 0.00291f
C1125 avss.n800 vw 0.01172f
C1126 avss.n803 vw 0.00291f
C1127 avss.n805 vw 0.00473f
C1128 avss.n807 vw 0.00408f
C1129 avss.n808 vw 0.00473f
C1130 avss.n809 vw 0.01274f
C1131 avss.n810 vw 0.01274f
C1132 avss.n812 vw 0.00291f
C1133 avss.n814 vw 0.00562f
C1134 avss.n815 vw 0.04255f
C1135 avss.n816 vw 0.00408f
C1136 avss.n818 vw 0.00473f
C1137 avss.n820 vw 0.00291f
C1138 avss.n821 vw 0.01135f
C1139 avss.n822 vw 0.01147f
C1140 avss.n823 vw 0.00757f
C1141 avss.n825 vw 0.00291f
C1142 avss.n826 vw 0.0262f
C1143 avss.n827 vw 0.00473f
C1144 avss.n828 vw 0.0262f
C1145 avss.n832 vw 0.00838f
C1146 avss.n834 vw 0.00291f
C1147 avss.n835 vw 0.0262f
C1148 avss.n836 vw 0.00473f
C1149 avss.n837 vw 0.0262f
C1150 avss.n841 vw 0.00838f
C1151 avss.n843 vw 0.00291f
C1152 avss.n844 vw 0.0262f
C1153 avss.n845 vw 0.00473f
C1154 avss.n846 vw 0.0407f
C1155 avss.n847 vw 0.02074f
C1156 avss.n848 vw 0.03865f
C1157 nvpost.n0 vw 0.04008f
C1158 nvpre.n0 vw 0.03432f
C1159 vpost.n0 vw 0.03249f
C1160 vpre.n0 vw 0.02141f
C1161 vb_idep.n0 vw 0.091f
C1162 vb_itd.n0 vw 0.08653f
C1163 vb_itp.n0 vw 0.05134f
C1164 vb_pot.n1 vw 0.00377f
C1165 vb_pot.n2 vw 0.00232f
C1166 vb_pot.n4 vw 0.00232f
C1167 vb_pot.n6 vw 0.00232f
C1168 vb_pot.n8 vw 0.00668f
C1169 vb_pot.n11 vw 0.00377f
C1170 vb_pot.n12 vw 0.00232f
C1171 vb_pot.n14 vw 0.00232f
C1172 vb_pot.n16 vw 0.00232f
C1173 vb_pot.n18 vw 0.00668f
C1174 vb_pot.n21 vw 0.00377f
C1175 vb_pot.n22 vw 0.00232f
C1176 vb_pot.n24 vw 0.00232f
C1177 vb_pot.n26 vw 0.00232f
C1178 vb_pot.n28 vw 0.00668f
C1179 vb_pot.n31 vw 0.00377f
C1180 vb_pot.n32 vw 0.00232f
C1181 vb_pot.n34 vw 0.00232f
C1182 vb_pot.n36 vw 0.00232f
C1183 vb_pot.n38 vw 0.00668f
C1184 vb_pot.n41 vw 0.00377f
C1185 vb_pot.n42 vw 0.00232f
C1186 vb_pot.n44 vw 0.00232f
C1187 vb_pot.n46 vw 0.00232f
C1188 vb_pot.n48 vw 0.00668f
C1189 vb_pot.n50 vw 0.01652f
C1190 vb_pot.n51 vw 0.03079f
C1191 vb_pot.n52 vw 0.03242f
C1192 vb_pot.n54 vw 0.00232f
C1193 vb_pot.n55 vw 0.00232f
C1194 vb_pot.n58 vw 0.00232f
C1195 vb_pot.n60 vw 0.00377f
C1196 vb_pot.n64 vw 0.00668f
C1197 vb_pot.n65 vw 0.00377f
C1198 vb_pot.n66 vw 0.00668f
C1199 vb_pot.n67 vw 0.00377f
C1200 vb_pot.n68 vw 0.02087f
C1201 vb_pot.n69 vw 0.02087f
C1202 vb_pot.n71 vw 0.00232f
C1203 vb_pot.n72 vw 0.00232f
C1204 vb_pot.n75 vw 0.00232f
C1205 vb_pot.n77 vw 0.00377f
C1206 vb_pot.n81 vw 0.00668f
C1207 vb_pot.n82 vw 0.00377f
C1208 vb_pot.n83 vw 0.00668f
C1209 vb_pot.n84 vw 0.00377f
C1210 vb_pot.n85 vw 0.02087f
C1211 vb_pot.n86 vw 0.02087f
C1212 vb_pot.n88 vw 0.00377f
C1213 vb_pot.n89 vw 0.00232f
C1214 vb_pot.n92 vw 0.00325f
C1215 vb_pot.n95 vw 0.00232f
C1216 vb_pot.n96 vw 0.00325f
C1217 vb_pot.n97 vw 0.00325f
C1218 vb_pot.n98 vw 0.00232f
C1219 vb_pot.n100 vw 0.00933f
C1220 vb_pot.n103 vw 0.00232f
C1221 vb_pot.n105 vw 0.00377f
C1222 vb_pot.n107 vw 0.00325f
C1223 vb_pot.n108 vw 0.00377f
C1224 vb_pot.n109 vw 0.01015f
C1225 vb_pot.n110 vw 0.01015f
C1226 vb_pot.n112 vw 0.00232f
C1227 vb_pot.n114 vw 0.00448f
C1228 vb_pot.n115 vw 0.03389f
C1229 vb_pot.n116 vw 0.00325f
C1230 vb_pot.n118 vw 0.00377f
C1231 vb_pot.n120 vw 0.00232f
C1232 vb_pot.n121 vw 0.00904f
C1233 vb_pot.n122 vw 0.00914f
C1234 vb_pot.n124 vw 0.00232f
C1235 vb_pot.n125 vw 0.00232f
C1236 vb_pot.n128 vw 0.00232f
C1237 vb_pot.n129 vw 0.00377f
C1238 vb_pot.n133 vw 0.00603f
C1239 vb_pot.n134 vw 0.00377f
C1240 vb_pot.n135 vw 0.00399f
C1241 vb_pot.n136 vw 0.00377f
C1242 vb_pot.n137 vw 0.02087f
C1243 vb_pot.n138 vw 0.02087f
C1244 vb_pot.n140 vw 0.00232f
C1245 vb_pot.n141 vw 0.00232f
C1246 vb_pot.n144 vw 0.00232f
C1247 vb_pot.n146 vw 0.00377f
C1248 vb_pot.n150 vw 0.00668f
C1249 vb_pot.n151 vw 0.00377f
C1250 vb_pot.n152 vw 0.00668f
C1251 vb_pot.n153 vw 0.00377f
C1252 vb_pot.n154 vw 0.02087f
C1253 vb_pot.n155 vw 0.02087f
C1254 vb_pot.n157 vw 0.00232f
C1255 vb_pot.n158 vw 0.00232f
C1256 vb_pot.n161 vw 0.00232f
C1257 vb_pot.n163 vw 0.00377f
C1258 vb_pot.n167 vw 0.00668f
C1259 vb_pot.n168 vw 0.00377f
C1260 vb_pot.n169 vw 0.00668f
C1261 vb_pot.n170 vw 0.00377f
C1262 vb_pot.n171 vw 0.03311f
C1263 vb_pot.n172 vw 0.01604f
C1264 vb_pot.n173 vw 0.01355f
C1265 vb_pot.n174 vw 0
C1266 vb_pot.n175 vw 0
C1267 vb_pot.n176 vw 0
C1268 vb_pot.n177 vw 0
C1269 vb_pot.n178 vw 0
C1270 vb_pot.n179 vw 0.00736f
C1271 vb_pot.n180 vw 0
C1272 vb_pot.n181 vw 0.01458f
C1273 vb_pot.n182 vw 0
C1274 vb_pot.n183 vw 0
C1275 vb_pot.n184 vw 0
C1276 vb_pot.n185 vw 0.00252f
C1277 vb_pot.n186 vw 0
C1278 vb_pot.n187 vw 0
C1279 vb_pot.n188 vw 0.00834f
C1280 vb_pot.n189 vw 0
C1281 vb_pot.n190 vw 0
C1282 vb_pot.n191 vw 0
C1283 vb_pot.n192 vw 0
C1284 vb_pot.n193 vw 0
C1285 vb_pot.n194 vw 0
C1286 vb_pot.n195 vw 0
C1287 vb_pot.n196 vw 0
C1288 vb_pot.n197 vw 0.01051f
C1289 vb_pot.n198 vw 0
C1290 vb_pot.n199 vw 0
C1291 vb_pot.n200 vw 0.01051f
C1292 vb_pot.n201 vw 0
C1293 vb_pot.n202 vw 0
C1294 vb_pot.n203 vw 0.00245f
C1295 vb_pot.n204 vw 0
C1296 vb_pot.n205 vw 0
C1297 vb_pot.n206 vw 0
C1298 vb_pot.n207 vw 0.00236f
C1299 vb_pot.n208 vw 0
C1300 vb_pot.n210 vw 0.00145f
C1301 vb_pot.n211 vw 0
C1302 vb_pot.n212 vw 0
C1303 vb_pot.n213 vw 0.00235f
C1304 vb_pot.n214 vw 0.0131f
C1305 vb_pot.n215 vw 0
C1306 vb_pot.n216 vw 0.00317f
C1307 vb_pot.n217 vw 0.00319f
C1308 vb_pot.n218 vw 0
C1309 vb_pot.n219 vw 0
C1310 vb_pot.n220 vw 0
C1311 vb_pot.n221 vw 0
C1312 vb_pot.n222 vw 0
C1313 vb_pot.n223 vw 0
C1314 vb_pot.n224 vw 0
C1315 vb_pot.n225 vw 0
C1316 vb_pot.n226 vw 0.01051f
C1317 vb_pot.n227 vw 0
C1318 vb_pot.n228 vw 0
C1319 vb_pot.n229 vw 0
C1320 vb_pot.n230 vw 0
C1321 vb_pot.n231 vw 0
C1322 vb_pot.n232 vw 0
C1323 vb_pot.n233 vw 0
C1324 vb_pot.n234 vw 0
C1325 vb_pot.n235 vw 0.00834f
C1326 vb_pot.n236 vw 0
C1327 vb_pot.n237 vw 0.00736f
C1328 vb_pot.n238 vw 0
C1329 vb_pot.n239 vw 0
C1330 vb_pot.n240 vw 0
C1331 vb_pot.n241 vw 0
C1332 vb_pot.n242 vw 0
C1333 vb_pot.n243 vw 0
C1334 vb_pot.n244 vw 0
C1335 vb_pot.n245 vw 0
C1336 vb_pot.n246 vw 0
C1337 vb_pot.n247 vw 0
C1338 vb_pot.n248 vw 0.00539f
C1339 vb_pot.n249 vw 0
C1340 vb_pot.n250 vw 0.0086f
C1341 vb_pot.n251 vw 0
C1342 vb_pot.n252 vw 0
C1343 vb_pot.n253 vw 0
C1344 vb_pot.n254 vw 0.00575f
C1345 vb_pot.n255 vw 0
C1346 vb_pot.n256 vw 0.00525f
C1347 vb_pot.n257 vw 0
C1348 vb_pot.n258 vw 0
C1349 vb_pot.n259 vw 0
C1350 vb_pot.n260 vw 0
C1351 vb_pot.n261 vw 0
C1352 vb_pot.n262 vw 0
C1353 vb_pot.n263 vw 0
C1354 vb_pot.n264 vw 0
C1355 vb_pot.n265 vw 0
C1356 vb_pot.n266 vw 0
C1357 vb_pot.n267 vw 0.00525f
C1358 vb_pot.n268 vw 0
C1359 vb_pot.n269 vw 0
C1360 vb_pot.n270 vw 0.0051f
C1361 vb_pot.n271 vw 0.01435f
C1362 vb_pot.n272 vw 0
C1363 vb_pot.n273 vw 0
C1364 vb_pot.n274 vw 0.00221f
C1365 vb_pot.n275 vw 0
C1366 vb_pot.n276 vw 0
C1367 vb_pot.n277 vw 0
C1368 vb_pot.n278 vw 0
C1369 vb_pot.n279 vw 0
C1370 vb_pot.n280 vw 0.00136f
C1371 vb_pot.n281 vw 0
C1372 vb_pot.n282 vw 0
C1373 vb_pot.n283 vw 0
C1374 vb_pot.n284 vw 0.00893f
C1375 vb_pot.n285 vw 0
C1376 vb_pot.n286 vw 0
C1377 vb_pot.n287 vw 0
C1378 vb_pot.n288 vw 0
C1379 vb_pot.n289 vw 0
C1380 vb_pot.n290 vw 0
C1381 vb_pot.n291 vw 0
C1382 vb_pot.n292 vw 0
C1383 vb_pot.n293 vw 0.00736f
C1384 vb_pot.n294 vw 0
C1385 vb_pot.n295 vw 0.00584f
C1386 vb_pot.n296 vw 0
C1387 vb_pot.n297 vw 0
C1388 vb_pot.n298 vw 0
C1389 vb_pot.n299 vw 0.00142f
C1390 vb_pot.n300 vw 0
C1391 vb_pot.n301 vw 0
C1392 vb_pot.n302 vw 0.00525f
C1393 vb_pot.n303 vw 0
C1394 vb_pot.n304 vw 0
C1395 vb_pot.n305 vw 0.00709f
C1396 vb_pot.n306 vw 0
C1397 vb_pot.n307 vw 0
C1398 vb_pot.n308 vw 0
C1399 vb_pot.n309 vw 0
C1400 vb_pot.n310 vw 0
C1401 vb_pot.n311 vw 0
C1402 vb_pot.n312 vw 0
C1403 vb_pot.n313 vw 0
C1404 vb_pot.n314 vw 0.00525f
C1405 vb_pot.n315 vw 0
C1406 vb_pot.n316 vw 0.00647f
C1407 vb_pot.n317 vw 0.00623f
C1408 vb_pot.n318 vw 0
C1409 vb_pot.n319 vw 0
C1410 vb_pot.n320 vw 0.00525f
C1411 vb_pot.n321 vw 0
C1412 vb_pot.n322 vw 0
C1413 vb_pot.n323 vw 0
C1414 vb_pot.n324 vw 0
C1415 vb_pot.n325 vw 0
C1416 vb_pot.n326 vw 0
C1417 vb_pot.n327 vw 0
C1418 vb_pot.n328 vw 0.00525f
C1419 vb_pot.n329 vw 0
C1420 vb_pot.n330 vw 0
C1421 vb_pot.n331 vw 0.0091f
C1422 vb_pot.n332 vw 0
C1423 vb_pot.n333 vw 0
C1424 vb_pot.n334 vw 0
C1425 vb_pot.n335 vw 0
C1426 vb_pot.n336 vw 0
C1427 vb_pot.n337 vw 0
C1428 vb_pot.n338 vw 0
C1429 vb_pot.n339 vw 0
C1430 vb_pot.n340 vw 0
C1431 vb_pot.n341 vw 0
C1432 vb_pot.n342 vw 0.00525f
C1433 vb_pot.n343 vw 0.00729f
C1434 vb_pot.n344 vw 0
C1435 vb_pot.n345 vw 0
C1436 vb_pot.n346 vw 0
C1437 vb_pot.n347 vw 0
C1438 vb_pot.n348 vw 0
C1439 vb_pot.n349 vw 0
C1440 vb_pot.n350 vw 0
C1441 vb_pot.n351 vw 0.00525f
C1442 vb_pot.n352 vw 0
C1443 vb_pot.n353 vw 0
C1444 vb_pot.n354 vw 0
C1445 vb_pot.n355 vw 0
C1446 vb_pot.n356 vw 0
C1447 vb_pot.n357 vw 0.0085f
C1448 vb_pot.n358 vw 0
C1449 vb_pot.n359 vw 0
C1450 vb_pot.n360 vw 0
C1451 vb_pot.n361 vw 0
C1452 vb_pot.n362 vw 0
C1453 vb_pot.n363 vw 0
C1454 vb_pot.n364 vw 0
C1455 vb_pot.n365 vw 0
C1456 vb_pot.n366 vw 0
C1457 vb_pot.n367 vw 0
C1458 vb_pot.n368 vw 0
C1459 vb_pot.n369 vw 0
C1460 vb_pot.n370 vw 0
C1461 vb_pot.n371 vw 0.0091f
C1462 vb_pot.n372 vw 0
C1463 vb_pot.n373 vw 0
C1464 vb_pot.n374 vw 0
C1465 vb_pot.n375 vw 0
C1466 vb_pot.n376 vw 0
C1467 vb_pot.n377 vw 0
C1468 vb_pot.n378 vw 0.00254f
C1469 vb_pot.n379 vw 0
C1470 vb_pot.n380 vw 0
C1471 vb_pot.n381 vw 0.05074f
C1472 vb_pot.n384 vw 0
C1473 vb_pot.n385 vw 0
C1474 vb_pot.n386 vw 0
C1475 vb_pot.n387 vw 0
C1476 vb_pot.n388 vw 0
C1477 vb_pot.n389 vw 0
C1478 vb_pot.n390 vw 0
C1479 vb_pot.n391 vw 0
C1480 vb_pot.n396 vw 0.00427f
C1481 vb_pot.n397 vw 0.00916f
C1482 vb_pot.n400 vw 0
C1483 vb_pot.n401 vw 0.00136f
C1484 vb_pot.n402 vw 0
C1485 vb_pot.n403 vw 0
C1486 vb_pot.n404 vw 0
C1487 vb_pot.n405 vw 0
C1488 vb_pot.n406 vw 0
C1489 vb_pot.n407 vw 0
C1490 vb_pot.n408 vw 0
C1491 vb_pot.n409 vw 0
C1492 vb_pot.n410 vw 0
C1493 vb_pot.n411 vw 0
C1494 vb_pot.n412 vw 0
C1495 vb_pot.n413 vw 0
C1496 vb_pot.n414 vw 0
C1497 vb_pot.n415 vw 0
C1498 vb_pot.n416 vw 0
C1499 vb_pot.n417 vw 0
C1500 vb_pot.n418 vw 0
C1501 vb_pot.n419 vw 0
C1502 vb_pot.n420 vw 0
C1503 vb_pot.n421 vw 0
C1504 vb_pot.n422 vw 0
C1505 vb_pot.n423 vw 0
C1506 vb_pot.n424 vw 0
C1507 vb_pot.n425 vw 0
C1508 vb_pot.n426 vw 0
C1509 vb_pot.n427 vw 0
C1510 vb_pot.n428 vw 0
C1511 vb_pot.n429 vw 0
C1512 vb_pot.n430 vw 0
C1513 vb_pot.n431 vw 0
C1514 vb_pot.n432 vw 0
C1515 vb_pot.n433 vw 0
C1516 vb_pot.n434 vw 0
C1517 vb_pot.n435 vw 0
C1518 vb_pot.n436 vw 0
C1519 vb_pot.n437 vw 0
C1520 vb_pot.n438 vw 0
C1521 vb_pot.n439 vw 0
C1522 vb_pot.n440 vw 0
C1523 vb_pot.n441 vw 0
C1524 vb_pot.n442 vw 0.04873f
C1525 vb_pot.n452 vw 0
C1526 vb_pot.n453 vw 0.11557f
C1527 vb_pot.n454 vw 0
C1528 vb_pot.n455 vw 0
C1529 vb_pot.n456 vw 0
C1530 vb_pot.n457 vw 0
C1531 vb_pot.n459 vw 0
C1532 vb_pot.n460 vw 0
C1533 vb_pot.n461 vw 0
C1534 vb_pot.n462 vw 0
C1535 vb_pot.n463 vw 0
C1536 vb_pot.n464 vw 0
C1537 vb_pot.n465 vw 0
C1538 vb_pot.n466 vw 0
C1539 vb_pot.n467 vw 0
C1540 vb_pot.n468 vw 0
C1541 vb_pot.n469 vw 0
C1542 vb_pot.n471 vw 0
C1543 vb_pot.n472 vw 0
C1544 vb_pot.n473 vw 0
C1545 vb_pot.n474 vw 0
C1546 vb_pot.n475 vw 0
C1547 vb_pot.n476 vw 0
C1548 vb_pot.n478 vw 0
C1549 vb_pot.n479 vw 0
C1550 vb_pot.n480 vw 0
C1551 vb_pot.n481 vw 0
C1552 vb_pot.n482 vw 0
C1553 vb_pot.n483 vw 0
C1554 vb_pot.n484 vw 0
C1555 vb_pot.n485 vw 0
C1556 vb_pot.n486 vw 0
C1557 vb_pot.n487 vw 0
C1558 vb_pot.n488 vw 0
C1559 vb_pot.n489 vw 0
C1560 vb_pot.n490 vw 0
C1561 vb_pot.n491 vw 0
C1562 vb_pot.n492 vw 0
C1563 vb_pot.n493 vw 0
C1564 vb_pot.n494 vw 0
C1565 vb_pot.n495 vw 0
C1566 vb_pot.n496 vw 0
C1567 vb_pot.n497 vw 0
C1568 vb_pot.n498 vw 0
C1569 vb_pot.n499 vw 0
C1570 vb_pot.n500 vw 0
C1571 vb_pot.n501 vw 0
C1572 vb_pot.n502 vw 0
C1573 vb_pot.n503 vw 0
C1574 vb_pot.n504 vw 0
C1575 vb_pot.n505 vw 0
C1576 vb_pot.n506 vw 0
C1577 vb_pot.n507 vw 0
C1578 vb_pot.n508 vw 0
C1579 vb_pot.n509 vw 0
C1580 vb_pot.n510 vw 0
C1581 vb_pot.n511 vw 0
C1582 vb_pot.n512 vw 0
C1583 vb_pot.n513 vw 0
C1584 vb_pot.n514 vw 0
C1585 vb_pot.n515 vw 0
C1586 vb_pot.n516 vw 0
C1587 vb_pot.n517 vw 0
C1588 vb_pot.n518 vw 0
C1589 vb_pot.n519 vw 0
C1590 vb_pot.n520 vw 0.00132f
C1591 vb_pot.n521 vw 0
C1592 vb_pot.n522 vw 0
C1593 vb_pot.n523 vw 0
C1594 vb_pot.n525 vw 0
C1595 vb_pot.n526 vw 0
C1596 vb_pot.n527 vw 0
C1597 vb_pot.n528 vw 0
C1598 vb_pot.n529 vw 0
C1599 vb_pot.n530 vw 0
C1600 vb_pot.n532 vw 0
C1601 vb_pot.n533 vw 0
C1602 vb_pot.n534 vw 0
C1603 vb_pot.n535 vw 0
C1604 vb_pot.n536 vw 0
C1605 vb_pot.n537 vw 0
C1606 vb_pot.n539 vw 0
C1607 vb_pot.n540 vw 0
C1608 vb_pot.n542 vw 0
C1609 vb_pot.n543 vw 0
C1610 vb_pot.n544 vw 0
C1611 vb_pot.n545 vw 0
C1612 vb_pot.n546 vw 0
C1613 vb_pot.n547 vw 0.00495f
C1614 vb_pot.n548 vw 0
C1615 vb_pot.n549 vw 0
C1616 vb_pot.n550 vw 0
C1617 vb_pot.n551 vw 0
C1618 vb_pot.n552 vw 0
C1619 vb_pot.n553 vw 0
C1620 vb_pot.n554 vw 0
C1621 vb_pot.n555 vw 0
C1622 vb_pot.n556 vw 0
C1623 vb_pot.n557 vw 0
C1624 vb_pot.n558 vw 0
C1625 vb_pot.n559 vw 0
C1626 vb_pot.n560 vw 0
C1627 vb_pot.n562 vw 0
C1628 vb_pot.n563 vw 0
C1629 vb_pot.n564 vw 0
C1630 vb_pot.n565 vw 0
C1631 vb_pot.n566 vw 0
C1632 vb_pot.n567 vw 0
C1633 vb_pot.n568 vw 0
C1634 vb_pot.n569 vw 0
C1635 vb_pot.n570 vw 0
C1636 vb_pot.n572 vw 0
C1637 vb_pot.n573 vw 0
C1638 vb_pot.n574 vw 0
C1639 vb_pot.n575 vw 0
C1640 vb_pot.n576 vw 0
C1641 vb_pot.n577 vw 0
C1642 vb_pot.n579 vw 0
C1643 vb_pot.n580 vw 0
C1644 vb_pot.n581 vw 0
C1645 vb_pot.n582 vw 0
C1646 vb_pot.n583 vw 0
C1647 vb_pot.n584 vw 0
C1648 vb_pot.n586 vw 0
C1649 vb_pot.n587 vw 0
C1650 vb_pot.n588 vw 0
C1651 vb_pot.n589 vw 0
C1652 vb_pot.n590 vw 0
C1653 vb_pot.n591 vw 0
C1654 vb_pot.n592 vw 0
C1655 vb_pot.n593 vw 0
C1656 vb_pot.n594 vw 0
C1657 vb_pot.n595 vw 0
C1658 vb_pot.n597 vw 0
C1659 vb_pot.n598 vw 0
C1660 vb_pot.n599 vw 0
C1661 vb_pot.n600 vw 0
C1662 vb_pot.n601 vw 0.0251f
C1663 vb_pot.n602 vw 0
C1664 vb_pot.n603 vw 0
C1665 vb_pot.n604 vw 0
C1666 vb_pot.n605 vw 0
C1667 vb_pot.n606 vw 0
C1668 vb_pot.n607 vw 0
C1669 vb_pot.n608 vw 0
C1670 vb_pot.n610 vw 0
C1671 vb_pot.n611 vw 0
C1672 vb_pot.n612 vw 0
C1673 vb_pot.n613 vw 0
C1674 vb_pot.n614 vw 0
C1675 vb_pot.n616 vw 0
C1676 vb_pot.n617 vw 0
C1677 vb_pot.n618 vw 0
C1678 vb_pot.n619 vw 0
C1679 vb_pot.n620 vw 0
C1680 vb_pot.n622 vw 0
C1681 vb_pot.n623 vw 0
C1682 vb_pot.n624 vw 0
C1683 vb_pot.n625 vw 0
C1684 vb_pot.n626 vw 0
C1685 vb_pot.n627 vw 0
C1686 vb_pot.n629 vw 0
C1687 vb_pot.n630 vw 0
C1688 vb_pot.n632 vw 0
C1689 vb_pot.n633 vw 0
C1690 vb_pot.n634 vw 0
C1691 vb_pot.n635 vw 0
C1692 vb_pot.n636 vw 0
C1693 vb_pot.n637 vw 0.00136f
C1694 vb_pot.n638 vw 0
C1695 vb_pot.n639 vw 0.05074f
C1696 vb_pot.n640 vw 0.02607f
C1697 vb_pot.n641 vw 0.02881f
C1698 vb_pot.n642 vw 0.0132f
C1699 vb_pot.n643 vw 0.01703f
C1700 vb_pot.n644 vw 0
C1701 vb_pot.n645 vw 0
C1702 vb_pot.n646 vw 0
C1703 vb_pot.n647 vw 0
C1704 vb_pot.n648 vw 0
C1705 vb_pot.n649 vw 0
C1706 vb_pot.n651 vw 0
C1707 vb_pot.n652 vw 0
C1708 vb_pot.n653 vw 0
C1709 vb_pot.n654 vw 0
C1710 vb_pot.n655 vw 0
C1711 vb_pot.n656 vw 0
C1712 vb_pot.n657 vw 0
C1713 vb_pot.n659 vw 0
C1714 vb_pot.n660 vw 0
C1715 vb_pot.n661 vw 0
C1716 vb_pot.n662 vw 0
C1717 vb_pot.n663 vw 0
C1718 vb_pot.n665 vw 0
C1719 vb_pot.n666 vw 0
C1720 vb_pot.n667 vw 0
C1721 vb_pot.n668 vw 0
C1722 vb_pot.n669 vw 0
C1723 vb_pot.n670 vw 0
C1724 vb_pot.n672 vw 0
C1725 vb_pot.n673 vw 0
C1726 vb_pot.n674 vw 0
C1727 vb_pot.n675 vw 0
C1728 vb_pot.n676 vw 0
C1729 vb_pot.n677 vw 0
C1730 vb_pot.n678 vw 0
C1731 vb_pot.n679 vw 0
C1732 vb_pot.n680 vw 0
C1733 vb_pot.n681 vw 0
C1734 vb_pot.n682 vw 0.47463f
C1735 vb_pot.n683 vw 0.26839f
C1736 vb_pot.n684 vw 0.0647f
C1737 vb_pot.n685 vw 0.10713f
C1738 vb_pot.n686 vw 0.04282f
C1739 vb_pot.n687 vw 0.03881f
C1740 vb_pot.n688 vw 0
C1741 vb_pot.n689 vw 0
C1742 vb_pot.n690 vw 0
C1743 vb_pot.n691 vw 0
C1744 vb_pot.n692 vw 0
C1745 vb_pot.n693 vw 0
C1746 vb_pot.n694 vw 0
C1747 vb_pot.n695 vw 0
C1748 vb_pot.n696 vw 0.00194f
C1749 vb_pot.n697 vw 0.00194f
C1750 vb_pot.n698 vw 0.0034f
C1751 vb_pot.n699 vw 0
C1752 vb_pot.n700 vw 0
C1753 vb_pot.n701 vw 0
C1754 vb_pot.n702 vw 0
C1755 vb_pot.n703 vw 0
C1756 vb_pot.n704 vw 0.00136f
C1757 vb_pot.n705 vw 0
C1758 vb_pot.n706 vw 0
C1759 vb_pot.n707 vw 0
C1760 vb_pot.n708 vw 0.00525f
C1761 vb_pot.n709 vw 0.00525f
C1762 vb_pot.n710 vw 0
C1763 vb_pot.n711 vw 0
C1764 vb_pot.n712 vw 0
C1765 vb_pot.n713 vw 0
C1766 vb_pot.n714 vw 0
C1767 vb_pot.n715 vw 0.00591f
C1768 vb_pot.n716 vw 0.00663f
C1769 vb_pot.n717 vw 0.00736f
C1770 vb_pot.n718 vw 0.00729f
C1771 vb_pot.n719 vw 0
C1772 vb_pot.n720 vw 0
C1773 vb_pot.n721 vw 0
C1774 vb_pot.n722 vw 0
C1775 vb_pot.n723 vw 0
C1776 vb_pot.n724 vw 0.00726f
C1777 vb_pot.n725 vw 0.00525f
C1778 vb_pot.n726 vw 0
C1779 vb_pot.n727 vw 0
C1780 vb_pot.n728 vw 0
C1781 vb_pot.n729 vw 0
C1782 vb_pot.n730 vw 0
C1783 vb_pot.n731 vw 0
C1784 vb_pot.n732 vw 0.00525f
C1785 vb_pot.n733 vw 0.00729f
C1786 vb_pot.n734 vw 0
C1787 vb_pot.n735 vw 0
C1788 vb_pot.n736 vw 0
C1789 vb_pot.n737 vw 0
C1790 vb_pot.n738 vw 0
C1791 vb_pot.n739 vw 0.00136f
C1792 vb_pot.n740 vw 0
C1793 vb_pot.n741 vw 0.0085f
C1794 vb_pot.n742 vw 0.00542f
C1795 vb_pot.n743 vw 0
C1796 vb_pot.n744 vw 0
C1797 vb_pot.n745 vw 0
C1798 vb_pot.n746 vw 0
C1799 vb_pot.n747 vw 0
C1800 vb_pot.n748 vw 0
C1801 vb_pot.n749 vw 0
C1802 vb_pot.n750 vw 0
C1803 vb_pot.n751 vw 0
C1804 vb_pot.n752 vw 0
C1805 vb_pot.n753 vw 0
C1806 vb_pot.n754 vw 0
C1807 vb_pot.n755 vw 0
C1808 vb_pot.n756 vw 0.00194f
C1809 vb_pot.n757 vw 0.00406f
C1810 vb_pot.n758 vw 0
C1811 vb_pot.n759 vw 0.00916f
C1812 vb_pot.n760 vw 0
C1813 vb_pot.n761 vw 0
C1814 vb_pot.n762 vw 0
C1815 vb_pot.n763 vw 0
C1816 vb_pot.n764 vw 0
C1817 vb_pot.n765 vw 0
C1818 vb_pot.n766 vw 0
C1819 vb_pot.n767 vw 0
C1820 vb_pot.n768 vw 0
C1821 vb_pot.n769 vw 0
C1822 vb_pot.n770 vw 0
C1823 vb_pot.n771 vw 0
C1824 vb_pot.n772 vw 0
C1825 vb_pot.n773 vw 0
C1826 vb_pot.n774 vw 0
C1827 vb_pot.n775 vw 0
C1828 vb_pot.n776 vw 0
C1829 vb_pot.n777 vw 0
C1830 vb_pot.n778 vw 0
C1831 vb_pot.n779 vw 0
C1832 vb_pot.n780 vw 0
C1833 vb_pot.n781 vw 0
C1834 vb_pot.n782 vw 0
C1835 vb_pot.n783 vw 0
C1836 vb_pot.n784 vw 0
C1837 vb_pot.n785 vw 0
C1838 vb_pot.n786 vw 0
C1839 vb_pot.n787 vw 0
C1840 vb_pot.n788 vw 0
C1841 vb_pot.n789 vw 0.0091f
C1842 vb_pot.n790 vw 0
C1843 vb_pot.n791 vw 0
C1844 vb_pot.n792 vw 0
C1845 vb_pot.n793 vw 0
C1846 vb_pot.n794 vw 0
C1847 vb_pot.n795 vw 0
C1848 vb_pot.n796 vw 0.00132f
C1849 vb_pot.n797 vw 0
C1850 vb_pot.n798 vw 0
C1851 vb_pot.n799 vw 0.00729f
C1852 vb_pot.n800 vw 0.01045f
C1853 vb_pot.n801 vw 0.00637f
C1854 vb_pot.n802 vw 0.00617f
C1855 vb_pot.n803 vw 0
C1856 vb_pot.n804 vw 0
C1857 vb_pot.n805 vw 0
C1858 vb_pot.n806 vw 0
C1859 vb_pot.n807 vw 0
C1860 vb_pot.n808 vw 0.00525f
C1861 vb_pot.n809 vw 0.00525f
C1862 vb_pot.n810 vw 0
C1863 vb_pot.n811 vw 0
C1864 vb_pot.n812 vw 0.00525f
C1865 vb_pot.n813 vw 0.00716f
C1866 vb_pot.n814 vw 0
C1867 vb_pot.n815 vw 0
C1868 vb_pot.n816 vw 0
C1869 vb_pot.n817 vw 0
C1870 vb_pot.n818 vw 0
C1871 vb_pot.n819 vw 0.00729f
C1872 vb_pot.n820 vw 0.00525f
C1873 vb_pot.n821 vw 0
C1874 vb_pot.n822 vw 0.00281f
C1875 vb_pot.n823 vw 0.00179f
C1876 vb_pot.n824 vw 0
C1877 vb_pot.n825 vw 0
C1878 vb_pot.n826 vw 0
C1879 vb_pot.n827 vw 0
C1880 vb_pot.n828 vw 0.01051f
C1881 vb_pot.n829 vw 0
C1882 vb_pot.n830 vw 0
C1883 vb_pot.n831 vw 0
C1884 vb_pot.n832 vw 0
C1885 vb_pot.n833 vw 0
C1886 vb_pot.n834 vw 0.00136f
C1887 vb_pot.n835 vw 0
C1888 vb_pot.n836 vw 0.00834f
C1889 vb_pot.n837 vw 0.01458f
C1890 vb_pot.n838 vw 0
C1891 vb_pot.n839 vw 0.00281f
C1892 vb_pot.n840 vw 0.00319f
C1893 vb_pot.n841 vw 0
C1894 vb_pot.n842 vw 0.00834f
C1895 vb_pot.n843 vw 0.00453f
C1896 vb_pot.n844 vw 0
C1897 vb_pot.n845 vw 0
C1898 vb_pot.n846 vw 0
C1899 vb_pot.n847 vw 0.00132f
C1900 vb_pot.n848 vw 0.00641f
C1901 vb_pot.n849 vw 0.00438f
C1902 vw.n1 vw 0.00261f
C1903 vw.n2 vw 0.0016f
C1904 vw.n4 vw 0.0016f
C1905 vw.n6 vw 0.0016f
C1906 vw.n8 vw 0.00462f
C1907 vw.n11 vw 0.00261f
C1908 vw.n12 vw 0.0016f
C1909 vw.n14 vw 0.0016f
C1910 vw.n16 vw 0.0016f
C1911 vw.n18 vw 0.00462f
C1912 vw.n21 vw 0.00261f
C1913 vw.n22 vw 0.0016f
C1914 vw.n24 vw 0.0016f
C1915 vw.n26 vw 0.0016f
C1916 vw.n28 vw 0.00462f
C1917 vw.n31 vw 0.00261f
C1918 vw.n32 vw 0.0016f
C1919 vw.n34 vw 0.0016f
C1920 vw.n36 vw 0.0016f
C1921 vw.n38 vw 0.00462f
C1922 vw.n41 vw 0.00261f
C1923 vw.n42 vw 0.0016f
C1924 vw.n44 vw 0.0016f
C1925 vw.n46 vw 0.0016f
C1926 vw.n48 vw 0.00462f
C1927 vw.n50 vw 0.01143f
C1928 vw.n51 vw 0.0213f
C1929 vw.n52 vw 0.02243f
C1930 vw.n54 vw 0.0016f
C1931 vw.n55 vw 0.0016f
C1932 vw.n58 vw 0.0016f
C1933 vw.n60 vw 0.00261f
C1934 vw.n64 vw 0.00462f
C1935 vw.n65 vw 0.00261f
C1936 vw.n66 vw 0.00462f
C1937 vw.n67 vw 0.00261f
C1938 vw.n68 vw 0.01444f
C1939 vw.n69 vw 0.01444f
C1940 vw.n71 vw 0.0016f
C1941 vw.n72 vw 0.0016f
C1942 vw.n75 vw 0.0016f
C1943 vw.n77 vw 0.00261f
C1944 vw.n81 vw 0.00462f
C1945 vw.n82 vw 0.00261f
C1946 vw.n83 vw 0.00462f
C1947 vw.n84 vw 0.00261f
C1948 vw.n85 vw 0.01444f
C1949 vw.n86 vw 0.01444f
C1950 vw.n88 vw 0.00261f
C1951 vw.n89 vw 0.0016f
C1952 vw.n92 vw 0.00225f
C1953 vw.n95 vw 0.0016f
C1954 vw.n96 vw 0.00225f
C1955 vw.n97 vw 0.00225f
C1956 vw.n98 vw 0.0016f
C1957 vw.n100 vw 0.00646f
C1958 vw.n103 vw 0.0016f
C1959 vw.n105 vw 0.00261f
C1960 vw.n107 vw 0.00225f
C1961 vw.n108 vw 0.00261f
C1962 vw.n109 vw 0.00702f
C1963 vw.n110 vw 0.00702f
C1964 vw.n112 vw 0.0016f
C1965 vw.n114 vw 0.0031f
C1966 vw.n115 vw 0.02345f
C1967 vw.n116 vw 0.00225f
C1968 vw.n118 vw 0.00261f
C1969 vw.n120 vw 0.0016f
C1970 vw.n121 vw 0.00626f
C1971 vw.n122 vw 0.00632f
C1972 vw.n124 vw 0.0016f
C1973 vw.n125 vw 0.0016f
C1974 vw.n128 vw 0.0016f
C1975 vw.n129 vw 0.00261f
C1976 vw.n133 vw 0.00417f
C1977 vw.n134 vw 0.00261f
C1978 vw.n135 vw 0.00276f
C1979 vw.n136 vw 0.00261f
C1980 vw.n137 vw 0.01444f
C1981 vw.n138 vw 0.01444f
C1982 vw.n140 vw 0.0016f
C1983 vw.n141 vw 0.0016f
C1984 vw.n144 vw 0.0016f
C1985 vw.n146 vw 0.00261f
C1986 vw.n150 vw 0.00462f
C1987 vw.n151 vw 0.00261f
C1988 vw.n152 vw 0.00462f
C1989 vw.n153 vw 0.00261f
C1990 vw.n154 vw 0.01444f
C1991 vw.n155 vw 0.01444f
C1992 vw.n157 vw 0.0016f
C1993 vw.n158 vw 0.0016f
C1994 vw.n161 vw 0.0016f
C1995 vw.n163 vw 0.00261f
C1996 vw.n167 vw 0.00462f
C1997 vw.n168 vw 0.00261f
C1998 vw.n169 vw 0.00462f
C1999 vw.n170 vw 0.00261f
C2000 vw.n171 vw 0.02291f
C2001 vw.n172 vw 0.01109f
C2002 vw.n173 vw 0.00937f
C2003 vw.n174 vw 0
C2004 vw.n175 vw 0
C2005 vw.n176 vw 0
C2006 vw.n177 vw 0
C2007 vw.n178 vw 0
C2008 vw.n179 vw 0.00509f
C2009 vw.n180 vw 0
C2010 vw.n181 vw 0.01009f
C2011 vw.n182 vw 0
C2012 vw.n183 vw 0
C2013 vw.n184 vw 0
C2014 vw.n185 vw 0.00175f
C2015 vw.n186 vw 0
C2016 vw.n187 vw 0
C2017 vw.n188 vw 0.00577f
C2018 vw.n189 vw 0
C2019 vw.n190 vw 0
C2020 vw.n191 vw 0
C2021 vw.n192 vw 0
C2022 vw.n193 vw 0
C2023 vw.n194 vw 0
C2024 vw.n195 vw 0
C2025 vw.n196 vw 0
C2026 vw.n197 vw 0.00727f
C2027 vw.n198 vw 0
C2028 vw.n199 vw 0
C2029 vw.n200 vw 0.00727f
C2030 vw.n201 vw 0
C2031 vw.n202 vw 0
C2032 vw.n203 vw 0.0017f
C2033 vw.n204 vw 0
C2034 vw.n205 vw 0
C2035 vw.n206 vw 0.00163f
C2036 vw.n207 vw 0
C2037 vw.n209 vw 0.001f
C2038 vw.n210 vw 0
C2039 vw.n211 vw 0
C2040 vw.n212 vw 0.00163f
C2041 vw.n213 vw 0.00906f
C2042 vw.n214 vw 0
C2043 vw.n215 vw 0.00219f
C2044 vw.n216 vw 0.00221f
C2045 vw.n217 vw 0
C2046 vw.n218 vw 0
C2047 vw.n219 vw 0
C2048 vw.n220 vw 0
C2049 vw.n221 vw 0
C2050 vw.n222 vw 0
C2051 vw.n223 vw 0
C2052 vw.n224 vw 0
C2053 vw.n225 vw 0
C2054 vw.n226 vw 0.00727f
C2055 vw.n227 vw 0
C2056 vw.n228 vw 0
C2057 vw.n229 vw 0
C2058 vw.n230 vw 0
C2059 vw.n231 vw 0
C2060 vw.n232 vw 0
C2061 vw.n233 vw 0
C2062 vw.n234 vw 0
C2063 vw.n235 vw 0.00577f
C2064 vw.n236 vw 0
C2065 vw.n237 vw 0.00509f
C2066 vw.n238 vw 0
C2067 vw.n239 vw 0
C2068 vw.n240 vw 0
C2069 vw.n241 vw 0
C2070 vw.n242 vw 0
C2071 vw.n243 vw 0
C2072 vw.n244 vw 0
C2073 vw.n245 vw 0
C2074 vw.n246 vw 0
C2075 vw.n247 vw 0
C2076 vw.n248 vw 0.00373f
C2077 vw.n249 vw 0
C2078 vw.n250 vw 0.00595f
C2079 vw.n251 vw 0
C2080 vw.n252 vw 0
C2081 vw.n253 vw 0
C2082 vw.n254 vw 0.00398f
C2083 vw.n255 vw 0
C2084 vw.n256 vw 0.00363f
C2085 vw.n257 vw 0
C2086 vw.n258 vw 0
C2087 vw.n259 vw 0
C2088 vw.n260 vw 0
C2089 vw.n261 vw 0
C2090 vw.n262 vw 0
C2091 vw.n263 vw 0
C2092 vw.n264 vw 0
C2093 vw.n265 vw 0
C2094 vw.n266 vw 0
C2095 vw.n267 vw 0.00363f
C2096 vw.n268 vw 0
C2097 vw.n269 vw 0
C2098 vw.n270 vw 0.00353f
C2099 vw.n271 vw 0.00993f
C2100 vw.n272 vw 0
C2101 vw.n273 vw 0
C2102 vw.n274 vw 0.00153f
C2103 vw.n275 vw 0
C2104 vw.n276 vw 0
C2105 vw.n277 vw 0
C2106 vw.n278 vw 0
C2107 vw.n279 vw 0
C2108 vw.n280 vw 0
C2109 vw.n281 vw 0
C2110 vw.n282 vw 0
C2111 vw.n283 vw 0
C2112 vw.n284 vw 0
C2113 vw.n285 vw 0
C2114 vw.n286 vw 0
C2115 vw.n287 vw 0
C2116 vw.n288 vw 0
C2117 vw.n289 vw 0
C2118 vw.n290 vw 0
C2119 vw.n291 vw 0
C2120 vw.n292 vw 0
C2121 vw.n293 vw 0.00618f
C2122 vw.n294 vw 0
C2123 vw.n295 vw 0
C2124 vw.n296 vw 0
C2125 vw.n297 vw 0
C2126 vw.n298 vw 0
C2127 vw.n299 vw 0
C2128 vw.n300 vw 0
C2129 vw.n301 vw 0
C2130 vw.n302 vw 0.00509f
C2131 vw.n303 vw 0
C2132 vw.n304 vw 0.00404f
C2133 vw.n305 vw 0
C2134 vw.n306 vw 0
C2135 vw.n307 vw 0
C2136 vw.n308 vw 0
C2137 vw.n309 vw 0
C2138 vw.n310 vw 0
C2139 vw.n311 vw 0.00363f
C2140 vw.n312 vw 0
C2141 vw.n313 vw 0
C2142 vw.n314 vw 0.00491f
C2143 vw.n315 vw 0
C2144 vw.n316 vw 0
C2145 vw.n317 vw 0
C2146 vw.n318 vw 0
C2147 vw.n319 vw 0
C2148 vw.n320 vw 0
C2149 vw.n321 vw 0
C2150 vw.n322 vw 0
C2151 vw.n323 vw 0.00363f
C2152 vw.n324 vw 0
C2153 vw.n325 vw 0.00448f
C2154 vw.n326 vw 0.00431f
C2155 vw.n327 vw 0
C2156 vw.n328 vw 0
C2157 vw.n329 vw 0.00363f
C2158 vw.n330 vw 0
C2159 vw.n331 vw 0
C2160 vw.n332 vw 0
C2161 vw.n333 vw 0
C2162 vw.n334 vw 0
C2163 vw.n335 vw 0
C2164 vw.n336 vw 0
C2165 vw.n337 vw 0.00363f
C2166 vw.n338 vw 0
C2167 vw.n339 vw 0
C2168 vw.n340 vw 0.00629f
C2169 vw.n341 vw 0
C2170 vw.n342 vw 0
C2171 vw.n343 vw 0
C2172 vw.n344 vw 0
C2173 vw.n345 vw 0
C2174 vw.n346 vw 0
C2175 vw.n347 vw 0
C2176 vw.n348 vw 0
C2177 vw.n349 vw 0
C2178 vw.n350 vw 0
C2179 vw.n351 vw 0.00363f
C2180 vw.n352 vw 0.00504f
C2181 vw.n353 vw 0
C2182 vw.n354 vw 0
C2183 vw.n355 vw 0
C2184 vw.n356 vw 0
C2185 vw.n357 vw 0
C2186 vw.n358 vw 0
C2187 vw.n359 vw 0
C2188 vw.n360 vw 0.00363f
C2189 vw.n361 vw 0
C2190 vw.n362 vw 0
C2191 vw.n363 vw 0
C2192 vw.n364 vw 0
C2193 vw.n365 vw 0
C2194 vw.n366 vw 0.00588f
C2195 vw.n367 vw 0
C2196 vw.n368 vw 0
C2197 vw.n369 vw 0
C2198 vw.n370 vw 0
C2199 vw.n371 vw 0
C2200 vw.n372 vw 0
C2201 vw.n373 vw 0
C2202 vw.n374 vw 0
C2203 vw.n375 vw 0
C2204 vw.n376 vw 0
C2205 vw.n377 vw 0
C2206 vw.n378 vw 0
C2207 vw.n379 vw 0
C2208 vw.n380 vw 0.00629f
C2209 vw.n381 vw 0
C2210 vw.n382 vw 0
C2211 vw.n383 vw 0
C2212 vw.n384 vw 0
C2213 vw.n385 vw 0
C2214 vw.n386 vw 0
C2215 vw.n387 vw 0.00176f
C2216 vw.n388 vw 0
C2217 vw.n389 vw 0
C2218 vw.n390 vw 0.0351f
C2219 vw.n393 vw 0
C2220 vw.n394 vw 0
C2221 vw.n395 vw 0
C2222 vw.n396 vw 0
C2223 vw.n397 vw 0
C2224 vw.n398 vw 0
C2225 vw.n399 vw 0
C2226 vw.n400 vw 0
C2227 vw.n405 vw 0.01804f
C2228 vw.n408 vw 0
C2229 vw.n409 vw 0
C2230 vw.n410 vw 0
C2231 vw.n411 vw 0
C2232 vw.n412 vw 0
C2233 vw.n413 vw 0
C2234 vw.n414 vw 0
C2235 vw.n415 vw 0
C2236 vw.n416 vw 0
C2237 vw.n417 vw 0
C2238 vw.n418 vw 0
C2239 vw.n419 vw 0
C2240 vw.n420 vw 0
C2241 vw.n421 vw 0
C2242 vw.n422 vw 0
C2243 vw.n423 vw 0
C2244 vw.n424 vw 0
C2245 vw.n425 vw 0
C2246 vw.n426 vw 0
C2247 vw.n427 vw 0
C2248 vw.n428 vw 0
C2249 vw.n429 vw 0
C2250 vw.n430 vw 0
C2251 vw.n431 vw 0
C2252 vw.n432 vw 0
C2253 vw.n433 vw 0
C2254 vw.n434 vw 0
C2255 vw.n435 vw 0
C2256 vw.n436 vw 0
C2257 vw.n437 vw 0
C2258 vw.n438 vw 0
C2259 vw.n439 vw 0
C2260 vw.n440 vw 0
C2261 vw.n441 vw 0
C2262 vw.n442 vw 0
C2263 vw.n443 vw 0
C2264 vw.n444 vw 0
C2265 vw.n445 vw 0
C2266 vw.n446 vw 0
C2267 vw.n447 vw 0
C2268 vw.n448 vw 0
C2269 vw.n449 vw 0
C2270 vw.n450 vw 0.03371f
C2271 vw.n451 vw 0.00634f
C2272 vw.n452 vw 0
C2273 vw.n453 vw 0
C2274 vw.n454 vw 0
C2275 vw.n455 vw 0
C2276 vw.n456 vw 0
C2277 vw.n457 vw 0
C2278 vw.n458 vw 0
C2279 vw.n459 vw 0
C2280 vw.n460 vw 0
C2281 vw.n461 vw 0
C2282 vw.n462 vw 0
C2283 vw.n463 vw 0
C2284 vw.n464 vw 0
C2285 vw.n465 vw 0
C2286 vw.n466 vw 0
C2287 vw.n467 vw 0.0351f
C2288 vw.n468 vw 0
C2289 vw.n475 vw 0
C2290 vw.n476 vw 0
C2291 vw.n477 vw 0
C2292 vw.n478 vw 0.00342f
C2293 vw.n479 vw 0
C2294 vw.n480 vw 0
C2295 vw.n481 vw 0
C2296 vw.n482 vw 0
C2297 vw.n483 vw 0
C2298 vw.n484 vw 0
C2299 vw.n485 vw 0
C2300 vw.n486 vw 0
C2301 vw.n487 vw 0
C2302 vw.n488 vw 0
C2303 vw.n489 vw 0
C2304 vw.n490 vw 0
C2305 vw.n491 vw 0
C2306 vw.n492 vw 0
C2307 vw.n493 vw 0
C2308 vw.n494 vw 0
C2309 vw.n495 vw 0
C2310 vw.n496 vw 0
C2311 vw.n497 vw 0
C2312 vw.n498 vw 0
C2313 vw.n499 vw 0
C2314 vw.n500 vw 0
C2315 vw.n501 vw 0
C2316 vw.n502 vw 0
C2317 vw.n503 vw 0
C2318 vw.n504 vw 0
C2319 vw.n505 vw 0
C2320 vw.n506 vw 0
C2321 vw.n507 vw 0
C2322 vw.n508 vw 0
C2323 vw.n509 vw 0
C2324 vw.n510 vw 0
C2325 vw.n511 vw 0
C2326 vw.n512 vw 0
C2327 vw.n514 vw 0
C2328 vw.n516 vw 0
C2329 vw.n517 vw 0
C2330 vw.n518 vw 0
C2331 vw.n519 vw 0
C2332 vw.n520 vw 0
C2333 vw.n521 vw 0
C2334 vw.n522 vw 0
C2335 vw.n524 vw 0
C2336 vw.n526 vw 0
C2337 vw.n527 vw 0
C2338 vw.n528 vw 0
C2339 vw.n529 vw 0
C2340 vw.n530 vw 0
C2341 vw.n531 vw 0
C2342 vw.n532 vw 0
C2343 vw.n534 vw 0
C2344 vw.n536 vw 0
C2345 vw.n537 vw 0
C2346 vw.n538 vw 0
C2347 vw.n539 vw 0
C2348 vw.n540 vw 0
C2349 vw.n541 vw 0
C2350 vw.n542 vw 0
C2351 vw.n544 vw 0
C2352 vw.n545 vw 0
C2353 vw.n546 vw 0
C2354 vw.n547 vw 0
C2355 vw.n548 vw 0
C2356 vw.n549 vw 0
C2357 vw.n550 vw 0
C2358 vw.n551 vw 0
C2359 vw.n552 vw 0
C2360 vw.n553 vw 0
C2361 vw.n554 vw 0
C2362 vw.n555 vw 0
C2363 vw.n556 vw 0
C2364 vw.n557 vw 0
C2365 vw.n558 vw 0
C2366 vw.n559 vw 0
C2367 vw.n560 vw 0
C2368 vw.n561 vw 0
C2369 vw.n562 vw 0
C2370 vw.n563 vw 0
C2371 vw.n564 vw 0
C2372 vw.n565 vw 0
C2373 vw.n566 vw 0
C2374 vw.n567 vw 0
C2375 vw.n568 vw 0
C2376 vw.n569 vw 0
C2377 vw.n570 vw 0.07995f
C2378 vw.n571 vw 0
C2379 vw.n572 vw 0
C2380 vw.n573 vw 0
C2381 vw.n574 vw 0
C2382 vw.n575 vw 0
C2383 vw.n576 vw 0
C2384 vw.n577 vw 0
C2385 vw.n579 vw 0.01736f
C2386 vw.n580 vw 0
C2387 vw.n581 vw 0
C2388 vw.n582 vw 0
C2389 vw.n583 vw 0
C2390 vw.n584 vw 0
C2391 vw.n585 vw 0
C2392 vw.n587 vw 0
C2393 vw.n588 vw 0
C2394 vw.n589 vw 0
C2395 vw.n590 vw 0
C2396 vw.n592 vw 0
C2397 vw.n593 vw 0
C2398 vw.n594 vw 0
C2399 vw.n595 vw 0
C2400 vw.n596 vw 0
C2401 vw.n597 vw 0
C2402 vw.n599 vw 0
C2403 vw.n600 vw 0
C2404 vw.n601 vw 0
C2405 vw.n602 vw 0
C2406 vw.n603 vw 0
C2407 vw.n604 vw 0
C2408 vw.n606 vw 0
C2409 vw.n607 vw 0
C2410 vw.n609 vw 0
C2411 vw.n610 vw 0
C2412 vw.n611 vw 0
C2413 vw.n612 vw 0
C2414 vw.n613 vw 0
C2415 vw.n614 vw 0
C2416 vw.n615 vw 0
C2417 vw.n617 vw 0
C2418 vw.n619 vw 0
C2419 vw.n620 vw 0
C2420 vw.n621 vw 0
C2421 vw.n622 vw 0
C2422 vw.n623 vw 0
C2423 vw.n624 vw 0
C2424 vw.n625 vw 0
C2425 vw.n627 vw 0
C2426 vw.n629 vw 0
C2427 vw.n630 vw 0
C2428 vw.n631 vw 0
C2429 vw.n632 vw 0
C2430 vw.n633 vw 0
C2431 vw.n634 vw 0
C2432 vw.n635 vw 0
C2433 vw.n637 vw 0
C2434 vw.n639 vw 0
C2435 vw.n640 vw 0
C2436 vw.n641 vw 0
C2437 vw.n642 vw 0
C2438 vw.n643 vw 0
C2439 vw.n644 vw 0
C2440 vw.n645 vw 0
C2441 vw.n646 vw 0
C2442 vw.n647 vw 0
C2443 vw.n648 vw 0.00295f
C2444 vw.n649 vw 0.01993f
C2445 vw.n650 vw 0.00913f
C2446 vw.n651 vw 0.01178f
C2447 vw.n652 vw 0
C2448 vw.n653 vw 0
C2449 vw.n654 vw 0
C2450 vw.n655 vw 0
C2451 vw.n656 vw 0
C2452 vw.n657 vw 0
C2453 vw.n659 vw 0
C2454 vw.n660 vw 0
C2455 vw.n661 vw 0
C2456 vw.n662 vw 0
C2457 vw.n663 vw 0
C2458 vw.n664 vw 0
C2459 vw.n665 vw 0
C2460 vw.n667 vw 0
C2461 vw.n668 vw 0
C2462 vw.n669 vw 0
C2463 vw.n670 vw 0
C2464 vw.n671 vw 0
C2465 vw.n673 vw 0
C2466 vw.n674 vw 0
C2467 vw.n675 vw 0
C2468 vw.n676 vw 0
C2469 vw.n677 vw 0
C2470 vw.n678 vw 0
C2471 vw.n680 vw 0
C2472 vw.n681 vw 0
C2473 vw.n682 vw 0
C2474 vw.n683 vw 0
C2475 vw.n684 vw 0
C2476 vw.n685 vw 0
C2477 vw.n686 vw 0
C2478 vw.n687 vw 0
C2479 vw.n688 vw 0
C2480 vw.n689 vw 0
C2481 vw.n690 vw 0.32834f
C2482 vw.n691 vw 0.18567f
C2483 vw.n692 vw 0.04476f
C2484 vw.n693 vw 0.07411f
C2485 vw.n694 vw 0.02963f
C2486 vw.n695 vw 0.02684f
C2487 vw.n696 vw 0
C2488 vw.n697 vw 0
C2489 vw.n698 vw 0
C2490 vw.n699 vw 0
C2491 vw.n700 vw 0
C2492 vw.n701 vw 0
C2493 vw.n702 vw 0
C2494 vw.n703 vw 0
C2495 vw.n704 vw 0.00134f
C2496 vw.n705 vw 0.00134f
C2497 vw.n706 vw 0.00235f
C2498 vw.n707 vw 0
C2499 vw.n708 vw 0
C2500 vw.n709 vw 0
C2501 vw.n710 vw 0
C2502 vw.n711 vw 0
C2503 vw.n712 vw 0
C2504 vw.n713 vw 0
C2505 vw.n714 vw 0
C2506 vw.n715 vw 0
C2507 vw.n716 vw 0.00363f
C2508 vw.n717 vw 0.00363f
C2509 vw.n718 vw 0
C2510 vw.n719 vw 0
C2511 vw.n720 vw 0
C2512 vw.n721 vw 0
C2513 vw.n722 vw 0
C2514 vw.n723 vw 0.00409f
C2515 vw.n724 vw 0.00459f
C2516 vw.n725 vw 0.00509f
C2517 vw.n726 vw 0.00504f
C2518 vw.n727 vw 0
C2519 vw.n728 vw 0
C2520 vw.n729 vw 0
C2521 vw.n730 vw 0
C2522 vw.n731 vw 0
C2523 vw.n732 vw 0.00502f
C2524 vw.n733 vw 0.00363f
C2525 vw.n734 vw 0
C2526 vw.n735 vw 0
C2527 vw.n736 vw 0
C2528 vw.n737 vw 0
C2529 vw.n738 vw 0
C2530 vw.n739 vw 0
C2531 vw.n740 vw 0.00363f
C2532 vw.n741 vw 0.00504f
C2533 vw.n742 vw 0
C2534 vw.n743 vw 0
C2535 vw.n744 vw 0
C2536 vw.n745 vw 0
C2537 vw.n746 vw 0
C2538 vw.n747 vw 0
C2539 vw.n748 vw 0
C2540 vw.n749 vw 0.00588f
C2541 vw.n750 vw 0.00375f
C2542 vw.n751 vw 0
C2543 vw.n752 vw 0
C2544 vw.n753 vw 0
C2545 vw.n754 vw 0
C2546 vw.n755 vw 0.00134f
C2547 vw.n756 vw 0.00281f
C2548 vw.n757 vw 0
C2549 vw.n758 vw 0.00634f
C2550 vw.n759 vw 0
C2551 vw.n760 vw 0
C2552 vw.n761 vw 0
C2553 vw.n762 vw 0
C2554 vw.n763 vw 0
C2555 vw.n764 vw 0
C2556 vw.n765 vw 0
C2557 vw.n766 vw 0
C2558 vw.n767 vw 0
C2559 vw.n768 vw 0
C2560 vw.n769 vw 0
C2561 vw.n770 vw 0
C2562 vw.n771 vw 0
C2563 vw.n772 vw 0
C2564 vw.n773 vw 0
C2565 vw.n774 vw 0
C2566 vw.n775 vw 0
C2567 vw.n776 vw 0
C2568 vw.n777 vw 0
C2569 vw.n778 vw 0
C2570 vw.n779 vw 0
C2571 vw.n780 vw 0
C2572 vw.n781 vw 0
C2573 vw.n782 vw 0
C2574 vw.n783 vw 0
C2575 vw.n784 vw 0
C2576 vw.n785 vw 0
C2577 vw.n786 vw 0
C2578 vw.n787 vw 0
C2579 vw.n788 vw 0.00629f
C2580 vw.n789 vw 0
C2581 vw.n790 vw 0
C2582 vw.n791 vw 0
C2583 vw.n792 vw 0
C2584 vw.n793 vw 0
C2585 vw.n794 vw 0
C2586 vw.n795 vw 0
C2587 vw.n796 vw 0
C2588 vw.n797 vw 0
C2589 vw.n798 vw 0.00504f
C2590 vw.n799 vw 0.00723f
C2591 vw.n800 vw 0.00441f
C2592 vw.n801 vw 0.00427f
C2593 vw.n802 vw 0
C2594 vw.n803 vw 0
C2595 vw.n804 vw 0
C2596 vw.n805 vw 0
C2597 vw.n806 vw 0
C2598 vw.n807 vw 0.00363f
C2599 vw.n808 vw 0.00363f
C2600 vw.n809 vw 0
C2601 vw.n810 vw 0
C2602 vw.n811 vw 0.00363f
C2603 vw.n812 vw 0.00495f
C2604 vw.n813 vw 0
C2605 vw.n814 vw 0
C2606 vw.n815 vw 0
C2607 vw.n816 vw 0
C2608 vw.n817 vw 0
C2609 vw.n818 vw 0.00504f
C2610 vw.n819 vw 0.00363f
C2611 vw.n820 vw 0
C2612 vw.n821 vw 0.00194f
C2613 vw.n822 vw 0.00124f
C2614 vw.n823 vw 0
C2615 vw.n824 vw 0
C2616 vw.n825 vw 0
C2617 vw.n826 vw 0
C2618 vw.n827 vw 0.00727f
C2619 vw.n828 vw 0
C2620 vw.n829 vw 0
C2621 vw.n830 vw 0
C2622 vw.n831 vw 0
C2623 vw.n832 vw 0
C2624 vw.n833 vw 0
C2625 vw.n834 vw 0
C2626 vw.n835 vw 0.00577f
C2627 vw.n836 vw 0.01009f
C2628 vw.n837 vw 0
C2629 vw.n838 vw 0.00194f
C2630 vw.n839 vw 0.00221f
C2631 vw.n840 vw 0
C2632 vw.n841 vw 0.00577f
C2633 vw.n842 vw 0.00313f
C2634 vw.n843 vw 0
C2635 vw.n844 vw 0
C2636 vw.n845 vw 0
C2637 vw.n846 vw 0
C2638 vw.n847 vw 0.00443f
C2639 vw.n848 vw 0.00303f
C2640 xmcm_chain_2_0/a_1000_n131# vw -0.20137f
C2641 xm9_0/a_63_n131# vw -3.02421f
C2642 xmcm_chain_3_0/a_1000_n131# vw -0.20106f
C2643 cdep_0/m4_n700_n700# vw 0.43204f
C2644 avdd vw -11.07953f
C2645 xm4_0/a_63_n131# vw 0.18503f
C2646 xm1_0/a_63_n131# vw -0.59853f
C2647 cw_0/m4_n700_n700# vw 0.79566f
C2648 xm8_0/a_63_n131# vw -0.74234f
C2649 xmcm_chain_4_0/a_1000_n131# vw -0.13381f
C2650 xmcm_chain_4_0/a_n1000_n339# vw -1.22641f
C2651 xmcm_chain_1_0/a_1000_n131# vw 2.61918f
C2652 vb_idep vw -0.07606f
C2653 xm1_0/a_n63_n339# vw -3.02027f
.ends
