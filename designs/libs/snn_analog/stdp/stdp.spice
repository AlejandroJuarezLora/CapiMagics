* NGSPICE file created from stdp.ext - technology: gf180mcuD

.subckt xm5 a_n1500_n339# a_n1620_n131# w_n1886_n560# a_1500_n131#
X0 a_1500_n131# a_n1500_n339# a_n1620_n131# w_n1886_n560# pfet_03v3 ad=0.3p pd=2.2u as=0.3p ps=2.2u w=0.5u l=15u
.ends

.subckt xm3 a_63_n131# a_n393_n504# a_n63_n339# a_n183_n131#
X0 a_63_n131# a_n63_n339# a_n183_n131# a_n393_n504# nfet_03v3 ad=0.3p pd=2.2u as=0.3p ps=2.2u w=0.5u l=0.63u
.ends

.subckt xm1 a_63_n131# a_n63_n339# w_n449_n560# a_n183_n131#
X0 a_63_n131# a_n63_n339# a_n183_n131# w_n449_n560# pfet_03v3 ad=0.3p pd=2.2u as=0.3p ps=2.2u w=0.5u l=0.63u
.ends

.subckt xmcm_chain_4 a_n1120_n131# a_n1330_n504# a_1000_n131# a_n1000_n339#
X0 a_1000_n131# a_n1000_n339# a_n1120_n131# a_n1330_n504# nfet_03v3 ad=0.3p pd=2.2u as=0.3p ps=2.2u w=0.5u l=10u
.ends

.subckt cpot m4_n700_n700# m4_n500_n500#
X0 m4_n500_n500# m4_n700_n700# cap_mim_2f0_m4m5_noshield c_width=5u c_length=5u
X1 m4_n500_n500# m4_n700_n700# cap_mim_2f0_m4m5_noshield c_width=5u c_length=5u
.ends

.subckt xm8 a_63_n131# a_n63_n339# w_n449_n560# a_n183_n131#
X0 a_63_n131# a_n63_n339# a_n183_n131# w_n449_n560# pfet_03v3 ad=0.3p pd=2.2u as=0.3p ps=2.2u w=0.5u l=0.63u
.ends

.subckt xmcm_chain_2 a_n1120_n131# a_n1330_n504# a_1000_n131# a_n1000_n339#
X0 a_1000_n131# a_n1000_n339# a_n1120_n131# a_n1330_n504# nfet_03v3 ad=0.3p pd=2.2u as=0.3p ps=2.2u w=0.5u l=10u
.ends

.subckt xm16 a_n400_n1101# a_n280_n1309# w_n666_n1529# a_280_n1101#
X0 a_280_n1101# a_n280_n1309# a_n400_n1101# w_n666_n1529# pfet_03v3 ad=6.12p pd=21.6u as=6.12p ps=21.6u w=10.2u l=2.8u
.ends

.subckt xmcm_chain_0 a_n1120_n131# a_n1330_n504# a_1000_n131# a_n1000_n339#
X0 a_1000_n131# a_n1000_n339# a_n1120_n131# a_n1330_n504# nfet_03v3 ad=0.3p pd=2.2u as=0.3p ps=2.2u w=0.5u l=10u
.ends

.subckt cw m4_n700_n700# m4_n500_n500#
X0 m4_n500_n500# m4_n700_n700# cap_mim_2f0_m4m5_noshield c_width=5u c_length=5u
X1 m4_n500_n500# m4_n700_n700# cap_mim_2f0_m4m5_noshield c_width=5u c_length=5u
X2 m4_n500_n500# m4_n700_n700# cap_mim_2f0_m4m5_noshield c_width=5u c_length=5u
X3 m4_n500_n500# m4_n700_n700# cap_mim_2f0_m4m5_noshield c_width=5u c_length=5u
X4 m4_n500_n500# m4_n700_n700# cap_mim_2f0_m4m5_noshield c_width=5u c_length=5u
X5 m4_n500_n500# m4_n700_n700# cap_mim_2f0_m4m5_noshield c_width=5u c_length=5u
X6 m4_n500_n500# m4_n700_n700# cap_mim_2f0_m4m5_noshield c_width=5u c_length=5u
X7 m4_n500_n500# m4_n700_n700# cap_mim_2f0_m4m5_noshield c_width=5u c_length=5u
X8 m4_n500_n500# m4_n700_n700# cap_mim_2f0_m4m5_noshield c_width=5u c_length=5u
X9 m4_n500_n500# m4_n700_n700# cap_mim_2f0_m4m5_noshield c_width=5u c_length=5u
.ends

.subckt xm4 a_63_n131# a_n393_n504# a_n63_n339# a_n183_n131#
X0 a_63_n131# a_n63_n339# a_n183_n131# a_n393_n504# nfet_03v3 ad=0.3p pd=2.2u as=0.3p ps=2.2u w=0.5u l=0.63u
.ends

.subckt xm12 a_63_n131# a_n393_n504# a_n63_n339# a_n183_n131#
X0 a_63_n131# a_n63_n339# a_n183_n131# a_n393_n504# nfet_03v3 ad=0.3p pd=2.2u as=0.3p ps=2.2u w=0.5u l=0.63u
.ends

.subckt xm2 a_63_n131# a_n63_n339# w_n449_n560# a_n183_n131#
X0 a_63_n131# a_n63_n339# a_n183_n131# w_n449_n560# pfet_03v3 ad=0.3p pd=2.2u as=0.3p ps=2.2u w=0.5u l=0.63u
.ends

.subckt cdep m4_n700_n700# m4_n500_n500#
X0 m4_n500_n500# m4_n700_n700# cap_mim_2f0_m4m5_noshield c_width=5u c_length=5u
X1 m4_n500_n500# m4_n700_n700# cap_mim_2f0_m4m5_noshield c_width=5u c_length=5u
.ends

.subckt xmcm_1 a_n280_n350# a_n400_n141# a_280_n141# a_n610_n515#
X0 a_280_n141# a_n280_n350# a_n400_n141# a_n610_n515# nfet_03v3 ad=0.366p pd=2.42u as=0.366p ps=2.42u w=0.61u l=2.8u
.ends

.subckt xm9 a_63_n131# a_n393_n504# a_n63_n339# a_n183_n131#
X0 a_63_n131# a_n63_n339# a_n183_n131# a_n393_n504# nfet_03v3 ad=0.3p pd=2.2u as=0.3p ps=2.2u w=0.5u l=0.63u
.ends

.subckt xmcm_chain_3 a_n1120_n131# a_n1330_n504# a_1000_n131# a_n1000_n339#
X0 a_1000_n131# a_n1000_n339# a_n1120_n131# a_n1330_n504# nfet_03v3 ad=0.3p pd=2.2u as=0.3p ps=2.2u w=0.5u l=10u
.ends

.subckt xm17 a_n460_n339# w_n846_n560# a_n580_n131# a_460_n131#
X0 a_460_n131# a_n460_n339# a_n580_n131# w_n846_n560# pfet_03v3 ad=0.3p pd=2.2u as=0.3p ps=2.2u w=0.5u l=4.6u
.ends

.subckt xm7 a_63_n131# a_n63_n339# w_n449_n560# a_n183_n131#
X0 a_63_n131# a_n63_n339# a_n183_n131# w_n449_n560# pfet_03v3 ad=0.3p pd=2.2u as=0.3p ps=2.2u w=0.5u l=0.63u
.ends

.subckt xmcm_chain_1 a_n1120_n131# a_n1330_n504# a_1000_n131# a_n1000_n339#
X0 a_1000_n131# a_n1000_n339# a_n1120_n131# a_n1330_n504# nfet_03v3 ad=0.3p pd=2.2u as=0.3p ps=2.2u w=0.5u l=10u
.ends

.subckt stdp avdd avss nvpost nvpre vpost vpre vb_idep vb_itd vb_itp vb_pot vw Iout
Xxm5_0 vw avdd avdd Iout xm5
Xxm3_0 vw avss vpre xm4_0/a_63_n131# xm3
Xxm1_0 xm1_0/a_63_n131# xm1_0/a_n63_n339# avdd avdd xm1
Xxmcm_chain_4_0 avss avss xmcm_chain_4_0/a_1000_n131# vb_itd xmcm_chain_4
Xcpot_0 xm1_0/a_n63_n339# avdd cpot
Xxm8_0 xm8_0/a_63_n131# nvpre avdd xm1_0/a_n63_n339# xm8
Xxmcm_chain_2_0 xmcm_chain_3_0/a_1000_n131# avss xmcm_chain_2_0/a_1000_n131# vb_itd
+ xmcm_chain_2
Xxm16_0 avdd vb_idep avdd xm9_0/a_63_n131# xm16
Xxmcm_chain_0_0 xmcm_chain_1_0/a_1000_n131# avss xm4_0/a_n63_n339# vb_itd xmcm_chain_0
Xcw_0 avss vw cw
Xxm4_0 xm4_0/a_63_n131# avss xm4_0/a_n63_n339# avss xm4
Xxm12_0 xm9_0/a_63_n131# avss vpost xm4_0/a_n63_n339# xm12
Xxm2_0 vw nvpost avdd xm1_0/a_63_n131# xm2
Xcdep_0 avss xm4_0/a_n63_n339# cdep
Xxmcm_1_0 vb_pot avss xm7_0/a_63_n131# avss xmcm_1
Xxm9_0 xm9_0/a_63_n131# avss xm9_0/a_63_n131# avss xm9
Xxmcm_chain_3_0 xmcm_chain_4_0/a_1000_n131# avss xmcm_chain_3_0/a_1000_n131# vb_itd
+ xmcm_chain_3
Xxm17_0 vb_itp avdd avdd xm1_0/a_n63_n339# xm17
Xxm7_0 xm7_0/a_63_n131# xm8_0/a_63_n131# avdd avdd xm7
Xxmcm_chain_1_0 xmcm_chain_2_0/a_1000_n131# avss xmcm_chain_1_0/a_1000_n131# vb_itd
+ xmcm_chain_1
.ends
