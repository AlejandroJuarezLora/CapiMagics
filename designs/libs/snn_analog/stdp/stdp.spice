* NGSPICE file created from stdp.ext - technology: gf180mcuD

.subckt xm3 a_63_n131# a_n393_n504# a_n63_n339# a_n183_n131#
X0 a_63_n131# a_n63_n339# a_n183_n131# a_n393_n504# nfet_03v3 ad=0.3p pd=2.2u as=0.3p ps=2.2u w=0.5u l=0.63u
C0 a_n63_n339# a_63_n131# 0.01741f
C1 a_63_n131# a_n183_n131# 0.33209f
C2 a_n63_n339# a_n183_n131# 0.04027f
C3 a_63_n131# a_n393_n504# 0.53054f
C4 a_n183_n131# a_n393_n504# 0.26905f
C5 a_n63_n339# a_n393_n504# 0.50927f
.ends

.subckt xm1 a_63_n131# a_n63_n339# w_n449_n560# a_n183_n131# VSUBS
X0 a_63_n131# a_n63_n339# a_n183_n131# w_n449_n560# pfet_03v3 ad=0.3p pd=2.2u as=0.3p ps=2.2u w=0.5u l=0.63u
C0 a_n63_n339# a_63_n131# 0.01741f
C1 w_n449_n560# a_n183_n131# 0.2249f
C2 a_n183_n131# a_63_n131# 0.33209f
C3 w_n449_n560# a_63_n131# 0.48511f
C4 a_n183_n131# a_n63_n339# 0.04027f
C5 w_n449_n560# a_n63_n339# 0.45684f
C6 a_63_n131# VSUBS 0.04546f
C7 a_n183_n131# VSUBS 0.04416f
C8 a_n63_n339# VSUBS 0.05243f
C9 w_n449_n560# VSUBS 3.76898f
.ends

.subckt xmcm_chain_4 a_n1120_n131# a_n1330_n504# a_1000_n131# a_n1000_n339#
X0 a_1000_n131# a_n1000_n339# a_n1120_n131# a_n1330_n504# nfet_03v3 ad=0.3p pd=2.2u as=0.3p ps=2.2u w=0.5u l=10u
C0 a_n1000_n339# a_1000_n131# 0.06176f
C1 a_1000_n131# a_n1120_n131# 1.01551f
C2 a_n1000_n339# a_n1120_n131# 0.42273f
C3 a_1000_n131# a_n1330_n504# 1.43795f
C4 a_n1120_n131# a_n1330_n504# 0.4423f
C5 a_n1000_n339# a_n1330_n504# 4.53847f
.ends

.subckt xm8 a_63_n131# a_n63_n339# w_n449_n560# a_n183_n131# VSUBS
X0 a_63_n131# a_n63_n339# a_n183_n131# w_n449_n560# pfet_03v3 ad=0.3p pd=2.2u as=0.3p ps=2.2u w=0.5u l=0.63u
C0 a_n63_n339# a_63_n131# 0.01741f
C1 w_n449_n560# a_n183_n131# 0.2249f
C2 a_n183_n131# a_63_n131# 0.33209f
C3 w_n449_n560# a_63_n131# 0.48511f
C4 a_n183_n131# a_n63_n339# 0.04027f
C5 w_n449_n560# a_n63_n339# 0.45684f
C6 a_63_n131# VSUBS 0.04546f
C7 a_n183_n131# VSUBS 0.04416f
C8 a_n63_n339# VSUBS 0.05243f
C9 w_n449_n560# VSUBS 3.76898f
.ends

.subckt xmcm_chain_2 a_n1120_n131# a_n1330_n504# a_1000_n131# a_n1000_n339#
X0 a_1000_n131# a_n1000_n339# a_n1120_n131# a_n1330_n504# nfet_03v3 ad=0.3p pd=2.2u as=0.3p ps=2.2u w=0.5u l=10u
C0 a_n1000_n339# a_1000_n131# 0.06176f
C1 a_1000_n131# a_n1120_n131# 1.01551f
C2 a_n1000_n339# a_n1120_n131# 0.42273f
C3 a_1000_n131# a_n1330_n504# 1.43795f
C4 a_n1120_n131# a_n1330_n504# 0.4423f
C5 a_n1000_n339# a_n1330_n504# 4.53847f
.ends

.subckt xm16 a_n400_n1101# a_n280_n1309# w_n666_n1529# a_280_n1101# VSUBS
X0 a_280_n1101# a_n280_n1309# a_n400_n1101# w_n666_n1529# pfet_03v3 ad=6.12p pd=21.6u as=6.12p ps=21.6u w=10.2u l=2.8u
C0 a_n280_n1309# a_280_n1101# 0.57005f
C1 w_n666_n1529# a_n400_n1101# 1.08957f
C2 a_n400_n1101# a_280_n1101# 0.72266f
C3 w_n666_n1529# a_280_n1101# 1.53123f
C4 a_n400_n1101# a_n280_n1309# 0.64393f
C5 w_n666_n1529# a_n280_n1309# 1.30956f
C6 a_280_n1101# VSUBS 0.28176f
C7 a_n400_n1101# VSUBS 0.30514f
C8 a_n280_n1309# VSUBS 0.12268f
C9 w_n666_n1529# VSUBS 13.9301f
.ends

.subckt xmcm_chain_0 a_n1120_n131# a_n1330_n504# a_1000_n131# a_n1000_n339#
X0 a_1000_n131# a_n1000_n339# a_n1120_n131# a_n1330_n504# nfet_03v3 ad=0.3p pd=2.2u as=0.3p ps=2.2u w=0.5u l=10u
C0 a_n1000_n339# a_1000_n131# 0.06176f
C1 a_1000_n131# a_n1120_n131# 1.01551f
C2 a_n1000_n339# a_n1120_n131# 0.42273f
C3 a_1000_n131# a_n1330_n504# 1.43795f
C4 a_n1120_n131# a_n1330_n504# 0.4423f
C5 a_n1000_n339# a_n1330_n504# 4.53847f
.ends

.subckt xm4 a_63_n131# a_n393_n504# a_n63_n339# a_n183_n131#
X0 a_63_n131# a_n63_n339# a_n183_n131# a_n393_n504# nfet_03v3 ad=0.3p pd=2.2u as=0.3p ps=2.2u w=0.5u l=0.63u
C0 a_n63_n339# a_63_n131# 0.01741f
C1 a_63_n131# a_n183_n131# 0.33209f
C2 a_n63_n339# a_n183_n131# 0.04027f
C3 a_63_n131# a_n393_n504# 0.53054f
C4 a_n183_n131# a_n393_n504# 0.26905f
C5 a_n63_n339# a_n393_n504# 0.50927f
.ends

.subckt xm12 a_63_n131# a_n393_n504# a_n63_n339# a_n183_n131#
X0 a_63_n131# a_n63_n339# a_n183_n131# a_n393_n504# nfet_03v3 ad=0.3p pd=2.2u as=0.3p ps=2.2u w=0.5u l=0.63u
C0 a_n63_n339# a_63_n131# 0.01741f
C1 a_63_n131# a_n183_n131# 0.33209f
C2 a_n63_n339# a_n183_n131# 0.04027f
C3 a_63_n131# a_n393_n504# 0.53054f
C4 a_n183_n131# a_n393_n504# 0.26905f
C5 a_n63_n339# a_n393_n504# 0.50927f
.ends

.subckt xm2 a_63_n131# a_n63_n339# w_n449_n560# a_n183_n131# VSUBS
X0 a_63_n131# a_n63_n339# a_n183_n131# w_n449_n560# pfet_03v3 ad=0.3p pd=2.2u as=0.3p ps=2.2u w=0.5u l=0.63u
C0 a_n63_n339# a_63_n131# 0.01741f
C1 w_n449_n560# a_n183_n131# 0.2249f
C2 a_n183_n131# a_63_n131# 0.33209f
C3 w_n449_n560# a_63_n131# 0.48511f
C4 a_n183_n131# a_n63_n339# 0.04027f
C5 w_n449_n560# a_n63_n339# 0.45684f
C6 a_63_n131# VSUBS 0.04546f
C7 a_n183_n131# VSUBS 0.04416f
C8 a_n63_n339# VSUBS 0.05243f
C9 w_n449_n560# VSUBS 3.76898f
.ends

.subckt xmcm_1 a_n280_n350# a_n400_n141# a_280_n141# a_n610_n515#
X0 a_280_n141# a_n280_n350# a_n400_n141# a_n610_n515# nfet_03v3 ad=0.366p pd=2.42u as=0.366p ps=2.42u w=0.61u l=2.8u
C0 a_n280_n350# a_280_n141# 0.04694f
C1 a_280_n141# a_n400_n141# 0.4351f
C2 a_n280_n350# a_n400_n141# 0.1455f
C3 a_280_n141# a_n610_n515# 0.76826f
C4 a_n400_n141# a_n610_n515# 0.3279f
C5 a_n280_n350# a_n610_n515# 1.4155f
.ends

.subckt xm9 a_63_n131# a_n393_n504# a_n63_n339# a_n183_n131#
X0 a_63_n131# a_n63_n339# a_n183_n131# a_n393_n504# nfet_03v3 ad=0.3p pd=2.2u as=0.3p ps=2.2u w=0.5u l=0.63u
C0 a_n63_n339# a_63_n131# 0.01741f
C1 a_63_n131# a_n183_n131# 0.33209f
C2 a_n63_n339# a_n183_n131# 0.04027f
C3 a_63_n131# a_n393_n504# 0.53054f
C4 a_n183_n131# a_n393_n504# 0.26905f
C5 a_n63_n339# a_n393_n504# 0.50927f
.ends

.subckt xmcm_chain_3 a_n1120_n131# a_n1330_n504# a_1000_n131# a_n1000_n339#
X0 a_1000_n131# a_n1000_n339# a_n1120_n131# a_n1330_n504# nfet_03v3 ad=0.3p pd=2.2u as=0.3p ps=2.2u w=0.5u l=10u
C0 a_n1000_n339# a_1000_n131# 0.06176f
C1 a_1000_n131# a_n1120_n131# 1.01551f
C2 a_n1000_n339# a_n1120_n131# 0.42273f
C3 a_1000_n131# a_n1330_n504# 1.43795f
C4 a_n1120_n131# a_n1330_n504# 0.4423f
C5 a_n1000_n339# a_n1330_n504# 4.53847f
.ends

.subckt xm17 a_n460_n339# w_n846_n560# a_n580_n131# a_460_n131# VSUBS
X0 a_460_n131# a_n460_n339# a_n580_n131# w_n846_n560# pfet_03v3 ad=0.3p pd=2.2u as=0.3p ps=2.2u w=0.5u l=4.6u
C0 a_n460_n339# a_460_n131# 0.04912f
C1 w_n846_n560# a_n580_n131# 0.30191f
C2 a_n580_n131# a_460_n131# 0.57434f
C3 w_n846_n560# a_460_n131# 0.87034f
C4 a_n580_n131# a_n460_n339# 0.21491f
C5 w_n846_n560# a_n460_n339# 2.05763f
C6 a_460_n131# VSUBS 0.04483f
C7 a_n580_n131# VSUBS 0.04363f
C8 a_n460_n339# VSUBS 0.12333f
C9 w_n846_n560# VSUBS 6.90762f
.ends

.subckt xm7 a_63_n131# a_n63_n339# w_n449_n560# a_n183_n131# VSUBS
X0 a_63_n131# a_n63_n339# a_n183_n131# w_n449_n560# pfet_03v3 ad=0.3p pd=2.2u as=0.3p ps=2.2u w=0.5u l=0.63u
C0 a_n63_n339# a_63_n131# 0.01741f
C1 w_n449_n560# a_n183_n131# 0.2249f
C2 a_n183_n131# a_63_n131# 0.33209f
C3 w_n449_n560# a_63_n131# 0.48511f
C4 a_n183_n131# a_n63_n339# 0.04027f
C5 w_n449_n560# a_n63_n339# 0.45684f
C6 a_63_n131# VSUBS 0.04546f
C7 a_n183_n131# VSUBS 0.04416f
C8 a_n63_n339# VSUBS 0.05243f
C9 w_n449_n560# VSUBS 3.76898f
.ends

.subckt xmcm_chain_1 a_n1120_n131# a_n1330_n504# a_1000_n131# a_n1000_n339#
X0 a_1000_n131# a_n1000_n339# a_n1120_n131# a_n1330_n504# nfet_03v3 ad=0.3p pd=2.2u as=0.3p ps=2.2u w=0.5u l=10u
C0 a_n1000_n339# a_1000_n131# 0.06176f
C1 a_1000_n131# a_n1120_n131# 1.01551f
C2 a_n1000_n339# a_n1120_n131# 0.42273f
C3 a_1000_n131# a_n1330_n504# 1.43795f
C4 a_n1120_n131# a_n1330_n504# 0.4423f
C5 a_n1000_n339# a_n1330_n504# 4.53847f
.ends

.subckt stdp avdd nvpost nvpre vpost vpre vb_idep vb_itd vb_itp vb_pot vw
Xxm3_0 vw vw vpre vw xm3
Xxm1_0 xm1_0/a_63_n131# avdd avdd avdd vw xm1
Xxmcm_chain_4_0 vw vw xmcm_chain_4_0/a_1000_n131# xmcm_chain_4_0/a_n1000_n339# xmcm_chain_4
Xxm8_0 avdd nvpre avdd avdd vw xm8
Xxmcm_chain_2_0 xmcm_chain_4_0/a_1000_n131# vw xmcm_chain_4_0/a_1000_n131# xmcm_chain_4_0/a_n1000_n339#
+ xmcm_chain_2
Xxm16_0 avdd vb_idep avdd xm9_0/a_63_n131# vw xm16
Xxmcm_chain_0_0 xmcm_chain_4_0/a_1000_n131# vw vw vb_itd xmcm_chain_0
Xxm4_0 vw vw vw vw xm4
Xxm12_0 xm12_0/a_63_n131# vw vpost vw xm12
Xxm2_0 vw nvpost avdd xm1_0/a_63_n131# vw xm2
Xxmcm_1_0 vb_pot vw xm7_0/a_63_n131# vw xmcm_1
Xxm9_0 xm9_0/a_63_n131# vw xm9_0/a_63_n131# vw xm9
Xxmcm_chain_3_0 xmcm_chain_4_0/a_1000_n131# vw xmcm_chain_4_0/a_1000_n131# xmcm_chain_4_0/a_n1000_n339#
+ xmcm_chain_3
Xxm17_0 vb_itp avdd avdd avdd vw xm17
Xxm7_0 xm7_0/a_63_n131# avdd avdd avdd vw xm7
Xxmcm_chain_1_0 xmcm_chain_4_0/a_1000_n131# vw xmcm_chain_4_0/a_1000_n131# xmcm_chain_4_0/a_n1000_n339#
+ xmcm_chain_1
R0 avss.n506 avss.n101 14000
R1 avss.n505 avss.n102 14000
R2 avss.n504 avss.n103 14000
R3 avss.n503 avss.n104 14000
R4 avss.n507 avss.n71 14000
R5 avss.n503 avss.n502 10194.3
R6 avss.n538 avss.n507 4163.87
R7 avss.n575 avss.n574 2283.78
R8 avss.n370 avss.n54 2283.78
R9 avss.n507 avss.n506 2067.12
R10 avss.n506 avss.n505 1226.3
R11 avss.n505 avss.n504 1226.3
R12 avss.n504 avss.n503 1226.3
R13 avss.n574 avss.n36 1051.61
R14 avss.n381 avss.n380 203.708
R15 avss.n538 avss.n94 203.343
R16 avss.n553 avss.n94 203.343
R17 avss.n608 avss.n7 203.343
R18 avss.n667 avss.n7 203.343
R19 avss.n286 avss.n285 198.688
R20 avss.n553 avss.n36 187.267
R21 avss.n198 avss.n154 182.19
R22 avss.n502 avss.n105 182.19
R23 avss.n152 avss.n102 157.803
R24 avss.n380 avss.n323 114.766
R25 avss.n392 avss.n381 114.766
R26 avss.n406 avss.n316 114.766
R27 avss.n417 avss.n316 114.766
R28 avss.n417 avss.n310 114.766
R29 avss.n426 avss.n310 114.766
R30 avss.n426 avss.n295 114.766
R31 avss.n441 avss.n303 114.766
R32 avss.n466 avss.n141 114.766
R33 avss.n482 avss.n128 114.766
R34 avss.n285 avss.n284 114.766
R35 avss.n271 avss.n163 114.766
R36 avss.n176 avss.n175 114.766
R37 avss.n239 avss.n187 114.766
R38 avss.n447 avss.n101 111.897
R39 avss.n465 avss.n144 104.007
R40 avss.n474 avss.n134 104.007
R41 avss.n211 avss.n197 101.855
R42 avss.n272 avss.n161 101.855
R43 avss.n238 avss.n113 100.419
R44 avss.n494 avss.n113 98.268
R45 avss.n493 avss.n116 98.268
R46 avss.n474 avss.n135 94.6816
R47 avss.n245 avss.n104 84.6397
R48 avss.n586 avss.n71 83.2051
R49 avss.n246 avss.n245 74.5977
R50 avss.n440 avss.n141 73.1632
R51 avss.n172 avss.n163 71.0113
R52 avss.n265 avss.n264 71.0113
R53 avss.n501 avss.n107 68.9311
R54 avss.n501 avss.n108 68.9311
R55 avss.n495 avss.n112 68.9311
R56 avss.n114 avss.n112 68.9311
R57 avss.n247 avss.n174 68.9311
R58 avss.n263 avss.n247 68.9311
R59 avss.n273 avss.n160 68.9311
R60 avss.n273 avss.n159 68.9311
R61 avss.n155 avss.n153 68.9311
R62 avss.n283 avss.n155 68.9311
R63 avss.n287 avss.n151 68.9311
R64 avss.n287 avss.n150 68.9311
R65 avss.n458 avss.n457 68.9311
R66 avss.n458 avss.n146 68.9311
R67 avss.n464 avss.n145 68.9311
R68 avss.n145 avss.n143 68.9311
R69 avss.n449 avss.n293 67.7644
R70 avss.n449 avss.n294 67.7644
R71 avss.n407 avss.n322 67.7644
R72 avss.n405 avss.n322 67.7644
R73 avss.n324 avss.n323 67.4249
R74 avss.n406 avss.n392 67.4249
R75 avss.n448 avss.n295 67.4249
R76 avss.n232 avss.n106 66.6949
R77 avss.n118 avss.n106 66.6949
R78 avss.n204 avss.n199 66.6949
R79 avss.n204 avss.n196 66.6949
R80 avss.n481 avss.n127 66.6949
R81 avss.n483 avss.n127 66.6949
R82 avss.n391 avss.n315 66.6949
R83 avss.n391 avss.n382 66.6949
R84 avss.n74 avss.n70 66.6949
R85 avss.n585 avss.n74 66.6949
R86 avss.n552 avss.n96 66.6949
R87 avss.n539 avss.n96 66.6949
R88 avss.n379 avss.n69 66.6949
R89 avss.n379 avss.n325 66.6949
R90 avss.n343 avss.n342 66.6949
R91 avss.n343 avss.n47 66.6949
R92 avss.n20 avss.n16 66.6949
R93 avss.n666 avss.n16 66.6949
R94 avss.n610 avss.n6 66.6949
R95 avss.n668 avss.n6 66.6949
R96 avss.n211 avss.n103 57.383
R97 avss.n161 avss.n103 57.383
R98 avss.n448 avss.n447 47.341
R99 avss.n265 avss.n172 43.7546
R100 avss.n264 avss.n175 43.7546
R101 avss.n441 avss.n440 41.6028
R102 avss.n246 avss.n176 40.1682
R103 avss.n54 avss.n36 31.7197
R104 avss.n324 avss.n71 31.5609
R105 avss.n187 avss.n104 30.1263
R106 avss.n1 avss.n0 30.0192
R107 avss.n482 avss.n102 24.3881
R108 avss.n135 avss.n128 20.0844
R109 avss.n257 avss.n1 19.8198
R110 avss.n258 avss.n257 19.2403
R111 avss.n494 avss.n493 16.498
R112 avss.n116 avss.n105 16.498
R113 avss.n495 avss.n108 15.5561
R114 avss.n114 avss.n107 15.5561
R115 avss.n263 avss.n160 15.5561
R116 avss.n174 avss.n159 15.5561
R117 avss.n283 avss.n151 15.5561
R118 avss.n153 avss.n150 15.5561
R119 avss.n464 avss.n146 15.5561
R120 avss.n457 avss.n143 15.5561
R121 avss.n407 avss.n319 15.5561
R122 avss.n416 avss.n319 15.5561
R123 avss.n416 avss.n320 15.5561
R124 avss.n320 avss.n294 15.5561
R125 avss.n405 avss.n393 15.5561
R126 avss.n393 avss.n317 15.5561
R127 avss.n398 avss.n317 15.5561
R128 avss.n398 avss.n293 15.5561
R129 avss.n210 avss.n199 15.5561
R130 avss.n210 avss.n164 15.5561
R131 avss.n270 avss.n164 15.5561
R132 avss.n270 avss.n165 15.5561
R133 avss.n266 avss.n165 15.5561
R134 avss.n266 avss.n171 15.5561
R135 avss.n178 avss.n171 15.5561
R136 avss.n244 avss.n178 15.5561
R137 avss.n244 avss.n179 15.5561
R138 avss.n240 avss.n179 15.5561
R139 avss.n240 avss.n117 15.5561
R140 avss.n492 avss.n117 15.5561
R141 avss.n492 avss.n118 15.5561
R142 avss.n212 avss.n196 15.5561
R143 avss.n213 avss.n212 15.5561
R144 avss.n213 avss.n162 15.5561
R145 avss.n216 avss.n162 15.5561
R146 avss.n216 avss.n173 15.5561
R147 avss.n222 avss.n173 15.5561
R148 avss.n223 avss.n222 15.5561
R149 avss.n223 avss.n177 15.5561
R150 avss.n188 avss.n177 15.5561
R151 avss.n237 avss.n188 15.5561
R152 avss.n237 avss.n189 15.5561
R153 avss.n189 avss.n115 15.5561
R154 avss.n232 avss.n115 15.5561
R155 avss.n418 avss.n315 15.5561
R156 avss.n418 avss.n311 15.5561
R157 avss.n425 avss.n311 15.5561
R158 avss.n425 avss.n297 15.5561
R159 avss.n446 avss.n297 15.5561
R160 avss.n446 avss.n298 15.5561
R161 avss.n442 avss.n298 15.5561
R162 avss.n442 avss.n140 15.5561
R163 avss.n467 avss.n140 15.5561
R164 avss.n467 avss.n136 15.5561
R165 avss.n473 avss.n136 15.5561
R166 avss.n473 avss.n126 15.5561
R167 avss.n483 avss.n126 15.5561
R168 avss.n382 avss.n318 15.5561
R169 avss.n318 avss.n309 15.5561
R170 avss.n427 avss.n309 15.5561
R171 avss.n428 avss.n427 15.5561
R172 avss.n428 avss.n296 15.5561
R173 avss.n304 avss.n296 15.5561
R174 avss.n439 avss.n304 15.5561
R175 avss.n439 avss.n305 15.5561
R176 avss.n305 avss.n142 15.5561
R177 avss.n142 avss.n133 15.5561
R178 avss.n475 avss.n133 15.5561
R179 avss.n475 avss.n129 15.5561
R180 avss.n481 avss.n129 15.5561
R181 avss.n552 avss.n97 15.5561
R182 avss.n544 avss.n93 15.5561
R183 avss.n556 avss.n555 15.5561
R184 avss.n562 avss.n561 15.5561
R185 avss.n566 avss.n565 15.5561
R186 avss.n572 avss.n87 15.5561
R187 avss.n585 avss.n73 15.5561
R188 avss.n539 avss.n100 15.5561
R189 avss.n536 avss.n509 15.5561
R190 avss.n532 avss.n531 15.5561
R191 avss.n528 avss.n527 15.5561
R192 avss.n524 avss.n523 15.5561
R193 avss.n520 avss.n80 15.5561
R194 avss.n577 avss.n70 15.5561
R195 avss.n349 avss.n348 15.5561
R196 avss.n352 avss.n351 15.5561
R197 avss.n359 avss.n358 15.5561
R198 avss.n361 avss.n335 15.5561
R199 avss.n368 avss.n332 15.5561
R200 avss.n372 avss.n72 15.5561
R201 avss.n325 avss.n72 15.5561
R202 avss.n606 avss.n48 15.5561
R203 avss.n602 avss.n601 15.5561
R204 avss.n599 avss.n55 15.5561
R205 avss.n595 avss.n594 15.5561
R206 avss.n592 avss.n62 15.5561
R207 avss.n588 avss.n587 15.5561
R208 avss.n587 avss.n69 15.5561
R209 avss.n22 avss.n21 15.5561
R210 avss.n38 avss.n25 15.5561
R211 avss.n27 avss.n26 15.5561
R212 avss.n41 avss.n30 15.5561
R213 avss.n32 avss.n31 15.5561
R214 avss.n44 avss.n35 15.5561
R215 avss.n666 avss.n17 15.5561
R216 avss.n635 avss.n634 15.5561
R217 avss.n637 avss.n636 15.5561
R218 avss.n641 avss.n640 15.5561
R219 avss.n643 avss.n642 15.5561
R220 avss.n647 avss.n646 15.5561
R221 avss.n668 avss.n5 15.5561
R222 vw avss.n1 14.644
R223 avss.n239 avss.n238 14.3461
R224 avss.n198 avss.n197 12.9116
R225 avss.n272 avss.n271 12.9116
R226 avss.n466 avss.n465 10.7597
R227 avss.n144 avss.n134 10.7597
R228 avss.n586 avss.n36 10.0424
R229 avss.n488 avss.n487 6.52425
R230 avss.n608 avss.n36 5.6489
R231 avss.n589 avss.n588 5.2005
R232 avss.n590 avss.n62 5.2005
R233 avss.n592 avss.n591 5.2005
R234 avss.n594 avss.n60 5.2005
R235 avss.n596 avss.n595 5.2005
R236 avss.n597 avss.n55 5.2005
R237 avss.n599 avss.n598 5.2005
R238 avss.n601 avss.n53 5.2005
R239 avss.n373 avss.n372 5.2005
R240 avss.n332 avss.n330 5.2005
R241 avss.n368 avss.n367 5.2005
R242 avss.n336 avss.n335 5.2005
R243 avss.n362 avss.n361 5.2005
R244 avss.n360 avss.n359 5.2005
R245 avss.n358 avss.n357 5.2005
R246 avss.n351 avss.n338 5.2005
R247 avss.n578 avss.n577 5.2005
R248 avss.n80 avss.n79 5.2005
R249 avss.n521 avss.n520 5.2005
R250 avss.n523 avss.n522 5.2005
R251 avss.n525 avss.n524 5.2005
R252 avss.n527 avss.n526 5.2005
R253 avss.n529 avss.n528 5.2005
R254 avss.n531 avss.n530 5.2005
R255 avss.n75 avss.n73 5.2005
R256 avss.n572 avss.n571 5.2005
R257 avss.n88 avss.n87 5.2005
R258 avss.n567 avss.n566 5.2005
R259 avss.n565 avss.n564 5.2005
R260 avss.n563 avss.n562 5.2005
R261 avss.n561 avss.n90 5.2005
R262 avss.n557 avss.n556 5.2005
R263 avss.n327 avss.n69 5.2005
R264 avss.n324 avss.n69 5.2005
R265 avss.n587 avss.n67 5.2005
R266 avss.n587 avss.n586 5.2005
R267 avss.n375 avss.n325 5.2005
R268 avss.n325 avss.n324 5.2005
R269 avss.n374 avss.n72 5.2005
R270 avss.n586 avss.n72 5.2005
R271 avss.n481 avss.n480 5.2005
R272 avss.n482 avss.n481 5.2005
R273 avss.n130 avss.n129 5.2005
R274 avss.n129 avss.n128 5.2005
R275 avss.n476 avss.n475 5.2005
R276 avss.n475 avss.n474 5.2005
R277 avss.n133 avss.n132 5.2005
R278 avss.n144 avss.n133 5.2005
R279 avss.n436 avss.n142 5.2005
R280 avss.n466 avss.n142 5.2005
R281 avss.n437 avss.n305 5.2005
R282 avss.n305 avss.n141 5.2005
R283 avss.n439 avss.n438 5.2005
R284 avss.n441 avss.n439 5.2005
R285 avss.n306 avss.n304 5.2005
R286 avss.n304 avss.n303 5.2005
R287 avss.n430 avss.n296 5.2005
R288 avss.n447 avss.n296 5.2005
R289 avss.n429 avss.n428 5.2005
R290 avss.n428 avss.n295 5.2005
R291 avss.n427 avss.n308 5.2005
R292 avss.n427 avss.n426 5.2005
R293 avss.n386 avss.n309 5.2005
R294 avss.n310 avss.n309 5.2005
R295 avss.n387 avss.n318 5.2005
R296 avss.n417 avss.n318 5.2005
R297 avss.n388 avss.n382 5.2005
R298 avss.n382 avss.n316 5.2005
R299 avss.n484 avss.n483 5.2005
R300 avss.n483 avss.n482 5.2005
R301 avss.n126 avss.n125 5.2005
R302 avss.n128 avss.n126 5.2005
R303 avss.n473 avss.n472 5.2005
R304 avss.n474 avss.n473 5.2005
R305 avss.n137 avss.n136 5.2005
R306 avss.n144 avss.n136 5.2005
R307 avss.n468 avss.n467 5.2005
R308 avss.n467 avss.n466 5.2005
R309 avss.n140 avss.n139 5.2005
R310 avss.n141 avss.n140 5.2005
R311 avss.n443 avss.n442 5.2005
R312 avss.n442 avss.n441 5.2005
R313 avss.n444 avss.n298 5.2005
R314 avss.n303 avss.n298 5.2005
R315 avss.n446 avss.n445 5.2005
R316 avss.n447 avss.n446 5.2005
R317 avss.n299 avss.n297 5.2005
R318 avss.n297 avss.n295 5.2005
R319 avss.n425 avss.n424 5.2005
R320 avss.n426 avss.n425 5.2005
R321 avss.n312 avss.n311 5.2005
R322 avss.n311 avss.n310 5.2005
R323 avss.n419 avss.n418 5.2005
R324 avss.n418 avss.n417 5.2005
R325 avss.n315 avss.n314 5.2005
R326 avss.n316 avss.n315 5.2005
R327 avss.n233 avss.n232 5.2005
R328 avss.n232 avss.n105 5.2005
R329 avss.n234 avss.n115 5.2005
R330 avss.n493 avss.n115 5.2005
R331 avss.n235 avss.n189 5.2005
R332 avss.n189 avss.n113 5.2005
R333 avss.n237 avss.n236 5.2005
R334 avss.n239 avss.n237 5.2005
R335 avss.n190 avss.n188 5.2005
R336 avss.n188 avss.n187 5.2005
R337 avss.n225 avss.n177 5.2005
R338 avss.n245 avss.n177 5.2005
R339 avss.n224 avss.n223 5.2005
R340 avss.n223 avss.n176 5.2005
R341 avss.n222 avss.n221 5.2005
R342 avss.n222 avss.n175 5.2005
R343 avss.n192 avss.n173 5.2005
R344 avss.n265 avss.n173 5.2005
R345 avss.n217 avss.n216 5.2005
R346 avss.n216 avss.n163 5.2005
R347 avss.n215 avss.n162 5.2005
R348 avss.n271 avss.n162 5.2005
R349 avss.n214 avss.n213 5.2005
R350 avss.n213 avss.n161 5.2005
R351 avss.n212 avss.n194 5.2005
R352 avss.n212 avss.n211 5.2005
R353 avss.n202 avss.n196 5.2005
R354 avss.n198 avss.n196 5.2005
R355 avss.n490 avss.n118 5.2005
R356 avss.n118 avss.n105 5.2005
R357 avss.n492 avss.n491 5.2005
R358 avss.n493 avss.n492 5.2005
R359 avss.n119 avss.n117 5.2005
R360 avss.n117 avss.n113 5.2005
R361 avss.n241 avss.n240 5.2005
R362 avss.n240 avss.n239 5.2005
R363 avss.n242 avss.n179 5.2005
R364 avss.n187 avss.n179 5.2005
R365 avss.n244 avss.n243 5.2005
R366 avss.n245 avss.n244 5.2005
R367 avss.n180 avss.n178 5.2005
R368 avss.n178 avss.n176 5.2005
R369 avss.n171 avss.n170 5.2005
R370 avss.n175 avss.n171 5.2005
R371 avss.n267 avss.n266 5.2005
R372 avss.n266 avss.n265 5.2005
R373 avss.n268 avss.n165 5.2005
R374 avss.n165 avss.n163 5.2005
R375 avss.n270 avss.n269 5.2005
R376 avss.n271 avss.n270 5.2005
R377 avss.n166 avss.n164 5.2005
R378 avss.n164 avss.n161 5.2005
R379 avss.n210 avss.n209 5.2005
R380 avss.n211 avss.n210 5.2005
R381 avss.n200 avss.n199 5.2005
R382 avss.n199 avss.n198 5.2005
R383 avss.n579 avss.n70 5.2005
R384 avss.n586 avss.n70 5.2005
R385 avss.n585 avss.n584 5.2005
R386 avss.n586 avss.n585 5.2005
R387 avss.n397 avss.n293 5.2005
R388 avss.n426 avss.n293 5.2005
R389 avss.n399 avss.n398 5.2005
R390 avss.n398 avss.n310 5.2005
R391 avss.n396 avss.n317 5.2005
R392 avss.n417 avss.n317 5.2005
R393 avss.n403 avss.n393 5.2005
R394 avss.n393 avss.n316 5.2005
R395 avss.n405 avss.n404 5.2005
R396 avss.n406 avss.n405 5.2005
R397 avss.n413 avss.n294 5.2005
R398 avss.n426 avss.n294 5.2005
R399 avss.n414 avss.n320 5.2005
R400 avss.n320 avss.n310 5.2005
R401 avss.n416 avss.n415 5.2005
R402 avss.n417 avss.n416 5.2005
R403 avss.n321 avss.n319 5.2005
R404 avss.n319 avss.n316 5.2005
R405 avss.n408 avss.n407 5.2005
R406 avss.n407 avss.n406 5.2005
R407 avss.n457 avss.n456 5.2005
R408 avss.n457 avss.n134 5.2005
R409 avss.n455 avss.n143 5.2005
R410 avss.n465 avss.n143 5.2005
R411 avss.n462 avss.n146 5.2005
R412 avss.n146 avss.n134 5.2005
R413 avss.n464 avss.n463 5.2005
R414 avss.n465 avss.n464 5.2005
R415 avss.n277 avss.n153 5.2005
R416 avss.n284 avss.n153 5.2005
R417 avss.n276 avss.n150 5.2005
R418 avss.n285 avss.n150 5.2005
R419 avss.n283 avss.n282 5.2005
R420 avss.n284 avss.n283 5.2005
R421 avss.n156 avss.n151 5.2005
R422 avss.n285 avss.n151 5.2005
R423 avss.n255 avss.n174 5.2005
R424 avss.n264 avss.n174 5.2005
R425 avss.n254 avss.n159 5.2005
R426 avss.n172 avss.n159 5.2005
R427 avss.n263 avss.n262 5.2005
R428 avss.n264 avss.n263 5.2005
R429 avss.n248 avss.n160 5.2005
R430 avss.n172 avss.n160 5.2005
R431 avss.n249 avss.n107 5.2005
R432 avss.n116 avss.n107 5.2005
R433 avss.n250 avss.n114 5.2005
R434 avss.n494 avss.n114 5.2005
R435 avss.n497 avss.n108 5.2005
R436 avss.n116 avss.n108 5.2005
R437 avss.n496 avss.n495 5.2005
R438 avss.n495 avss.n494 5.2005
R439 avss.n603 avss.n602 5.2005
R440 avss.n604 avss.n48 5.2005
R441 avss.n606 avss.n605 5.2005
R442 avss.n49 avss.n47 5.2005
R443 avss.n353 avss.n352 5.2005
R444 avss.n350 avss.n349 5.2005
R445 avss.n348 avss.n347 5.2005
R446 avss.n342 avss.n340 5.2005
R447 avss.n533 avss.n532 5.2005
R448 avss.n534 avss.n509 5.2005
R449 avss.n536 avss.n535 5.2005
R450 avss.n100 avss.n99 5.2005
R451 avss.n540 avss.n539 5.2005
R452 avss.n539 avss.n538 5.2005
R453 avss.n555 avss.n92 5.2005
R454 avss.n546 avss.n93 5.2005
R455 avss.n545 avss.n544 5.2005
R456 avss.n550 avss.n97 5.2005
R457 avss.n552 avss.n551 5.2005
R458 avss.n553 avss.n552 5.2005
R459 avss.n611 avss.n610 5.2005
R460 avss.n612 avss.n35 5.2005
R461 avss.n44 avss.n33 5.2005
R462 avss.n616 avss.n32 5.2005
R463 avss.n617 avss.n31 5.2005
R464 avss.n618 avss.n30 5.2005
R465 avss.n41 avss.n28 5.2005
R466 avss.n622 avss.n27 5.2005
R467 avss.n623 avss.n26 5.2005
R468 avss.n624 avss.n25 5.2005
R469 avss.n38 avss.n23 5.2005
R470 avss.n628 avss.n22 5.2005
R471 avss.n629 avss.n21 5.2005
R472 avss.n630 avss.n20 5.2005
R473 avss.n669 avss.n668 5.2005
R474 avss.n668 avss.n667 5.2005
R475 avss.n5 avss.n4 5.2005
R476 avss.n648 avss.n647 5.2005
R477 avss.n649 avss.n646 5.2005
R478 avss.n644 avss.n643 5.2005
R479 avss.n653 avss.n642 5.2005
R480 avss.n654 avss.n641 5.2005
R481 avss.n655 avss.n640 5.2005
R482 avss.n638 avss.n637 5.2005
R483 avss.n659 avss.n636 5.2005
R484 avss.n660 avss.n635 5.2005
R485 avss.n661 avss.n634 5.2005
R486 avss.n18 avss.n17 5.2005
R487 avss.n666 avss.n665 5.2005
R488 avss.n667 avss.n666 5.2005
R489 avss.n500 avss.n109 5.20011
R490 avss.n252 avss.n251 5.20011
R491 avss.n274 avss.n158 5.20011
R492 avss.n288 avss.n149 5.20011
R493 avss.n459 avss.n290 5.20011
R494 avss.n454 avss.n453 5.20011
R495 avss.n279 avss.n278 5.19229
R496 avss.n395 avss.n394 5.19017
R497 avss.n450 avss.n292 5.18235
R498 avss.n479 avss.n123 5.17941
R499 avss.n390 avss.n313 5.17941
R500 avss.n390 avss.n389 5.17941
R501 avss.n581 avss.n580 5.17941
R502 avss.n205 avss.n203 5.17941
R503 avss.n206 avss.n205 5.17941
R504 avss.n543 avss.n542 5.17941
R505 avss.n542 avss.n541 5.17941
R506 avss.n378 avss.n328 5.17941
R507 avss.n345 avss.n344 5.17941
R508 avss.n344 avss.n341 5.17941
R509 avss.n664 avss.n632 5.17941
R510 avss.n632 avss.n631 5.17941
R511 avss.n34 avss.n2 5.17159
R512 avss.n487 avss.n486 5.15985
R513 avss.n377 avss.n122 5.15985
R514 avss.n672 avss.n671 5.15985
R515 avss.n258 avss.n256 5.07
R516 avss.n451 avss.n450 4.96517
R517 avss.n394 avss.n77 4.96517
R518 avss.n582 avss.n581 4.95441
R519 avss.n253 avss.n252 4.95441
R520 avss.n260 avss.n259 4.95441
R521 avss.n275 avss.n274 4.95441
R522 avss.n280 avss.n279 4.95441
R523 avss.n289 avss.n288 4.95441
R524 avss.n460 avss.n459 4.95441
R525 avss.n453 avss.n452 4.95441
R526 avss.n499 avss.n498 4.7462
R527 avss.n486 avss.n485 4.7255
R528 avss.n231 avss.n110 4.7255
R529 avss.n489 avss.n488 4.7255
R530 avss.n377 avss.n376 4.7255
R531 avss.n671 avss.n670 4.7255
R532 avss.n420 avss.n419 4.5005
R533 avss.n421 avss.n312 4.5005
R534 avss.n424 avss.n423 4.5005
R535 avss.n422 avss.n299 4.5005
R536 avss.n445 avss.n300 4.5005
R537 avss.n444 avss.n301 4.5005
R538 avss.n443 avss.n302 4.5005
R539 avss.n139 avss.n138 4.5005
R540 avss.n469 avss.n468 4.5005
R541 avss.n470 avss.n137 4.5005
R542 avss.n472 avss.n471 4.5005
R543 avss.n125 avss.n124 4.5005
R544 avss.n485 avss.n484 4.5005
R545 avss.n314 avss.n313 4.5005
R546 avss.n387 avss.n383 4.5005
R547 avss.n386 avss.n385 4.5005
R548 avss.n384 avss.n308 4.5005
R549 avss.n429 avss.n307 4.5005
R550 avss.n431 avss.n430 4.5005
R551 avss.n432 avss.n306 4.5005
R552 avss.n438 avss.n433 4.5005
R553 avss.n437 avss.n434 4.5005
R554 avss.n436 avss.n435 4.5005
R555 avss.n132 avss.n131 4.5005
R556 avss.n477 avss.n476 4.5005
R557 avss.n478 avss.n130 4.5005
R558 avss.n480 avss.n479 4.5005
R559 avss.n389 avss.n388 4.5005
R560 avss.n403 avss.n402 4.5005
R561 avss.n401 avss.n396 4.5005
R562 avss.n400 avss.n399 4.5005
R563 avss.n397 avss.n292 4.5005
R564 avss.n404 avss.n395 4.5005
R565 avss.n201 avss.n194 4.5005
R566 avss.n214 avss.n195 4.5005
R567 avss.n215 avss.n193 4.5005
R568 avss.n218 avss.n217 4.5005
R569 avss.n219 avss.n192 4.5005
R570 avss.n221 avss.n220 4.5005
R571 avss.n224 avss.n191 4.5005
R572 avss.n226 avss.n225 4.5005
R573 avss.n227 avss.n190 4.5005
R574 avss.n236 avss.n228 4.5005
R575 avss.n235 avss.n229 4.5005
R576 avss.n234 avss.n230 4.5005
R577 avss.n233 avss.n231 4.5005
R578 avss.n203 avss.n202 4.5005
R579 avss.n209 avss.n208 4.5005
R580 avss.n207 avss.n166 4.5005
R581 avss.n269 avss.n167 4.5005
R582 avss.n268 avss.n168 4.5005
R583 avss.n267 avss.n169 4.5005
R584 avss.n181 avss.n170 4.5005
R585 avss.n182 avss.n180 4.5005
R586 avss.n243 avss.n183 4.5005
R587 avss.n242 avss.n184 4.5005
R588 avss.n241 avss.n186 4.5005
R589 avss.n185 avss.n119 4.5005
R590 avss.n491 avss.n120 4.5005
R591 avss.n490 avss.n489 4.5005
R592 avss.n206 avss.n200 4.5005
R593 avss.n249 avss.n109 4.5005
R594 avss.n251 avss.n250 4.5005
R595 avss.n256 avss.n255 4.5005
R596 avss.n254 avss.n158 4.5005
R597 avss.n278 avss.n277 4.5005
R598 avss.n276 avss.n149 4.5005
R599 avss.n456 avss.n290 4.5005
R600 avss.n455 avss.n454 4.5005
R601 avss.n462 avss.n461 4.5005
R602 avss.n463 avss.n147 4.5005
R603 avss.n282 avss.n281 4.5005
R604 avss.n156 avss.n148 4.5005
R605 avss.n262 avss.n261 4.5005
R606 avss.n248 avss.n157 4.5005
R607 avss.n498 avss.n497 4.5005
R608 avss.n496 avss.n111 4.5005
R609 avss.n410 avss.n321 4.5005
R610 avss.n415 avss.n411 4.5005
R611 avss.n414 avss.n412 4.5005
R612 avss.n413 avss.n291 4.5005
R613 avss.n409 avss.n408 4.5005
R614 avss.n550 avss.n549 4.5005
R615 avss.n548 avss.n545 4.5005
R616 avss.n547 avss.n546 4.5005
R617 avss.n92 avss.n91 4.5005
R618 avss.n558 avss.n557 4.5005
R619 avss.n559 avss.n90 4.5005
R620 avss.n563 avss.n560 4.5005
R621 avss.n564 avss.n89 4.5005
R622 avss.n568 avss.n567 4.5005
R623 avss.n569 avss.n88 4.5005
R624 avss.n571 avss.n570 4.5005
R625 avss.n76 avss.n75 4.5005
R626 avss.n584 avss.n583 4.5005
R627 avss.n551 avss.n543 4.5005
R628 avss.n99 avss.n98 4.5005
R629 avss.n535 avss.n510 4.5005
R630 avss.n534 avss.n511 4.5005
R631 avss.n533 avss.n512 4.5005
R632 avss.n530 avss.n513 4.5005
R633 avss.n529 avss.n514 4.5005
R634 avss.n526 avss.n515 4.5005
R635 avss.n525 avss.n516 4.5005
R636 avss.n522 avss.n517 4.5005
R637 avss.n521 avss.n519 4.5005
R638 avss.n518 avss.n79 4.5005
R639 avss.n578 avss.n78 4.5005
R640 avss.n580 avss.n579 4.5005
R641 avss.n541 avss.n540 4.5005
R642 avss.n347 avss.n346 4.5005
R643 avss.n350 avss.n339 4.5005
R644 avss.n354 avss.n353 4.5005
R645 avss.n355 avss.n338 4.5005
R646 avss.n357 avss.n356 4.5005
R647 avss.n360 avss.n337 4.5005
R648 avss.n363 avss.n362 4.5005
R649 avss.n364 avss.n336 4.5005
R650 avss.n367 avss.n366 4.5005
R651 avss.n365 avss.n330 4.5005
R652 avss.n373 avss.n331 4.5005
R653 avss.n374 avss.n329 4.5005
R654 avss.n376 avss.n375 4.5005
R655 avss.n345 avss.n340 4.5005
R656 avss.n605 avss.n50 4.5005
R657 avss.n604 avss.n51 4.5005
R658 avss.n603 avss.n52 4.5005
R659 avss.n56 avss.n53 4.5005
R660 avss.n598 avss.n57 4.5005
R661 avss.n597 avss.n58 4.5005
R662 avss.n596 avss.n59 4.5005
R663 avss.n63 avss.n60 4.5005
R664 avss.n591 avss.n64 4.5005
R665 avss.n590 avss.n65 4.5005
R666 avss.n589 avss.n66 4.5005
R667 avss.n326 avss.n67 4.5005
R668 avss.n328 avss.n327 4.5005
R669 avss.n341 avss.n49 4.5005
R670 avss.n663 avss.n18 4.5005
R671 avss.n662 avss.n661 4.5005
R672 avss.n660 avss.n633 4.5005
R673 avss.n659 avss.n658 4.5005
R674 avss.n657 avss.n638 4.5005
R675 avss.n656 avss.n655 4.5005
R676 avss.n654 avss.n639 4.5005
R677 avss.n653 avss.n652 4.5005
R678 avss.n651 avss.n644 4.5005
R679 avss.n650 avss.n649 4.5005
R680 avss.n648 avss.n645 4.5005
R681 avss.n4 avss.n3 4.5005
R682 avss.n670 avss.n669 4.5005
R683 avss.n665 avss.n664 4.5005
R684 avss.n629 avss.n19 4.5005
R685 avss.n628 avss.n627 4.5005
R686 avss.n626 avss.n23 4.5005
R687 avss.n625 avss.n624 4.5005
R688 avss.n623 avss.n24 4.5005
R689 avss.n622 avss.n621 4.5005
R690 avss.n620 avss.n28 4.5005
R691 avss.n619 avss.n618 4.5005
R692 avss.n617 avss.n29 4.5005
R693 avss.n616 avss.n615 4.5005
R694 avss.n614 avss.n33 4.5005
R695 avss.n613 avss.n612 4.5005
R696 avss.n611 avss.n34 4.5005
R697 avss.n631 avss.n630 4.5005
R698 avss.n284 avss.n154 3.5869
R699 avss.n544 avss.n95 3.11744
R700 avss.n555 avss.n554 3.11744
R701 avss.n561 avss.n84 3.11744
R702 avss.n565 avss.n85 3.11744
R703 avss.n87 avss.n86 3.11744
R704 avss.n573 avss.n73 3.11744
R705 avss.n537 avss.n536 3.11744
R706 avss.n532 avss.n508 3.11744
R707 avss.n528 avss.n81 3.11744
R708 avss.n524 avss.n82 3.11744
R709 avss.n520 avss.n83 3.11744
R710 avss.n577 avss.n576 3.11744
R711 avss.n348 avss.n8 3.11744
R712 avss.n352 avss.n9 3.11744
R713 avss.n358 avss.n333 3.11744
R714 avss.n361 avss.n334 3.11744
R715 avss.n369 avss.n368 3.11744
R716 avss.n372 avss.n371 3.11744
R717 avss.n607 avss.n606 3.11744
R718 avss.n602 avss.n46 3.11744
R719 avss.n600 avss.n599 3.11744
R720 avss.n595 avss.n61 3.11744
R721 avss.n593 avss.n592 3.11744
R722 avss.n588 avss.n68 3.11744
R723 avss.n68 avss.n62 3.11744
R724 avss.n594 avss.n593 3.11744
R725 avss.n61 avss.n55 3.11744
R726 avss.n601 avss.n600 3.11744
R727 avss.n371 avss.n332 3.11744
R728 avss.n369 avss.n335 3.11744
R729 avss.n359 avss.n334 3.11744
R730 avss.n351 avss.n333 3.11744
R731 avss.n576 avss.n80 3.11744
R732 avss.n523 avss.n83 3.11744
R733 avss.n527 avss.n82 3.11744
R734 avss.n531 avss.n81 3.11744
R735 avss.n573 avss.n572 3.11744
R736 avss.n566 avss.n86 3.11744
R737 avss.n562 avss.n85 3.11744
R738 avss.n556 avss.n84 3.11744
R739 avss.n48 avss.n46 3.11744
R740 avss.n607 avss.n47 3.11744
R741 avss.n349 avss.n9 3.11744
R742 avss.n342 avss.n8 3.11744
R743 avss.n509 avss.n508 3.11744
R744 avss.n537 avss.n100 3.11744
R745 avss.n554 avss.n93 3.11744
R746 avss.n97 avss.n95 3.11744
R747 avss.n37 avss.n20 3.11744
R748 avss.n39 avss.n22 3.11744
R749 avss.n40 avss.n25 3.11744
R750 avss.n42 avss.n27 3.11744
R751 avss.n43 avss.n30 3.11744
R752 avss.n45 avss.n32 3.11744
R753 avss.n609 avss.n35 3.11744
R754 avss.n610 avss.n609 3.11744
R755 avss.n45 avss.n44 3.11744
R756 avss.n43 avss.n31 3.11744
R757 avss.n42 avss.n41 3.11744
R758 avss.n40 avss.n26 3.11744
R759 avss.n39 avss.n38 3.11744
R760 avss.n37 avss.n21 3.11744
R761 avss.n634 avss.n15 3.11744
R762 avss.n636 avss.n14 3.11744
R763 avss.n640 avss.n13 3.11744
R764 avss.n642 avss.n12 3.11744
R765 avss.n646 avss.n11 3.11744
R766 avss.n10 avss.n5 3.11744
R767 avss.n647 avss.n10 3.11744
R768 avss.n643 avss.n11 3.11744
R769 avss.n641 avss.n12 3.11744
R770 avss.n637 avss.n13 3.11744
R771 avss.n635 avss.n14 3.11744
R772 avss.n17 avss.n15 3.11744
R773 avss.n303 avss.n101 2.86962
R774 vw avss.n672 1.45515
R775 avss.n286 avss.n152 1.43506
R776 avss.n487 avss.n122 1.3649
R777 avss.n68 avss.n54 1.04278
R778 avss.n593 avss.n54 1.04278
R779 avss.n61 avss.n54 1.04278
R780 avss.n600 avss.n54 1.04278
R781 avss.n371 avss.n370 1.04278
R782 avss.n370 avss.n369 1.04278
R783 avss.n370 avss.n334 1.04278
R784 avss.n370 avss.n333 1.04278
R785 avss.n576 avss.n575 1.04278
R786 avss.n575 avss.n83 1.04278
R787 avss.n575 avss.n82 1.04278
R788 avss.n575 avss.n81 1.04278
R789 avss.n574 avss.n573 1.04278
R790 avss.n574 avss.n86 1.04278
R791 avss.n574 avss.n85 1.04278
R792 avss.n574 avss.n84 1.04278
R793 avss.n608 avss.n46 1.04278
R794 avss.n608 avss.n607 1.04278
R795 avss.n667 avss.n9 1.04278
R796 avss.n667 avss.n8 1.04278
R797 avss.n538 avss.n508 1.04278
R798 avss.n538 avss.n537 1.04278
R799 avss.n554 avss.n553 1.04278
R800 avss.n553 avss.n95 1.04278
R801 avss.n609 avss.n608 1.04278
R802 avss.n608 avss.n45 1.04278
R803 avss.n608 avss.n43 1.04278
R804 avss.n608 avss.n42 1.04278
R805 avss.n608 avss.n40 1.04278
R806 avss.n608 avss.n39 1.04278
R807 avss.n608 avss.n37 1.04278
R808 avss.n667 avss.n10 1.04278
R809 avss.n667 avss.n11 1.04278
R810 avss.n667 avss.n12 1.04278
R811 avss.n667 avss.n13 1.04278
R812 avss.n667 avss.n14 1.04278
R813 avss.n667 avss.n15 1.04278
R814 avss.n672 vw 0.7592
R815 avss.n379 avss.n378 0.743357
R816 avss.n380 avss.n379 0.743357
R817 avss.n391 avss.n390 0.743357
R818 avss.n392 avss.n391 0.743357
R819 avss.n127 avss.n123 0.743357
R820 avss.n152 avss.n127 0.743357
R821 avss.n205 avss.n204 0.743357
R822 avss.n204 avss.n154 0.743357
R823 avss.n121 avss.n106 0.743357
R824 avss.n502 avss.n106 0.743357
R825 avss.n581 avss.n74 0.743357
R826 avss.n323 avss.n74 0.743357
R827 avss.n394 avss.n322 0.743357
R828 avss.n381 avss.n322 0.743357
R829 avss.n450 avss.n449 0.743357
R830 avss.n449 avss.n448 0.743357
R831 avss.n453 avss.n145 0.743357
R832 avss.n440 avss.n145 0.743357
R833 avss.n459 avss.n458 0.743357
R834 avss.n458 avss.n135 0.743357
R835 avss.n288 avss.n287 0.743357
R836 avss.n287 avss.n286 0.743357
R837 avss.n279 avss.n155 0.743357
R838 avss.n197 avss.n155 0.743357
R839 avss.n274 avss.n273 0.743357
R840 avss.n273 avss.n272 0.743357
R841 avss.n259 avss.n247 0.743357
R842 avss.n247 avss.n246 0.743357
R843 avss.n252 avss.n112 0.743357
R844 avss.n238 avss.n112 0.743357
R845 avss.n501 avss.n500 0.743357
R846 avss.n502 avss.n501 0.743357
R847 avss.n344 avss.n343 0.743357
R848 avss.n343 avss.n7 0.743357
R849 avss.n542 avss.n96 0.743357
R850 avss.n96 avss.n94 0.743357
R851 avss.n632 avss.n16 0.743357
R852 avss.n16 avss.n7 0.743357
R853 avss.n6 avss.n2 0.743357
R854 avss.n7 avss.n6 0.743357
R855 avss.n122 vw 0.6026
R856 avss.n486 avss.n123 0.454413
R857 avss.n488 avss.n121 0.454413
R858 avss.n121 avss.n110 0.454413
R859 avss.n500 avss.n499 0.454413
R860 avss.n378 avss.n377 0.454413
R861 avss.n671 avss.n2 0.454413
R862 avss.n499 avss.n110 0.427022
R863 avss.n460 avss.n289 0.4073
R864 avss.n280 avss.n275 0.4073
R865 avss.n260 avss.n253 0.4073
R866 avss.n452 avss.n451 0.402841
R867 avss.n582 avss.n77 0.402841
R868 avss.n452 avss.n147 0.2462
R869 avss.n461 avss.n460 0.2462
R870 avss.n289 avss.n148 0.2462
R871 avss.n281 avss.n280 0.2462
R872 avss.n275 avss.n157 0.2462
R873 avss.n261 avss.n260 0.2462
R874 avss.n253 avss.n111 0.2462
R875 avss.n583 avss.n582 0.2255
R876 avss.n409 avss.n77 0.203203
R877 avss.n451 avss.n291 0.203203
R878 avss.n419 avss.n314 0.1445
R879 avss.n419 avss.n312 0.1445
R880 avss.n424 avss.n312 0.1445
R881 avss.n424 avss.n299 0.1445
R882 avss.n445 avss.n299 0.1445
R883 avss.n445 avss.n444 0.1445
R884 avss.n444 avss.n443 0.1445
R885 avss.n443 avss.n139 0.1445
R886 avss.n468 avss.n139 0.1445
R887 avss.n468 avss.n137 0.1445
R888 avss.n472 avss.n137 0.1445
R889 avss.n472 avss.n125 0.1445
R890 avss.n484 avss.n125 0.1445
R891 avss.n420 avss.n313 0.1445
R892 avss.n421 avss.n420 0.1445
R893 avss.n423 avss.n421 0.1445
R894 avss.n423 avss.n422 0.1445
R895 avss.n422 avss.n300 0.1445
R896 avss.n301 avss.n300 0.1445
R897 avss.n302 avss.n301 0.1445
R898 avss.n302 avss.n138 0.1445
R899 avss.n469 avss.n138 0.1445
R900 avss.n470 avss.n469 0.1445
R901 avss.n471 avss.n470 0.1445
R902 avss.n471 avss.n124 0.1445
R903 avss.n485 avss.n124 0.1445
R904 avss.n389 avss.n383 0.1445
R905 avss.n385 avss.n383 0.1445
R906 avss.n385 avss.n384 0.1445
R907 avss.n384 avss.n307 0.1445
R908 avss.n431 avss.n307 0.1445
R909 avss.n432 avss.n431 0.1445
R910 avss.n433 avss.n432 0.1445
R911 avss.n434 avss.n433 0.1445
R912 avss.n435 avss.n434 0.1445
R913 avss.n435 avss.n131 0.1445
R914 avss.n477 avss.n131 0.1445
R915 avss.n478 avss.n477 0.1445
R916 avss.n479 avss.n478 0.1445
R917 avss.n388 avss.n387 0.1445
R918 avss.n387 avss.n386 0.1445
R919 avss.n386 avss.n308 0.1445
R920 avss.n429 avss.n308 0.1445
R921 avss.n430 avss.n429 0.1445
R922 avss.n430 avss.n306 0.1445
R923 avss.n438 avss.n306 0.1445
R924 avss.n438 avss.n437 0.1445
R925 avss.n437 avss.n436 0.1445
R926 avss.n436 avss.n132 0.1445
R927 avss.n476 avss.n132 0.1445
R928 avss.n476 avss.n130 0.1445
R929 avss.n480 avss.n130 0.1445
R930 avss.n551 avss.n550 0.1445
R931 avss.n550 avss.n545 0.1445
R932 avss.n546 avss.n545 0.1445
R933 avss.n546 avss.n92 0.1445
R934 avss.n557 avss.n92 0.1445
R935 avss.n557 avss.n90 0.1445
R936 avss.n563 avss.n90 0.1445
R937 avss.n564 avss.n563 0.1445
R938 avss.n567 avss.n564 0.1445
R939 avss.n567 avss.n88 0.1445
R940 avss.n571 avss.n88 0.1445
R941 avss.n571 avss.n75 0.1445
R942 avss.n584 avss.n75 0.1445
R943 avss.n408 avss.n321 0.1445
R944 avss.n415 avss.n321 0.1445
R945 avss.n415 avss.n414 0.1445
R946 avss.n414 avss.n413 0.1445
R947 avss.n404 avss.n403 0.1445
R948 avss.n403 avss.n396 0.1445
R949 avss.n399 avss.n396 0.1445
R950 avss.n399 avss.n397 0.1445
R951 avss.n402 avss.n395 0.1445
R952 avss.n402 avss.n401 0.1445
R953 avss.n401 avss.n400 0.1445
R954 avss.n400 avss.n292 0.1445
R955 avss.n497 avss.n496 0.1445
R956 avss.n262 avss.n248 0.1445
R957 avss.n282 avss.n156 0.1445
R958 avss.n463 avss.n462 0.1445
R959 avss.n250 avss.n249 0.1445
R960 avss.n209 avss.n200 0.1445
R961 avss.n209 avss.n166 0.1445
R962 avss.n269 avss.n166 0.1445
R963 avss.n269 avss.n268 0.1445
R964 avss.n268 avss.n267 0.1445
R965 avss.n267 avss.n170 0.1445
R966 avss.n180 avss.n170 0.1445
R967 avss.n243 avss.n180 0.1445
R968 avss.n243 avss.n242 0.1445
R969 avss.n242 avss.n241 0.1445
R970 avss.n241 avss.n119 0.1445
R971 avss.n491 avss.n119 0.1445
R972 avss.n491 avss.n490 0.1445
R973 avss.n202 avss.n194 0.1445
R974 avss.n214 avss.n194 0.1445
R975 avss.n215 avss.n214 0.1445
R976 avss.n217 avss.n215 0.1445
R977 avss.n217 avss.n192 0.1445
R978 avss.n221 avss.n192 0.1445
R979 avss.n224 avss.n221 0.1445
R980 avss.n225 avss.n224 0.1445
R981 avss.n225 avss.n190 0.1445
R982 avss.n236 avss.n190 0.1445
R983 avss.n236 avss.n235 0.1445
R984 avss.n235 avss.n234 0.1445
R985 avss.n234 avss.n233 0.1445
R986 avss.n203 avss.n201 0.1445
R987 avss.n201 avss.n195 0.1445
R988 avss.n195 avss.n193 0.1445
R989 avss.n218 avss.n193 0.1445
R990 avss.n219 avss.n218 0.1445
R991 avss.n220 avss.n219 0.1445
R992 avss.n220 avss.n191 0.1445
R993 avss.n226 avss.n191 0.1445
R994 avss.n227 avss.n226 0.1445
R995 avss.n228 avss.n227 0.1445
R996 avss.n229 avss.n228 0.1445
R997 avss.n230 avss.n229 0.1445
R998 avss.n231 avss.n230 0.1445
R999 avss.n208 avss.n206 0.1445
R1000 avss.n208 avss.n207 0.1445
R1001 avss.n207 avss.n167 0.1445
R1002 avss.n168 avss.n167 0.1445
R1003 avss.n169 avss.n168 0.1445
R1004 avss.n181 avss.n169 0.1445
R1005 avss.n182 avss.n181 0.1445
R1006 avss.n183 avss.n182 0.1445
R1007 avss.n184 avss.n183 0.1445
R1008 avss.n186 avss.n184 0.1445
R1009 avss.n186 avss.n185 0.1445
R1010 avss.n185 avss.n120 0.1445
R1011 avss.n489 avss.n120 0.1445
R1012 avss.n251 avss.n109 0.1445
R1013 avss.n255 avss.n254 0.1445
R1014 avss.n256 avss.n158 0.1445
R1015 avss.n277 avss.n276 0.1445
R1016 avss.n278 avss.n149 0.1445
R1017 avss.n456 avss.n455 0.1445
R1018 avss.n454 avss.n290 0.1445
R1019 avss.n461 avss.n147 0.1445
R1020 avss.n281 avss.n148 0.1445
R1021 avss.n261 avss.n157 0.1445
R1022 avss.n498 avss.n111 0.1445
R1023 avss.n549 avss.n543 0.1445
R1024 avss.n549 avss.n548 0.1445
R1025 avss.n548 avss.n547 0.1445
R1026 avss.n547 avss.n91 0.1445
R1027 avss.n558 avss.n91 0.1445
R1028 avss.n559 avss.n558 0.1445
R1029 avss.n560 avss.n559 0.1445
R1030 avss.n560 avss.n89 0.1445
R1031 avss.n568 avss.n89 0.1445
R1032 avss.n569 avss.n568 0.1445
R1033 avss.n570 avss.n569 0.1445
R1034 avss.n570 avss.n76 0.1445
R1035 avss.n583 avss.n76 0.1445
R1036 avss.n541 avss.n98 0.1445
R1037 avss.n510 avss.n98 0.1445
R1038 avss.n511 avss.n510 0.1445
R1039 avss.n512 avss.n511 0.1445
R1040 avss.n513 avss.n512 0.1445
R1041 avss.n514 avss.n513 0.1445
R1042 avss.n515 avss.n514 0.1445
R1043 avss.n516 avss.n515 0.1445
R1044 avss.n517 avss.n516 0.1445
R1045 avss.n519 avss.n517 0.1445
R1046 avss.n519 avss.n518 0.1445
R1047 avss.n518 avss.n78 0.1445
R1048 avss.n580 avss.n78 0.1445
R1049 avss.n540 avss.n99 0.1445
R1050 avss.n535 avss.n99 0.1445
R1051 avss.n535 avss.n534 0.1445
R1052 avss.n534 avss.n533 0.1445
R1053 avss.n533 avss.n530 0.1445
R1054 avss.n530 avss.n529 0.1445
R1055 avss.n529 avss.n526 0.1445
R1056 avss.n526 avss.n525 0.1445
R1057 avss.n525 avss.n522 0.1445
R1058 avss.n522 avss.n521 0.1445
R1059 avss.n521 avss.n79 0.1445
R1060 avss.n578 avss.n79 0.1445
R1061 avss.n579 avss.n578 0.1445
R1062 avss.n347 avss.n340 0.1445
R1063 avss.n350 avss.n347 0.1445
R1064 avss.n353 avss.n350 0.1445
R1065 avss.n353 avss.n338 0.1445
R1066 avss.n357 avss.n338 0.1445
R1067 avss.n360 avss.n357 0.1445
R1068 avss.n362 avss.n360 0.1445
R1069 avss.n362 avss.n336 0.1445
R1070 avss.n367 avss.n336 0.1445
R1071 avss.n367 avss.n330 0.1445
R1072 avss.n373 avss.n330 0.1445
R1073 avss.n374 avss.n373 0.1445
R1074 avss.n375 avss.n374 0.1445
R1075 avss.n346 avss.n345 0.1445
R1076 avss.n346 avss.n339 0.1445
R1077 avss.n354 avss.n339 0.1445
R1078 avss.n355 avss.n354 0.1445
R1079 avss.n356 avss.n355 0.1445
R1080 avss.n356 avss.n337 0.1445
R1081 avss.n363 avss.n337 0.1445
R1082 avss.n364 avss.n363 0.1445
R1083 avss.n366 avss.n364 0.1445
R1084 avss.n366 avss.n365 0.1445
R1085 avss.n365 avss.n331 0.1445
R1086 avss.n331 avss.n329 0.1445
R1087 avss.n376 avss.n329 0.1445
R1088 avss.n341 avss.n50 0.1445
R1089 avss.n51 avss.n50 0.1445
R1090 avss.n52 avss.n51 0.1445
R1091 avss.n56 avss.n52 0.1445
R1092 avss.n57 avss.n56 0.1445
R1093 avss.n58 avss.n57 0.1445
R1094 avss.n59 avss.n58 0.1445
R1095 avss.n63 avss.n59 0.1445
R1096 avss.n64 avss.n63 0.1445
R1097 avss.n65 avss.n64 0.1445
R1098 avss.n66 avss.n65 0.1445
R1099 avss.n326 avss.n66 0.1445
R1100 avss.n328 avss.n326 0.1445
R1101 avss.n605 avss.n49 0.1445
R1102 avss.n605 avss.n604 0.1445
R1103 avss.n604 avss.n603 0.1445
R1104 avss.n603 avss.n53 0.1445
R1105 avss.n598 avss.n53 0.1445
R1106 avss.n598 avss.n597 0.1445
R1107 avss.n597 avss.n596 0.1445
R1108 avss.n596 avss.n60 0.1445
R1109 avss.n591 avss.n60 0.1445
R1110 avss.n591 avss.n590 0.1445
R1111 avss.n590 avss.n589 0.1445
R1112 avss.n589 avss.n67 0.1445
R1113 avss.n327 avss.n67 0.1445
R1114 avss.n630 avss.n629 0.1445
R1115 avss.n629 avss.n628 0.1445
R1116 avss.n628 avss.n23 0.1445
R1117 avss.n624 avss.n23 0.1445
R1118 avss.n624 avss.n623 0.1445
R1119 avss.n623 avss.n622 0.1445
R1120 avss.n622 avss.n28 0.1445
R1121 avss.n618 avss.n28 0.1445
R1122 avss.n618 avss.n617 0.1445
R1123 avss.n617 avss.n616 0.1445
R1124 avss.n616 avss.n33 0.1445
R1125 avss.n612 avss.n33 0.1445
R1126 avss.n612 avss.n611 0.1445
R1127 avss.n665 avss.n18 0.1445
R1128 avss.n661 avss.n18 0.1445
R1129 avss.n661 avss.n660 0.1445
R1130 avss.n660 avss.n659 0.1445
R1131 avss.n659 avss.n638 0.1445
R1132 avss.n655 avss.n638 0.1445
R1133 avss.n655 avss.n654 0.1445
R1134 avss.n654 avss.n653 0.1445
R1135 avss.n653 avss.n644 0.1445
R1136 avss.n649 avss.n644 0.1445
R1137 avss.n649 avss.n648 0.1445
R1138 avss.n648 avss.n4 0.1445
R1139 avss.n669 avss.n4 0.1445
R1140 avss.n664 avss.n663 0.1445
R1141 avss.n663 avss.n662 0.1445
R1142 avss.n662 avss.n633 0.1445
R1143 avss.n658 avss.n633 0.1445
R1144 avss.n658 avss.n657 0.1445
R1145 avss.n657 avss.n656 0.1445
R1146 avss.n656 avss.n639 0.1445
R1147 avss.n652 avss.n639 0.1445
R1148 avss.n652 avss.n651 0.1445
R1149 avss.n651 avss.n650 0.1445
R1150 avss.n650 avss.n645 0.1445
R1151 avss.n645 avss.n3 0.1445
R1152 avss.n670 avss.n3 0.1445
R1153 avss.n631 avss.n19 0.1445
R1154 avss.n627 avss.n19 0.1445
R1155 avss.n627 avss.n626 0.1445
R1156 avss.n626 avss.n625 0.1445
R1157 avss.n625 avss.n24 0.1445
R1158 avss.n621 avss.n24 0.1445
R1159 avss.n621 avss.n620 0.1445
R1160 avss.n620 avss.n619 0.1445
R1161 avss.n619 avss.n29 0.1445
R1162 avss.n615 avss.n29 0.1445
R1163 avss.n615 avss.n614 0.1445
R1164 avss.n614 avss.n613 0.1445
R1165 avss.n613 avss.n34 0.1445
R1166 avss.n410 avss.n409 0.13023
R1167 avss.n411 avss.n410 0.13023
R1168 avss.n412 avss.n411 0.13023
R1169 avss.n412 avss.n291 0.13023
R1170 avss.n259 avss.n258 0.122783
R1171 avdd.n186 avdd.n155 1078.83
R1172 avdd.n167 avdd.n155 1078.83
R1173 avdd.n18 avdd.n6 522.652
R1174 avdd.n10 avdd.n6 522.652
R1175 avdd.n38 avdd.n27 522.652
R1176 avdd.n30 avdd.n27 522.652
R1177 avdd.n86 avdd.n49 522.652
R1178 avdd.n78 avdd.n49 522.652
R1179 avdd.n72 avdd.n56 522.652
R1180 avdd.n72 avdd.n55 522.652
R1181 avdd.n187 avdd.n153 144.812
R1182 avdd.n168 avdd.n153 144.812
R1183 avdd.n177 avdd.n176 144.812
R1184 avdd.n178 avdd.n177 144.812
R1185 avdd.n117 avdd.n109 142.857
R1186 avdd.n126 avdd.n109 142.857
R1187 avdd.n126 avdd.n103 142.857
R1188 avdd.n134 avdd.n103 142.857
R1189 avdd.n134 avdd.n97 142.857
R1190 avdd.n142 avdd.n97 142.857
R1191 avdd.n19 avdd.n5 62.038
R1192 avdd.n11 avdd.n5 62.038
R1193 avdd.n16 avdd.n7 62.038
R1194 avdd.n17 avdd.n16 62.038
R1195 avdd.n39 avdd.n26 62.038
R1196 avdd.n31 avdd.n26 62.038
R1197 avdd.n36 avdd.n28 62.038
R1198 avdd.n37 avdd.n36 62.038
R1199 avdd.n87 avdd.n48 62.038
R1200 avdd.n79 avdd.n48 62.038
R1201 avdd.n84 avdd.n50 62.038
R1202 avdd.n85 avdd.n84 62.038
R1203 avdd.n73 avdd.n53 62.038
R1204 avdd.n71 avdd.n57 62.038
R1205 avdd.n71 avdd.n58 62.038
R1206 avdd.n73 avdd.n54 62.038
R1207 avdd.n141 avdd.n96 61.7755
R1208 avdd.n116 avdd.n113 61.7755
R1209 avdd avdd.n0 51.5153
R1210 avdd.n143 avdd.n96 48.3669
R1211 avdd.n118 avdd.n113 48.3669
R1212 avdd.n66 avdd.n65 24.6473
R1213 avdd.n2 avdd.n1 18.5323
R1214 avdd.n64 avdd.n63 18.5323
R1215 avdd.n119 avdd.n110 14.0005
R1216 avdd.n125 avdd.n110 14.0005
R1217 avdd.n125 avdd.n102 14.0005
R1218 avdd.n135 avdd.n102 14.0005
R1219 avdd.n135 avdd.n98 14.0005
R1220 avdd.n141 avdd.n98 14.0005
R1221 avdd.n116 avdd.n108 14.0005
R1222 avdd.n127 avdd.n108 14.0005
R1223 avdd.n127 avdd.n104 14.0005
R1224 avdd.n133 avdd.n104 14.0005
R1225 avdd.n133 avdd.n95 14.0005
R1226 avdd.n144 avdd.n95 14.0005
R1227 avdd.n163 avdd.n162 14.0005
R1228 avdd.n168 avdd.n164 14.0005
R1229 avdd.n184 avdd.n156 14.0005
R1230 avdd.n187 avdd.n152 14.0005
R1231 avdd.n43 avdd.n22 7.95932
R1232 avdd.n43 avdd.n42 7.43822
R1233 avdd.n62 avdd.n44 7.43822
R1234 avdd.n91 avdd.n90 7.43822
R1235 avdd.n148 avdd.n147 7.43822
R1236 avdd.n191 avdd.n190 6.49028
R1237 avdd.n12 avdd.n11 6.3005
R1238 avdd.n13 avdd.n7 6.3005
R1239 avdd.n20 avdd.n19 6.3005
R1240 avdd.n17 avdd.n4 6.3005
R1241 avdd.n32 avdd.n31 6.3005
R1242 avdd.n33 avdd.n28 6.3005
R1243 avdd.n40 avdd.n39 6.3005
R1244 avdd.n37 avdd.n25 6.3005
R1245 avdd.n80 avdd.n79 6.3005
R1246 avdd.n81 avdd.n50 6.3005
R1247 avdd.n88 avdd.n87 6.3005
R1248 avdd.n85 avdd.n47 6.3005
R1249 avdd.n60 avdd.n57 6.3005
R1250 avdd.n59 avdd.n53 6.3005
R1251 avdd.n68 avdd.n58 6.3005
R1252 avdd.n67 avdd.n54 6.3005
R1253 avdd.n141 avdd.n140 6.3005
R1254 avdd.n142 avdd.n141 6.3005
R1255 avdd.n99 avdd.n98 6.3005
R1256 avdd.n98 avdd.n97 6.3005
R1257 avdd.n136 avdd.n135 6.3005
R1258 avdd.n135 avdd.n134 6.3005
R1259 avdd.n102 avdd.n101 6.3005
R1260 avdd.n103 avdd.n102 6.3005
R1261 avdd.n125 avdd.n124 6.3005
R1262 avdd.n126 avdd.n125 6.3005
R1263 avdd.n111 avdd.n110 6.3005
R1264 avdd.n110 avdd.n109 6.3005
R1265 avdd.n120 avdd.n119 6.3005
R1266 avdd.n145 avdd.n144 6.3005
R1267 avdd.n95 avdd.n94 6.3005
R1268 avdd.n97 avdd.n95 6.3005
R1269 avdd.n133 avdd.n132 6.3005
R1270 avdd.n134 avdd.n133 6.3005
R1271 avdd.n105 avdd.n104 6.3005
R1272 avdd.n104 avdd.n103 6.3005
R1273 avdd.n128 avdd.n127 6.3005
R1274 avdd.n127 avdd.n126 6.3005
R1275 avdd.n108 avdd.n107 6.3005
R1276 avdd.n109 avdd.n108 6.3005
R1277 avdd.n116 avdd.n115 6.3005
R1278 avdd.n117 avdd.n116 6.3005
R1279 avdd.n169 avdd.n168 6.3005
R1280 avdd.n168 avdd.n167 6.3005
R1281 avdd.n170 avdd.n164 6.3005
R1282 avdd.n171 avdd.n163 6.3005
R1283 avdd.n162 avdd.n160 6.3005
R1284 avdd.n176 avdd.n175 6.3005
R1285 avdd.n179 avdd.n178 6.3005
R1286 avdd.n157 avdd.n156 6.3005
R1287 avdd.n184 avdd.n183 6.3005
R1288 avdd.n152 avdd.n151 6.3005
R1289 avdd.n188 avdd.n187 6.3005
R1290 avdd.n187 avdd.n186 6.3005
R1291 avdd.n180 avdd.n158 6.12735
R1292 avdd.n174 avdd.n158 6.12735
R1293 avdd.n165 avdd.n149 6.12735
R1294 avdd.n15 avdd.n3 5.20011
R1295 avdd.n15 avdd.n14 5.20011
R1296 avdd.n9 avdd.n8 5.20011
R1297 avdd.n35 avdd.n24 5.20011
R1298 avdd.n35 avdd.n34 5.20011
R1299 avdd.n29 avdd.n23 5.20011
R1300 avdd.n83 avdd.n46 5.20011
R1301 avdd.n74 avdd.n52 5.20011
R1302 avdd.n70 avdd.n69 5.20011
R1303 avdd.n114 avdd.n112 5.19741
R1304 avdd.n121 avdd.n112 5.19741
R1305 avdd.n139 avdd.n92 5.19741
R1306 avdd.n83 avdd.n82 5.14197
R1307 avdd.n75 avdd.n74 4.95441
R1308 avdd.n76 avdd.n45 4.95441
R1309 avdd.n118 avdd.n117 4.9335
R1310 avdd.n143 avdd.n142 4.9335
R1311 avdd.n22 avdd.n21 4.7462
R1312 avdd.n42 avdd.n41 4.7462
R1313 avdd.n90 avdd.n89 4.7462
R1314 avdd.n62 avdd.n61 4.7462
R1315 avdd.n147 avdd.n146 4.7435
R1316 avdd.n190 avdd.n189 4.7255
R1317 avdd.n21 avdd.n20 4.5005
R1318 avdd.n4 avdd.n3 4.5005
R1319 avdd.n12 avdd.n9 4.5005
R1320 avdd.n14 avdd.n13 4.5005
R1321 avdd.n41 avdd.n40 4.5005
R1322 avdd.n25 avdd.n24 4.5005
R1323 avdd.n32 avdd.n29 4.5005
R1324 avdd.n34 avdd.n33 4.5005
R1325 avdd.n89 avdd.n88 4.5005
R1326 avdd.n47 avdd.n46 4.5005
R1327 avdd.n61 avdd.n60 4.5005
R1328 avdd.n59 avdd.n52 4.5005
R1329 avdd.n69 avdd.n68 4.5005
R1330 avdd.n67 avdd.n51 4.5005
R1331 avdd.n80 avdd.n77 4.5005
R1332 avdd.n82 avdd.n81 4.5005
R1333 avdd.n107 avdd.n106 4.5005
R1334 avdd.n129 avdd.n128 4.5005
R1335 avdd.n130 avdd.n105 4.5005
R1336 avdd.n132 avdd.n131 4.5005
R1337 avdd.n94 avdd.n93 4.5005
R1338 avdd.n146 avdd.n145 4.5005
R1339 avdd.n115 avdd.n114 4.5005
R1340 avdd.n122 avdd.n111 4.5005
R1341 avdd.n124 avdd.n123 4.5005
R1342 avdd.n101 avdd.n100 4.5005
R1343 avdd.n137 avdd.n136 4.5005
R1344 avdd.n138 avdd.n99 4.5005
R1345 avdd.n140 avdd.n139 4.5005
R1346 avdd.n121 avdd.n120 4.5005
R1347 avdd.n180 avdd.n179 4.5005
R1348 avdd.n181 avdd.n157 4.5005
R1349 avdd.n183 avdd.n182 4.5005
R1350 avdd.n151 avdd.n150 4.5005
R1351 avdd.n189 avdd.n188 4.5005
R1352 avdd.n173 avdd.n160 4.5005
R1353 avdd.n172 avdd.n171 4.5005
R1354 avdd.n170 avdd.n161 4.5005
R1355 avdd.n169 avdd.n165 4.5005
R1356 avdd.n175 avdd.n174 4.5005
R1357 avdd.n10 avdd.n7 3.31679
R1358 avdd.n11 avdd.n10 3.31679
R1359 avdd.n18 avdd.n17 3.31679
R1360 avdd.n19 avdd.n18 3.31679
R1361 avdd.n30 avdd.n28 3.31679
R1362 avdd.n31 avdd.n30 3.31679
R1363 avdd.n38 avdd.n37 3.31679
R1364 avdd.n39 avdd.n38 3.31679
R1365 avdd.n78 avdd.n50 3.31679
R1366 avdd.n79 avdd.n78 3.31679
R1367 avdd.n86 avdd.n85 3.31679
R1368 avdd.n87 avdd.n86 3.31679
R1369 avdd.n55 avdd.n53 3.31679
R1370 avdd.n57 avdd.n55 3.31679
R1371 avdd.n58 avdd.n56 3.31679
R1372 avdd.n56 avdd.n54 3.31679
R1373 avdd.n176 avdd.n159 3.31679
R1374 avdd.n166 avdd.n163 3.31679
R1375 avdd.n166 avdd.n164 3.31679
R1376 avdd.n162 avdd.n159 3.31679
R1377 avdd.n156 avdd.n154 3.31679
R1378 avdd.n185 avdd.n184 3.31679
R1379 avdd.n178 avdd.n154 3.31679
R1380 avdd.n185 avdd.n152 3.31679
R1381 avdd.n167 avdd.n166 1.49311
R1382 avdd.n167 avdd.n159 1.49311
R1383 avdd.n186 avdd.n154 1.49311
R1384 avdd.n186 avdd.n185 1.49311
R1385 avdd.n190 avdd.n149 1.39452
R1386 avdd.n144 avdd.n143 1.24194
R1387 avdd.n119 avdd.n118 1.24194
R1388 avdd.n16 avdd.n15 0.9005
R1389 avdd.n16 avdd.n6 0.9005
R1390 avdd.n8 avdd.n5 0.9005
R1391 avdd.n6 avdd.n5 0.9005
R1392 avdd.n36 avdd.n35 0.9005
R1393 avdd.n36 avdd.n27 0.9005
R1394 avdd.n26 avdd.n23 0.9005
R1395 avdd.n27 avdd.n26 0.9005
R1396 avdd.n84 avdd.n83 0.9005
R1397 avdd.n84 avdd.n49 0.9005
R1398 avdd.n74 avdd.n73 0.9005
R1399 avdd.n73 avdd.n72 0.9005
R1400 avdd.n71 avdd.n70 0.9005
R1401 avdd.n72 avdd.n71 0.9005
R1402 avdd.n48 avdd.n45 0.9005
R1403 avdd.n49 avdd.n48 0.9005
R1404 avdd.n113 avdd.n112 0.9005
R1405 avdd.n96 avdd.n92 0.9005
R1406 avdd.n191 avdd.n148 0.8789
R1407 avdd.n148 avdd.n91 0.5216
R1408 avdd.n91 avdd.n44 0.5216
R1409 avdd.n44 avdd.n43 0.5216
R1410 avdd.n42 avdd.n23 0.454413
R1411 avdd.n90 avdd.n45 0.454413
R1412 avdd.n147 avdd.n92 0.446587
R1413 avdd.n76 avdd.n75 0.386002
R1414 avdd avdd.n191 0.3686
R1415 avdd.n22 avdd.n2 0.324304
R1416 avdd.n64 avdd.n62 0.324304
R1417 avdd.n177 avdd.n158 0.2255
R1418 avdd.n177 avdd.n155 0.2255
R1419 avdd.n153 avdd.n149 0.2255
R1420 avdd.n155 avdd.n153 0.2255
R1421 avdd.n75 avdd.n51 0.188057
R1422 avdd.n77 avdd.n76 0.188057
R1423 avdd.n13 avdd.n12 0.1445
R1424 avdd.n20 avdd.n4 0.1445
R1425 avdd.n21 avdd.n3 0.1445
R1426 avdd.n14 avdd.n9 0.1445
R1427 avdd.n33 avdd.n32 0.1445
R1428 avdd.n40 avdd.n25 0.1445
R1429 avdd.n41 avdd.n24 0.1445
R1430 avdd.n34 avdd.n29 0.1445
R1431 avdd.n81 avdd.n80 0.1445
R1432 avdd.n88 avdd.n47 0.1445
R1433 avdd.n89 avdd.n46 0.1445
R1434 avdd.n68 avdd.n67 0.1445
R1435 avdd.n60 avdd.n59 0.1445
R1436 avdd.n61 avdd.n52 0.1445
R1437 avdd.n120 avdd.n111 0.1445
R1438 avdd.n124 avdd.n111 0.1445
R1439 avdd.n124 avdd.n101 0.1445
R1440 avdd.n136 avdd.n101 0.1445
R1441 avdd.n136 avdd.n99 0.1445
R1442 avdd.n140 avdd.n99 0.1445
R1443 avdd.n115 avdd.n107 0.1445
R1444 avdd.n128 avdd.n107 0.1445
R1445 avdd.n128 avdd.n105 0.1445
R1446 avdd.n132 avdd.n105 0.1445
R1447 avdd.n132 avdd.n94 0.1445
R1448 avdd.n145 avdd.n94 0.1445
R1449 avdd.n114 avdd.n106 0.1445
R1450 avdd.n129 avdd.n106 0.1445
R1451 avdd.n130 avdd.n129 0.1445
R1452 avdd.n131 avdd.n130 0.1445
R1453 avdd.n131 avdd.n93 0.1445
R1454 avdd.n146 avdd.n93 0.1445
R1455 avdd.n122 avdd.n121 0.1445
R1456 avdd.n123 avdd.n122 0.1445
R1457 avdd.n123 avdd.n100 0.1445
R1458 avdd.n137 avdd.n100 0.1445
R1459 avdd.n138 avdd.n137 0.1445
R1460 avdd.n139 avdd.n138 0.1445
R1461 avdd.n175 avdd.n160 0.1445
R1462 avdd.n171 avdd.n160 0.1445
R1463 avdd.n171 avdd.n170 0.1445
R1464 avdd.n170 avdd.n169 0.1445
R1465 avdd.n179 avdd.n157 0.1445
R1466 avdd.n183 avdd.n157 0.1445
R1467 avdd.n183 avdd.n151 0.1445
R1468 avdd.n188 avdd.n151 0.1445
R1469 avdd.n181 avdd.n180 0.1445
R1470 avdd.n182 avdd.n181 0.1445
R1471 avdd.n182 avdd.n150 0.1445
R1472 avdd.n189 avdd.n150 0.1445
R1473 avdd.n174 avdd.n173 0.1445
R1474 avdd.n173 avdd.n172 0.1445
R1475 avdd.n172 avdd.n161 0.1445
R1476 avdd.n165 avdd.n161 0.1445
R1477 avdd.n8 avdd.n2 0.122783
R1478 avdd.n70 avdd.n64 0.122783
R1479 avdd.n82 avdd.n77 0.110424
R1480 avdd.n66 avdd.n51 0.0543845
R1481 avdd.n69 avdd.n66 0.0508473
R1482 vw.n513 vw.n56 14000
R1483 vw.n514 vw.n212 14000
R1484 vw.n516 vw.n515 14000
R1485 vw.n138 vw.n124 14000
R1486 vw.n512 vw.n7 14000
R1487 vw.n572 vw.n124 10194.3
R1488 vw.n512 vw.n511 4163.87
R1489 vw.n473 vw.n472 2283.78
R1490 vw.n401 vw.n273 2283.78
R1491 vw.n513 vw.n512 2067.12
R1492 vw.n514 vw.n513 1226.3
R1493 vw.n515 vw.n514 1226.3
R1494 vw.n515 vw.n124 1226.3
R1495 vw.n472 vw.n471 1051.61
R1496 vw.n659 vw.n9 203.708
R1497 vw.n511 vw.n213 203.343
R1498 vw.n272 vw.n213 203.343
R1499 vw.n289 vw.n228 203.343
R1500 vw.n392 vw.n289 203.343
R1501 vw.n618 vw.n617 198.688
R1502 vw.n471 vw.n272 187.267
R1503 vw.n517 vw.n84 182.19
R1504 vw.n573 vw.n572 182.19
R1505 vw.n212 vw.n82 157.803
R1506 vw.n666 vw.n9 114.766
R1507 vw.n659 vw.n658 114.766
R1508 vw.n45 vw.n18 114.766
R1509 vw.n45 vw.n27 114.766
R1510 vw.n650 vw.n27 114.766
R1511 vw.n650 vw.n30 114.766
R1512 vw.n54 vw.n30 114.766
R1513 vw.n635 vw.n67 114.766
R1514 vw.n171 vw.n69 114.766
R1515 vw.n211 vw.n152 114.766
R1516 vw.n617 vw.n616 114.766
R1517 vw.n603 vw.n93 114.766
R1518 vw.n544 vw.n105 114.766
R1519 vw.n553 vw.n112 114.766
R1520 vw.n641 vw.n56 111.897
R1521 vw.n160 vw.n74 104.007
R1522 vw.n627 vw.n75 104.007
R1523 vw.n527 vw.n150 101.855
R1524 vw.n604 vw.n91 101.855
R1525 vw.n580 vw.n579 100.419
R1526 vw.n579 vw.n114 98.268
R1527 vw.n560 vw.n122 98.268
R1528 vw.n151 vw.n75 94.6816
R1529 vw.n542 vw.n138 84.6397
R1530 vw.n470 vw.n7 83.2051
R1531 vw.n543 vw.n542 74.5977
R1532 vw.n634 vw.n69 73.1632
R1533 vw.n102 vw.n93 71.0113
R1534 vw.n597 vw.n596 71.0113
R1535 vw.n571 vw.n125 68.9311
R1536 vw.n571 vw.n126 68.9311
R1537 vw.n581 vw.n111 68.9311
R1538 vw.n581 vw.n110 68.9311
R1539 vw.n106 vw.n104 68.9311
R1540 vw.n595 vw.n106 68.9311
R1541 vw.n605 vw.n90 68.9311
R1542 vw.n605 vw.n89 68.9311
R1543 vw.n85 vw.n83 68.9311
R1544 vw.n615 vw.n85 68.9311
R1545 vw.n619 vw.n81 68.9311
R1546 vw.n619 vw.n80 68.9311
R1547 vw.n628 vw.n73 68.9311
R1548 vw.n626 vw.n73 68.9311
R1549 vw.n633 vw.n71 68.9311
R1550 vw.n633 vw.n70 68.9311
R1551 vw.n643 vw.n53 67.7644
R1552 vw.n643 vw.n32 67.7644
R1553 vw.n660 vw.n17 67.7644
R1554 vw.n660 vw.n16 67.7644
R1555 vw.n667 vw.n666 67.4249
R1556 vw.n658 vw.n18 67.4249
R1557 vw.n642 vw.n54 67.4249
R1558 vw.n123 vw.n121 66.6949
R1559 vw.n574 vw.n121 66.6949
R1560 vw.n520 vw.n518 66.6949
R1561 vw.n520 vw.n148 66.6949
R1562 vw.n155 vw.n153 66.6949
R1563 vw.n210 vw.n155 66.6949
R1564 vw.n657 vw.n20 66.6949
R1565 vw.n657 vw.n19 66.6949
R1566 vw.n665 vw.n10 66.6949
R1567 vw.n665 vw.n11 66.6949
R1568 vw.n271 vw.n216 66.6949
R1569 vw.n510 vw.n216 66.6949
R1570 vw.n8 vw.n6 66.6949
R1571 vw.n668 vw.n6 66.6949
R1572 vw.n431 vw.n286 66.6949
R1573 vw.n437 vw.n286 66.6949
R1574 vw.n334 vw.n297 66.6949
R1575 vw.n391 vw.n297 66.6949
R1576 vw.n367 vw.n366 66.6949
R1577 vw.n367 vw.n290 66.6949
R1578 vw.n527 vw.n516 57.383
R1579 vw.n516 vw.n91 57.383
R1580 vw.n642 vw.n641 47.341
R1581 vw.n597 vw.n102 43.7546
R1582 vw.n596 vw.n105 43.7546
R1583 vw.n635 vw.n634 41.6028
R1584 vw.n544 vw.n543 40.1682
R1585 vw.n471 vw.n273 31.7197
R1586 vw.n667 vw.n7 31.5609
R1587 vw.n553 vw.n138 30.1263
R1588 vw.n588 vw.n587 30.0192
R1589 vw.n212 vw.n211 24.3881
R1590 vw.n152 vw.n151 20.0844
R1591 vw.n589 vw.n588 19.8198
R1592 vw.n590 vw.n589 19.2403
R1593 vw.n560 vw.n114 16.498
R1594 vw.n573 vw.n122 16.498
R1595 vw.n126 vw.n111 15.5561
R1596 vw.n125 vw.n110 15.5561
R1597 vw.n595 vw.n90 15.5561
R1598 vw.n104 vw.n89 15.5561
R1599 vw.n615 vw.n81 15.5561
R1600 vw.n83 vw.n80 15.5561
R1601 vw.n626 vw.n71 15.5561
R1602 vw.n628 vw.n70 15.5561
R1603 vw.n44 vw.n17 15.5561
R1604 vw.n44 vw.n31 15.5561
R1605 vw.n649 vw.n31 15.5561
R1606 vw.n649 vw.n32 15.5561
R1607 vw.n46 vw.n16 15.5561
R1608 vw.n46 vw.n39 15.5561
R1609 vw.n39 vw.n28 15.5561
R1610 vw.n53 vw.n28 15.5561
R1611 vw.n526 vw.n518 15.5561
R1612 vw.n526 vw.n94 15.5561
R1613 vw.n602 vw.n94 15.5561
R1614 vw.n602 vw.n95 15.5561
R1615 vw.n598 vw.n95 15.5561
R1616 vw.n598 vw.n101 15.5561
R1617 vw.n545 vw.n101 15.5561
R1618 vw.n545 vw.n139 15.5561
R1619 vw.n552 vw.n139 15.5561
R1620 vw.n552 vw.n115 15.5561
R1621 vw.n578 vw.n115 15.5561
R1622 vw.n578 vw.n116 15.5561
R1623 vw.n574 vw.n116 15.5561
R1624 vw.n528 vw.n148 15.5561
R1625 vw.n528 vw.n149 15.5561
R1626 vw.n149 vw.n92 15.5561
R1627 vw.n534 vw.n92 15.5561
R1628 vw.n534 vw.n103 15.5561
R1629 vw.n142 vw.n103 15.5561
R1630 vw.n541 vw.n142 15.5561
R1631 vw.n541 vw.n136 15.5561
R1632 vw.n554 vw.n136 15.5561
R1633 vw.n554 vw.n137 15.5561
R1634 vw.n137 vw.n113 15.5561
R1635 vw.n561 vw.n113 15.5561
R1636 vw.n561 vw.n123 15.5561
R1637 vw.n23 vw.n20 15.5561
R1638 vw.n651 vw.n23 15.5561
R1639 vw.n651 vw.n26 15.5561
R1640 vw.n57 vw.n26 15.5561
R1641 vw.n640 vw.n57 15.5561
R1642 vw.n640 vw.n58 15.5561
R1643 vw.n636 vw.n58 15.5561
R1644 vw.n636 vw.n66 15.5561
R1645 vw.n170 vw.n66 15.5561
R1646 vw.n170 vw.n161 15.5561
R1647 vw.n166 vw.n161 15.5561
R1648 vw.n166 vw.n154 15.5561
R1649 vw.n210 vw.n154 15.5561
R1650 vw.n178 vw.n19 15.5561
R1651 vw.n178 vw.n29 15.5561
R1652 vw.n184 vw.n29 15.5561
R1653 vw.n185 vw.n184 15.5561
R1654 vw.n185 vw.n55 15.5561
R1655 vw.n190 vw.n55 15.5561
R1656 vw.n190 vw.n68 15.5561
R1657 vw.n193 vw.n68 15.5561
R1658 vw.n193 vw.n172 15.5561
R1659 vw.n200 vw.n172 15.5561
R1660 vw.n201 vw.n200 15.5561
R1661 vw.n202 vw.n201 15.5561
R1662 vw.n202 vw.n153 15.5561
R1663 vw.n271 vw.n231 15.5561
R1664 vw.n264 vw.n263 15.5561
R1665 vw.n261 vw.n260 15.5561
R1666 vw.n257 vw.n256 15.5561
R1667 vw.n253 vw.n252 15.5561
R1668 vw.n249 vw.n248 15.5561
R1669 vw.n245 vw.n11 15.5561
R1670 vw.n510 vw.n217 15.5561
R1671 vw.n506 vw.n505 15.5561
R1672 vw.n502 vw.n501 15.5561
R1673 vw.n499 vw.n474 15.5561
R1674 vw.n495 vw.n494 15.5561
R1675 vw.n492 vw.n481 15.5561
R1676 vw.n488 vw.n10 15.5561
R1677 vw.n429 vw.n428 15.5561
R1678 vw.n426 vw.n394 15.5561
R1679 vw.n422 vw.n421 15.5561
R1680 vw.n419 vw.n402 15.5561
R1681 vw.n415 vw.n414 15.5561
R1682 vw.n412 vw.n5 15.5561
R1683 vw.n668 vw.n5 15.5561
R1684 vw.n441 vw.n439 15.5561
R1685 vw.n447 vw.n282 15.5561
R1686 vw.n451 vw.n449 15.5561
R1687 vw.n457 vw.n278 15.5561
R1688 vw.n461 vw.n459 15.5561
R1689 vw.n469 vw.n274 15.5561
R1690 vw.n469 vw.n8 15.5561
R1691 vw.n338 vw.n336 15.5561
R1692 vw.n344 vw.n328 15.5561
R1693 vw.n348 vw.n346 15.5561
R1694 vw.n354 vw.n324 15.5561
R1695 vw.n358 vw.n356 15.5561
R1696 vw.n364 vw.n320 15.5561
R1697 vw.n391 vw.n298 15.5561
R1698 vw.n303 vw.n302 15.5561
R1699 vw.n305 vw.n304 15.5561
R1700 vw.n309 vw.n308 15.5561
R1701 vw.n311 vw.n310 15.5561
R1702 vw.n315 vw.n314 15.5561
R1703 vw.n316 vw.n290 15.5561
R1704 vw.n588 vw 14.644
R1705 vw.n580 vw.n112 14.3461
R1706 vw.n517 vw.n150 12.9116
R1707 vw.n604 vw.n603 12.9116
R1708 vw.n171 vw.n160 10.7597
R1709 vw.n627 vw.n74 10.7597
R1710 vw.n471 vw.n470 10.0424
R1711 vw.n130 vw.n1 6.52425
R1712 vw.n471 vw.n228 5.6489
R1713 vw.n275 vw.n274 5.2005
R1714 vw.n462 vw.n461 5.2005
R1715 vw.n459 vw.n277 5.2005
R1716 vw.n457 vw.n456 5.2005
R1717 vw.n279 vw.n278 5.2005
R1718 vw.n452 vw.n451 5.2005
R1719 vw.n449 vw.n281 5.2005
R1720 vw.n447 vw.n446 5.2005
R1721 vw.n412 vw.n411 5.2005
R1722 vw.n414 vw.n407 5.2005
R1723 vw.n416 vw.n415 5.2005
R1724 vw.n417 vw.n402 5.2005
R1725 vw.n419 vw.n418 5.2005
R1726 vw.n421 vw.n399 5.2005
R1727 vw.n423 vw.n422 5.2005
R1728 vw.n424 vw.n394 5.2005
R1729 vw.n489 vw.n488 5.2005
R1730 vw.n490 vw.n481 5.2005
R1731 vw.n492 vw.n491 5.2005
R1732 vw.n494 vw.n479 5.2005
R1733 vw.n496 vw.n495 5.2005
R1734 vw.n497 vw.n474 5.2005
R1735 vw.n499 vw.n498 5.2005
R1736 vw.n501 vw.n223 5.2005
R1737 vw.n246 vw.n245 5.2005
R1738 vw.n248 vw.n247 5.2005
R1739 vw.n250 vw.n249 5.2005
R1740 vw.n252 vw.n251 5.2005
R1741 vw.n254 vw.n253 5.2005
R1742 vw.n256 vw.n255 5.2005
R1743 vw.n258 vw.n257 5.2005
R1744 vw.n260 vw.n259 5.2005
R1745 vw.n467 vw.n8 5.2005
R1746 vw.n667 vw.n8 5.2005
R1747 vw.n469 vw.n468 5.2005
R1748 vw.n470 vw.n469 5.2005
R1749 vw.n669 vw.n668 5.2005
R1750 vw.n668 vw.n667 5.2005
R1751 vw.n5 vw.n4 5.2005
R1752 vw.n470 vw.n5 5.2005
R1753 vw.n204 vw.n153 5.2005
R1754 vw.n211 vw.n153 5.2005
R1755 vw.n203 vw.n202 5.2005
R1756 vw.n202 vw.n152 5.2005
R1757 vw.n201 vw.n159 5.2005
R1758 vw.n201 vw.n75 5.2005
R1759 vw.n200 vw.n199 5.2005
R1760 vw.n200 vw.n74 5.2005
R1761 vw.n173 vw.n172 5.2005
R1762 vw.n172 vw.n171 5.2005
R1763 vw.n194 vw.n193 5.2005
R1764 vw.n193 vw.n69 5.2005
R1765 vw.n192 vw.n68 5.2005
R1766 vw.n635 vw.n68 5.2005
R1767 vw.n191 vw.n190 5.2005
R1768 vw.n190 vw.n67 5.2005
R1769 vw.n175 vw.n55 5.2005
R1770 vw.n641 vw.n55 5.2005
R1771 vw.n186 vw.n185 5.2005
R1772 vw.n185 vw.n54 5.2005
R1773 vw.n184 vw.n183 5.2005
R1774 vw.n184 vw.n30 5.2005
R1775 vw.n182 vw.n29 5.2005
R1776 vw.n650 vw.n29 5.2005
R1777 vw.n179 vw.n178 5.2005
R1778 vw.n178 vw.n27 5.2005
R1779 vw.n177 vw.n19 5.2005
R1780 vw.n45 vw.n19 5.2005
R1781 vw.n210 vw.n209 5.2005
R1782 vw.n211 vw.n210 5.2005
R1783 vw.n156 vw.n154 5.2005
R1784 vw.n154 vw.n152 5.2005
R1785 vw.n167 vw.n166 5.2005
R1786 vw.n166 vw.n75 5.2005
R1787 vw.n168 vw.n161 5.2005
R1788 vw.n161 vw.n74 5.2005
R1789 vw.n170 vw.n169 5.2005
R1790 vw.n171 vw.n170 5.2005
R1791 vw.n66 vw.n65 5.2005
R1792 vw.n69 vw.n66 5.2005
R1793 vw.n637 vw.n636 5.2005
R1794 vw.n636 vw.n635 5.2005
R1795 vw.n638 vw.n58 5.2005
R1796 vw.n67 vw.n58 5.2005
R1797 vw.n640 vw.n639 5.2005
R1798 vw.n641 vw.n640 5.2005
R1799 vw.n59 vw.n57 5.2005
R1800 vw.n57 vw.n54 5.2005
R1801 vw.n26 vw.n25 5.2005
R1802 vw.n30 vw.n26 5.2005
R1803 vw.n652 vw.n651 5.2005
R1804 vw.n651 vw.n650 5.2005
R1805 vw.n653 vw.n23 5.2005
R1806 vw.n27 vw.n23 5.2005
R1807 vw.n654 vw.n20 5.2005
R1808 vw.n45 vw.n20 5.2005
R1809 vw.n563 vw.n123 5.2005
R1810 vw.n573 vw.n123 5.2005
R1811 vw.n562 vw.n561 5.2005
R1812 vw.n561 vw.n560 5.2005
R1813 vw.n559 vw.n113 5.2005
R1814 vw.n579 vw.n113 5.2005
R1815 vw.n137 vw.n133 5.2005
R1816 vw.n137 vw.n112 5.2005
R1817 vw.n555 vw.n554 5.2005
R1818 vw.n554 vw.n553 5.2005
R1819 vw.n136 vw.n135 5.2005
R1820 vw.n542 vw.n136 5.2005
R1821 vw.n541 vw.n540 5.2005
R1822 vw.n544 vw.n541 5.2005
R1823 vw.n143 vw.n142 5.2005
R1824 vw.n142 vw.n105 5.2005
R1825 vw.n536 vw.n103 5.2005
R1826 vw.n597 vw.n103 5.2005
R1827 vw.n535 vw.n534 5.2005
R1828 vw.n534 vw.n93 5.2005
R1829 vw.n533 vw.n92 5.2005
R1830 vw.n603 vw.n92 5.2005
R1831 vw.n149 vw.n145 5.2005
R1832 vw.n149 vw.n91 5.2005
R1833 vw.n529 vw.n528 5.2005
R1834 vw.n528 vw.n527 5.2005
R1835 vw.n148 vw.n147 5.2005
R1836 vw.n517 vw.n148 5.2005
R1837 vw.n575 vw.n574 5.2005
R1838 vw.n574 vw.n573 5.2005
R1839 vw.n576 vw.n116 5.2005
R1840 vw.n560 vw.n116 5.2005
R1841 vw.n578 vw.n577 5.2005
R1842 vw.n579 vw.n578 5.2005
R1843 vw.n117 vw.n115 5.2005
R1844 vw.n115 vw.n112 5.2005
R1845 vw.n552 vw.n551 5.2005
R1846 vw.n553 vw.n552 5.2005
R1847 vw.n140 vw.n139 5.2005
R1848 vw.n542 vw.n139 5.2005
R1849 vw.n546 vw.n545 5.2005
R1850 vw.n545 vw.n544 5.2005
R1851 vw.n101 vw.n100 5.2005
R1852 vw.n105 vw.n101 5.2005
R1853 vw.n599 vw.n598 5.2005
R1854 vw.n598 vw.n597 5.2005
R1855 vw.n600 vw.n95 5.2005
R1856 vw.n95 vw.n93 5.2005
R1857 vw.n602 vw.n601 5.2005
R1858 vw.n603 vw.n602 5.2005
R1859 vw.n96 vw.n94 5.2005
R1860 vw.n94 vw.n91 5.2005
R1861 vw.n526 vw.n525 5.2005
R1862 vw.n527 vw.n526 5.2005
R1863 vw.n519 vw.n518 5.2005
R1864 vw.n518 vw.n517 5.2005
R1865 vw.n486 vw.n10 5.2005
R1866 vw.n470 vw.n10 5.2005
R1867 vw.n244 vw.n11 5.2005
R1868 vw.n470 vw.n11 5.2005
R1869 vw.n53 vw.n52 5.2005
R1870 vw.n53 vw.n30 5.2005
R1871 vw.n51 vw.n28 5.2005
R1872 vw.n650 vw.n28 5.2005
R1873 vw.n39 vw.n37 5.2005
R1874 vw.n39 vw.n27 5.2005
R1875 vw.n47 vw.n46 5.2005
R1876 vw.n46 vw.n45 5.2005
R1877 vw.n38 vw.n16 5.2005
R1878 vw.n18 vw.n16 5.2005
R1879 vw.n647 vw.n32 5.2005
R1880 vw.n32 vw.n30 5.2005
R1881 vw.n649 vw.n648 5.2005
R1882 vw.n650 vw.n649 5.2005
R1883 vw.n33 vw.n31 5.2005
R1884 vw.n31 vw.n27 5.2005
R1885 vw.n44 vw.n43 5.2005
R1886 vw.n45 vw.n44 5.2005
R1887 vw.n40 vw.n17 5.2005
R1888 vw.n18 vw.n17 5.2005
R1889 vw.n629 vw.n628 5.2005
R1890 vw.n628 vw.n627 5.2005
R1891 vw.n630 vw.n70 5.2005
R1892 vw.n160 vw.n70 5.2005
R1893 vw.n626 vw.n625 5.2005
R1894 vw.n627 vw.n626 5.2005
R1895 vw.n76 vw.n71 5.2005
R1896 vw.n160 vw.n71 5.2005
R1897 vw.n609 vw.n83 5.2005
R1898 vw.n616 vw.n83 5.2005
R1899 vw.n608 vw.n80 5.2005
R1900 vw.n617 vw.n80 5.2005
R1901 vw.n615 vw.n614 5.2005
R1902 vw.n616 vw.n615 5.2005
R1903 vw.n86 vw.n81 5.2005
R1904 vw.n617 vw.n81 5.2005
R1905 vw.n585 vw.n104 5.2005
R1906 vw.n596 vw.n104 5.2005
R1907 vw.n584 vw.n89 5.2005
R1908 vw.n102 vw.n89 5.2005
R1909 vw.n595 vw.n594 5.2005
R1910 vw.n596 vw.n595 5.2005
R1911 vw.n107 vw.n90 5.2005
R1912 vw.n102 vw.n90 5.2005
R1913 vw.n128 vw.n125 5.2005
R1914 vw.n125 vw.n122 5.2005
R1915 vw.n127 vw.n110 5.2005
R1916 vw.n114 vw.n110 5.2005
R1917 vw.n567 vw.n126 5.2005
R1918 vw.n126 vw.n122 5.2005
R1919 vw.n566 vw.n111 5.2005
R1920 vw.n114 vw.n111 5.2005
R1921 vw.n283 vw.n282 5.2005
R1922 vw.n442 vw.n441 5.2005
R1923 vw.n439 vw.n285 5.2005
R1924 vw.n437 vw.n436 5.2005
R1925 vw.n426 vw.n425 5.2005
R1926 vw.n428 vw.n393 5.2005
R1927 vw.n429 vw.n288 5.2005
R1928 vw.n432 vw.n431 5.2005
R1929 vw.n503 vw.n502 5.2005
R1930 vw.n505 vw.n504 5.2005
R1931 vw.n507 vw.n506 5.2005
R1932 vw.n508 vw.n217 5.2005
R1933 vw.n510 vw.n509 5.2005
R1934 vw.n511 vw.n510 5.2005
R1935 vw.n262 vw.n261 5.2005
R1936 vw.n265 vw.n264 5.2005
R1937 vw.n263 vw.n234 5.2005
R1938 vw.n269 vw.n231 5.2005
R1939 vw.n271 vw.n270 5.2005
R1940 vw.n272 vw.n271 5.2005
R1941 vw.n366 vw.n319 5.2005
R1942 vw.n364 vw.n363 5.2005
R1943 vw.n321 vw.n320 5.2005
R1944 vw.n359 vw.n358 5.2005
R1945 vw.n356 vw.n323 5.2005
R1946 vw.n354 vw.n353 5.2005
R1947 vw.n325 vw.n324 5.2005
R1948 vw.n349 vw.n348 5.2005
R1949 vw.n346 vw.n327 5.2005
R1950 vw.n344 vw.n343 5.2005
R1951 vw.n329 vw.n328 5.2005
R1952 vw.n339 vw.n338 5.2005
R1953 vw.n336 vw.n331 5.2005
R1954 vw.n334 vw.n333 5.2005
R1955 vw.n317 vw.n290 5.2005
R1956 vw.n392 vw.n290 5.2005
R1957 vw.n372 vw.n316 5.2005
R1958 vw.n373 vw.n315 5.2005
R1959 vw.n374 vw.n314 5.2005
R1960 vw.n312 vw.n311 5.2005
R1961 vw.n378 vw.n310 5.2005
R1962 vw.n379 vw.n309 5.2005
R1963 vw.n380 vw.n308 5.2005
R1964 vw.n306 vw.n305 5.2005
R1965 vw.n384 vw.n304 5.2005
R1966 vw.n385 vw.n303 5.2005
R1967 vw.n386 vw.n302 5.2005
R1968 vw.n299 vw.n298 5.2005
R1969 vw.n391 vw.n390 5.2005
R1970 vw.n392 vw.n391 5.2005
R1971 vw.n570 vw.n129 5.20011
R1972 vw.n582 vw.n109 5.20011
R1973 vw.n606 vw.n88 5.20011
R1974 vw.n620 vw.n79 5.20011
R1975 vw.n622 vw.n72 5.20011
R1976 vw.n632 vw.n631 5.20011
R1977 vw.n611 vw.n610 5.19229
R1978 vw.n661 vw.n15 5.19017
R1979 vw.n644 vw.n36 5.18235
R1980 vw.n206 vw.n205 5.17941
R1981 vw.n656 vw.n655 5.17941
R1982 vw.n656 vw.n21 5.17941
R1983 vw.n664 vw.n12 5.17941
R1984 vw.n521 vw.n146 5.17941
R1985 vw.n522 vw.n521 5.17941
R1986 vw.n233 vw.n232 5.17941
R1987 vw.n232 vw.n218 5.17941
R1988 vw.n466 vw.n2 5.17941
R1989 vw.n434 vw.n433 5.17941
R1990 vw.n435 vw.n434 5.17941
R1991 vw.n389 vw.n300 5.17941
R1992 vw.n332 vw.n300 5.17941
R1993 vw.n368 vw.n318 5.17159
R1994 vw.n207 vw.n1 5.15985
R1995 vw.n672 vw.n671 5.15985
R1996 vw.n369 vw.n0 5.15985
R1997 vw.n590 vw.n586 5.07
R1998 vw.n645 vw.n644 4.96517
R1999 vw.n662 vw.n661 4.96517
R2000 vw.n664 vw.n663 4.95441
R2001 vw.n583 vw.n582 4.95441
R2002 vw.n592 vw.n591 4.95441
R2003 vw.n607 vw.n606 4.95441
R2004 vw.n612 vw.n611 4.95441
R2005 vw.n621 vw.n620 4.95441
R2006 vw.n623 vw.n622 4.95441
R2007 vw.n632 vw.n35 4.95441
R2008 vw.n569 vw.n568 4.7462
R2009 vw.n208 vw.n207 4.7255
R2010 vw.n565 vw.n564 4.7255
R2011 vw.n130 vw.n120 4.7255
R2012 vw.n671 vw.n670 4.7255
R2013 vw.n370 vw.n369 4.7255
R2014 vw.n653 vw.n22 4.5005
R2015 vw.n652 vw.n24 4.5005
R2016 vw.n60 vw.n25 4.5005
R2017 vw.n61 vw.n59 4.5005
R2018 vw.n639 vw.n62 4.5005
R2019 vw.n638 vw.n63 4.5005
R2020 vw.n637 vw.n64 4.5005
R2021 vw.n162 vw.n65 4.5005
R2022 vw.n169 vw.n163 4.5005
R2023 vw.n168 vw.n164 4.5005
R2024 vw.n167 vw.n165 4.5005
R2025 vw.n157 vw.n156 4.5005
R2026 vw.n209 vw.n208 4.5005
R2027 vw.n655 vw.n654 4.5005
R2028 vw.n180 vw.n179 4.5005
R2029 vw.n182 vw.n181 4.5005
R2030 vw.n183 vw.n176 4.5005
R2031 vw.n187 vw.n186 4.5005
R2032 vw.n188 vw.n175 4.5005
R2033 vw.n191 vw.n189 4.5005
R2034 vw.n192 vw.n174 4.5005
R2035 vw.n195 vw.n194 4.5005
R2036 vw.n196 vw.n173 4.5005
R2037 vw.n199 vw.n198 4.5005
R2038 vw.n197 vw.n159 4.5005
R2039 vw.n203 vw.n158 4.5005
R2040 vw.n205 vw.n204 4.5005
R2041 vw.n177 vw.n21 4.5005
R2042 vw.n48 vw.n47 4.5005
R2043 vw.n49 vw.n37 4.5005
R2044 vw.n51 vw.n50 4.5005
R2045 vw.n52 vw.n36 4.5005
R2046 vw.n38 vw.n15 4.5005
R2047 vw.n530 vw.n529 4.5005
R2048 vw.n531 vw.n145 4.5005
R2049 vw.n533 vw.n532 4.5005
R2050 vw.n535 vw.n144 4.5005
R2051 vw.n537 vw.n536 4.5005
R2052 vw.n538 vw.n143 4.5005
R2053 vw.n540 vw.n539 4.5005
R2054 vw.n135 vw.n134 4.5005
R2055 vw.n556 vw.n555 4.5005
R2056 vw.n557 vw.n133 4.5005
R2057 vw.n559 vw.n558 4.5005
R2058 vw.n562 vw.n132 4.5005
R2059 vw.n564 vw.n563 4.5005
R2060 vw.n147 vw.n146 4.5005
R2061 vw.n525 vw.n524 4.5005
R2062 vw.n523 vw.n96 4.5005
R2063 vw.n601 vw.n97 4.5005
R2064 vw.n600 vw.n98 4.5005
R2065 vw.n599 vw.n99 4.5005
R2066 vw.n141 vw.n100 4.5005
R2067 vw.n547 vw.n546 4.5005
R2068 vw.n548 vw.n140 4.5005
R2069 vw.n551 vw.n550 4.5005
R2070 vw.n549 vw.n117 4.5005
R2071 vw.n577 vw.n118 4.5005
R2072 vw.n576 vw.n119 4.5005
R2073 vw.n575 vw.n120 4.5005
R2074 vw.n522 vw.n519 4.5005
R2075 vw.n129 vw.n128 4.5005
R2076 vw.n127 vw.n109 4.5005
R2077 vw.n586 vw.n585 4.5005
R2078 vw.n584 vw.n88 4.5005
R2079 vw.n610 vw.n609 4.5005
R2080 vw.n608 vw.n79 4.5005
R2081 vw.n629 vw.n72 4.5005
R2082 vw.n631 vw.n630 4.5005
R2083 vw.n625 vw.n624 4.5005
R2084 vw.n77 vw.n76 4.5005
R2085 vw.n614 vw.n613 4.5005
R2086 vw.n86 vw.n78 4.5005
R2087 vw.n594 vw.n593 4.5005
R2088 vw.n107 vw.n87 4.5005
R2089 vw.n568 vw.n567 4.5005
R2090 vw.n566 vw.n108 4.5005
R2091 vw.n43 vw.n42 4.5005
R2092 vw.n41 vw.n33 4.5005
R2093 vw.n648 vw.n34 4.5005
R2094 vw.n647 vw.n646 4.5005
R2095 vw.n40 vw.n14 4.5005
R2096 vw.n269 vw.n268 4.5005
R2097 vw.n267 vw.n234 4.5005
R2098 vw.n266 vw.n265 4.5005
R2099 vw.n262 vw.n235 4.5005
R2100 vw.n259 vw.n236 4.5005
R2101 vw.n258 vw.n237 4.5005
R2102 vw.n255 vw.n238 4.5005
R2103 vw.n254 vw.n239 4.5005
R2104 vw.n251 vw.n240 4.5005
R2105 vw.n250 vw.n241 4.5005
R2106 vw.n247 vw.n242 4.5005
R2107 vw.n246 vw.n243 4.5005
R2108 vw.n244 vw.n13 4.5005
R2109 vw.n270 vw.n233 4.5005
R2110 vw.n508 vw.n219 4.5005
R2111 vw.n507 vw.n220 4.5005
R2112 vw.n504 vw.n221 4.5005
R2113 vw.n503 vw.n222 4.5005
R2114 vw.n475 vw.n223 4.5005
R2115 vw.n498 vw.n476 4.5005
R2116 vw.n497 vw.n477 4.5005
R2117 vw.n496 vw.n478 4.5005
R2118 vw.n482 vw.n479 4.5005
R2119 vw.n491 vw.n483 4.5005
R2120 vw.n490 vw.n484 4.5005
R2121 vw.n489 vw.n485 4.5005
R2122 vw.n486 vw.n12 4.5005
R2123 vw.n509 vw.n218 4.5005
R2124 vw.n288 vw.n287 4.5005
R2125 vw.n395 vw.n393 4.5005
R2126 vw.n425 vw.n396 4.5005
R2127 vw.n424 vw.n397 4.5005
R2128 vw.n423 vw.n398 4.5005
R2129 vw.n403 vw.n399 4.5005
R2130 vw.n418 vw.n404 4.5005
R2131 vw.n417 vw.n405 4.5005
R2132 vw.n416 vw.n406 4.5005
R2133 vw.n409 vw.n407 4.5005
R2134 vw.n411 vw.n410 4.5005
R2135 vw.n4 vw.n3 4.5005
R2136 vw.n670 vw.n669 4.5005
R2137 vw.n433 vw.n432 4.5005
R2138 vw.n285 vw.n284 4.5005
R2139 vw.n443 vw.n442 4.5005
R2140 vw.n444 vw.n283 4.5005
R2141 vw.n446 vw.n445 4.5005
R2142 vw.n281 vw.n280 4.5005
R2143 vw.n453 vw.n452 4.5005
R2144 vw.n454 vw.n279 4.5005
R2145 vw.n456 vw.n455 4.5005
R2146 vw.n277 vw.n276 4.5005
R2147 vw.n463 vw.n462 4.5005
R2148 vw.n464 vw.n275 4.5005
R2149 vw.n468 vw.n465 4.5005
R2150 vw.n467 vw.n466 4.5005
R2151 vw.n436 vw.n435 4.5005
R2152 vw.n388 vw.n299 4.5005
R2153 vw.n387 vw.n386 4.5005
R2154 vw.n385 vw.n301 4.5005
R2155 vw.n384 vw.n383 4.5005
R2156 vw.n382 vw.n306 4.5005
R2157 vw.n381 vw.n380 4.5005
R2158 vw.n379 vw.n307 4.5005
R2159 vw.n378 vw.n377 4.5005
R2160 vw.n376 vw.n312 4.5005
R2161 vw.n375 vw.n374 4.5005
R2162 vw.n373 vw.n313 4.5005
R2163 vw.n372 vw.n371 4.5005
R2164 vw.n370 vw.n317 4.5005
R2165 vw.n390 vw.n389 4.5005
R2166 vw.n331 vw.n330 4.5005
R2167 vw.n340 vw.n339 4.5005
R2168 vw.n341 vw.n329 4.5005
R2169 vw.n343 vw.n342 4.5005
R2170 vw.n327 vw.n326 4.5005
R2171 vw.n350 vw.n349 4.5005
R2172 vw.n351 vw.n325 4.5005
R2173 vw.n353 vw.n352 4.5005
R2174 vw.n323 vw.n322 4.5005
R2175 vw.n360 vw.n359 4.5005
R2176 vw.n361 vw.n321 4.5005
R2177 vw.n363 vw.n362 4.5005
R2178 vw.n319 vw.n318 4.5005
R2179 vw.n333 vw.n332 4.5005
R2180 vw.n616 vw.n84 3.5869
R2181 vw.n263 vw.n230 3.11744
R2182 vw.n261 vw.n229 3.11744
R2183 vw.n257 vw.n224 3.11744
R2184 vw.n253 vw.n225 3.11744
R2185 vw.n249 vw.n226 3.11744
R2186 vw.n245 vw.n227 3.11744
R2187 vw.n506 vw.n215 3.11744
R2188 vw.n502 vw.n214 3.11744
R2189 vw.n500 vw.n499 3.11744
R2190 vw.n495 vw.n480 3.11744
R2191 vw.n493 vw.n492 3.11744
R2192 vw.n488 vw.n487 3.11744
R2193 vw.n430 vw.n429 3.11744
R2194 vw.n427 vw.n426 3.11744
R2195 vw.n422 vw.n400 3.11744
R2196 vw.n420 vw.n419 3.11744
R2197 vw.n415 vw.n408 3.11744
R2198 vw.n413 vw.n412 3.11744
R2199 vw.n439 vw.n438 3.11744
R2200 vw.n440 vw.n282 3.11744
R2201 vw.n449 vw.n448 3.11744
R2202 vw.n450 vw.n278 3.11744
R2203 vw.n459 vw.n458 3.11744
R2204 vw.n460 vw.n274 3.11744
R2205 vw.n461 vw.n460 3.11744
R2206 vw.n458 vw.n457 3.11744
R2207 vw.n451 vw.n450 3.11744
R2208 vw.n448 vw.n447 3.11744
R2209 vw.n414 vw.n413 3.11744
R2210 vw.n408 vw.n402 3.11744
R2211 vw.n421 vw.n420 3.11744
R2212 vw.n400 vw.n394 3.11744
R2213 vw.n487 vw.n481 3.11744
R2214 vw.n494 vw.n493 3.11744
R2215 vw.n480 vw.n474 3.11744
R2216 vw.n501 vw.n500 3.11744
R2217 vw.n248 vw.n227 3.11744
R2218 vw.n252 vw.n226 3.11744
R2219 vw.n256 vw.n225 3.11744
R2220 vw.n260 vw.n224 3.11744
R2221 vw.n441 vw.n440 3.11744
R2222 vw.n438 vw.n437 3.11744
R2223 vw.n428 vw.n427 3.11744
R2224 vw.n431 vw.n430 3.11744
R2225 vw.n505 vw.n214 3.11744
R2226 vw.n217 vw.n215 3.11744
R2227 vw.n264 vw.n229 3.11744
R2228 vw.n231 vw.n230 3.11744
R2229 vw.n335 vw.n334 3.11744
R2230 vw.n338 vw.n337 3.11744
R2231 vw.n345 vw.n344 3.11744
R2232 vw.n348 vw.n347 3.11744
R2233 vw.n355 vw.n354 3.11744
R2234 vw.n358 vw.n357 3.11744
R2235 vw.n365 vw.n364 3.11744
R2236 vw.n366 vw.n365 3.11744
R2237 vw.n357 vw.n320 3.11744
R2238 vw.n356 vw.n355 3.11744
R2239 vw.n347 vw.n324 3.11744
R2240 vw.n346 vw.n345 3.11744
R2241 vw.n337 vw.n328 3.11744
R2242 vw.n336 vw.n335 3.11744
R2243 vw.n302 vw.n296 3.11744
R2244 vw.n304 vw.n295 3.11744
R2245 vw.n308 vw.n294 3.11744
R2246 vw.n310 vw.n293 3.11744
R2247 vw.n314 vw.n292 3.11744
R2248 vw.n316 vw.n291 3.11744
R2249 vw.n315 vw.n291 3.11744
R2250 vw.n311 vw.n292 3.11744
R2251 vw.n309 vw.n293 3.11744
R2252 vw.n305 vw.n294 3.11744
R2253 vw.n303 vw.n295 3.11744
R2254 vw.n298 vw.n296 3.11744
R2255 vw.n67 vw.n56 2.86962
R2256 vw vw.n0 1.45515
R2257 vw.n618 vw.n82 1.43506
R2258 vw.n672 vw.n1 1.3649
R2259 vw.n460 vw.n273 1.04278
R2260 vw.n458 vw.n273 1.04278
R2261 vw.n450 vw.n273 1.04278
R2262 vw.n448 vw.n273 1.04278
R2263 vw.n413 vw.n401 1.04278
R2264 vw.n408 vw.n401 1.04278
R2265 vw.n420 vw.n401 1.04278
R2266 vw.n401 vw.n400 1.04278
R2267 vw.n487 vw.n473 1.04278
R2268 vw.n493 vw.n473 1.04278
R2269 vw.n480 vw.n473 1.04278
R2270 vw.n500 vw.n473 1.04278
R2271 vw.n472 vw.n227 1.04278
R2272 vw.n472 vw.n226 1.04278
R2273 vw.n472 vw.n225 1.04278
R2274 vw.n472 vw.n224 1.04278
R2275 vw.n440 vw.n228 1.04278
R2276 vw.n438 vw.n228 1.04278
R2277 vw.n427 vw.n392 1.04278
R2278 vw.n430 vw.n392 1.04278
R2279 vw.n511 vw.n214 1.04278
R2280 vw.n511 vw.n215 1.04278
R2281 vw.n272 vw.n229 1.04278
R2282 vw.n272 vw.n230 1.04278
R2283 vw.n365 vw.n228 1.04278
R2284 vw.n357 vw.n228 1.04278
R2285 vw.n355 vw.n228 1.04278
R2286 vw.n347 vw.n228 1.04278
R2287 vw.n345 vw.n228 1.04278
R2288 vw.n337 vw.n228 1.04278
R2289 vw.n335 vw.n228 1.04278
R2290 vw.n392 vw.n291 1.04278
R2291 vw.n392 vw.n292 1.04278
R2292 vw.n392 vw.n293 1.04278
R2293 vw.n392 vw.n294 1.04278
R2294 vw.n392 vw.n295 1.04278
R2295 vw.n392 vw.n296 1.04278
R2296 vw vw.n0 0.7592
R2297 vw.n6 vw.n2 0.743357
R2298 vw.n9 vw.n6 0.743357
R2299 vw.n657 vw.n656 0.743357
R2300 vw.n658 vw.n657 0.743357
R2301 vw.n206 vw.n155 0.743357
R2302 vw.n155 vw.n82 0.743357
R2303 vw.n521 vw.n520 0.743357
R2304 vw.n520 vw.n84 0.743357
R2305 vw.n131 vw.n121 0.743357
R2306 vw.n572 vw.n121 0.743357
R2307 vw.n665 vw.n664 0.743357
R2308 vw.n666 vw.n665 0.743357
R2309 vw.n661 vw.n660 0.743357
R2310 vw.n660 vw.n659 0.743357
R2311 vw.n644 vw.n643 0.743357
R2312 vw.n643 vw.n642 0.743357
R2313 vw.n633 vw.n632 0.743357
R2314 vw.n634 vw.n633 0.743357
R2315 vw.n622 vw.n73 0.743357
R2316 vw.n151 vw.n73 0.743357
R2317 vw.n620 vw.n619 0.743357
R2318 vw.n619 vw.n618 0.743357
R2319 vw.n611 vw.n85 0.743357
R2320 vw.n150 vw.n85 0.743357
R2321 vw.n606 vw.n605 0.743357
R2322 vw.n605 vw.n604 0.743357
R2323 vw.n591 vw.n106 0.743357
R2324 vw.n543 vw.n106 0.743357
R2325 vw.n582 vw.n581 0.743357
R2326 vw.n581 vw.n580 0.743357
R2327 vw.n571 vw.n570 0.743357
R2328 vw.n572 vw.n571 0.743357
R2329 vw.n434 vw.n286 0.743357
R2330 vw.n289 vw.n286 0.743357
R2331 vw.n232 vw.n216 0.743357
R2332 vw.n216 vw.n213 0.743357
R2333 vw.n300 vw.n297 0.743357
R2334 vw.n297 vw.n289 0.743357
R2335 vw.n368 vw.n367 0.743357
R2336 vw.n367 vw.n289 0.743357
R2337 vw vw.n672 0.6026
R2338 vw.n207 vw.n206 0.454413
R2339 vw.n131 vw.n130 0.454413
R2340 vw.n565 vw.n131 0.454413
R2341 vw.n570 vw.n569 0.454413
R2342 vw.n671 vw.n2 0.454413
R2343 vw.n369 vw.n368 0.454413
R2344 vw.n569 vw.n565 0.427022
R2345 vw.n623 vw.n621 0.4073
R2346 vw.n612 vw.n607 0.4073
R2347 vw.n592 vw.n583 0.4073
R2348 vw.n645 vw.n35 0.402841
R2349 vw.n663 vw.n662 0.402841
R2350 vw.n77 vw.n35 0.2462
R2351 vw.n624 vw.n623 0.2462
R2352 vw.n621 vw.n78 0.2462
R2353 vw.n613 vw.n612 0.2462
R2354 vw.n607 vw.n87 0.2462
R2355 vw.n593 vw.n592 0.2462
R2356 vw.n583 vw.n108 0.2462
R2357 vw.n663 vw.n13 0.2255
R2358 vw.n662 vw.n14 0.203203
R2359 vw.n646 vw.n645 0.203203
R2360 vw.n654 vw.n653 0.1445
R2361 vw.n653 vw.n652 0.1445
R2362 vw.n652 vw.n25 0.1445
R2363 vw.n59 vw.n25 0.1445
R2364 vw.n639 vw.n59 0.1445
R2365 vw.n639 vw.n638 0.1445
R2366 vw.n638 vw.n637 0.1445
R2367 vw.n637 vw.n65 0.1445
R2368 vw.n169 vw.n65 0.1445
R2369 vw.n169 vw.n168 0.1445
R2370 vw.n168 vw.n167 0.1445
R2371 vw.n167 vw.n156 0.1445
R2372 vw.n209 vw.n156 0.1445
R2373 vw.n655 vw.n22 0.1445
R2374 vw.n24 vw.n22 0.1445
R2375 vw.n60 vw.n24 0.1445
R2376 vw.n61 vw.n60 0.1445
R2377 vw.n62 vw.n61 0.1445
R2378 vw.n63 vw.n62 0.1445
R2379 vw.n64 vw.n63 0.1445
R2380 vw.n162 vw.n64 0.1445
R2381 vw.n163 vw.n162 0.1445
R2382 vw.n164 vw.n163 0.1445
R2383 vw.n165 vw.n164 0.1445
R2384 vw.n165 vw.n157 0.1445
R2385 vw.n208 vw.n157 0.1445
R2386 vw.n180 vw.n21 0.1445
R2387 vw.n181 vw.n180 0.1445
R2388 vw.n181 vw.n176 0.1445
R2389 vw.n187 vw.n176 0.1445
R2390 vw.n188 vw.n187 0.1445
R2391 vw.n189 vw.n188 0.1445
R2392 vw.n189 vw.n174 0.1445
R2393 vw.n195 vw.n174 0.1445
R2394 vw.n196 vw.n195 0.1445
R2395 vw.n198 vw.n196 0.1445
R2396 vw.n198 vw.n197 0.1445
R2397 vw.n197 vw.n158 0.1445
R2398 vw.n205 vw.n158 0.1445
R2399 vw.n179 vw.n177 0.1445
R2400 vw.n182 vw.n179 0.1445
R2401 vw.n183 vw.n182 0.1445
R2402 vw.n186 vw.n183 0.1445
R2403 vw.n186 vw.n175 0.1445
R2404 vw.n191 vw.n175 0.1445
R2405 vw.n192 vw.n191 0.1445
R2406 vw.n194 vw.n192 0.1445
R2407 vw.n194 vw.n173 0.1445
R2408 vw.n199 vw.n173 0.1445
R2409 vw.n199 vw.n159 0.1445
R2410 vw.n203 vw.n159 0.1445
R2411 vw.n204 vw.n203 0.1445
R2412 vw.n270 vw.n269 0.1445
R2413 vw.n269 vw.n234 0.1445
R2414 vw.n265 vw.n234 0.1445
R2415 vw.n265 vw.n262 0.1445
R2416 vw.n262 vw.n259 0.1445
R2417 vw.n259 vw.n258 0.1445
R2418 vw.n258 vw.n255 0.1445
R2419 vw.n255 vw.n254 0.1445
R2420 vw.n254 vw.n251 0.1445
R2421 vw.n251 vw.n250 0.1445
R2422 vw.n250 vw.n247 0.1445
R2423 vw.n247 vw.n246 0.1445
R2424 vw.n246 vw.n244 0.1445
R2425 vw.n43 vw.n40 0.1445
R2426 vw.n43 vw.n33 0.1445
R2427 vw.n648 vw.n33 0.1445
R2428 vw.n648 vw.n647 0.1445
R2429 vw.n47 vw.n38 0.1445
R2430 vw.n47 vw.n37 0.1445
R2431 vw.n51 vw.n37 0.1445
R2432 vw.n52 vw.n51 0.1445
R2433 vw.n48 vw.n15 0.1445
R2434 vw.n49 vw.n48 0.1445
R2435 vw.n50 vw.n49 0.1445
R2436 vw.n50 vw.n36 0.1445
R2437 vw.n567 vw.n566 0.1445
R2438 vw.n594 vw.n107 0.1445
R2439 vw.n614 vw.n86 0.1445
R2440 vw.n625 vw.n76 0.1445
R2441 vw.n128 vw.n127 0.1445
R2442 vw.n525 vw.n519 0.1445
R2443 vw.n525 vw.n96 0.1445
R2444 vw.n601 vw.n96 0.1445
R2445 vw.n601 vw.n600 0.1445
R2446 vw.n600 vw.n599 0.1445
R2447 vw.n599 vw.n100 0.1445
R2448 vw.n546 vw.n100 0.1445
R2449 vw.n546 vw.n140 0.1445
R2450 vw.n551 vw.n140 0.1445
R2451 vw.n551 vw.n117 0.1445
R2452 vw.n577 vw.n117 0.1445
R2453 vw.n577 vw.n576 0.1445
R2454 vw.n576 vw.n575 0.1445
R2455 vw.n529 vw.n147 0.1445
R2456 vw.n529 vw.n145 0.1445
R2457 vw.n533 vw.n145 0.1445
R2458 vw.n535 vw.n533 0.1445
R2459 vw.n536 vw.n535 0.1445
R2460 vw.n536 vw.n143 0.1445
R2461 vw.n540 vw.n143 0.1445
R2462 vw.n540 vw.n135 0.1445
R2463 vw.n555 vw.n135 0.1445
R2464 vw.n555 vw.n133 0.1445
R2465 vw.n559 vw.n133 0.1445
R2466 vw.n562 vw.n559 0.1445
R2467 vw.n563 vw.n562 0.1445
R2468 vw.n530 vw.n146 0.1445
R2469 vw.n531 vw.n530 0.1445
R2470 vw.n532 vw.n531 0.1445
R2471 vw.n532 vw.n144 0.1445
R2472 vw.n537 vw.n144 0.1445
R2473 vw.n538 vw.n537 0.1445
R2474 vw.n539 vw.n538 0.1445
R2475 vw.n539 vw.n134 0.1445
R2476 vw.n556 vw.n134 0.1445
R2477 vw.n557 vw.n556 0.1445
R2478 vw.n558 vw.n557 0.1445
R2479 vw.n558 vw.n132 0.1445
R2480 vw.n564 vw.n132 0.1445
R2481 vw.n524 vw.n522 0.1445
R2482 vw.n524 vw.n523 0.1445
R2483 vw.n523 vw.n97 0.1445
R2484 vw.n98 vw.n97 0.1445
R2485 vw.n99 vw.n98 0.1445
R2486 vw.n141 vw.n99 0.1445
R2487 vw.n547 vw.n141 0.1445
R2488 vw.n548 vw.n547 0.1445
R2489 vw.n550 vw.n548 0.1445
R2490 vw.n550 vw.n549 0.1445
R2491 vw.n549 vw.n118 0.1445
R2492 vw.n119 vw.n118 0.1445
R2493 vw.n120 vw.n119 0.1445
R2494 vw.n129 vw.n109 0.1445
R2495 vw.n585 vw.n584 0.1445
R2496 vw.n586 vw.n88 0.1445
R2497 vw.n609 vw.n608 0.1445
R2498 vw.n610 vw.n79 0.1445
R2499 vw.n630 vw.n629 0.1445
R2500 vw.n631 vw.n72 0.1445
R2501 vw.n624 vw.n77 0.1445
R2502 vw.n613 vw.n78 0.1445
R2503 vw.n593 vw.n87 0.1445
R2504 vw.n568 vw.n108 0.1445
R2505 vw.n268 vw.n233 0.1445
R2506 vw.n268 vw.n267 0.1445
R2507 vw.n267 vw.n266 0.1445
R2508 vw.n266 vw.n235 0.1445
R2509 vw.n236 vw.n235 0.1445
R2510 vw.n237 vw.n236 0.1445
R2511 vw.n238 vw.n237 0.1445
R2512 vw.n239 vw.n238 0.1445
R2513 vw.n240 vw.n239 0.1445
R2514 vw.n241 vw.n240 0.1445
R2515 vw.n242 vw.n241 0.1445
R2516 vw.n243 vw.n242 0.1445
R2517 vw.n243 vw.n13 0.1445
R2518 vw.n219 vw.n218 0.1445
R2519 vw.n220 vw.n219 0.1445
R2520 vw.n221 vw.n220 0.1445
R2521 vw.n222 vw.n221 0.1445
R2522 vw.n475 vw.n222 0.1445
R2523 vw.n476 vw.n475 0.1445
R2524 vw.n477 vw.n476 0.1445
R2525 vw.n478 vw.n477 0.1445
R2526 vw.n482 vw.n478 0.1445
R2527 vw.n483 vw.n482 0.1445
R2528 vw.n484 vw.n483 0.1445
R2529 vw.n485 vw.n484 0.1445
R2530 vw.n485 vw.n12 0.1445
R2531 vw.n509 vw.n508 0.1445
R2532 vw.n508 vw.n507 0.1445
R2533 vw.n507 vw.n504 0.1445
R2534 vw.n504 vw.n503 0.1445
R2535 vw.n503 vw.n223 0.1445
R2536 vw.n498 vw.n223 0.1445
R2537 vw.n498 vw.n497 0.1445
R2538 vw.n497 vw.n496 0.1445
R2539 vw.n496 vw.n479 0.1445
R2540 vw.n491 vw.n479 0.1445
R2541 vw.n491 vw.n490 0.1445
R2542 vw.n490 vw.n489 0.1445
R2543 vw.n489 vw.n486 0.1445
R2544 vw.n432 vw.n288 0.1445
R2545 vw.n393 vw.n288 0.1445
R2546 vw.n425 vw.n393 0.1445
R2547 vw.n425 vw.n424 0.1445
R2548 vw.n424 vw.n423 0.1445
R2549 vw.n423 vw.n399 0.1445
R2550 vw.n418 vw.n399 0.1445
R2551 vw.n418 vw.n417 0.1445
R2552 vw.n417 vw.n416 0.1445
R2553 vw.n416 vw.n407 0.1445
R2554 vw.n411 vw.n407 0.1445
R2555 vw.n411 vw.n4 0.1445
R2556 vw.n669 vw.n4 0.1445
R2557 vw.n433 vw.n287 0.1445
R2558 vw.n395 vw.n287 0.1445
R2559 vw.n396 vw.n395 0.1445
R2560 vw.n397 vw.n396 0.1445
R2561 vw.n398 vw.n397 0.1445
R2562 vw.n403 vw.n398 0.1445
R2563 vw.n404 vw.n403 0.1445
R2564 vw.n405 vw.n404 0.1445
R2565 vw.n406 vw.n405 0.1445
R2566 vw.n409 vw.n406 0.1445
R2567 vw.n410 vw.n409 0.1445
R2568 vw.n410 vw.n3 0.1445
R2569 vw.n670 vw.n3 0.1445
R2570 vw.n435 vw.n284 0.1445
R2571 vw.n443 vw.n284 0.1445
R2572 vw.n444 vw.n443 0.1445
R2573 vw.n445 vw.n444 0.1445
R2574 vw.n445 vw.n280 0.1445
R2575 vw.n453 vw.n280 0.1445
R2576 vw.n454 vw.n453 0.1445
R2577 vw.n455 vw.n454 0.1445
R2578 vw.n455 vw.n276 0.1445
R2579 vw.n463 vw.n276 0.1445
R2580 vw.n464 vw.n463 0.1445
R2581 vw.n465 vw.n464 0.1445
R2582 vw.n466 vw.n465 0.1445
R2583 vw.n436 vw.n285 0.1445
R2584 vw.n442 vw.n285 0.1445
R2585 vw.n442 vw.n283 0.1445
R2586 vw.n446 vw.n283 0.1445
R2587 vw.n446 vw.n281 0.1445
R2588 vw.n452 vw.n281 0.1445
R2589 vw.n452 vw.n279 0.1445
R2590 vw.n456 vw.n279 0.1445
R2591 vw.n456 vw.n277 0.1445
R2592 vw.n462 vw.n277 0.1445
R2593 vw.n462 vw.n275 0.1445
R2594 vw.n468 vw.n275 0.1445
R2595 vw.n468 vw.n467 0.1445
R2596 vw.n333 vw.n331 0.1445
R2597 vw.n339 vw.n331 0.1445
R2598 vw.n339 vw.n329 0.1445
R2599 vw.n343 vw.n329 0.1445
R2600 vw.n343 vw.n327 0.1445
R2601 vw.n349 vw.n327 0.1445
R2602 vw.n349 vw.n325 0.1445
R2603 vw.n353 vw.n325 0.1445
R2604 vw.n353 vw.n323 0.1445
R2605 vw.n359 vw.n323 0.1445
R2606 vw.n359 vw.n321 0.1445
R2607 vw.n363 vw.n321 0.1445
R2608 vw.n363 vw.n319 0.1445
R2609 vw.n390 vw.n299 0.1445
R2610 vw.n386 vw.n299 0.1445
R2611 vw.n386 vw.n385 0.1445
R2612 vw.n385 vw.n384 0.1445
R2613 vw.n384 vw.n306 0.1445
R2614 vw.n380 vw.n306 0.1445
R2615 vw.n380 vw.n379 0.1445
R2616 vw.n379 vw.n378 0.1445
R2617 vw.n378 vw.n312 0.1445
R2618 vw.n374 vw.n312 0.1445
R2619 vw.n374 vw.n373 0.1445
R2620 vw.n373 vw.n372 0.1445
R2621 vw.n372 vw.n317 0.1445
R2622 vw.n389 vw.n388 0.1445
R2623 vw.n388 vw.n387 0.1445
R2624 vw.n387 vw.n301 0.1445
R2625 vw.n383 vw.n301 0.1445
R2626 vw.n383 vw.n382 0.1445
R2627 vw.n382 vw.n381 0.1445
R2628 vw.n381 vw.n307 0.1445
R2629 vw.n377 vw.n307 0.1445
R2630 vw.n377 vw.n376 0.1445
R2631 vw.n376 vw.n375 0.1445
R2632 vw.n375 vw.n313 0.1445
R2633 vw.n371 vw.n313 0.1445
R2634 vw.n371 vw.n370 0.1445
R2635 vw.n332 vw.n330 0.1445
R2636 vw.n340 vw.n330 0.1445
R2637 vw.n341 vw.n340 0.1445
R2638 vw.n342 vw.n341 0.1445
R2639 vw.n342 vw.n326 0.1445
R2640 vw.n350 vw.n326 0.1445
R2641 vw.n351 vw.n350 0.1445
R2642 vw.n352 vw.n351 0.1445
R2643 vw.n352 vw.n322 0.1445
R2644 vw.n360 vw.n322 0.1445
R2645 vw.n361 vw.n360 0.1445
R2646 vw.n362 vw.n361 0.1445
R2647 vw.n362 vw.n318 0.1445
R2648 vw.n42 vw.n14 0.13023
R2649 vw.n42 vw.n41 0.13023
R2650 vw.n41 vw.n34 0.13023
R2651 vw.n646 vw.n34 0.13023
R2652 vw.n591 vw.n590 0.122783
R2653 vb_itd vb_itd.n0 5.38731
R2654 vb_pot vb_pot.n0 6.19174
R2655 vpost vpost.n0 24.5769
R2656 vpre vpre.n0 24.5769
R2657 vb_idep vb_idep.n0 18.6975
R2658 vb_itp vb_itp.n0 4.94853
R2659 nvpre nvpre.n0 24.5769
R2660 nvpost nvpost.n0 24.5769
C0 avdd xm12_0/a_63_n131# 0
C1 xm9_0/a_63_n131# xm7_0/a_63_n131# 0.384f
C2 xm12_0/a_63_n131# vb_pot 0
C3 xmcm_chain_4_0/a_1000_n131# avdd 0.01098f
C4 vpost xmcm_chain_4_0/a_n1000_n339# 0
C5 xmcm_chain_4_0/a_1000_n131# vb_pot 0.00205f
C6 xm7_0/a_63_n131# nvpre 0
C7 xmcm_chain_4_0/a_1000_n131# vb_idep 0
C8 xm9_0/a_63_n131# nvpre 0
C9 xm7_0/a_63_n131# xm12_0/a_63_n131# 0.01182f
C10 vpre xmcm_chain_4_0/a_1000_n131# 0
C11 xmcm_chain_4_0/a_1000_n131# xm7_0/a_63_n131# 0.00589f
C12 vb_itd xmcm_chain_4_0/a_n1000_n339# 0.0203f
C13 vpost vb_pot 0.00676f
C14 xm9_0/a_63_n131# xm12_0/a_63_n131# 0.00545f
C15 xmcm_chain_4_0/a_1000_n131# xm9_0/a_63_n131# 0.00319f
C16 xm1_0/a_63_n131# avdd 1.0369f
C17 xmcm_chain_4_0/a_n1000_n339# vb_pot 0.00454f
C18 vpost xm7_0/a_63_n131# 0
C19 avdd vb_itd 0.02038f
C20 vb_itd vb_pot 0.00689f
C21 xm1_0/a_63_n131# nvpost 0.006f
C22 vpost xm9_0/a_63_n131# 0.00758f
C23 vpre xmcm_chain_4_0/a_n1000_n339# 0
C24 vb_itd vb_idep 0.00343f
C25 xm1_0/a_63_n131# xm7_0/a_63_n131# 0.07138f
C26 avdd vb_itp 0.07109f
C27 avdd vb_idep 0.10619f
C28 xmcm_chain_4_0/a_n1000_n339# xm9_0/a_63_n131# 0.00136f
C29 vb_itd xm7_0/a_63_n131# 0
C30 vpost xm12_0/a_63_n131# 0.01456f
C31 xmcm_chain_4_0/a_1000_n131# vpost 0
C32 avdd nvpost 0.04877f
C33 vb_itd xm9_0/a_63_n131# 0
C34 avdd xm7_0/a_63_n131# 1.06997f
C35 xm7_0/a_63_n131# vb_pot 0.01448f
C36 xmcm_chain_4_0/a_n1000_n339# xm12_0/a_63_n131# 0
C37 xmcm_chain_4_0/a_1000_n131# xmcm_chain_4_0/a_n1000_n339# 2.30433f
C38 avdd xm9_0/a_63_n131# 0.9212f
C39 xm9_0/a_63_n131# vb_pot 0
C40 xm9_0/a_63_n131# vb_itp 0.02002f
C41 avdd nvpre 0.06941f
C42 nvpost xm7_0/a_63_n131# 0.00625f
C43 vb_idep xm9_0/a_63_n131# 0.10503f
C44 nvpre vb_itp 0.00736f
C45 xmcm_chain_4_0/a_1000_n131# vb_itd 0.05546f
C46 vpost.n0 vw 0.00112f
C47 vb_pot.n0 vw 0.00357f
C48 vb_itd.n0 vw 0.00144f
C49 avdd.n0 vw 0.04802f
C50 avdd.n1 vw 0
C51 avdd.n2 vw 0.00218f
C52 avdd.n3 vw 0.00118f
C53 avdd.n4 vw 0
C54 avdd.n5 vw 0.00149f
C55 avdd.n6 vw 0.01187f
C56 avdd.n7 vw 0
C57 avdd.n8 vw 0.00149f
C58 avdd.n9 vw 0.00118f
C59 avdd.n10 vw 0.00821f
C60 avdd.n11 vw 0
C61 avdd.n12 vw 0
C62 avdd.n13 vw 0
C63 avdd.n14 vw 0.00118f
C64 avdd.n15 vw 0.00264f
C65 avdd.n16 vw 0.00149f
C66 avdd.n17 vw 0
C67 avdd.n18 vw 0.00821f
C68 avdd.n19 vw 0
C69 avdd.n20 vw 0
C70 avdd.n21 vw 0.00111f
C71 avdd.n22 vw 0.00717f
C72 avdd.n23 vw 0.00192f
C73 avdd.n24 vw 0.00118f
C74 avdd.n25 vw 0
C75 avdd.n26 vw 0.00149f
C76 avdd.n27 vw 0.01187f
C77 avdd.n28 vw 0
C78 avdd.n29 vw 0.00118f
C79 avdd.n30 vw 0.00821f
C80 avdd.n31 vw 0
C81 avdd.n32 vw 0
C82 avdd.n33 vw 0
C83 avdd.n34 vw 0.00118f
C84 avdd.n35 vw 0.00264f
C85 avdd.n36 vw 0.00149f
C86 avdd.n37 vw 0
C87 avdd.n38 vw 0.00821f
C88 avdd.n39 vw 0
C89 avdd.n40 vw 0
C90 avdd.n41 vw 0.00111f
C91 avdd.n42 vw 0.00685f
C92 avdd.n43 vw 0.01506f
C93 avdd.n44 vw 0.00801f
C94 avdd.n45 vw 0.00189f
C95 avdd.n46 vw 0.00118f
C96 avdd.n47 vw 0
C97 avdd.n48 vw 0.00149f
C98 avdd.n49 vw 0.01187f
C99 avdd.n50 vw 0
C100 avdd.n51 vw 0
C101 avdd.n52 vw 0.00118f
C102 avdd.n53 vw 0
C103 avdd.n54 vw 0
C104 avdd.n55 vw 0.00821f
C105 avdd.n56 vw 0.00821f
C106 avdd.n57 vw 0
C107 avdd.n58 vw 0
C108 avdd.n59 vw 0
C109 avdd.n60 vw 0
C110 avdd.n61 vw 0.00111f
C111 avdd.n62 vw 0.00668f
C112 avdd.n63 vw 0
C113 avdd.n64 vw 0.00218f
C114 avdd.n65 vw 0
C115 avdd.n66 vw 0.00114f
C116 avdd.n67 vw 0
C117 avdd.n68 vw 0
C118 avdd.n69 vw 0.00107f
C119 avdd.n70 vw 0.00149f
C120 avdd.n71 vw 0.00149f
C121 avdd.n72 vw 0.01187f
C122 avdd.n73 vw 0.00149f
C123 avdd.n74 vw 0.00261f
C124 avdd.n75 vw 0.00125f
C125 avdd.n76 vw 0.00125f
C126 avdd.n77 vw 0
C127 avdd.n78 vw 0.00821f
C128 avdd.n79 vw 0
C129 avdd.n80 vw 0
C130 avdd.n81 vw 0
C131 avdd.n82 vw 0.00582f
C132 avdd.n83 vw 0.00278f
C133 avdd.n84 vw 0.00149f
C134 avdd.n85 vw 0
C135 avdd.n86 vw 0.00821f
C136 avdd.n87 vw 0
C137 avdd.n88 vw 0
C138 avdd.n89 vw 0.00111f
C139 avdd.n90 vw 0.00685f
C140 avdd.n91 vw 0.00801f
C141 avdd.n92 vw 0.00491f
C142 avdd.n93 vw 0
C143 avdd.n94 vw 0
C144 avdd.n95 vw 0
C145 avdd.n96 vw 0.00867f
C146 avdd.n97 vw 0.00504f
C147 avdd.n98 vw 0
C148 avdd.n99 vw 0
C149 avdd.n100 vw 0
C150 avdd.n101 vw 0
C151 avdd.n102 vw 0
C152 avdd.n103 vw 0.00504f
C153 avdd.n104 vw 0
C154 avdd.n105 vw 0
C155 avdd.n106 vw 0
C156 avdd.n107 vw 0
C157 avdd.n108 vw 0
C158 avdd.n109 vw 0.00504f
C159 avdd.n110 vw 0
C160 avdd.n111 vw 0
C161 avdd.n112 vw 0.00264f
C162 avdd.n113 vw 0.00867f
C163 avdd.n114 vw 0.00117f
C164 avdd.n115 vw 0
C165 avdd.n116 vw 0
C166 avdd.n117 vw 0.00686f
C167 avdd.n119 vw 0
C168 avdd.n120 vw 0
C169 avdd.n121 vw 0.00117f
C170 avdd.n122 vw 0
C171 avdd.n123 vw 0
C172 avdd.n124 vw 0
C173 avdd.n125 vw 0
C174 avdd.n126 vw 0.00504f
C175 avdd.n127 vw 0
C176 avdd.n128 vw 0
C177 avdd.n129 vw 0
C178 avdd.n130 vw 0
C179 avdd.n131 vw 0
C180 avdd.n132 vw 0
C181 avdd.n133 vw 0
C182 avdd.n134 vw 0.00504f
C183 avdd.n135 vw 0
C184 avdd.n136 vw 0
C185 avdd.n137 vw 0
C186 avdd.n138 vw 0
C187 avdd.n139 vw 0.00117f
C188 avdd.n140 vw 0
C189 avdd.n141 vw 0
C190 avdd.n142 vw 0.00686f
C191 avdd.n144 vw 0
C192 avdd.n145 vw 0
C193 avdd.n146 vw 0.0011f
C194 avdd.n147 vw 0.00797f
C195 avdd.n148 vw 0.01024f
C196 avdd.n149 vw 0.00701f
C197 avdd.n150 vw 0
C198 avdd.n151 vw 0
C199 avdd.n152 vw 0
C200 avdd.n153 vw 0.00337f
C201 avdd.n155 vw 0.05383f
C202 avdd.n156 vw 0
C203 avdd.n157 vw 0
C204 avdd.n158 vw 0.00685f
C205 avdd.n160 vw 0
C206 avdd.n161 vw 0
C207 avdd.n162 vw 0
C208 avdd.n163 vw 0
C209 avdd.n164 vw 0
C210 avdd.n165 vw 0.00151f
C211 avdd.n167 vw 0.03036f
C212 avdd.n168 vw 0.0019f
C213 avdd.n169 vw 0
C214 avdd.n170 vw 0
C215 avdd.n171 vw 0
C216 avdd.n172 vw 0
C217 avdd.n173 vw 0
C218 avdd.n174 vw 0.00151f
C219 avdd.n175 vw 0
C220 avdd.n176 vw 0.0019f
C221 avdd.n177 vw 0.00337f
C222 avdd.n178 vw 0.0019f
C223 avdd.n179 vw 0
C224 avdd.n180 vw 0.00151f
C225 avdd.n181 vw 0
C226 avdd.n182 vw 0
C227 avdd.n183 vw 0
C228 avdd.n184 vw 0
C229 avdd.n186 vw 0.03036f
C230 avdd.n187 vw 0.0019f
C231 avdd.n188 vw 0
C232 avdd.n189 vw 0.00105f
C233 avdd.n190 vw 0.01209f
C234 avdd.n191 vw 0.00857f
C235 avss.n0 vw 0
C236 avss.n1 vw 0.01162f
C237 avss.n2 vw 0.00288f
C238 avss.n3 vw 0
C239 avss.n4 vw 0
C240 avss.n5 vw 0
C241 avss.n6 vw 0
C242 avss.n7 vw 0.03185f
C243 avss.n16 vw 0
C244 avss.n17 vw 0
C245 avss.n18 vw 0
C246 avss.n19 vw 0
C247 avss.n20 vw 0
C248 avss.n21 vw 0
C249 avss.n22 vw 0
C250 avss.n23 vw 0
C251 avss.n24 vw 0
C252 avss.n25 vw 0
C253 avss.n26 vw 0
C254 avss.n27 vw 0
C255 avss.n28 vw 0
C256 avss.n29 vw 0
C257 avss.n30 vw 0
C258 avss.n31 vw 0
C259 avss.n32 vw 0
C260 avss.n33 vw 0
C261 avss.n34 vw 0
C262 avss.n35 vw 0
C263 avss.n36 vw 0.01809f
C264 avss.n38 vw 0
C265 avss.n41 vw 0
C266 avss.n44 vw 0
C267 avss.n47 vw 0
C268 avss.n48 vw 0
C269 avss.n49 vw 0
C270 avss.n50 vw 0
C271 avss.n51 vw 0
C272 avss.n52 vw 0
C273 avss.n53 vw 0
C274 avss.n54 vw 0.00575f
C275 avss.n55 vw 0
C276 avss.n56 vw 0
C277 avss.n57 vw 0
C278 avss.n58 vw 0
C279 avss.n59 vw 0
C280 avss.n60 vw 0
C281 avss.n62 vw 0
C282 avss.n63 vw 0
C283 avss.n64 vw 0
C284 avss.n65 vw 0
C285 avss.n66 vw 0
C286 avss.n67 vw 0
C287 avss.n69 vw 0
C288 avss.n70 vw 0
C289 avss.n71 vw 0.00462f
C290 avss.n72 vw 0
C291 avss.n73 vw 0
C292 avss.n74 vw 0
C293 avss.n75 vw 0
C294 avss.n76 vw 0
C295 avss.n77 vw 0
C296 avss.n78 vw 0
C297 avss.n79 vw 0
C298 avss.n80 vw 0
C299 avss.n87 vw 0
C300 avss.n88 vw 0
C301 avss.n89 vw 0
C302 avss.n90 vw 0
C303 avss.n91 vw 0
C304 avss.n92 vw 0
C305 avss.n93 vw 0
C306 avss.n94 vw 0.03185f
C307 avss.n96 vw 0
C308 avss.n97 vw 0
C309 avss.n98 vw 0
C310 avss.n99 vw 0
C311 avss.n100 vw 0
C312 avss.n101 vw 0.00462f
C313 avss.n102 vw 0.00656f
C314 avss.n103 vw 0.00462f
C315 avss.n104 vw 0.00462f
C316 avss.n105 vw 0.00571f
C317 avss.n106 vw 0
C318 avss.n107 vw 0
C319 avss.n108 vw 0
C320 avss.n109 vw 0
C321 avss.n110 vw 0
C322 avss.n111 vw 0
C323 avss.n112 vw 0
C324 avss.n113 vw 0.00571f
C325 avss.n114 vw 0
C326 avss.n115 vw 0
C327 avss.n116 vw 0.0033f
C328 avss.n117 vw 0
C329 avss.n118 vw 0
C330 avss.n119 vw 0
C331 avss.n120 vw 0
C332 avss.n121 vw 0
C333 avss.n122 vw 0.00401f
C334 avss.n123 vw 0
C335 avss.n124 vw 0
C336 avss.n125 vw 0
C337 avss.n126 vw 0
C338 avss.n127 vw 0
C339 avss.n128 vw 0.00388f
C340 avss.n129 vw 0
C341 avss.n130 vw 0
C342 avss.n131 vw 0
C343 avss.n132 vw 0
C344 avss.n133 vw 0
C345 avss.n134 vw 0.0033f
C346 avss.n135 vw 0.0033f
C347 avss.n136 vw 0
C348 avss.n137 vw 0
C349 avss.n138 vw 0
C350 avss.n139 vw 0
C351 avss.n140 vw 0
C352 avss.n141 vw 0.0054f
C353 avss.n142 vw 0
C354 avss.n143 vw 0
C355 avss.n144 vw 0.0033f
C356 avss.n145 vw 0
C357 avss.n146 vw 0
C358 avss.n147 vw 0
C359 avss.n148 vw 0
C360 avss.n149 vw 0
C361 avss.n150 vw 0
C362 avss.n151 vw 0
C363 avss.n152 vw 0.00458f
C364 avss.n153 vw 0
C365 avss.n154 vw 0.00534f
C366 avss.n155 vw 0
C367 avss.n156 vw 0
C368 avss.n157 vw 0
C369 avss.n158 vw 0
C370 avss.n159 vw 0
C371 avss.n160 vw 0
C372 avss.n161 vw 0.00458f
C373 avss.n162 vw 0
C374 avss.n163 vw 0.00534f
C375 avss.n164 vw 0
C376 avss.n165 vw 0
C377 avss.n166 vw 0
C378 avss.n167 vw 0
C379 avss.n168 vw 0
C380 avss.n169 vw 0
C381 avss.n170 vw 0
C382 avss.n171 vw 0
C383 avss.n172 vw 0.0033f
C384 avss.n173 vw 0
C385 avss.n174 vw 0
C386 avss.n175 vw 0.00456f
C387 avss.n176 vw 0.00445f
C388 avss.n177 vw 0
C389 avss.n178 vw 0
C390 avss.n179 vw 0
C391 avss.n180 vw 0
C392 avss.n181 vw 0
C393 avss.n182 vw 0
C394 avss.n183 vw 0
C395 avss.n184 vw 0
C396 avss.n185 vw 0
C397 avss.n186 vw 0
C398 avss.n187 vw 0.00416f
C399 avss.n188 vw 0
C400 avss.n189 vw 0
C401 avss.n190 vw 0
C402 avss.n191 vw 0
C403 avss.n192 vw 0
C404 avss.n193 vw 0
C405 avss.n194 vw 0
C406 avss.n195 vw 0
C407 avss.n196 vw 0
C408 avss.n197 vw 0.0033f
C409 avss.n198 vw 0.00561f
C410 avss.n199 vw 0
C411 avss.n200 vw 0
C412 avss.n201 vw 0
C413 avss.n202 vw 0
C414 avss.n203 vw 0
C415 avss.n204 vw 0
C416 avss.n205 vw 0
C417 avss.n206 vw 0
C418 avss.n207 vw 0
C419 avss.n208 vw 0
C420 avss.n209 vw 0
C421 avss.n210 vw 0
C422 avss.n211 vw 0.00458f
C423 avss.n212 vw 0
C424 avss.n213 vw 0
C425 avss.n214 vw 0
C426 avss.n215 vw 0
C427 avss.n216 vw 0
C428 avss.n217 vw 0
C429 avss.n218 vw 0
C430 avss.n219 vw 0
C431 avss.n220 vw 0
C432 avss.n221 vw 0
C433 avss.n222 vw 0
C434 avss.n223 vw 0
C435 avss.n224 vw 0
C436 avss.n225 vw 0
C437 avss.n226 vw 0
C438 avss.n227 vw 0
C439 avss.n228 vw 0
C440 avss.n229 vw 0
C441 avss.n230 vw 0
C442 avss.n231 vw 0
C443 avss.n232 vw 0
C444 avss.n233 vw 0
C445 avss.n234 vw 0
C446 avss.n235 vw 0
C447 avss.n236 vw 0
C448 avss.n237 vw 0
C449 avss.n238 vw 0.0033f
C450 avss.n239 vw 0.00371f
C451 avss.n240 vw 0
C452 avss.n241 vw 0
C453 avss.n242 vw 0
C454 avss.n243 vw 0
C455 avss.n244 vw 0
C456 avss.n245 vw 0.00458f
C457 avss.n246 vw 0.0033f
C458 avss.n247 vw 0
C459 avss.n248 vw 0
C460 avss.n249 vw 0
C461 avss.n250 vw 0
C462 avss.n251 vw 0
C463 avss.n252 vw 0
C464 avss.n253 vw 0
C465 avss.n254 vw 0
C466 avss.n255 vw 0
C467 avss.n256 vw 0
C468 avss.n257 vw 0
C469 avss.n258 vw 0
C470 avss.n259 vw 0
C471 avss.n260 vw 0
C472 avss.n261 vw 0
C473 avss.n262 vw 0
C474 avss.n263 vw 0
C475 avss.n264 vw 0.0033f
C476 avss.n265 vw 0.0033f
C477 avss.n266 vw 0
C478 avss.n267 vw 0
C479 avss.n268 vw 0
C480 avss.n269 vw 0
C481 avss.n270 vw 0
C482 avss.n271 vw 0.00367f
C483 avss.n272 vw 0.0033f
C484 avss.n273 vw 0
C485 avss.n274 vw 0
C486 avss.n275 vw 0
C487 avss.n276 vw 0
C488 avss.n277 vw 0
C489 avss.n278 vw 0
C490 avss.n279 vw 0.00144f
C491 avss.n280 vw 0
C492 avss.n281 vw 0
C493 avss.n282 vw 0
C494 avss.n283 vw 0
C495 avss.n284 vw 0.0034f
C496 avss.n285 vw 0.00901f
C497 avss.n286 vw 0.00575f
C498 avss.n287 vw 0
C499 avss.n288 vw 0
C500 avss.n289 vw 0
C501 avss.n290 vw 0
C502 avss.n291 vw 0
C503 avss.n292 vw 0
C504 avss.n293 vw 0
C505 avss.n294 vw 0
C506 avss.n295 vw 0.00524f
C507 avss.n296 vw 0
C508 avss.n297 vw 0
C509 avss.n298 vw 0
C510 avss.n299 vw 0
C511 avss.n300 vw 0
C512 avss.n301 vw 0
C513 avss.n302 vw 0
C514 avss.n303 vw 0.00338f
C515 avss.n304 vw 0
C516 avss.n305 vw 0
C517 avss.n306 vw 0
C518 avss.n307 vw 0
C519 avss.n308 vw 0
C520 avss.n309 vw 0
C521 avss.n310 vw 0.0066f
C522 avss.n311 vw 0
C523 avss.n312 vw 0
C524 avss.n313 vw 0
C525 avss.n314 vw 0
C526 avss.n315 vw 0
C527 avss.n316 vw 0.0066f
C528 avss.n317 vw 0
C529 avss.n318 vw 0
C530 avss.n319 vw 0
C531 avss.n320 vw 0
C532 avss.n321 vw 0
C533 avss.n322 vw 0
C534 avss.n323 vw 0.00524f
C535 avss.n324 vw 0.00284f
C536 avss.n325 vw 0
C537 avss.n326 vw 0
C538 avss.n327 vw 0
C539 avss.n328 vw 0
C540 avss.n329 vw 0
C541 avss.n330 vw 0
C542 avss.n331 vw 0
C543 avss.n332 vw 0
C544 avss.n335 vw 0
C545 avss.n336 vw 0
C546 avss.n337 vw 0
C547 avss.n338 vw 0
C548 avss.n339 vw 0
C549 avss.n340 vw 0
C550 avss.n341 vw 0
C551 avss.n342 vw 0
C552 avss.n343 vw 0
C553 avss.n344 vw 0
C554 avss.n345 vw 0
C555 avss.n346 vw 0
C556 avss.n347 vw 0
C557 avss.n348 vw 0
C558 avss.n349 vw 0
C559 avss.n350 vw 0
C560 avss.n351 vw 0
C561 avss.n352 vw 0
C562 avss.n353 vw 0
C563 avss.n354 vw 0
C564 avss.n355 vw 0
C565 avss.n356 vw 0
C566 avss.n357 vw 0
C567 avss.n358 vw 0
C568 avss.n359 vw 0
C569 avss.n360 vw 0
C570 avss.n361 vw 0
C571 avss.n362 vw 0
C572 avss.n363 vw 0
C573 avss.n364 vw 0
C574 avss.n365 vw 0
C575 avss.n366 vw 0
C576 avss.n367 vw 0
C577 avss.n368 vw 0
C578 avss.n370 vw 0.01576f
C579 avss.n372 vw 0
C580 avss.n373 vw 0
C581 avss.n374 vw 0
C582 avss.n375 vw 0
C583 avss.n376 vw 0
C584 avss.n377 vw 0
C585 avss.n378 vw 0
C586 avss.n379 vw 0
C587 avss.n380 vw 0.00915f
C588 avss.n381 vw 0.00915f
C589 avss.n382 vw 0
C590 avss.n383 vw 0
C591 avss.n384 vw 0
C592 avss.n385 vw 0
C593 avss.n386 vw 0
C594 avss.n387 vw 0
C595 avss.n388 vw 0
C596 avss.n389 vw 0
C597 avss.n390 vw 0
C598 avss.n391 vw 0
C599 avss.n392 vw 0.00524f
C600 avss.n393 vw 0
C601 avss.n394 vw 0
C602 avss.n395 vw 0
C603 avss.n396 vw 0
C604 avss.n397 vw 0
C605 avss.n398 vw 0
C606 avss.n399 vw 0
C607 avss.n400 vw 0
C608 avss.n401 vw 0
C609 avss.n402 vw 0
C610 avss.n403 vw 0
C611 avss.n404 vw 0
C612 avss.n405 vw 0
C613 avss.n406 vw 0.00524f
C614 avss.n407 vw 0
C615 avss.n408 vw 0
C616 avss.n409 vw 0
C617 avss.n410 vw 0
C618 avss.n411 vw 0
C619 avss.n412 vw 0
C620 avss.n413 vw 0
C621 avss.n414 vw 0
C622 avss.n415 vw 0
C623 avss.n416 vw 0
C624 avss.n417 vw 0.0066f
C625 avss.n418 vw 0
C626 avss.n419 vw 0
C627 avss.n420 vw 0
C628 avss.n421 vw 0
C629 avss.n422 vw 0
C630 avss.n423 vw 0
C631 avss.n424 vw 0
C632 avss.n425 vw 0
C633 avss.n426 vw 0.0066f
C634 avss.n427 vw 0
C635 avss.n428 vw 0
C636 avss.n429 vw 0
C637 avss.n430 vw 0
C638 avss.n431 vw 0
C639 avss.n432 vw 0
C640 avss.n433 vw 0
C641 avss.n434 vw 0
C642 avss.n435 vw 0
C643 avss.n436 vw 0
C644 avss.n437 vw 0
C645 avss.n438 vw 0
C646 avss.n439 vw 0
C647 avss.n440 vw 0.0033f
C648 avss.n441 vw 0.00449f
C649 avss.n442 vw 0
C650 avss.n443 vw 0
C651 avss.n444 vw 0
C652 avss.n445 vw 0
C653 avss.n446 vw 0
C654 avss.n447 vw 0.00458f
C655 avss.n448 vw 0.0033f
C656 avss.n449 vw 0
C657 avss.n450 vw 0.00179f
C658 avss.n451 vw 0
C659 avss.n452 vw 0
C660 avss.n453 vw 0
C661 avss.n454 vw 0
C662 avss.n455 vw 0
C663 avss.n456 vw 0
C664 avss.n457 vw 0
C665 avss.n458 vw 0
C666 avss.n459 vw 0
C667 avss.n460 vw 0
C668 avss.n461 vw 0
C669 avss.n462 vw 0
C670 avss.n463 vw 0
C671 avss.n464 vw 0
C672 avss.n465 vw 0.0033f
C673 avss.n466 vw 0.00361f
C674 avss.n467 vw 0
C675 avss.n468 vw 0
C676 avss.n469 vw 0
C677 avss.n470 vw 0
C678 avss.n471 vw 0
C679 avss.n472 vw 0
C680 avss.n473 vw 0
C681 avss.n474 vw 0.00571f
C682 avss.n475 vw 0
C683 avss.n476 vw 0
C684 avss.n477 vw 0
C685 avss.n478 vw 0
C686 avss.n479 vw 0
C687 avss.n480 vw 0
C688 avss.n481 vw 0
C689 avss.n482 vw 0.004f
C690 avss.n483 vw 0
C691 avss.n484 vw 0
C692 avss.n485 vw 0
C693 avss.n486 vw 0
C694 avss.n487 vw 0.00847f
C695 avss.n488 vw 0.00149f
C696 avss.n489 vw 0
C697 avss.n490 vw 0
C698 avss.n491 vw 0
C699 avss.n492 vw 0
C700 avss.n493 vw 0.0033f
C701 avss.n494 vw 0.0033f
C702 avss.n495 vw 0
C703 avss.n496 vw 0
C704 avss.n497 vw 0
C705 avss.n498 vw 0
C706 avss.n499 vw 0
C707 avss.n500 vw 0
C708 avss.n501 vw 0
C709 avss.n502 vw 0.03137f
C710 avss.n503 vw 0.05718f
C711 avss.n504 vw 0.03366f
C712 avss.n505 vw 0.03366f
C713 avss.n506 vw 0.04475f
C714 avss.n507 vw 0.15679f
C715 avss.n509 vw 0
C716 avss.n510 vw 0
C717 avss.n511 vw 0
C718 avss.n512 vw 0
C719 avss.n513 vw 0
C720 avss.n514 vw 0
C721 avss.n515 vw 0
C722 avss.n516 vw 0
C723 avss.n517 vw 0
C724 avss.n518 vw 0
C725 avss.n519 vw 0
C726 avss.n520 vw 0
C727 avss.n521 vw 0
C728 avss.n522 vw 0
C729 avss.n523 vw 0
C730 avss.n524 vw 0
C731 avss.n525 vw 0
C732 avss.n526 vw 0
C733 avss.n527 vw 0
C734 avss.n528 vw 0
C735 avss.n529 vw 0
C736 avss.n530 vw 0
C737 avss.n531 vw 0
C738 avss.n532 vw 0
C739 avss.n533 vw 0
C740 avss.n534 vw 0
C741 avss.n535 vw 0
C742 avss.n536 vw 0
C743 avss.n538 vw 0.29602f
C744 avss.n539 vw 0
C745 avss.n540 vw 0
C746 avss.n541 vw 0
C747 avss.n542 vw 0
C748 avss.n543 vw 0
C749 avss.n544 vw 0
C750 avss.n545 vw 0
C751 avss.n546 vw 0
C752 avss.n547 vw 0
C753 avss.n548 vw 0
C754 avss.n549 vw 0
C755 avss.n550 vw 0
C756 avss.n551 vw 0
C757 avss.n552 vw 0
C758 avss.n553 vw 0.03059f
C759 avss.n555 vw 0
C760 avss.n556 vw 0
C761 avss.n557 vw 0
C762 avss.n558 vw 0
C763 avss.n559 vw 0
C764 avss.n560 vw 0
C765 avss.n561 vw 0
C766 avss.n562 vw 0
C767 avss.n563 vw 0
C768 avss.n564 vw 0
C769 avss.n565 vw 0
C770 avss.n566 vw 0
C771 avss.n567 vw 0
C772 avss.n568 vw 0
C773 avss.n569 vw 0
C774 avss.n570 vw 0
C775 avss.n571 vw 0
C776 avss.n572 vw 0
C777 avss.n574 vw 0.00828f
C778 avss.n575 vw 0.01069f
C779 avss.n577 vw 0
C780 avss.n578 vw 0
C781 avss.n579 vw 0
C782 avss.n580 vw 0
C783 avss.n581 vw 0
C784 avss.n582 vw 0
C785 avss.n583 vw 0
C786 avss.n584 vw 0
C787 avss.n585 vw 0
C788 avss.n586 vw 0.00268f
C789 avss.n587 vw 0
C790 avss.n588 vw 0
C791 avss.n589 vw 0
C792 avss.n590 vw 0
C793 avss.n591 vw 0
C794 avss.n592 vw 0
C795 avss.n594 vw 0
C796 avss.n595 vw 0
C797 avss.n596 vw 0
C798 avss.n597 vw 0
C799 avss.n598 vw 0
C800 avss.n599 vw 0
C801 avss.n601 vw 0
C802 avss.n602 vw 0
C803 avss.n603 vw 0
C804 avss.n604 vw 0
C805 avss.n605 vw 0
C806 avss.n606 vw 0
C807 avss.n608 vw 0.01637f
C808 avss.n610 vw 0
C809 avss.n611 vw 0
C810 avss.n612 vw 0
C811 avss.n613 vw 0
C812 avss.n614 vw 0
C813 avss.n615 vw 0
C814 avss.n616 vw 0
C815 avss.n617 vw 0
C816 avss.n618 vw 0
C817 avss.n619 vw 0
C818 avss.n620 vw 0
C819 avss.n621 vw 0
C820 avss.n622 vw 0
C821 avss.n623 vw 0
C822 avss.n624 vw 0
C823 avss.n625 vw 0
C824 avss.n626 vw 0
C825 avss.n627 vw 0
C826 avss.n628 vw 0
C827 avss.n629 vw 0
C828 avss.n630 vw 0
C829 avss.n631 vw 0
C830 avss.n632 vw 0
C831 avss.n633 vw 0
C832 avss.n634 vw 0
C833 avss.n635 vw 0
C834 avss.n636 vw 0
C835 avss.n637 vw 0
C836 avss.n638 vw 0
C837 avss.n639 vw 0
C838 avss.n640 vw 0
C839 avss.n641 vw 0
C840 avss.n642 vw 0
C841 avss.n643 vw 0
C842 avss.n644 vw 0
C843 avss.n645 vw 0
C844 avss.n646 vw 0
C845 avss.n647 vw 0
C846 avss.n648 vw 0
C847 avss.n649 vw 0
C848 avss.n650 vw 0
C849 avss.n651 vw 0
C850 avss.n652 vw 0
C851 avss.n653 vw 0
C852 avss.n654 vw 0
C853 avss.n655 vw 0
C854 avss.n656 vw 0
C855 avss.n657 vw 0
C856 avss.n658 vw 0
C857 avss.n659 vw 0
C858 avss.n660 vw 0
C859 avss.n661 vw 0
C860 avss.n662 vw 0
C861 avss.n663 vw 0
C862 avss.n664 vw 0
C863 avss.n665 vw 0
C864 avss.n666 vw 0
C865 avss.n667 vw 0.07255f
C866 avss.n668 vw 0
C867 avss.n669 vw 0
C868 avss.n670 vw 0
C869 avss.n671 vw 0
C870 avss.n672 vw 0.00463f
C871 vb_itp vw -0.02509f
C872 vb_pot vw 0.03107f
C873 avdd vw -16.75011f
C874 nvpost vw -0.01361f
C875 xm12_0/a_63_n131# vw 0.00799f
C876 vpost vw 0.00814f
C877 vb_itd vw -0.00533f
C878 xm7_0/a_63_n131# vw -0.85885f
C879 vb_idep vw -0.01078f
C880 xmcm_chain_4_0/a_n1000_n339# vw -1.3575f
C881 nvpre vw -0.02816f
C882 vpre vw 0.04317f
C883 xmcm_chain_4_0/a_1000_n131# vw -3.13764f
C884 xm9_0/a_63_n131# vw -2.5471f
C885 xm1_0/a_63_n131# vw -0.57919f
.ends
