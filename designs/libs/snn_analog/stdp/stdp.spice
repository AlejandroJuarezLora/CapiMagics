* NGSPICE file created from stdp.ext - technology: gf180mcuD

.subckt xm5 a_n1500_n339# a_n1620_n131# w_n1886_n560# a_1500_n131# VSUBS
X0 a_1500_n131# a_n1500_n339# a_n1620_n131# w_n1886_n560# pfet_03v3 ad=0.3p pd=2.2u as=0.3p ps=2.2u w=0.5u l=15u
C0 w_n1886_n560# a_n1620_n131# 0.45972f
C1 a_1500_n131# a_n1500_n339# 0.06934f
C2 a_n1500_n339# a_n1620_n131# 0.6108f
C3 w_n1886_n560# a_n1500_n339# 6.38155f
C4 a_1500_n131# a_n1620_n131# 1.44038f
C5 w_n1886_n560# a_1500_n131# 1.82938f
C6 a_1500_n131# VSUBS 0.06141f
C7 a_n1620_n131# VSUBS 0.05599f
C8 a_n1500_n339# VSUBS 0.30906f
C9 w_n1886_n560# VSUBS 15.2029f
.ends

.subckt xm3 a_63_n131# a_n393_n504# a_n63_n339# a_n183_n131#
X0 a_63_n131# a_n63_n339# a_n183_n131# a_n393_n504# nfet_03v3 ad=0.3p pd=2.2u as=0.3p ps=2.2u w=0.5u l=0.63u
C0 a_n63_n339# a_63_n131# 0.01741f
C1 a_n183_n131# a_63_n131# 0.33209f
C2 a_n63_n339# a_n183_n131# 0.04027f
C3 a_63_n131# a_n393_n504# 0.53054f
C4 a_n183_n131# a_n393_n504# 0.26905f
C5 a_n63_n339# a_n393_n504# 0.50927f
.ends

.subckt xm1 a_63_n131# a_n63_n339# w_n449_n560# a_n183_n131# VSUBS
X0 a_63_n131# a_n63_n339# a_n183_n131# w_n449_n560# pfet_03v3 ad=0.3p pd=2.2u as=0.3p ps=2.2u w=0.5u l=0.63u
C0 w_n449_n560# a_n183_n131# 0.2249f
C1 a_63_n131# a_n63_n339# 0.01741f
C2 a_n63_n339# a_n183_n131# 0.04027f
C3 w_n449_n560# a_n63_n339# 0.45684f
C4 a_63_n131# a_n183_n131# 0.33209f
C5 w_n449_n560# a_63_n131# 0.48511f
C6 a_63_n131# VSUBS 0.04546f
C7 a_n183_n131# VSUBS 0.04416f
C8 a_n63_n339# VSUBS 0.05243f
C9 w_n449_n560# VSUBS 3.76898f
.ends

.subckt xmcm_chain_4 a_n1120_n131# a_n1330_n504# a_1000_n131# a_n1000_n339#
X0 a_1000_n131# a_n1000_n339# a_n1120_n131# a_n1330_n504# nfet_03v3 ad=0.3p pd=2.2u as=0.3p ps=2.2u w=0.5u l=10u
C0 a_n1000_n339# a_1000_n131# 0.06176f
C1 a_n1120_n131# a_1000_n131# 1.01551f
C2 a_n1000_n339# a_n1120_n131# 0.42273f
C3 a_1000_n131# a_n1330_n504# 1.43795f
C4 a_n1120_n131# a_n1330_n504# 0.4423f
C5 a_n1000_n339# a_n1330_n504# 4.53847f
.ends

.subckt xm8 a_63_n131# a_n63_n339# w_n449_n560# a_n183_n131# VSUBS
X0 a_63_n131# a_n63_n339# a_n183_n131# w_n449_n560# pfet_03v3 ad=0.3p pd=2.2u as=0.3p ps=2.2u w=0.5u l=0.63u
C0 w_n449_n560# a_n183_n131# 0.2249f
C1 a_63_n131# a_n63_n339# 0.01741f
C2 a_n63_n339# a_n183_n131# 0.04027f
C3 w_n449_n560# a_n63_n339# 0.45684f
C4 a_63_n131# a_n183_n131# 0.33209f
C5 w_n449_n560# a_63_n131# 0.48511f
C6 a_63_n131# VSUBS 0.04546f
C7 a_n183_n131# VSUBS 0.04416f
C8 a_n63_n339# VSUBS 0.05243f
C9 w_n449_n560# VSUBS 3.76898f
.ends

.subckt xmcm_chain_2 a_n1120_n131# a_n1330_n504# a_1000_n131# a_n1000_n339#
X0 a_1000_n131# a_n1000_n339# a_n1120_n131# a_n1330_n504# nfet_03v3 ad=0.3p pd=2.2u as=0.3p ps=2.2u w=0.5u l=10u
C0 a_n1000_n339# a_1000_n131# 0.06176f
C1 a_n1120_n131# a_1000_n131# 1.01551f
C2 a_n1000_n339# a_n1120_n131# 0.42273f
C3 a_1000_n131# a_n1330_n504# 1.43795f
C4 a_n1120_n131# a_n1330_n504# 0.4423f
C5 a_n1000_n339# a_n1330_n504# 4.53847f
.ends

.subckt xm16 a_n400_n1101# a_n280_n1309# w_n666_n1529# a_280_n1101# VSUBS
X0 a_280_n1101# a_n280_n1309# a_n400_n1101# w_n666_n1529# pfet_03v3 ad=6.12p pd=21.6u as=6.12p ps=21.6u w=10.2u l=2.8u
C0 w_n666_n1529# a_n400_n1101# 1.08957f
C1 a_280_n1101# a_n280_n1309# 0.57005f
C2 a_n280_n1309# a_n400_n1101# 0.64393f
C3 w_n666_n1529# a_n280_n1309# 1.30956f
C4 a_280_n1101# a_n400_n1101# 0.72266f
C5 w_n666_n1529# a_280_n1101# 1.53123f
C6 a_280_n1101# VSUBS 0.28176f
C7 a_n400_n1101# VSUBS 0.30514f
C8 a_n280_n1309# VSUBS 0.12268f
C9 w_n666_n1529# VSUBS 13.9301f
.ends

.subckt xmcm_chain_0 a_n1120_n131# a_n1330_n504# a_1000_n131# a_n1000_n339#
X0 a_1000_n131# a_n1000_n339# a_n1120_n131# a_n1330_n504# nfet_03v3 ad=0.3p pd=2.2u as=0.3p ps=2.2u w=0.5u l=10u
C0 a_n1000_n339# a_1000_n131# 0.06176f
C1 a_n1120_n131# a_1000_n131# 1.01551f
C2 a_n1000_n339# a_n1120_n131# 0.42273f
C3 a_1000_n131# a_n1330_n504# 1.43795f
C4 a_n1120_n131# a_n1330_n504# 0.4423f
C5 a_n1000_n339# a_n1330_n504# 4.53847f
.ends

.subckt xm4 a_63_n131# a_n393_n504# a_n63_n339# a_n183_n131#
X0 a_63_n131# a_n63_n339# a_n183_n131# a_n393_n504# nfet_03v3 ad=0.3p pd=2.2u as=0.3p ps=2.2u w=0.5u l=0.63u
C0 a_n63_n339# a_63_n131# 0.01741f
C1 a_n183_n131# a_63_n131# 0.33209f
C2 a_n63_n339# a_n183_n131# 0.04027f
C3 a_63_n131# a_n393_n504# 0.53054f
C4 a_n183_n131# a_n393_n504# 0.26905f
C5 a_n63_n339# a_n393_n504# 0.50927f
.ends

.subckt xm12 a_63_n131# a_n393_n504# a_n63_n339# a_n183_n131#
X0 a_63_n131# a_n63_n339# a_n183_n131# a_n393_n504# nfet_03v3 ad=0.3p pd=2.2u as=0.3p ps=2.2u w=0.5u l=0.63u
C0 a_n63_n339# a_63_n131# 0.01741f
C1 a_n183_n131# a_63_n131# 0.33209f
C2 a_n63_n339# a_n183_n131# 0.04027f
C3 a_63_n131# a_n393_n504# 0.53054f
C4 a_n183_n131# a_n393_n504# 0.26905f
C5 a_n63_n339# a_n393_n504# 0.50927f
.ends

.subckt xm2 a_63_n131# a_n63_n339# w_n449_n560# a_n183_n131# VSUBS
X0 a_63_n131# a_n63_n339# a_n183_n131# w_n449_n560# pfet_03v3 ad=0.3p pd=2.2u as=0.3p ps=2.2u w=0.5u l=0.63u
C0 w_n449_n560# a_n183_n131# 0.2249f
C1 a_63_n131# a_n63_n339# 0.01741f
C2 a_n63_n339# a_n183_n131# 0.04027f
C3 w_n449_n560# a_n63_n339# 0.45684f
C4 a_63_n131# a_n183_n131# 0.33209f
C5 w_n449_n560# a_63_n131# 0.48511f
C6 a_63_n131# VSUBS 0.04546f
C7 a_n183_n131# VSUBS 0.04416f
C8 a_n63_n339# VSUBS 0.05243f
C9 w_n449_n560# VSUBS 3.76898f
.ends

.subckt xmcm_1 a_n280_n350# a_n400_n141# a_280_n141# a_n610_n515#
X0 a_280_n141# a_n280_n350# a_n400_n141# a_n610_n515# nfet_03v3 ad=0.366p pd=2.42u as=0.366p ps=2.42u w=0.61u l=2.8u
C0 a_n280_n350# a_280_n141# 0.04694f
C1 a_n400_n141# a_280_n141# 0.4351f
C2 a_n280_n350# a_n400_n141# 0.1455f
C3 a_280_n141# a_n610_n515# 0.76826f
C4 a_n400_n141# a_n610_n515# 0.3279f
C5 a_n280_n350# a_n610_n515# 1.4155f
.ends

.subckt xm9 a_63_n131# a_n393_n504# a_n63_n339# a_n183_n131#
X0 a_63_n131# a_n63_n339# a_n183_n131# a_n393_n504# nfet_03v3 ad=0.3p pd=2.2u as=0.3p ps=2.2u w=0.5u l=0.63u
C0 a_n63_n339# a_63_n131# 0.01741f
C1 a_n183_n131# a_63_n131# 0.33209f
C2 a_n63_n339# a_n183_n131# 0.04027f
C3 a_63_n131# a_n393_n504# 0.53054f
C4 a_n183_n131# a_n393_n504# 0.26905f
C5 a_n63_n339# a_n393_n504# 0.50927f
.ends

.subckt xmcm_chain_3 a_n1120_n131# a_n1330_n504# a_1000_n131# a_n1000_n339#
X0 a_1000_n131# a_n1000_n339# a_n1120_n131# a_n1330_n504# nfet_03v3 ad=0.3p pd=2.2u as=0.3p ps=2.2u w=0.5u l=10u
C0 a_n1000_n339# a_1000_n131# 0.06176f
C1 a_n1120_n131# a_1000_n131# 1.01551f
C2 a_n1000_n339# a_n1120_n131# 0.42273f
C3 a_1000_n131# a_n1330_n504# 1.43795f
C4 a_n1120_n131# a_n1330_n504# 0.4423f
C5 a_n1000_n339# a_n1330_n504# 4.53847f
.ends

.subckt xm17 a_n460_n339# w_n846_n560# a_n580_n131# a_460_n131# VSUBS
X0 a_460_n131# a_n460_n339# a_n580_n131# w_n846_n560# pfet_03v3 ad=0.3p pd=2.2u as=0.3p ps=2.2u w=0.5u l=4.6u
C0 w_n846_n560# a_n580_n131# 0.30191f
C1 a_460_n131# a_n460_n339# 0.04912f
C2 a_n460_n339# a_n580_n131# 0.21491f
C3 w_n846_n560# a_n460_n339# 2.05763f
C4 a_460_n131# a_n580_n131# 0.57434f
C5 w_n846_n560# a_460_n131# 0.87034f
C6 a_460_n131# VSUBS 0.04483f
C7 a_n580_n131# VSUBS 0.04363f
C8 a_n460_n339# VSUBS 0.12333f
C9 w_n846_n560# VSUBS 6.90762f
.ends

.subckt xm7 a_63_n131# a_n63_n339# w_n449_n560# a_n183_n131# VSUBS
X0 a_63_n131# a_n63_n339# a_n183_n131# w_n449_n560# pfet_03v3 ad=0.3p pd=2.2u as=0.3p ps=2.2u w=0.5u l=0.63u
C0 w_n449_n560# a_n183_n131# 0.2249f
C1 a_63_n131# a_n63_n339# 0.01741f
C2 a_n63_n339# a_n183_n131# 0.04027f
C3 w_n449_n560# a_n63_n339# 0.45684f
C4 a_63_n131# a_n183_n131# 0.33209f
C5 w_n449_n560# a_63_n131# 0.48511f
C6 a_63_n131# VSUBS 0.04546f
C7 a_n183_n131# VSUBS 0.04416f
C8 a_n63_n339# VSUBS 0.05243f
C9 w_n449_n560# VSUBS 3.76898f
.ends

.subckt xmcm_chain_1 a_n1120_n131# a_n1330_n504# a_1000_n131# a_n1000_n339#
X0 a_1000_n131# a_n1000_n339# a_n1120_n131# a_n1330_n504# nfet_03v3 ad=0.3p pd=2.2u as=0.3p ps=2.2u w=0.5u l=10u
C0 a_n1000_n339# a_1000_n131# 0.06176f
C1 a_n1120_n131# a_1000_n131# 1.01551f
C2 a_n1000_n339# a_n1120_n131# 0.42273f
C3 a_1000_n131# a_n1330_n504# 1.43795f
C4 a_n1120_n131# a_n1330_n504# 0.4423f
C5 a_n1000_n339# a_n1330_n504# 4.53847f
.ends

.subckt stdp avdd nvpost nvpre vpost vpre vb_idep vb_itd vb_itp vb_pot vw Iout
Xxm5_0 vw avdd avdd Iout vw xm5
Xxm3_0 vw vw vpre xm4_0/a_63_n131# xm3
Xxm1_0 xm1_0/a_63_n131# avdd avdd avdd vw xm1
Xxmcm_chain_4_0 vw vw xmcm_chain_4_0/a_1000_n131# xmcm_chain_4_0/a_n1000_n339# xmcm_chain_4
Xxm8_0 xm8_0/a_63_n131# nvpre avdd avdd vw xm8
Xxmcm_chain_2_0 xmcm_chain_3_0/a_1000_n131# vw xmcm_chain_2_0/a_1000_n131# xmcm_chain_4_0/a_n1000_n339#
+ xmcm_chain_2
Xxm16_0 avdd vb_idep avdd xm9_0/a_63_n131# vw xm16
Xxmcm_chain_0_0 xmcm_chain_1_0/a_1000_n131# vw vw vb_itd xmcm_chain_0
Xxm4_0 xm4_0/a_63_n131# vw vw vw xm4
Xxm12_0 xm9_0/a_63_n131# vw vpost vw xm12
Xxm2_0 vw nvpost avdd xm1_0/a_63_n131# vw xm2
Xxmcm_1_0 vb_pot vw xm7_0/a_63_n131# vw xmcm_1
Xxm9_0 xm9_0/a_63_n131# vw xm9_0/a_63_n131# vw xm9
Xxmcm_chain_3_0 xmcm_chain_4_0/a_1000_n131# vw xmcm_chain_3_0/a_1000_n131# xmcm_chain_4_0/a_n1000_n339#
+ xmcm_chain_3
Xxm17_0 vb_itp avdd avdd avdd vw xm17
Xxm7_0 xm7_0/a_63_n131# xm8_0/a_63_n131# avdd avdd vw xm7
Xxmcm_chain_1_0 xmcm_chain_2_0/a_1000_n131# vw xmcm_chain_1_0/a_1000_n131# xmcm_chain_4_0/a_n1000_n339#
+ xmcm_chain_1
R0 avss.n129 avss.n101 27273.1
R1 avss.n506 avss.n101 17334.8
R2 avss.n505 avss.n504 14475
R3 avss.n504 avss.n503 14475
R4 avss.n507 avss.n100 14000
R5 avss.n504 avss.n103 14000
R6 avss.n505 avss.n102 14000
R7 avss.n503 avss.n502 14000
R8 avss.n508 avss.n70 14000
R9 avss.n503 avss.n101 12850
R10 avss.n506 avss.n505 5350
R11 avss.n539 avss.n508 4163.87
R12 avss.n576 avss.n575 2283.78
R13 avss.n362 avss.n53 2283.78
R14 avss.n508 avss.n507 2067.12
R15 avss.n575 avss.n35 1051.61
R16 avss.n507 avss.n506 773.053
R17 avss.n373 avss.n372 203.708
R18 avss.n539 avss.n93 203.343
R19 avss.n554 avss.n93 203.343
R20 avss.n609 avss.n6 203.343
R21 avss.n668 avss.n6 203.343
R22 avss.n278 avss.n277 198.688
R23 avss.n554 avss.n35 187.267
R24 avss.n196 avss.n163 182.19
R25 avss.n484 avss.n129 182.19
R26 avss.n161 avss.n102 157.803
R27 avss.n372 avss.n315 114.766
R28 avss.n384 avss.n373 114.766
R29 avss.n398 avss.n308 114.766
R30 avss.n409 avss.n308 114.766
R31 avss.n409 avss.n302 114.766
R32 avss.n418 avss.n302 114.766
R33 avss.n418 avss.n287 114.766
R34 avss.n433 avss.n295 114.766
R35 avss.n458 avss.n150 114.766
R36 avss.n474 avss.n137 114.766
R37 avss.n277 avss.n276 114.766
R38 avss.n263 avss.n173 114.766
R39 avss.n235 avss.n185 114.766
R40 avss.n501 avss.n106 114.766
R41 avss.n439 avss.n100 111.897
R42 avss.n457 avss.n153 104.007
R43 avss.n466 avss.n143 104.007
R44 avss.n206 avss.n195 101.855
R45 avss.n264 avss.n171 101.855
R46 avss.n495 avss.n115 100.419
R47 avss.n495 avss.n494 98.268
R48 avss.n128 avss.n118 98.268
R49 avss.n466 avss.n144 94.6816
R50 avss.n502 avss.n104 84.6397
R51 avss.n587 avss.n70 83.2051
R52 avss.n236 avss.n104 74.5977
R53 avss.n432 avss.n150 73.1632
R54 avss.n182 avss.n173 71.0113
R55 avss.n257 avss.n256 71.0113
R56 avss.n241 avss.n240 68.9311
R57 avss.n240 avss.n120 68.9311
R58 avss.n493 avss.n119 68.9311
R59 avss.n119 avss.n117 68.9311
R60 avss.n237 avss.n184 68.9311
R61 avss.n255 avss.n237 68.9311
R62 avss.n265 avss.n170 68.9311
R63 avss.n265 avss.n169 68.9311
R64 avss.n164 avss.n162 68.9311
R65 avss.n275 avss.n164 68.9311
R66 avss.n279 avss.n160 68.9311
R67 avss.n279 avss.n159 68.9311
R68 avss.n450 avss.n449 68.9311
R69 avss.n450 avss.n155 68.9311
R70 avss.n456 avss.n154 68.9311
R71 avss.n154 avss.n152 68.9311
R72 avss.n441 avss.n285 67.7644
R73 avss.n441 avss.n286 67.7644
R74 avss.n399 avss.n314 67.7644
R75 avss.n397 avss.n314 67.7644
R76 avss.n316 avss.n315 67.4249
R77 avss.n398 avss.n384 67.4249
R78 avss.n440 avss.n287 67.4249
R79 avss.n485 avss.n127 66.6949
R80 avss.n483 avss.n127 66.6949
R81 avss.n199 avss.n197 66.6949
R82 avss.n199 avss.n193 66.6949
R83 avss.n473 avss.n136 66.6949
R84 avss.n475 avss.n136 66.6949
R85 avss.n383 avss.n307 66.6949
R86 avss.n383 avss.n374 66.6949
R87 avss.n73 avss.n69 66.6949
R88 avss.n586 avss.n73 66.6949
R89 avss.n553 avss.n95 66.6949
R90 avss.n540 avss.n95 66.6949
R91 avss.n371 avss.n68 66.6949
R92 avss.n371 avss.n317 66.6949
R93 avss.n335 avss.n334 66.6949
R94 avss.n335 avss.n46 66.6949
R95 avss.n19 avss.n15 66.6949
R96 avss.n667 avss.n15 66.6949
R97 avss.n611 avss.n5 66.6949
R98 avss.n669 avss.n5 66.6949
R99 avss.n206 avss.n103 57.383
R100 avss.n171 avss.n103 57.383
R101 avss.n440 avss.n439 47.341
R102 avss.n678 avss.n677 44.0168
R103 avss.n257 avss.n182 43.7546
R104 avss.n256 avss.n185 43.7546
R105 avss.n433 avss.n432 41.6028
R106 avss.n236 avss.n235 40.1682
R107 avss.n53 avss.n35 31.7197
R108 avss.n316 avss.n70 31.5609
R109 avss.n502 avss.n501 30.1263
R110 avss.n680 avss.n679 29.2979
R111 avss.n474 avss.n102 24.3881
R112 avss.n144 avss.n137 20.0844
R113 avss.n168 avss.n167 19.4509
R114 avss.n494 avss.n118 16.498
R115 avss.n484 avss.n128 16.498
R116 avss.n493 avss.n120 15.5561
R117 avss.n241 avss.n117 15.5561
R118 avss.n255 avss.n170 15.5561
R119 avss.n184 avss.n169 15.5561
R120 avss.n275 avss.n160 15.5561
R121 avss.n162 avss.n159 15.5561
R122 avss.n456 avss.n155 15.5561
R123 avss.n449 avss.n152 15.5561
R124 avss.n399 avss.n311 15.5561
R125 avss.n408 avss.n311 15.5561
R126 avss.n408 avss.n312 15.5561
R127 avss.n312 avss.n286 15.5561
R128 avss.n397 avss.n385 15.5561
R129 avss.n385 avss.n309 15.5561
R130 avss.n390 avss.n309 15.5561
R131 avss.n390 avss.n285 15.5561
R132 avss.n205 avss.n197 15.5561
R133 avss.n205 avss.n174 15.5561
R134 avss.n262 avss.n174 15.5561
R135 avss.n262 avss.n175 15.5561
R136 avss.n258 avss.n175 15.5561
R137 avss.n258 avss.n181 15.5561
R138 avss.n234 avss.n181 15.5561
R139 avss.n234 avss.n107 15.5561
R140 avss.n500 avss.n107 15.5561
R141 avss.n500 avss.n108 15.5561
R142 avss.n496 avss.n108 15.5561
R143 avss.n496 avss.n114 15.5561
R144 avss.n483 avss.n114 15.5561
R145 avss.n207 avss.n193 15.5561
R146 avss.n207 avss.n194 15.5561
R147 avss.n194 avss.n172 15.5561
R148 avss.n213 avss.n172 15.5561
R149 avss.n213 avss.n183 15.5561
R150 avss.n186 avss.n183 15.5561
R151 avss.n229 avss.n186 15.5561
R152 avss.n229 avss.n187 15.5561
R153 avss.n187 avss.n105 15.5561
R154 avss.n224 avss.n105 15.5561
R155 avss.n224 avss.n116 15.5561
R156 avss.n126 avss.n116 15.5561
R157 avss.n485 avss.n126 15.5561
R158 avss.n410 avss.n307 15.5561
R159 avss.n410 avss.n303 15.5561
R160 avss.n417 avss.n303 15.5561
R161 avss.n417 avss.n289 15.5561
R162 avss.n438 avss.n289 15.5561
R163 avss.n438 avss.n290 15.5561
R164 avss.n434 avss.n290 15.5561
R165 avss.n434 avss.n149 15.5561
R166 avss.n459 avss.n149 15.5561
R167 avss.n459 avss.n145 15.5561
R168 avss.n465 avss.n145 15.5561
R169 avss.n465 avss.n135 15.5561
R170 avss.n475 avss.n135 15.5561
R171 avss.n374 avss.n310 15.5561
R172 avss.n310 avss.n301 15.5561
R173 avss.n419 avss.n301 15.5561
R174 avss.n420 avss.n419 15.5561
R175 avss.n420 avss.n288 15.5561
R176 avss.n296 avss.n288 15.5561
R177 avss.n431 avss.n296 15.5561
R178 avss.n431 avss.n297 15.5561
R179 avss.n297 avss.n151 15.5561
R180 avss.n151 avss.n142 15.5561
R181 avss.n467 avss.n142 15.5561
R182 avss.n467 avss.n138 15.5561
R183 avss.n473 avss.n138 15.5561
R184 avss.n553 avss.n96 15.5561
R185 avss.n545 avss.n92 15.5561
R186 avss.n557 avss.n556 15.5561
R187 avss.n563 avss.n562 15.5561
R188 avss.n567 avss.n566 15.5561
R189 avss.n573 avss.n86 15.5561
R190 avss.n586 avss.n72 15.5561
R191 avss.n540 avss.n99 15.5561
R192 avss.n537 avss.n510 15.5561
R193 avss.n533 avss.n532 15.5561
R194 avss.n529 avss.n528 15.5561
R195 avss.n525 avss.n524 15.5561
R196 avss.n521 avss.n79 15.5561
R197 avss.n578 avss.n69 15.5561
R198 avss.n341 avss.n340 15.5561
R199 avss.n344 avss.n343 15.5561
R200 avss.n351 avss.n350 15.5561
R201 avss.n353 avss.n327 15.5561
R202 avss.n360 avss.n324 15.5561
R203 avss.n364 avss.n71 15.5561
R204 avss.n317 avss.n71 15.5561
R205 avss.n607 avss.n47 15.5561
R206 avss.n603 avss.n602 15.5561
R207 avss.n600 avss.n54 15.5561
R208 avss.n596 avss.n595 15.5561
R209 avss.n593 avss.n61 15.5561
R210 avss.n589 avss.n588 15.5561
R211 avss.n588 avss.n68 15.5561
R212 avss.n21 avss.n20 15.5561
R213 avss.n37 avss.n24 15.5561
R214 avss.n26 avss.n25 15.5561
R215 avss.n40 avss.n29 15.5561
R216 avss.n31 avss.n30 15.5561
R217 avss.n43 avss.n34 15.5561
R218 avss.n667 avss.n16 15.5561
R219 avss.n636 avss.n635 15.5561
R220 avss.n638 avss.n637 15.5561
R221 avss.n642 avss.n641 15.5561
R222 avss.n644 avss.n643 15.5561
R223 avss.n648 avss.n647 15.5561
R224 avss.n669 avss.n4 15.5561
R225 avss.n115 avss.n106 14.3461
R226 avss.n196 avss.n195 12.9116
R227 avss.n264 avss.n263 12.9116
R228 avss.n458 avss.n457 10.7597
R229 avss.n153 avss.n143 10.7597
R230 avss.n587 avss.n35 10.0424
R231 avss.n480 avss.n479 6.52425
R232 avss.n693 avss.n673 6.39977
R233 avss.n609 avss.n35 5.6489
R234 avss.n590 avss.n589 5.2005
R235 avss.n591 avss.n61 5.2005
R236 avss.n593 avss.n592 5.2005
R237 avss.n595 avss.n59 5.2005
R238 avss.n597 avss.n596 5.2005
R239 avss.n598 avss.n54 5.2005
R240 avss.n600 avss.n599 5.2005
R241 avss.n602 avss.n52 5.2005
R242 avss.n365 avss.n364 5.2005
R243 avss.n324 avss.n322 5.2005
R244 avss.n360 avss.n359 5.2005
R245 avss.n328 avss.n327 5.2005
R246 avss.n354 avss.n353 5.2005
R247 avss.n352 avss.n351 5.2005
R248 avss.n350 avss.n349 5.2005
R249 avss.n343 avss.n330 5.2005
R250 avss.n579 avss.n578 5.2005
R251 avss.n79 avss.n78 5.2005
R252 avss.n522 avss.n521 5.2005
R253 avss.n524 avss.n523 5.2005
R254 avss.n526 avss.n525 5.2005
R255 avss.n528 avss.n527 5.2005
R256 avss.n530 avss.n529 5.2005
R257 avss.n532 avss.n531 5.2005
R258 avss.n74 avss.n72 5.2005
R259 avss.n573 avss.n572 5.2005
R260 avss.n87 avss.n86 5.2005
R261 avss.n568 avss.n567 5.2005
R262 avss.n566 avss.n565 5.2005
R263 avss.n564 avss.n563 5.2005
R264 avss.n562 avss.n89 5.2005
R265 avss.n558 avss.n557 5.2005
R266 avss.n319 avss.n68 5.2005
R267 avss.n316 avss.n68 5.2005
R268 avss.n588 avss.n66 5.2005
R269 avss.n588 avss.n587 5.2005
R270 avss.n367 avss.n317 5.2005
R271 avss.n317 avss.n316 5.2005
R272 avss.n366 avss.n71 5.2005
R273 avss.n587 avss.n71 5.2005
R274 avss.n473 avss.n472 5.2005
R275 avss.n474 avss.n473 5.2005
R276 avss.n139 avss.n138 5.2005
R277 avss.n138 avss.n137 5.2005
R278 avss.n468 avss.n467 5.2005
R279 avss.n467 avss.n466 5.2005
R280 avss.n142 avss.n141 5.2005
R281 avss.n153 avss.n142 5.2005
R282 avss.n428 avss.n151 5.2005
R283 avss.n458 avss.n151 5.2005
R284 avss.n429 avss.n297 5.2005
R285 avss.n297 avss.n150 5.2005
R286 avss.n431 avss.n430 5.2005
R287 avss.n433 avss.n431 5.2005
R288 avss.n298 avss.n296 5.2005
R289 avss.n296 avss.n295 5.2005
R290 avss.n422 avss.n288 5.2005
R291 avss.n439 avss.n288 5.2005
R292 avss.n421 avss.n420 5.2005
R293 avss.n420 avss.n287 5.2005
R294 avss.n419 avss.n300 5.2005
R295 avss.n419 avss.n418 5.2005
R296 avss.n378 avss.n301 5.2005
R297 avss.n302 avss.n301 5.2005
R298 avss.n379 avss.n310 5.2005
R299 avss.n409 avss.n310 5.2005
R300 avss.n380 avss.n374 5.2005
R301 avss.n374 avss.n308 5.2005
R302 avss.n476 avss.n475 5.2005
R303 avss.n475 avss.n474 5.2005
R304 avss.n135 avss.n134 5.2005
R305 avss.n137 avss.n135 5.2005
R306 avss.n465 avss.n464 5.2005
R307 avss.n466 avss.n465 5.2005
R308 avss.n146 avss.n145 5.2005
R309 avss.n153 avss.n145 5.2005
R310 avss.n460 avss.n459 5.2005
R311 avss.n459 avss.n458 5.2005
R312 avss.n149 avss.n148 5.2005
R313 avss.n150 avss.n149 5.2005
R314 avss.n435 avss.n434 5.2005
R315 avss.n434 avss.n433 5.2005
R316 avss.n436 avss.n290 5.2005
R317 avss.n295 avss.n290 5.2005
R318 avss.n438 avss.n437 5.2005
R319 avss.n439 avss.n438 5.2005
R320 avss.n291 avss.n289 5.2005
R321 avss.n289 avss.n287 5.2005
R322 avss.n417 avss.n416 5.2005
R323 avss.n418 avss.n417 5.2005
R324 avss.n304 avss.n303 5.2005
R325 avss.n303 avss.n302 5.2005
R326 avss.n411 avss.n410 5.2005
R327 avss.n410 avss.n409 5.2005
R328 avss.n307 avss.n306 5.2005
R329 avss.n308 avss.n307 5.2005
R330 avss.n486 avss.n485 5.2005
R331 avss.n485 avss.n484 5.2005
R332 avss.n126 avss.n125 5.2005
R333 avss.n126 avss.n118 5.2005
R334 avss.n223 avss.n116 5.2005
R335 avss.n495 avss.n116 5.2005
R336 avss.n225 avss.n224 5.2005
R337 avss.n224 avss.n106 5.2005
R338 avss.n226 avss.n105 5.2005
R339 avss.n501 avss.n105 5.2005
R340 avss.n227 avss.n187 5.2005
R341 avss.n187 avss.n104 5.2005
R342 avss.n229 avss.n228 5.2005
R343 avss.n235 avss.n229 5.2005
R344 avss.n188 avss.n186 5.2005
R345 avss.n186 avss.n185 5.2005
R346 avss.n215 avss.n183 5.2005
R347 avss.n257 avss.n183 5.2005
R348 avss.n214 avss.n213 5.2005
R349 avss.n213 avss.n173 5.2005
R350 avss.n212 avss.n172 5.2005
R351 avss.n263 avss.n172 5.2005
R352 avss.n194 avss.n190 5.2005
R353 avss.n194 avss.n171 5.2005
R354 avss.n208 avss.n207 5.2005
R355 avss.n207 avss.n206 5.2005
R356 avss.n193 avss.n192 5.2005
R357 avss.n196 avss.n193 5.2005
R358 avss.n483 avss.n482 5.2005
R359 avss.n484 avss.n483 5.2005
R360 avss.n114 avss.n113 5.2005
R361 avss.n118 avss.n114 5.2005
R362 avss.n497 avss.n496 5.2005
R363 avss.n496 avss.n495 5.2005
R364 avss.n498 avss.n108 5.2005
R365 avss.n108 avss.n106 5.2005
R366 avss.n500 avss.n499 5.2005
R367 avss.n501 avss.n500 5.2005
R368 avss.n109 avss.n107 5.2005
R369 avss.n107 avss.n104 5.2005
R370 avss.n234 avss.n233 5.2005
R371 avss.n235 avss.n234 5.2005
R372 avss.n181 avss.n180 5.2005
R373 avss.n185 avss.n181 5.2005
R374 avss.n259 avss.n258 5.2005
R375 avss.n258 avss.n257 5.2005
R376 avss.n260 avss.n175 5.2005
R377 avss.n175 avss.n173 5.2005
R378 avss.n262 avss.n261 5.2005
R379 avss.n263 avss.n262 5.2005
R380 avss.n176 avss.n174 5.2005
R381 avss.n174 avss.n171 5.2005
R382 avss.n205 avss.n204 5.2005
R383 avss.n206 avss.n205 5.2005
R384 avss.n198 avss.n197 5.2005
R385 avss.n197 avss.n196 5.2005
R386 avss.n580 avss.n69 5.2005
R387 avss.n587 avss.n69 5.2005
R388 avss.n586 avss.n585 5.2005
R389 avss.n587 avss.n586 5.2005
R390 avss.n389 avss.n285 5.2005
R391 avss.n418 avss.n285 5.2005
R392 avss.n391 avss.n390 5.2005
R393 avss.n390 avss.n302 5.2005
R394 avss.n388 avss.n309 5.2005
R395 avss.n409 avss.n309 5.2005
R396 avss.n395 avss.n385 5.2005
R397 avss.n385 avss.n308 5.2005
R398 avss.n397 avss.n396 5.2005
R399 avss.n398 avss.n397 5.2005
R400 avss.n405 avss.n286 5.2005
R401 avss.n418 avss.n286 5.2005
R402 avss.n406 avss.n312 5.2005
R403 avss.n312 avss.n302 5.2005
R404 avss.n408 avss.n407 5.2005
R405 avss.n409 avss.n408 5.2005
R406 avss.n313 avss.n311 5.2005
R407 avss.n311 avss.n308 5.2005
R408 avss.n400 avss.n399 5.2005
R409 avss.n399 avss.n398 5.2005
R410 avss.n449 avss.n448 5.2005
R411 avss.n449 avss.n143 5.2005
R412 avss.n447 avss.n152 5.2005
R413 avss.n457 avss.n152 5.2005
R414 avss.n454 avss.n155 5.2005
R415 avss.n155 avss.n143 5.2005
R416 avss.n456 avss.n455 5.2005
R417 avss.n457 avss.n456 5.2005
R418 avss.n269 avss.n162 5.2005
R419 avss.n276 avss.n162 5.2005
R420 avss.n268 avss.n159 5.2005
R421 avss.n277 avss.n159 5.2005
R422 avss.n275 avss.n274 5.2005
R423 avss.n276 avss.n275 5.2005
R424 avss.n165 avss.n160 5.2005
R425 avss.n277 avss.n160 5.2005
R426 avss.n249 avss.n184 5.2005
R427 avss.n256 avss.n184 5.2005
R428 avss.n248 avss.n169 5.2005
R429 avss.n182 avss.n169 5.2005
R430 avss.n255 avss.n254 5.2005
R431 avss.n256 avss.n255 5.2005
R432 avss.n238 avss.n170 5.2005
R433 avss.n182 avss.n170 5.2005
R434 avss.n242 avss.n241 5.2005
R435 avss.n241 avss.n128 5.2005
R436 avss.n243 avss.n117 5.2005
R437 avss.n494 avss.n117 5.2005
R438 avss.n491 avss.n120 5.2005
R439 avss.n128 avss.n120 5.2005
R440 avss.n493 avss.n492 5.2005
R441 avss.n494 avss.n493 5.2005
R442 avss.n604 avss.n603 5.2005
R443 avss.n605 avss.n47 5.2005
R444 avss.n607 avss.n606 5.2005
R445 avss.n48 avss.n46 5.2005
R446 avss.n345 avss.n344 5.2005
R447 avss.n342 avss.n341 5.2005
R448 avss.n340 avss.n339 5.2005
R449 avss.n334 avss.n332 5.2005
R450 avss.n534 avss.n533 5.2005
R451 avss.n535 avss.n510 5.2005
R452 avss.n537 avss.n536 5.2005
R453 avss.n99 avss.n98 5.2005
R454 avss.n541 avss.n540 5.2005
R455 avss.n540 avss.n539 5.2005
R456 avss.n556 avss.n91 5.2005
R457 avss.n547 avss.n92 5.2005
R458 avss.n546 avss.n545 5.2005
R459 avss.n551 avss.n96 5.2005
R460 avss.n553 avss.n552 5.2005
R461 avss.n554 avss.n553 5.2005
R462 avss.n612 avss.n611 5.2005
R463 avss.n613 avss.n34 5.2005
R464 avss.n43 avss.n32 5.2005
R465 avss.n617 avss.n31 5.2005
R466 avss.n618 avss.n30 5.2005
R467 avss.n619 avss.n29 5.2005
R468 avss.n40 avss.n27 5.2005
R469 avss.n623 avss.n26 5.2005
R470 avss.n624 avss.n25 5.2005
R471 avss.n625 avss.n24 5.2005
R472 avss.n37 avss.n22 5.2005
R473 avss.n629 avss.n21 5.2005
R474 avss.n630 avss.n20 5.2005
R475 avss.n631 avss.n19 5.2005
R476 avss.n670 avss.n669 5.2005
R477 avss.n669 avss.n668 5.2005
R478 avss.n4 avss.n3 5.2005
R479 avss.n649 avss.n648 5.2005
R480 avss.n650 avss.n647 5.2005
R481 avss.n645 avss.n644 5.2005
R482 avss.n654 avss.n643 5.2005
R483 avss.n655 avss.n642 5.2005
R484 avss.n656 avss.n641 5.2005
R485 avss.n639 avss.n638 5.2005
R486 avss.n660 avss.n637 5.2005
R487 avss.n661 avss.n636 5.2005
R488 avss.n662 avss.n635 5.2005
R489 avss.n17 avss.n16 5.2005
R490 avss.n667 avss.n666 5.2005
R491 avss.n668 avss.n667 5.2005
R492 avss.n239 avss.n122 5.20011
R493 avss.n245 avss.n244 5.20011
R494 avss.n251 avss.n250 5.20011
R495 avss.n271 avss.n270 5.20011
R496 avss.n451 avss.n282 5.20011
R497 avss.n446 avss.n445 5.20011
R498 avss.n280 avss.n158 5.19229
R499 avss.n442 avss.n284 5.19017
R500 avss.n387 avss.n386 5.18235
R501 avss.n471 avss.n132 5.17941
R502 avss.n382 avss.n305 5.17941
R503 avss.n382 avss.n381 5.17941
R504 avss.n582 avss.n581 5.17941
R505 avss.n200 avss.n191 5.17941
R506 avss.n201 avss.n200 5.17941
R507 avss.n544 avss.n543 5.17941
R508 avss.n543 avss.n542 5.17941
R509 avss.n370 avss.n320 5.17941
R510 avss.n337 avss.n336 5.17941
R511 avss.n336 avss.n333 5.17941
R512 avss.n665 avss.n633 5.17941
R513 avss.n33 avss.n1 5.17941
R514 avss.n633 avss.n632 5.17159
R515 avss.n479 avss.n478 5.15985
R516 avss.n369 avss.n131 5.15985
R517 avss.n673 avss.n672 5.15985
R518 avss.n247 avss.n168 5.07
R519 avss.n443 avss.n442 4.96517
R520 avss.n386 avss.n76 4.96517
R521 avss.n583 avss.n582 4.95441
R522 avss.n246 avss.n245 4.95441
R523 avss.n252 avss.n251 4.95441
R524 avss.n267 avss.n266 4.95441
R525 avss.n272 avss.n271 4.95441
R526 avss.n281 avss.n280 4.95441
R527 avss.n452 avss.n451 4.95441
R528 avss.n445 avss.n444 4.95441
R529 avss.n490 avss.n489 4.7462
R530 avss.n478 avss.n477 4.7255
R531 avss.n488 avss.n487 4.7255
R532 avss.n481 avss.n480 4.7255
R533 avss.n369 avss.n368 4.7255
R534 avss.n672 avss.n671 4.7255
R535 avss.n412 avss.n411 4.5005
R536 avss.n413 avss.n304 4.5005
R537 avss.n416 avss.n415 4.5005
R538 avss.n414 avss.n291 4.5005
R539 avss.n437 avss.n292 4.5005
R540 avss.n436 avss.n293 4.5005
R541 avss.n435 avss.n294 4.5005
R542 avss.n148 avss.n147 4.5005
R543 avss.n461 avss.n460 4.5005
R544 avss.n462 avss.n146 4.5005
R545 avss.n464 avss.n463 4.5005
R546 avss.n134 avss.n133 4.5005
R547 avss.n477 avss.n476 4.5005
R548 avss.n306 avss.n305 4.5005
R549 avss.n379 avss.n375 4.5005
R550 avss.n378 avss.n377 4.5005
R551 avss.n376 avss.n300 4.5005
R552 avss.n421 avss.n299 4.5005
R553 avss.n423 avss.n422 4.5005
R554 avss.n424 avss.n298 4.5005
R555 avss.n430 avss.n425 4.5005
R556 avss.n429 avss.n426 4.5005
R557 avss.n428 avss.n427 4.5005
R558 avss.n141 avss.n140 4.5005
R559 avss.n469 avss.n468 4.5005
R560 avss.n470 avss.n139 4.5005
R561 avss.n472 avss.n471 4.5005
R562 avss.n381 avss.n380 4.5005
R563 avss.n395 avss.n394 4.5005
R564 avss.n393 avss.n388 4.5005
R565 avss.n392 avss.n391 4.5005
R566 avss.n389 avss.n284 4.5005
R567 avss.n396 avss.n387 4.5005
R568 avss.n209 avss.n208 4.5005
R569 avss.n210 avss.n190 4.5005
R570 avss.n212 avss.n211 4.5005
R571 avss.n214 avss.n189 4.5005
R572 avss.n216 avss.n215 4.5005
R573 avss.n217 avss.n188 4.5005
R574 avss.n228 avss.n218 4.5005
R575 avss.n227 avss.n219 4.5005
R576 avss.n226 avss.n220 4.5005
R577 avss.n225 avss.n221 4.5005
R578 avss.n223 avss.n222 4.5005
R579 avss.n125 avss.n124 4.5005
R580 avss.n487 avss.n486 4.5005
R581 avss.n192 avss.n191 4.5005
R582 avss.n204 avss.n203 4.5005
R583 avss.n202 avss.n176 4.5005
R584 avss.n261 avss.n177 4.5005
R585 avss.n260 avss.n178 4.5005
R586 avss.n259 avss.n179 4.5005
R587 avss.n230 avss.n180 4.5005
R588 avss.n233 avss.n232 4.5005
R589 avss.n231 avss.n109 4.5005
R590 avss.n499 avss.n110 4.5005
R591 avss.n498 avss.n111 4.5005
R592 avss.n497 avss.n112 4.5005
R593 avss.n130 avss.n113 4.5005
R594 avss.n482 avss.n481 4.5005
R595 avss.n201 avss.n198 4.5005
R596 avss.n242 avss.n239 4.5005
R597 avss.n244 avss.n243 4.5005
R598 avss.n250 avss.n249 4.5005
R599 avss.n248 avss.n247 4.5005
R600 avss.n270 avss.n269 4.5005
R601 avss.n268 avss.n158 4.5005
R602 avss.n448 avss.n282 4.5005
R603 avss.n447 avss.n446 4.5005
R604 avss.n454 avss.n453 4.5005
R605 avss.n455 avss.n156 4.5005
R606 avss.n274 avss.n273 4.5005
R607 avss.n165 avss.n157 4.5005
R608 avss.n254 avss.n253 4.5005
R609 avss.n238 avss.n166 4.5005
R610 avss.n491 avss.n490 4.5005
R611 avss.n492 avss.n121 4.5005
R612 avss.n402 avss.n313 4.5005
R613 avss.n407 avss.n403 4.5005
R614 avss.n406 avss.n404 4.5005
R615 avss.n405 avss.n283 4.5005
R616 avss.n401 avss.n400 4.5005
R617 avss.n551 avss.n550 4.5005
R618 avss.n549 avss.n546 4.5005
R619 avss.n548 avss.n547 4.5005
R620 avss.n91 avss.n90 4.5005
R621 avss.n559 avss.n558 4.5005
R622 avss.n560 avss.n89 4.5005
R623 avss.n564 avss.n561 4.5005
R624 avss.n565 avss.n88 4.5005
R625 avss.n569 avss.n568 4.5005
R626 avss.n570 avss.n87 4.5005
R627 avss.n572 avss.n571 4.5005
R628 avss.n75 avss.n74 4.5005
R629 avss.n585 avss.n584 4.5005
R630 avss.n552 avss.n544 4.5005
R631 avss.n98 avss.n97 4.5005
R632 avss.n536 avss.n511 4.5005
R633 avss.n535 avss.n512 4.5005
R634 avss.n534 avss.n513 4.5005
R635 avss.n531 avss.n514 4.5005
R636 avss.n530 avss.n515 4.5005
R637 avss.n527 avss.n516 4.5005
R638 avss.n526 avss.n517 4.5005
R639 avss.n523 avss.n518 4.5005
R640 avss.n522 avss.n520 4.5005
R641 avss.n519 avss.n78 4.5005
R642 avss.n579 avss.n77 4.5005
R643 avss.n581 avss.n580 4.5005
R644 avss.n542 avss.n541 4.5005
R645 avss.n339 avss.n338 4.5005
R646 avss.n342 avss.n331 4.5005
R647 avss.n346 avss.n345 4.5005
R648 avss.n347 avss.n330 4.5005
R649 avss.n349 avss.n348 4.5005
R650 avss.n352 avss.n329 4.5005
R651 avss.n355 avss.n354 4.5005
R652 avss.n356 avss.n328 4.5005
R653 avss.n359 avss.n358 4.5005
R654 avss.n357 avss.n322 4.5005
R655 avss.n365 avss.n323 4.5005
R656 avss.n366 avss.n321 4.5005
R657 avss.n368 avss.n367 4.5005
R658 avss.n337 avss.n332 4.5005
R659 avss.n606 avss.n49 4.5005
R660 avss.n605 avss.n50 4.5005
R661 avss.n604 avss.n51 4.5005
R662 avss.n55 avss.n52 4.5005
R663 avss.n599 avss.n56 4.5005
R664 avss.n598 avss.n57 4.5005
R665 avss.n597 avss.n58 4.5005
R666 avss.n62 avss.n59 4.5005
R667 avss.n592 avss.n63 4.5005
R668 avss.n591 avss.n64 4.5005
R669 avss.n590 avss.n65 4.5005
R670 avss.n318 avss.n66 4.5005
R671 avss.n320 avss.n319 4.5005
R672 avss.n333 avss.n48 4.5005
R673 avss.n664 avss.n17 4.5005
R674 avss.n663 avss.n662 4.5005
R675 avss.n661 avss.n634 4.5005
R676 avss.n660 avss.n659 4.5005
R677 avss.n658 avss.n639 4.5005
R678 avss.n657 avss.n656 4.5005
R679 avss.n655 avss.n640 4.5005
R680 avss.n654 avss.n653 4.5005
R681 avss.n652 avss.n645 4.5005
R682 avss.n651 avss.n650 4.5005
R683 avss.n649 avss.n646 4.5005
R684 avss.n3 avss.n2 4.5005
R685 avss.n671 avss.n670 4.5005
R686 avss.n666 avss.n665 4.5005
R687 avss.n630 avss.n18 4.5005
R688 avss.n629 avss.n628 4.5005
R689 avss.n627 avss.n22 4.5005
R690 avss.n626 avss.n625 4.5005
R691 avss.n624 avss.n23 4.5005
R692 avss.n623 avss.n622 4.5005
R693 avss.n621 avss.n27 4.5005
R694 avss.n620 avss.n619 4.5005
R695 avss.n618 avss.n28 4.5005
R696 avss.n617 avss.n616 4.5005
R697 avss.n615 avss.n32 4.5005
R698 avss.n614 avss.n613 4.5005
R699 avss.n612 avss.n33 4.5005
R700 avss.n632 avss.n631 4.5005
R701 avss.n276 avss.n163 3.5869
R702 avss.n545 avss.n94 3.11744
R703 avss.n556 avss.n555 3.11744
R704 avss.n562 avss.n83 3.11744
R705 avss.n566 avss.n84 3.11744
R706 avss.n86 avss.n85 3.11744
R707 avss.n574 avss.n72 3.11744
R708 avss.n538 avss.n537 3.11744
R709 avss.n533 avss.n509 3.11744
R710 avss.n529 avss.n80 3.11744
R711 avss.n525 avss.n81 3.11744
R712 avss.n521 avss.n82 3.11744
R713 avss.n578 avss.n577 3.11744
R714 avss.n340 avss.n7 3.11744
R715 avss.n344 avss.n8 3.11744
R716 avss.n350 avss.n325 3.11744
R717 avss.n353 avss.n326 3.11744
R718 avss.n361 avss.n360 3.11744
R719 avss.n364 avss.n363 3.11744
R720 avss.n608 avss.n607 3.11744
R721 avss.n603 avss.n45 3.11744
R722 avss.n601 avss.n600 3.11744
R723 avss.n596 avss.n60 3.11744
R724 avss.n594 avss.n593 3.11744
R725 avss.n589 avss.n67 3.11744
R726 avss.n67 avss.n61 3.11744
R727 avss.n595 avss.n594 3.11744
R728 avss.n60 avss.n54 3.11744
R729 avss.n602 avss.n601 3.11744
R730 avss.n363 avss.n324 3.11744
R731 avss.n361 avss.n327 3.11744
R732 avss.n351 avss.n326 3.11744
R733 avss.n343 avss.n325 3.11744
R734 avss.n577 avss.n79 3.11744
R735 avss.n524 avss.n82 3.11744
R736 avss.n528 avss.n81 3.11744
R737 avss.n532 avss.n80 3.11744
R738 avss.n574 avss.n573 3.11744
R739 avss.n567 avss.n85 3.11744
R740 avss.n563 avss.n84 3.11744
R741 avss.n557 avss.n83 3.11744
R742 avss.n47 avss.n45 3.11744
R743 avss.n608 avss.n46 3.11744
R744 avss.n341 avss.n8 3.11744
R745 avss.n334 avss.n7 3.11744
R746 avss.n510 avss.n509 3.11744
R747 avss.n538 avss.n99 3.11744
R748 avss.n555 avss.n92 3.11744
R749 avss.n96 avss.n94 3.11744
R750 avss.n36 avss.n19 3.11744
R751 avss.n38 avss.n21 3.11744
R752 avss.n39 avss.n24 3.11744
R753 avss.n41 avss.n26 3.11744
R754 avss.n42 avss.n29 3.11744
R755 avss.n44 avss.n31 3.11744
R756 avss.n610 avss.n34 3.11744
R757 avss.n611 avss.n610 3.11744
R758 avss.n44 avss.n43 3.11744
R759 avss.n42 avss.n30 3.11744
R760 avss.n41 avss.n40 3.11744
R761 avss.n39 avss.n25 3.11744
R762 avss.n38 avss.n37 3.11744
R763 avss.n36 avss.n20 3.11744
R764 avss.n635 avss.n14 3.11744
R765 avss.n637 avss.n13 3.11744
R766 avss.n641 avss.n12 3.11744
R767 avss.n643 avss.n11 3.11744
R768 avss.n647 avss.n10 3.11744
R769 avss.n9 avss.n4 3.11744
R770 avss.n648 avss.n9 3.11744
R771 avss.n644 avss.n10 3.11744
R772 avss.n642 avss.n11 3.11744
R773 avss.n638 avss.n12 3.11744
R774 avss.n636 avss.n13 3.11744
R775 avss.n16 avss.n14 3.11744
R776 avss.n295 avss.n100 2.86962
R777 avss.n278 avss.n161 1.43506
R778 avss.n479 avss.n131 1.3649
R779 avss.n67 avss.n53 1.04278
R780 avss.n594 avss.n53 1.04278
R781 avss.n60 avss.n53 1.04278
R782 avss.n601 avss.n53 1.04278
R783 avss.n363 avss.n362 1.04278
R784 avss.n362 avss.n361 1.04278
R785 avss.n362 avss.n326 1.04278
R786 avss.n362 avss.n325 1.04278
R787 avss.n577 avss.n576 1.04278
R788 avss.n576 avss.n82 1.04278
R789 avss.n576 avss.n81 1.04278
R790 avss.n576 avss.n80 1.04278
R791 avss.n575 avss.n574 1.04278
R792 avss.n575 avss.n85 1.04278
R793 avss.n575 avss.n84 1.04278
R794 avss.n575 avss.n83 1.04278
R795 avss.n609 avss.n45 1.04278
R796 avss.n609 avss.n608 1.04278
R797 avss.n668 avss.n8 1.04278
R798 avss.n668 avss.n7 1.04278
R799 avss.n539 avss.n509 1.04278
R800 avss.n539 avss.n538 1.04278
R801 avss.n555 avss.n554 1.04278
R802 avss.n554 avss.n94 1.04278
R803 avss.n610 avss.n609 1.04278
R804 avss.n609 avss.n44 1.04278
R805 avss.n609 avss.n42 1.04278
R806 avss.n609 avss.n41 1.04278
R807 avss.n609 avss.n39 1.04278
R808 avss.n609 avss.n38 1.04278
R809 avss.n609 avss.n36 1.04278
R810 avss.n668 avss.n9 1.04278
R811 avss.n668 avss.n10 1.04278
R812 avss.n668 avss.n11 1.04278
R813 avss.n668 avss.n12 1.04278
R814 avss.n668 avss.n13 1.04278
R815 avss.n668 avss.n14 1.04278
R816 avss.n673 vw 0.7592
R817 avss.n371 avss.n370 0.743357
R818 avss.n372 avss.n371 0.743357
R819 avss.n383 avss.n382 0.743357
R820 avss.n384 avss.n383 0.743357
R821 avss.n136 avss.n132 0.743357
R822 avss.n161 avss.n136 0.743357
R823 avss.n200 avss.n199 0.743357
R824 avss.n199 avss.n163 0.743357
R825 avss.n127 avss.n123 0.743357
R826 avss.n129 avss.n127 0.743357
R827 avss.n582 avss.n73 0.743357
R828 avss.n315 avss.n73 0.743357
R829 avss.n386 avss.n314 0.743357
R830 avss.n373 avss.n314 0.743357
R831 avss.n442 avss.n441 0.743357
R832 avss.n441 avss.n440 0.743357
R833 avss.n445 avss.n154 0.743357
R834 avss.n432 avss.n154 0.743357
R835 avss.n451 avss.n450 0.743357
R836 avss.n450 avss.n144 0.743357
R837 avss.n280 avss.n279 0.743357
R838 avss.n279 avss.n278 0.743357
R839 avss.n271 avss.n164 0.743357
R840 avss.n195 avss.n164 0.743357
R841 avss.n266 avss.n265 0.743357
R842 avss.n265 avss.n264 0.743357
R843 avss.n251 avss.n237 0.743357
R844 avss.n237 avss.n236 0.743357
R845 avss.n245 avss.n119 0.743357
R846 avss.n119 avss.n115 0.743357
R847 avss.n240 avss.n122 0.743357
R848 avss.n240 avss.n129 0.743357
R849 avss.n336 avss.n335 0.743357
R850 avss.n335 avss.n6 0.743357
R851 avss.n543 avss.n95 0.743357
R852 avss.n95 avss.n93 0.743357
R853 avss.n633 avss.n15 0.743357
R854 avss.n15 avss.n6 0.743357
R855 avss.n5 avss.n1 0.743357
R856 avss.n6 avss.n5 0.743357
R857 avss.n131 vw 0.6026
R858 avss.n682 avss.n681 0.563
R859 avss.n683 avss.n676 0.563
R860 avss.n685 avss.n684 0.563
R861 avss.n686 avss.n675 0.563
R862 avss.n688 avss.n687 0.563
R863 avss.n689 avss.n674 0.563
R864 avss.n691 avss.n690 0.563
R865 avss.n692 avss.n0 0.563
R866 avss.n478 avss.n132 0.454413
R867 avss.n480 avss.n123 0.454413
R868 avss.n488 avss.n123 0.454413
R869 avss.n489 avss.n122 0.454413
R870 avss.n370 avss.n369 0.454413
R871 avss.n672 avss.n1 0.454413
R872 avss.n489 avss.n488 0.427022
R873 avss.n452 avss.n281 0.4073
R874 avss.n272 avss.n267 0.4073
R875 avss.n252 avss.n246 0.4073
R876 avss.n444 avss.n443 0.402841
R877 avss.n583 avss.n76 0.402841
R878 vw avss.n693 0.28475
R879 avss.n444 avss.n156 0.2462
R880 avss.n453 avss.n452 0.2462
R881 avss.n281 avss.n157 0.2462
R882 avss.n273 avss.n272 0.2462
R883 avss.n267 avss.n166 0.2462
R884 avss.n253 avss.n252 0.2462
R885 avss.n246 avss.n121 0.2462
R886 avss.n584 avss.n583 0.2255
R887 avss.n401 avss.n76 0.203203
R888 avss.n443 avss.n283 0.203203
R889 avss.n411 avss.n306 0.1445
R890 avss.n411 avss.n304 0.1445
R891 avss.n416 avss.n304 0.1445
R892 avss.n416 avss.n291 0.1445
R893 avss.n437 avss.n291 0.1445
R894 avss.n437 avss.n436 0.1445
R895 avss.n436 avss.n435 0.1445
R896 avss.n435 avss.n148 0.1445
R897 avss.n460 avss.n148 0.1445
R898 avss.n460 avss.n146 0.1445
R899 avss.n464 avss.n146 0.1445
R900 avss.n464 avss.n134 0.1445
R901 avss.n476 avss.n134 0.1445
R902 avss.n412 avss.n305 0.1445
R903 avss.n413 avss.n412 0.1445
R904 avss.n415 avss.n413 0.1445
R905 avss.n415 avss.n414 0.1445
R906 avss.n414 avss.n292 0.1445
R907 avss.n293 avss.n292 0.1445
R908 avss.n294 avss.n293 0.1445
R909 avss.n294 avss.n147 0.1445
R910 avss.n461 avss.n147 0.1445
R911 avss.n462 avss.n461 0.1445
R912 avss.n463 avss.n462 0.1445
R913 avss.n463 avss.n133 0.1445
R914 avss.n477 avss.n133 0.1445
R915 avss.n381 avss.n375 0.1445
R916 avss.n377 avss.n375 0.1445
R917 avss.n377 avss.n376 0.1445
R918 avss.n376 avss.n299 0.1445
R919 avss.n423 avss.n299 0.1445
R920 avss.n424 avss.n423 0.1445
R921 avss.n425 avss.n424 0.1445
R922 avss.n426 avss.n425 0.1445
R923 avss.n427 avss.n426 0.1445
R924 avss.n427 avss.n140 0.1445
R925 avss.n469 avss.n140 0.1445
R926 avss.n470 avss.n469 0.1445
R927 avss.n471 avss.n470 0.1445
R928 avss.n380 avss.n379 0.1445
R929 avss.n379 avss.n378 0.1445
R930 avss.n378 avss.n300 0.1445
R931 avss.n421 avss.n300 0.1445
R932 avss.n422 avss.n421 0.1445
R933 avss.n422 avss.n298 0.1445
R934 avss.n430 avss.n298 0.1445
R935 avss.n430 avss.n429 0.1445
R936 avss.n429 avss.n428 0.1445
R937 avss.n428 avss.n141 0.1445
R938 avss.n468 avss.n141 0.1445
R939 avss.n468 avss.n139 0.1445
R940 avss.n472 avss.n139 0.1445
R941 avss.n552 avss.n551 0.1445
R942 avss.n551 avss.n546 0.1445
R943 avss.n547 avss.n546 0.1445
R944 avss.n547 avss.n91 0.1445
R945 avss.n558 avss.n91 0.1445
R946 avss.n558 avss.n89 0.1445
R947 avss.n564 avss.n89 0.1445
R948 avss.n565 avss.n564 0.1445
R949 avss.n568 avss.n565 0.1445
R950 avss.n568 avss.n87 0.1445
R951 avss.n572 avss.n87 0.1445
R952 avss.n572 avss.n74 0.1445
R953 avss.n585 avss.n74 0.1445
R954 avss.n400 avss.n313 0.1445
R955 avss.n407 avss.n313 0.1445
R956 avss.n407 avss.n406 0.1445
R957 avss.n406 avss.n405 0.1445
R958 avss.n396 avss.n395 0.1445
R959 avss.n395 avss.n388 0.1445
R960 avss.n391 avss.n388 0.1445
R961 avss.n391 avss.n389 0.1445
R962 avss.n394 avss.n387 0.1445
R963 avss.n394 avss.n393 0.1445
R964 avss.n393 avss.n392 0.1445
R965 avss.n392 avss.n284 0.1445
R966 avss.n492 avss.n491 0.1445
R967 avss.n254 avss.n238 0.1445
R968 avss.n274 avss.n165 0.1445
R969 avss.n455 avss.n454 0.1445
R970 avss.n243 avss.n242 0.1445
R971 avss.n204 avss.n198 0.1445
R972 avss.n204 avss.n176 0.1445
R973 avss.n261 avss.n176 0.1445
R974 avss.n261 avss.n260 0.1445
R975 avss.n260 avss.n259 0.1445
R976 avss.n259 avss.n180 0.1445
R977 avss.n233 avss.n180 0.1445
R978 avss.n233 avss.n109 0.1445
R979 avss.n499 avss.n109 0.1445
R980 avss.n499 avss.n498 0.1445
R981 avss.n498 avss.n497 0.1445
R982 avss.n497 avss.n113 0.1445
R983 avss.n482 avss.n113 0.1445
R984 avss.n208 avss.n192 0.1445
R985 avss.n208 avss.n190 0.1445
R986 avss.n212 avss.n190 0.1445
R987 avss.n214 avss.n212 0.1445
R988 avss.n215 avss.n214 0.1445
R989 avss.n215 avss.n188 0.1445
R990 avss.n228 avss.n188 0.1445
R991 avss.n228 avss.n227 0.1445
R992 avss.n227 avss.n226 0.1445
R993 avss.n226 avss.n225 0.1445
R994 avss.n225 avss.n223 0.1445
R995 avss.n223 avss.n125 0.1445
R996 avss.n486 avss.n125 0.1445
R997 avss.n209 avss.n191 0.1445
R998 avss.n210 avss.n209 0.1445
R999 avss.n211 avss.n210 0.1445
R1000 avss.n211 avss.n189 0.1445
R1001 avss.n216 avss.n189 0.1445
R1002 avss.n217 avss.n216 0.1445
R1003 avss.n218 avss.n217 0.1445
R1004 avss.n219 avss.n218 0.1445
R1005 avss.n220 avss.n219 0.1445
R1006 avss.n221 avss.n220 0.1445
R1007 avss.n222 avss.n221 0.1445
R1008 avss.n222 avss.n124 0.1445
R1009 avss.n487 avss.n124 0.1445
R1010 avss.n203 avss.n201 0.1445
R1011 avss.n203 avss.n202 0.1445
R1012 avss.n202 avss.n177 0.1445
R1013 avss.n178 avss.n177 0.1445
R1014 avss.n179 avss.n178 0.1445
R1015 avss.n230 avss.n179 0.1445
R1016 avss.n232 avss.n230 0.1445
R1017 avss.n232 avss.n231 0.1445
R1018 avss.n231 avss.n110 0.1445
R1019 avss.n111 avss.n110 0.1445
R1020 avss.n112 avss.n111 0.1445
R1021 avss.n130 avss.n112 0.1445
R1022 avss.n481 avss.n130 0.1445
R1023 avss.n244 avss.n239 0.1445
R1024 avss.n249 avss.n248 0.1445
R1025 avss.n250 avss.n247 0.1445
R1026 avss.n269 avss.n268 0.1445
R1027 avss.n270 avss.n158 0.1445
R1028 avss.n448 avss.n447 0.1445
R1029 avss.n446 avss.n282 0.1445
R1030 avss.n453 avss.n156 0.1445
R1031 avss.n273 avss.n157 0.1445
R1032 avss.n253 avss.n166 0.1445
R1033 avss.n490 avss.n121 0.1445
R1034 avss.n550 avss.n544 0.1445
R1035 avss.n550 avss.n549 0.1445
R1036 avss.n549 avss.n548 0.1445
R1037 avss.n548 avss.n90 0.1445
R1038 avss.n559 avss.n90 0.1445
R1039 avss.n560 avss.n559 0.1445
R1040 avss.n561 avss.n560 0.1445
R1041 avss.n561 avss.n88 0.1445
R1042 avss.n569 avss.n88 0.1445
R1043 avss.n570 avss.n569 0.1445
R1044 avss.n571 avss.n570 0.1445
R1045 avss.n571 avss.n75 0.1445
R1046 avss.n584 avss.n75 0.1445
R1047 avss.n542 avss.n97 0.1445
R1048 avss.n511 avss.n97 0.1445
R1049 avss.n512 avss.n511 0.1445
R1050 avss.n513 avss.n512 0.1445
R1051 avss.n514 avss.n513 0.1445
R1052 avss.n515 avss.n514 0.1445
R1053 avss.n516 avss.n515 0.1445
R1054 avss.n517 avss.n516 0.1445
R1055 avss.n518 avss.n517 0.1445
R1056 avss.n520 avss.n518 0.1445
R1057 avss.n520 avss.n519 0.1445
R1058 avss.n519 avss.n77 0.1445
R1059 avss.n581 avss.n77 0.1445
R1060 avss.n541 avss.n98 0.1445
R1061 avss.n536 avss.n98 0.1445
R1062 avss.n536 avss.n535 0.1445
R1063 avss.n535 avss.n534 0.1445
R1064 avss.n534 avss.n531 0.1445
R1065 avss.n531 avss.n530 0.1445
R1066 avss.n530 avss.n527 0.1445
R1067 avss.n527 avss.n526 0.1445
R1068 avss.n526 avss.n523 0.1445
R1069 avss.n523 avss.n522 0.1445
R1070 avss.n522 avss.n78 0.1445
R1071 avss.n579 avss.n78 0.1445
R1072 avss.n580 avss.n579 0.1445
R1073 avss.n339 avss.n332 0.1445
R1074 avss.n342 avss.n339 0.1445
R1075 avss.n345 avss.n342 0.1445
R1076 avss.n345 avss.n330 0.1445
R1077 avss.n349 avss.n330 0.1445
R1078 avss.n352 avss.n349 0.1445
R1079 avss.n354 avss.n352 0.1445
R1080 avss.n354 avss.n328 0.1445
R1081 avss.n359 avss.n328 0.1445
R1082 avss.n359 avss.n322 0.1445
R1083 avss.n365 avss.n322 0.1445
R1084 avss.n366 avss.n365 0.1445
R1085 avss.n367 avss.n366 0.1445
R1086 avss.n338 avss.n337 0.1445
R1087 avss.n338 avss.n331 0.1445
R1088 avss.n346 avss.n331 0.1445
R1089 avss.n347 avss.n346 0.1445
R1090 avss.n348 avss.n347 0.1445
R1091 avss.n348 avss.n329 0.1445
R1092 avss.n355 avss.n329 0.1445
R1093 avss.n356 avss.n355 0.1445
R1094 avss.n358 avss.n356 0.1445
R1095 avss.n358 avss.n357 0.1445
R1096 avss.n357 avss.n323 0.1445
R1097 avss.n323 avss.n321 0.1445
R1098 avss.n368 avss.n321 0.1445
R1099 avss.n333 avss.n49 0.1445
R1100 avss.n50 avss.n49 0.1445
R1101 avss.n51 avss.n50 0.1445
R1102 avss.n55 avss.n51 0.1445
R1103 avss.n56 avss.n55 0.1445
R1104 avss.n57 avss.n56 0.1445
R1105 avss.n58 avss.n57 0.1445
R1106 avss.n62 avss.n58 0.1445
R1107 avss.n63 avss.n62 0.1445
R1108 avss.n64 avss.n63 0.1445
R1109 avss.n65 avss.n64 0.1445
R1110 avss.n318 avss.n65 0.1445
R1111 avss.n320 avss.n318 0.1445
R1112 avss.n606 avss.n48 0.1445
R1113 avss.n606 avss.n605 0.1445
R1114 avss.n605 avss.n604 0.1445
R1115 avss.n604 avss.n52 0.1445
R1116 avss.n599 avss.n52 0.1445
R1117 avss.n599 avss.n598 0.1445
R1118 avss.n598 avss.n597 0.1445
R1119 avss.n597 avss.n59 0.1445
R1120 avss.n592 avss.n59 0.1445
R1121 avss.n592 avss.n591 0.1445
R1122 avss.n591 avss.n590 0.1445
R1123 avss.n590 avss.n66 0.1445
R1124 avss.n319 avss.n66 0.1445
R1125 avss.n631 avss.n630 0.1445
R1126 avss.n630 avss.n629 0.1445
R1127 avss.n629 avss.n22 0.1445
R1128 avss.n625 avss.n22 0.1445
R1129 avss.n625 avss.n624 0.1445
R1130 avss.n624 avss.n623 0.1445
R1131 avss.n623 avss.n27 0.1445
R1132 avss.n619 avss.n27 0.1445
R1133 avss.n619 avss.n618 0.1445
R1134 avss.n618 avss.n617 0.1445
R1135 avss.n617 avss.n32 0.1445
R1136 avss.n613 avss.n32 0.1445
R1137 avss.n613 avss.n612 0.1445
R1138 avss.n666 avss.n17 0.1445
R1139 avss.n662 avss.n17 0.1445
R1140 avss.n662 avss.n661 0.1445
R1141 avss.n661 avss.n660 0.1445
R1142 avss.n660 avss.n639 0.1445
R1143 avss.n656 avss.n639 0.1445
R1144 avss.n656 avss.n655 0.1445
R1145 avss.n655 avss.n654 0.1445
R1146 avss.n654 avss.n645 0.1445
R1147 avss.n650 avss.n645 0.1445
R1148 avss.n650 avss.n649 0.1445
R1149 avss.n649 avss.n3 0.1445
R1150 avss.n670 avss.n3 0.1445
R1151 avss.n665 avss.n664 0.1445
R1152 avss.n664 avss.n663 0.1445
R1153 avss.n663 avss.n634 0.1445
R1154 avss.n659 avss.n634 0.1445
R1155 avss.n659 avss.n658 0.1445
R1156 avss.n658 avss.n657 0.1445
R1157 avss.n657 avss.n640 0.1445
R1158 avss.n653 avss.n640 0.1445
R1159 avss.n653 avss.n652 0.1445
R1160 avss.n652 avss.n651 0.1445
R1161 avss.n651 avss.n646 0.1445
R1162 avss.n646 avss.n2 0.1445
R1163 avss.n671 avss.n2 0.1445
R1164 avss.n632 avss.n18 0.1445
R1165 avss.n628 avss.n18 0.1445
R1166 avss.n628 avss.n627 0.1445
R1167 avss.n627 avss.n626 0.1445
R1168 avss.n626 avss.n23 0.1445
R1169 avss.n622 avss.n23 0.1445
R1170 avss.n622 avss.n621 0.1445
R1171 avss.n621 avss.n620 0.1445
R1172 avss.n620 avss.n28 0.1445
R1173 avss.n616 avss.n28 0.1445
R1174 avss.n616 avss.n615 0.1445
R1175 avss.n615 avss.n614 0.1445
R1176 avss.n614 avss.n33 0.1445
R1177 avss.n402 avss.n401 0.13023
R1178 avss.n403 avss.n402 0.13023
R1179 avss.n404 avss.n403 0.13023
R1180 avss.n404 avss.n283 0.13023
R1181 avss.n266 avss.n168 0.122783
R1182 avss.n680 avss.n678 0.0732989
R1183 avss.n681 avss.n680 0.046062
R1184 avss.n684 avss.n683 0.03175
R1185 avss.n690 avss.n689 0.03175
R1186 avss.n685 avss.n676 0.03175
R1187 avss.n691 avss.n674 0.03175
R1188 avss.n693 avss.n692 0.00847797
R1189 avss.n683 avss.n682 0.0055
R1190 avss.n684 avss.n675 0.0055
R1191 avss.n688 avss.n675 0.0055
R1192 avss.n689 avss.n688 0.0055
R1193 avss.n690 avss.n0 0.0055
R1194 avss.n681 avss.n676 0.0055
R1195 avss.n686 avss.n685 0.0055
R1196 avss.n687 avss.n686 0.0055
R1197 avss.n687 avss.n674 0.0055
R1198 avss.n692 avss.n691 0.0055
R1199 avss.n682 avss.n678 0.00396875
R1200 vw avss.n0 0.003
R1201 avdd.n326 avdd.n325 1078.83
R1202 avdd.n325 avdd.n324 1078.83
R1203 avdd.n176 avdd.n143 522.652
R1204 avdd.n149 avdd.n143 522.652
R1205 avdd.n168 avdd.n156 522.652
R1206 avdd.n160 avdd.n156 522.652
R1207 avdd.n215 avdd.n214 522.652
R1208 avdd.n215 avdd.n202 522.652
R1209 avdd.n225 avdd.n224 522.652
R1210 avdd.n224 avdd.n195 522.652
R1211 avdd.n327 avdd.n293 144.812
R1212 avdd.n323 avdd.n293 144.812
R1213 avdd.n302 avdd.n296 144.812
R1214 avdd.n304 avdd.n296 144.812
R1215 avdd.n70 avdd.n60 142.857
R1216 avdd.n70 avdd.n54 142.857
R1217 avdd.n78 avdd.n54 142.857
R1218 avdd.n78 avdd.n48 142.857
R1219 avdd.n86 avdd.n48 142.857
R1220 avdd.n86 avdd.n42 142.857
R1221 avdd.n94 avdd.n42 142.857
R1222 avdd.n94 avdd.n36 142.857
R1223 avdd.n102 avdd.n36 142.857
R1224 avdd.n102 avdd.n30 142.857
R1225 avdd.n110 avdd.n30 142.857
R1226 avdd.n110 avdd.n24 142.857
R1227 avdd.n118 avdd.n24 142.857
R1228 avdd.n118 avdd.n18 142.857
R1229 avdd.n126 avdd.n18 142.857
R1230 avdd.n126 avdd.n12 142.857
R1231 avdd.n134 avdd.n12 142.857
R1232 avdd.n134 avdd.n6 142.857
R1233 avdd.n185 avdd.n6 142.857
R1234 avdd.n257 avdd.n249 142.857
R1235 avdd.n266 avdd.n249 142.857
R1236 avdd.n266 avdd.n243 142.857
R1237 avdd.n274 avdd.n243 142.857
R1238 avdd.n274 avdd.n237 142.857
R1239 avdd.n282 avdd.n237 142.857
R1240 avdd.n177 avdd.n142 62.038
R1241 avdd.n150 avdd.n142 62.038
R1242 avdd.n174 avdd.n144 62.038
R1243 avdd.n175 avdd.n174 62.038
R1244 avdd.n166 avdd.n157 62.038
R1245 avdd.n167 avdd.n166 62.038
R1246 avdd.n161 avdd.n147 62.038
R1247 avdd.n169 avdd.n147 62.038
R1248 avdd.n216 avdd.n200 62.038
R1249 avdd.n216 avdd.n201 62.038
R1250 avdd.n207 avdd.n203 62.038
R1251 avdd.n213 avdd.n203 62.038
R1252 avdd.n226 avdd.n194 62.038
R1253 avdd.n196 avdd.n194 62.038
R1254 avdd.n223 avdd.n222 62.038
R1255 avdd.n223 avdd.n193 62.038
R1256 avdd.n184 avdd.n5 61.7755
R1257 avdd.n64 avdd.n61 61.7755
R1258 avdd.n281 avdd.n236 61.7755
R1259 avdd.n256 avdd.n253 61.7755
R1260 avdd avdd.n0 51.5153
R1261 avdd.n186 avdd.n5 48.3669
R1262 avdd.n64 avdd.n63 48.3669
R1263 avdd.n283 avdd.n236 48.3669
R1264 avdd.n258 avdd.n253 48.3669
R1265 avdd.n146 avdd.n145 18.7429
R1266 avdd.n71 avdd.n59 14.0005
R1267 avdd.n71 avdd.n55 14.0005
R1268 avdd.n77 avdd.n55 14.0005
R1269 avdd.n77 avdd.n47 14.0005
R1270 avdd.n87 avdd.n47 14.0005
R1271 avdd.n87 avdd.n43 14.0005
R1272 avdd.n93 avdd.n43 14.0005
R1273 avdd.n93 avdd.n35 14.0005
R1274 avdd.n103 avdd.n35 14.0005
R1275 avdd.n103 avdd.n31 14.0005
R1276 avdd.n109 avdd.n31 14.0005
R1277 avdd.n109 avdd.n23 14.0005
R1278 avdd.n119 avdd.n23 14.0005
R1279 avdd.n119 avdd.n19 14.0005
R1280 avdd.n125 avdd.n19 14.0005
R1281 avdd.n125 avdd.n11 14.0005
R1282 avdd.n135 avdd.n11 14.0005
R1283 avdd.n135 avdd.n7 14.0005
R1284 avdd.n184 avdd.n7 14.0005
R1285 avdd.n69 avdd.n61 14.0005
R1286 avdd.n69 avdd.n53 14.0005
R1287 avdd.n79 avdd.n53 14.0005
R1288 avdd.n79 avdd.n49 14.0005
R1289 avdd.n85 avdd.n49 14.0005
R1290 avdd.n85 avdd.n41 14.0005
R1291 avdd.n95 avdd.n41 14.0005
R1292 avdd.n95 avdd.n37 14.0005
R1293 avdd.n101 avdd.n37 14.0005
R1294 avdd.n101 avdd.n29 14.0005
R1295 avdd.n111 avdd.n29 14.0005
R1296 avdd.n111 avdd.n25 14.0005
R1297 avdd.n117 avdd.n25 14.0005
R1298 avdd.n117 avdd.n17 14.0005
R1299 avdd.n127 avdd.n17 14.0005
R1300 avdd.n127 avdd.n13 14.0005
R1301 avdd.n133 avdd.n13 14.0005
R1302 avdd.n133 avdd.n4 14.0005
R1303 avdd.n187 avdd.n4 14.0005
R1304 avdd.n259 avdd.n250 14.0005
R1305 avdd.n265 avdd.n250 14.0005
R1306 avdd.n265 avdd.n242 14.0005
R1307 avdd.n275 avdd.n242 14.0005
R1308 avdd.n275 avdd.n238 14.0005
R1309 avdd.n281 avdd.n238 14.0005
R1310 avdd.n256 avdd.n248 14.0005
R1311 avdd.n267 avdd.n248 14.0005
R1312 avdd.n267 avdd.n244 14.0005
R1313 avdd.n273 avdd.n244 14.0005
R1314 avdd.n273 avdd.n235 14.0005
R1315 avdd.n284 avdd.n235 14.0005
R1316 avdd.n317 avdd.n316 14.0005
R1317 avdd.n323 avdd.n299 14.0005
R1318 avdd.n306 avdd.n305 14.0005
R1319 avdd.n327 avdd.n292 14.0005
R1320 avdd.n231 avdd.n190 7.97282
R1321 avdd.n231 avdd.n230 7.43822
R1322 avdd.n288 avdd.n287 7.43822
R1323 avdd.n331 avdd.n330 6.49028
R1324 avdd.n184 avdd.n183 6.3005
R1325 avdd.n185 avdd.n184 6.3005
R1326 avdd.n8 avdd.n7 6.3005
R1327 avdd.n7 avdd.n6 6.3005
R1328 avdd.n136 avdd.n135 6.3005
R1329 avdd.n135 avdd.n134 6.3005
R1330 avdd.n11 avdd.n10 6.3005
R1331 avdd.n12 avdd.n11 6.3005
R1332 avdd.n125 avdd.n124 6.3005
R1333 avdd.n126 avdd.n125 6.3005
R1334 avdd.n20 avdd.n19 6.3005
R1335 avdd.n19 avdd.n18 6.3005
R1336 avdd.n120 avdd.n119 6.3005
R1337 avdd.n119 avdd.n118 6.3005
R1338 avdd.n23 avdd.n22 6.3005
R1339 avdd.n24 avdd.n23 6.3005
R1340 avdd.n109 avdd.n108 6.3005
R1341 avdd.n110 avdd.n109 6.3005
R1342 avdd.n32 avdd.n31 6.3005
R1343 avdd.n31 avdd.n30 6.3005
R1344 avdd.n104 avdd.n103 6.3005
R1345 avdd.n103 avdd.n102 6.3005
R1346 avdd.n35 avdd.n34 6.3005
R1347 avdd.n36 avdd.n35 6.3005
R1348 avdd.n93 avdd.n92 6.3005
R1349 avdd.n94 avdd.n93 6.3005
R1350 avdd.n44 avdd.n43 6.3005
R1351 avdd.n43 avdd.n42 6.3005
R1352 avdd.n88 avdd.n87 6.3005
R1353 avdd.n87 avdd.n86 6.3005
R1354 avdd.n47 avdd.n46 6.3005
R1355 avdd.n48 avdd.n47 6.3005
R1356 avdd.n77 avdd.n76 6.3005
R1357 avdd.n78 avdd.n77 6.3005
R1358 avdd.n56 avdd.n55 6.3005
R1359 avdd.n55 avdd.n54 6.3005
R1360 avdd.n72 avdd.n71 6.3005
R1361 avdd.n71 avdd.n70 6.3005
R1362 avdd.n59 avdd.n58 6.3005
R1363 avdd.n62 avdd.n61 6.3005
R1364 avdd.n61 avdd.n60 6.3005
R1365 avdd.n69 avdd.n68 6.3005
R1366 avdd.n70 avdd.n69 6.3005
R1367 avdd.n53 avdd.n52 6.3005
R1368 avdd.n54 avdd.n53 6.3005
R1369 avdd.n80 avdd.n79 6.3005
R1370 avdd.n79 avdd.n78 6.3005
R1371 avdd.n50 avdd.n49 6.3005
R1372 avdd.n49 avdd.n48 6.3005
R1373 avdd.n85 avdd.n84 6.3005
R1374 avdd.n86 avdd.n85 6.3005
R1375 avdd.n41 avdd.n40 6.3005
R1376 avdd.n42 avdd.n41 6.3005
R1377 avdd.n96 avdd.n95 6.3005
R1378 avdd.n95 avdd.n94 6.3005
R1379 avdd.n38 avdd.n37 6.3005
R1380 avdd.n37 avdd.n36 6.3005
R1381 avdd.n101 avdd.n100 6.3005
R1382 avdd.n102 avdd.n101 6.3005
R1383 avdd.n29 avdd.n28 6.3005
R1384 avdd.n30 avdd.n29 6.3005
R1385 avdd.n112 avdd.n111 6.3005
R1386 avdd.n111 avdd.n110 6.3005
R1387 avdd.n26 avdd.n25 6.3005
R1388 avdd.n25 avdd.n24 6.3005
R1389 avdd.n117 avdd.n116 6.3005
R1390 avdd.n118 avdd.n117 6.3005
R1391 avdd.n17 avdd.n16 6.3005
R1392 avdd.n18 avdd.n17 6.3005
R1393 avdd.n128 avdd.n127 6.3005
R1394 avdd.n127 avdd.n126 6.3005
R1395 avdd.n14 avdd.n13 6.3005
R1396 avdd.n13 avdd.n12 6.3005
R1397 avdd.n133 avdd.n132 6.3005
R1398 avdd.n134 avdd.n133 6.3005
R1399 avdd.n4 avdd.n3 6.3005
R1400 avdd.n6 avdd.n4 6.3005
R1401 avdd.n188 avdd.n187 6.3005
R1402 avdd.n151 avdd.n150 6.3005
R1403 avdd.n152 avdd.n144 6.3005
R1404 avdd.n178 avdd.n177 6.3005
R1405 avdd.n175 avdd.n141 6.3005
R1406 avdd.n162 avdd.n161 6.3005
R1407 avdd.n163 avdd.n157 6.3005
R1408 avdd.n170 avdd.n169 6.3005
R1409 avdd.n167 avdd.n155 6.3005
R1410 avdd.n208 avdd.n207 6.3005
R1411 avdd.n206 avdd.n200 6.3005
R1412 avdd.n213 avdd.n212 6.3005
R1413 avdd.n204 avdd.n201 6.3005
R1414 avdd.n197 avdd.n196 6.3005
R1415 avdd.n222 avdd.n221 6.3005
R1416 avdd.n227 avdd.n226 6.3005
R1417 avdd.n228 avdd.n193 6.3005
R1418 avdd.n281 avdd.n280 6.3005
R1419 avdd.n282 avdd.n281 6.3005
R1420 avdd.n239 avdd.n238 6.3005
R1421 avdd.n238 avdd.n237 6.3005
R1422 avdd.n276 avdd.n275 6.3005
R1423 avdd.n275 avdd.n274 6.3005
R1424 avdd.n242 avdd.n241 6.3005
R1425 avdd.n243 avdd.n242 6.3005
R1426 avdd.n265 avdd.n264 6.3005
R1427 avdd.n266 avdd.n265 6.3005
R1428 avdd.n251 avdd.n250 6.3005
R1429 avdd.n250 avdd.n249 6.3005
R1430 avdd.n260 avdd.n259 6.3005
R1431 avdd.n285 avdd.n284 6.3005
R1432 avdd.n235 avdd.n234 6.3005
R1433 avdd.n237 avdd.n235 6.3005
R1434 avdd.n273 avdd.n272 6.3005
R1435 avdd.n274 avdd.n273 6.3005
R1436 avdd.n245 avdd.n244 6.3005
R1437 avdd.n244 avdd.n243 6.3005
R1438 avdd.n268 avdd.n267 6.3005
R1439 avdd.n267 avdd.n266 6.3005
R1440 avdd.n248 avdd.n247 6.3005
R1441 avdd.n249 avdd.n248 6.3005
R1442 avdd.n256 avdd.n255 6.3005
R1443 avdd.n257 avdd.n256 6.3005
R1444 avdd.n323 avdd.n322 6.3005
R1445 avdd.n324 avdd.n323 6.3005
R1446 avdd.n300 avdd.n299 6.3005
R1447 avdd.n318 avdd.n317 6.3005
R1448 avdd.n316 avdd.n315 6.3005
R1449 avdd.n314 avdd.n302 6.3005
R1450 avdd.n328 avdd.n327 6.3005
R1451 avdd.n327 avdd.n326 6.3005
R1452 avdd.n292 avdd.n291 6.3005
R1453 avdd.n308 avdd.n306 6.3005
R1454 avdd.n309 avdd.n305 6.3005
R1455 avdd.n310 avdd.n304 6.3005
R1456 avdd.n313 avdd.n312 6.12735
R1457 avdd.n321 avdd.n289 6.12735
R1458 avdd.n312 avdd.n311 6.11952
R1459 avdd.n165 avdd.n154 5.20011
R1460 avdd.n165 avdd.n164 5.20011
R1461 avdd.n148 avdd.n139 5.20011
R1462 avdd.n211 avdd.n210 5.20011
R1463 avdd.n210 avdd.n209 5.20011
R1464 avdd.n220 avdd.n191 5.20011
R1465 avdd.n65 avdd.n57 5.19741
R1466 avdd.n261 avdd.n252 5.19741
R1467 avdd.n279 avdd.n232 5.19741
R1468 avdd.n66 avdd.n65 5.18959
R1469 avdd.n254 avdd.n252 5.18959
R1470 avdd.n63 avdd.n60 4.9335
R1471 avdd.n186 avdd.n185 4.9335
R1472 avdd.n258 avdd.n257 4.9335
R1473 avdd.n283 avdd.n282 4.9335
R1474 avdd.n172 avdd.n171 4.75136
R1475 avdd.n159 avdd.n158 4.75136
R1476 avdd.n218 avdd.n198 4.75136
R1477 avdd.n199 avdd.n192 4.75136
R1478 avdd.n158 avdd.n140 4.75135
R1479 avdd.n172 avdd.n153 4.75135
R1480 avdd.n205 avdd.n199 4.75135
R1481 avdd.n219 avdd.n218 4.75135
R1482 avdd.n180 avdd.n179 4.7462
R1483 avdd.n230 avdd.n229 4.7462
R1484 avdd.n190 avdd.n189 4.7435
R1485 avdd.n182 avdd.n181 4.7435
R1486 avdd.n287 avdd.n286 4.7435
R1487 avdd.n330 avdd.n329 4.7255
R1488 avdd.n66 avdd.n62 4.5005
R1489 avdd.n68 avdd.n67 4.5005
R1490 avdd.n52 avdd.n51 4.5005
R1491 avdd.n81 avdd.n80 4.5005
R1492 avdd.n82 avdd.n50 4.5005
R1493 avdd.n84 avdd.n83 4.5005
R1494 avdd.n40 avdd.n39 4.5005
R1495 avdd.n97 avdd.n96 4.5005
R1496 avdd.n98 avdd.n38 4.5005
R1497 avdd.n100 avdd.n99 4.5005
R1498 avdd.n28 avdd.n27 4.5005
R1499 avdd.n113 avdd.n112 4.5005
R1500 avdd.n114 avdd.n26 4.5005
R1501 avdd.n116 avdd.n115 4.5005
R1502 avdd.n16 avdd.n15 4.5005
R1503 avdd.n129 avdd.n128 4.5005
R1504 avdd.n130 avdd.n14 4.5005
R1505 avdd.n132 avdd.n131 4.5005
R1506 avdd.n3 avdd.n2 4.5005
R1507 avdd.n189 avdd.n188 4.5005
R1508 avdd.n73 avdd.n72 4.5005
R1509 avdd.n74 avdd.n56 4.5005
R1510 avdd.n76 avdd.n75 4.5005
R1511 avdd.n46 avdd.n45 4.5005
R1512 avdd.n89 avdd.n88 4.5005
R1513 avdd.n90 avdd.n44 4.5005
R1514 avdd.n92 avdd.n91 4.5005
R1515 avdd.n34 avdd.n33 4.5005
R1516 avdd.n105 avdd.n104 4.5005
R1517 avdd.n106 avdd.n32 4.5005
R1518 avdd.n108 avdd.n107 4.5005
R1519 avdd.n22 avdd.n21 4.5005
R1520 avdd.n121 avdd.n120 4.5005
R1521 avdd.n122 avdd.n20 4.5005
R1522 avdd.n124 avdd.n123 4.5005
R1523 avdd.n10 avdd.n9 4.5005
R1524 avdd.n137 avdd.n136 4.5005
R1525 avdd.n138 avdd.n8 4.5005
R1526 avdd.n183 avdd.n182 4.5005
R1527 avdd.n58 avdd.n57 4.5005
R1528 avdd.n179 avdd.n178 4.5005
R1529 avdd.n141 avdd.n140 4.5005
R1530 avdd.n171 avdd.n170 4.5005
R1531 avdd.n155 avdd.n154 4.5005
R1532 avdd.n162 avdd.n159 4.5005
R1533 avdd.n164 avdd.n163 4.5005
R1534 avdd.n151 avdd.n148 4.5005
R1535 avdd.n153 avdd.n152 4.5005
R1536 avdd.n212 avdd.n211 4.5005
R1537 avdd.n204 avdd.n198 4.5005
R1538 avdd.n209 avdd.n208 4.5005
R1539 avdd.n206 avdd.n205 4.5005
R1540 avdd.n227 avdd.n192 4.5005
R1541 avdd.n229 avdd.n228 4.5005
R1542 avdd.n219 avdd.n197 4.5005
R1543 avdd.n221 avdd.n220 4.5005
R1544 avdd.n247 avdd.n246 4.5005
R1545 avdd.n269 avdd.n268 4.5005
R1546 avdd.n270 avdd.n245 4.5005
R1547 avdd.n272 avdd.n271 4.5005
R1548 avdd.n234 avdd.n233 4.5005
R1549 avdd.n286 avdd.n285 4.5005
R1550 avdd.n255 avdd.n254 4.5005
R1551 avdd.n262 avdd.n251 4.5005
R1552 avdd.n264 avdd.n263 4.5005
R1553 avdd.n241 avdd.n240 4.5005
R1554 avdd.n277 avdd.n276 4.5005
R1555 avdd.n278 avdd.n239 4.5005
R1556 avdd.n280 avdd.n279 4.5005
R1557 avdd.n261 avdd.n260 4.5005
R1558 avdd.n309 avdd.n303 4.5005
R1559 avdd.n308 avdd.n307 4.5005
R1560 avdd.n291 avdd.n290 4.5005
R1561 avdd.n329 avdd.n328 4.5005
R1562 avdd.n311 avdd.n310 4.5005
R1563 avdd.n315 avdd.n301 4.5005
R1564 avdd.n319 avdd.n318 4.5005
R1565 avdd.n320 avdd.n300 4.5005
R1566 avdd.n322 avdd.n321 4.5005
R1567 avdd.n314 avdd.n313 4.5005
R1568 avdd.n149 avdd.n144 3.31679
R1569 avdd.n150 avdd.n149 3.31679
R1570 avdd.n176 avdd.n175 3.31679
R1571 avdd.n177 avdd.n176 3.31679
R1572 avdd.n160 avdd.n157 3.31679
R1573 avdd.n161 avdd.n160 3.31679
R1574 avdd.n168 avdd.n167 3.31679
R1575 avdd.n169 avdd.n168 3.31679
R1576 avdd.n202 avdd.n200 3.31679
R1577 avdd.n207 avdd.n202 3.31679
R1578 avdd.n214 avdd.n201 3.31679
R1579 avdd.n214 avdd.n213 3.31679
R1580 avdd.n222 avdd.n195 3.31679
R1581 avdd.n196 avdd.n195 3.31679
R1582 avdd.n225 avdd.n193 3.31679
R1583 avdd.n226 avdd.n225 3.31679
R1584 avdd.n302 avdd.n297 3.31679
R1585 avdd.n317 avdd.n298 3.31679
R1586 avdd.n299 avdd.n298 3.31679
R1587 avdd.n316 avdd.n297 3.31679
R1588 avdd.n305 avdd.n294 3.31679
R1589 avdd.n295 avdd.n292 3.31679
R1590 avdd.n306 avdd.n295 3.31679
R1591 avdd.n304 avdd.n294 3.31679
R1592 avdd.n324 avdd.n298 1.49311
R1593 avdd.n324 avdd.n297 1.49311
R1594 avdd.n326 avdd.n295 1.49311
R1595 avdd.n326 avdd.n294 1.49311
R1596 avdd.n330 avdd.n289 1.40235
R1597 avdd.n187 avdd.n186 1.24194
R1598 avdd.n63 avdd.n59 1.24194
R1599 avdd.n284 avdd.n283 1.24194
R1600 avdd.n259 avdd.n258 1.24194
R1601 avdd.n65 avdd.n64 0.9005
R1602 avdd.n166 avdd.n165 0.9005
R1603 avdd.n166 avdd.n156 0.9005
R1604 avdd.n173 avdd.n147 0.9005
R1605 avdd.n156 avdd.n147 0.9005
R1606 avdd.n174 avdd.n173 0.9005
R1607 avdd.n174 avdd.n143 0.9005
R1608 avdd.n142 avdd.n139 0.9005
R1609 avdd.n143 avdd.n142 0.9005
R1610 avdd.n5 avdd.n1 0.9005
R1611 avdd.n210 avdd.n203 0.9005
R1612 avdd.n215 avdd.n203 0.9005
R1613 avdd.n217 avdd.n194 0.9005
R1614 avdd.n224 avdd.n194 0.9005
R1615 avdd.n217 avdd.n216 0.9005
R1616 avdd.n216 avdd.n215 0.9005
R1617 avdd.n223 avdd.n191 0.9005
R1618 avdd.n224 avdd.n223 0.9005
R1619 avdd.n253 avdd.n252 0.9005
R1620 avdd.n236 avdd.n232 0.9005
R1621 avdd.n331 avdd.n288 0.8789
R1622 avdd.n180 avdd.n139 0.454413
R1623 avdd.n181 avdd.n1 0.454413
R1624 avdd.n190 avdd.n1 0.454413
R1625 avdd.n230 avdd.n191 0.454413
R1626 avdd.n287 avdd.n232 0.454413
R1627 avdd.n181 avdd.n180 0.427022
R1628 avdd avdd.n331 0.3686
R1629 avdd.n312 avdd.n296 0.2255
R1630 avdd.n325 avdd.n296 0.2255
R1631 avdd.n293 avdd.n289 0.2255
R1632 avdd.n325 avdd.n293 0.2255
R1633 avdd.n288 avdd.n231 0.2003
R1634 avdd.n72 avdd.n58 0.1445
R1635 avdd.n72 avdd.n56 0.1445
R1636 avdd.n76 avdd.n56 0.1445
R1637 avdd.n76 avdd.n46 0.1445
R1638 avdd.n88 avdd.n46 0.1445
R1639 avdd.n88 avdd.n44 0.1445
R1640 avdd.n92 avdd.n44 0.1445
R1641 avdd.n92 avdd.n34 0.1445
R1642 avdd.n104 avdd.n34 0.1445
R1643 avdd.n104 avdd.n32 0.1445
R1644 avdd.n108 avdd.n32 0.1445
R1645 avdd.n108 avdd.n22 0.1445
R1646 avdd.n120 avdd.n22 0.1445
R1647 avdd.n120 avdd.n20 0.1445
R1648 avdd.n124 avdd.n20 0.1445
R1649 avdd.n124 avdd.n10 0.1445
R1650 avdd.n136 avdd.n10 0.1445
R1651 avdd.n136 avdd.n8 0.1445
R1652 avdd.n183 avdd.n8 0.1445
R1653 avdd.n68 avdd.n62 0.1445
R1654 avdd.n68 avdd.n52 0.1445
R1655 avdd.n80 avdd.n52 0.1445
R1656 avdd.n80 avdd.n50 0.1445
R1657 avdd.n84 avdd.n50 0.1445
R1658 avdd.n84 avdd.n40 0.1445
R1659 avdd.n96 avdd.n40 0.1445
R1660 avdd.n96 avdd.n38 0.1445
R1661 avdd.n100 avdd.n38 0.1445
R1662 avdd.n100 avdd.n28 0.1445
R1663 avdd.n112 avdd.n28 0.1445
R1664 avdd.n112 avdd.n26 0.1445
R1665 avdd.n116 avdd.n26 0.1445
R1666 avdd.n116 avdd.n16 0.1445
R1667 avdd.n128 avdd.n16 0.1445
R1668 avdd.n128 avdd.n14 0.1445
R1669 avdd.n132 avdd.n14 0.1445
R1670 avdd.n132 avdd.n3 0.1445
R1671 avdd.n188 avdd.n3 0.1445
R1672 avdd.n67 avdd.n66 0.1445
R1673 avdd.n67 avdd.n51 0.1445
R1674 avdd.n81 avdd.n51 0.1445
R1675 avdd.n82 avdd.n81 0.1445
R1676 avdd.n83 avdd.n82 0.1445
R1677 avdd.n83 avdd.n39 0.1445
R1678 avdd.n97 avdd.n39 0.1445
R1679 avdd.n98 avdd.n97 0.1445
R1680 avdd.n99 avdd.n98 0.1445
R1681 avdd.n99 avdd.n27 0.1445
R1682 avdd.n113 avdd.n27 0.1445
R1683 avdd.n114 avdd.n113 0.1445
R1684 avdd.n115 avdd.n114 0.1445
R1685 avdd.n115 avdd.n15 0.1445
R1686 avdd.n129 avdd.n15 0.1445
R1687 avdd.n130 avdd.n129 0.1445
R1688 avdd.n131 avdd.n130 0.1445
R1689 avdd.n131 avdd.n2 0.1445
R1690 avdd.n189 avdd.n2 0.1445
R1691 avdd.n73 avdd.n57 0.1445
R1692 avdd.n74 avdd.n73 0.1445
R1693 avdd.n75 avdd.n74 0.1445
R1694 avdd.n75 avdd.n45 0.1445
R1695 avdd.n89 avdd.n45 0.1445
R1696 avdd.n90 avdd.n89 0.1445
R1697 avdd.n91 avdd.n90 0.1445
R1698 avdd.n91 avdd.n33 0.1445
R1699 avdd.n105 avdd.n33 0.1445
R1700 avdd.n106 avdd.n105 0.1445
R1701 avdd.n107 avdd.n106 0.1445
R1702 avdd.n107 avdd.n21 0.1445
R1703 avdd.n121 avdd.n21 0.1445
R1704 avdd.n122 avdd.n121 0.1445
R1705 avdd.n123 avdd.n122 0.1445
R1706 avdd.n123 avdd.n9 0.1445
R1707 avdd.n137 avdd.n9 0.1445
R1708 avdd.n138 avdd.n137 0.1445
R1709 avdd.n182 avdd.n138 0.1445
R1710 avdd.n152 avdd.n151 0.1445
R1711 avdd.n178 avdd.n141 0.1445
R1712 avdd.n179 avdd.n140 0.1445
R1713 avdd.n163 avdd.n162 0.1445
R1714 avdd.n170 avdd.n155 0.1445
R1715 avdd.n171 avdd.n154 0.1445
R1716 avdd.n164 avdd.n159 0.1445
R1717 avdd.n153 avdd.n148 0.1445
R1718 avdd.n208 avdd.n206 0.1445
R1719 avdd.n212 avdd.n204 0.1445
R1720 avdd.n211 avdd.n198 0.1445
R1721 avdd.n209 avdd.n205 0.1445
R1722 avdd.n221 avdd.n197 0.1445
R1723 avdd.n228 avdd.n227 0.1445
R1724 avdd.n229 avdd.n192 0.1445
R1725 avdd.n220 avdd.n219 0.1445
R1726 avdd.n260 avdd.n251 0.1445
R1727 avdd.n264 avdd.n251 0.1445
R1728 avdd.n264 avdd.n241 0.1445
R1729 avdd.n276 avdd.n241 0.1445
R1730 avdd.n276 avdd.n239 0.1445
R1731 avdd.n280 avdd.n239 0.1445
R1732 avdd.n255 avdd.n247 0.1445
R1733 avdd.n268 avdd.n247 0.1445
R1734 avdd.n268 avdd.n245 0.1445
R1735 avdd.n272 avdd.n245 0.1445
R1736 avdd.n272 avdd.n234 0.1445
R1737 avdd.n285 avdd.n234 0.1445
R1738 avdd.n254 avdd.n246 0.1445
R1739 avdd.n269 avdd.n246 0.1445
R1740 avdd.n270 avdd.n269 0.1445
R1741 avdd.n271 avdd.n270 0.1445
R1742 avdd.n271 avdd.n233 0.1445
R1743 avdd.n286 avdd.n233 0.1445
R1744 avdd.n262 avdd.n261 0.1445
R1745 avdd.n263 avdd.n262 0.1445
R1746 avdd.n263 avdd.n240 0.1445
R1747 avdd.n277 avdd.n240 0.1445
R1748 avdd.n278 avdd.n277 0.1445
R1749 avdd.n279 avdd.n278 0.1445
R1750 avdd.n315 avdd.n314 0.1445
R1751 avdd.n318 avdd.n315 0.1445
R1752 avdd.n318 avdd.n300 0.1445
R1753 avdd.n322 avdd.n300 0.1445
R1754 avdd.n310 avdd.n309 0.1445
R1755 avdd.n309 avdd.n308 0.1445
R1756 avdd.n308 avdd.n291 0.1445
R1757 avdd.n328 avdd.n291 0.1445
R1758 avdd.n311 avdd.n303 0.1445
R1759 avdd.n307 avdd.n303 0.1445
R1760 avdd.n307 avdd.n290 0.1445
R1761 avdd.n329 avdd.n290 0.1445
R1762 avdd.n313 avdd.n301 0.1445
R1763 avdd.n319 avdd.n301 0.1445
R1764 avdd.n320 avdd.n319 0.1445
R1765 avdd.n321 avdd.n320 0.1445
R1766 avdd.n173 avdd.n172 0.0740097
R1767 avdd.n218 avdd.n217 0.0740097
R1768 avdd.n217 avdd.n199 0.0740097
R1769 avdd.n158 avdd.n146 0.0523493
R1770 avdd.n173 avdd.n146 0.0221604
R1771 vw.n596 vw.n146 27273.1
R1772 vw.n536 vw.n146 17334.8
R1773 vw.n539 vw.n537 14475
R1774 vw.n539 vw.n538 14475
R1775 vw.n535 vw.n77 14000
R1776 vw.n540 vw.n539 14000
R1777 vw.n537 vw.n234 14000
R1778 vw.n538 vw.n160 14000
R1779 vw.n534 vw.n28 14000
R1780 vw.n538 vw.n146 12850
R1781 vw.n537 vw.n536 5350
R1782 vw.n534 vw.n533 4163.87
R1783 vw.n495 vw.n494 2283.78
R1784 vw.n423 vw.n295 2283.78
R1785 vw.n535 vw.n534 2067.12
R1786 vw.n494 vw.n493 1051.61
R1787 vw.n536 vw.n535 773.053
R1788 vw.n680 vw.n30 203.708
R1789 vw.n533 vw.n235 203.343
R1790 vw.n294 vw.n235 203.343
R1791 vw.n311 vw.n250 203.343
R1792 vw.n414 vw.n311 203.343
R1793 vw.n639 vw.n638 198.688
R1794 vw.n493 vw.n294 187.267
R1795 vw.n541 vw.n105 182.19
R1796 vw.n597 vw.n596 182.19
R1797 vw.n234 vw.n103 157.803
R1798 vw.n687 vw.n30 114.766
R1799 vw.n680 vw.n679 114.766
R1800 vw.n66 vw.n39 114.766
R1801 vw.n66 vw.n48 114.766
R1802 vw.n671 vw.n48 114.766
R1803 vw.n671 vw.n51 114.766
R1804 vw.n75 vw.n51 114.766
R1805 vw.n656 vw.n88 114.766
R1806 vw.n193 vw.n90 114.766
R1807 vw.n233 vw.n174 114.766
R1808 vw.n638 vw.n637 114.766
R1809 vw.n624 vw.n115 114.766
R1810 vw.n568 vw.n127 114.766
R1811 vw.n577 vw.n134 114.766
R1812 vw.n662 vw.n77 111.897
R1813 vw.n182 vw.n95 104.007
R1814 vw.n648 vw.n96 104.007
R1815 vw.n551 vw.n172 101.855
R1816 vw.n625 vw.n113 101.855
R1817 vw.n604 vw.n603 100.419
R1818 vw.n603 vw.n136 98.268
R1819 vw.n584 vw.n144 98.268
R1820 vw.n173 vw.n96 94.6816
R1821 vw.n566 vw.n160 84.6397
R1822 vw.n492 vw.n28 83.2051
R1823 vw.n567 vw.n566 74.5977
R1824 vw.n655 vw.n90 73.1632
R1825 vw.n124 vw.n115 71.0113
R1826 vw.n618 vw.n617 71.0113
R1827 vw.n595 vw.n147 68.9311
R1828 vw.n595 vw.n148 68.9311
R1829 vw.n605 vw.n133 68.9311
R1830 vw.n605 vw.n132 68.9311
R1831 vw.n128 vw.n126 68.9311
R1832 vw.n616 vw.n128 68.9311
R1833 vw.n626 vw.n112 68.9311
R1834 vw.n626 vw.n111 68.9311
R1835 vw.n106 vw.n104 68.9311
R1836 vw.n636 vw.n106 68.9311
R1837 vw.n640 vw.n102 68.9311
R1838 vw.n640 vw.n101 68.9311
R1839 vw.n649 vw.n94 68.9311
R1840 vw.n647 vw.n94 68.9311
R1841 vw.n654 vw.n92 68.9311
R1842 vw.n654 vw.n91 68.9311
R1843 vw.n664 vw.n74 67.7644
R1844 vw.n664 vw.n53 67.7644
R1845 vw.n681 vw.n38 67.7644
R1846 vw.n681 vw.n37 67.7644
R1847 vw.n688 vw.n687 67.4249
R1848 vw.n679 vw.n39 67.4249
R1849 vw.n663 vw.n75 67.4249
R1850 vw.n145 vw.n143 66.6949
R1851 vw.n598 vw.n143 66.6949
R1852 vw.n544 vw.n542 66.6949
R1853 vw.n544 vw.n170 66.6949
R1854 vw.n177 vw.n175 66.6949
R1855 vw.n232 vw.n177 66.6949
R1856 vw.n678 vw.n41 66.6949
R1857 vw.n678 vw.n40 66.6949
R1858 vw.n686 vw.n31 66.6949
R1859 vw.n686 vw.n32 66.6949
R1860 vw.n293 vw.n238 66.6949
R1861 vw.n532 vw.n238 66.6949
R1862 vw.n29 vw.n27 66.6949
R1863 vw.n689 vw.n27 66.6949
R1864 vw.n453 vw.n308 66.6949
R1865 vw.n459 vw.n308 66.6949
R1866 vw.n356 vw.n319 66.6949
R1867 vw.n413 vw.n319 66.6949
R1868 vw.n389 vw.n388 66.6949
R1869 vw.n389 vw.n312 66.6949
R1870 vw.n551 vw.n540 57.383
R1871 vw.n540 vw.n113 57.383
R1872 vw.n663 vw.n662 47.341
R1873 vw.n7 vw.n6 44.0168
R1874 vw.n618 vw.n124 43.7546
R1875 vw.n617 vw.n127 43.7546
R1876 vw.n656 vw.n655 41.6028
R1877 vw.n568 vw.n567 40.1682
R1878 vw.n493 vw.n295 31.7197
R1879 vw.n688 vw.n28 31.5609
R1880 vw.n577 vw.n160 30.1263
R1881 vw.n5 vw.n4 29.2979
R1882 vw.n234 vw.n233 24.3881
R1883 vw.n174 vw.n173 20.0844
R1884 vw.n110 vw.n109 19.4509
R1885 vw.n584 vw.n136 16.498
R1886 vw.n597 vw.n144 16.498
R1887 vw.n148 vw.n133 15.5561
R1888 vw.n147 vw.n132 15.5561
R1889 vw.n616 vw.n112 15.5561
R1890 vw.n126 vw.n111 15.5561
R1891 vw.n636 vw.n102 15.5561
R1892 vw.n104 vw.n101 15.5561
R1893 vw.n647 vw.n92 15.5561
R1894 vw.n649 vw.n91 15.5561
R1895 vw.n65 vw.n38 15.5561
R1896 vw.n65 vw.n52 15.5561
R1897 vw.n670 vw.n52 15.5561
R1898 vw.n670 vw.n53 15.5561
R1899 vw.n67 vw.n37 15.5561
R1900 vw.n67 vw.n60 15.5561
R1901 vw.n60 vw.n49 15.5561
R1902 vw.n74 vw.n49 15.5561
R1903 vw.n550 vw.n542 15.5561
R1904 vw.n550 vw.n116 15.5561
R1905 vw.n623 vw.n116 15.5561
R1906 vw.n623 vw.n117 15.5561
R1907 vw.n619 vw.n117 15.5561
R1908 vw.n619 vw.n123 15.5561
R1909 vw.n569 vw.n123 15.5561
R1910 vw.n569 vw.n161 15.5561
R1911 vw.n576 vw.n161 15.5561
R1912 vw.n576 vw.n137 15.5561
R1913 vw.n602 vw.n137 15.5561
R1914 vw.n602 vw.n138 15.5561
R1915 vw.n598 vw.n138 15.5561
R1916 vw.n552 vw.n170 15.5561
R1917 vw.n552 vw.n171 15.5561
R1918 vw.n171 vw.n114 15.5561
R1919 vw.n558 vw.n114 15.5561
R1920 vw.n558 vw.n125 15.5561
R1921 vw.n164 vw.n125 15.5561
R1922 vw.n565 vw.n164 15.5561
R1923 vw.n565 vw.n158 15.5561
R1924 vw.n578 vw.n158 15.5561
R1925 vw.n578 vw.n159 15.5561
R1926 vw.n159 vw.n135 15.5561
R1927 vw.n585 vw.n135 15.5561
R1928 vw.n585 vw.n145 15.5561
R1929 vw.n44 vw.n41 15.5561
R1930 vw.n672 vw.n44 15.5561
R1931 vw.n672 vw.n47 15.5561
R1932 vw.n78 vw.n47 15.5561
R1933 vw.n661 vw.n78 15.5561
R1934 vw.n661 vw.n79 15.5561
R1935 vw.n657 vw.n79 15.5561
R1936 vw.n657 vw.n87 15.5561
R1937 vw.n192 vw.n87 15.5561
R1938 vw.n192 vw.n183 15.5561
R1939 vw.n188 vw.n183 15.5561
R1940 vw.n188 vw.n176 15.5561
R1941 vw.n232 vw.n176 15.5561
R1942 vw.n200 vw.n40 15.5561
R1943 vw.n200 vw.n50 15.5561
R1944 vw.n206 vw.n50 15.5561
R1945 vw.n207 vw.n206 15.5561
R1946 vw.n207 vw.n76 15.5561
R1947 vw.n212 vw.n76 15.5561
R1948 vw.n212 vw.n89 15.5561
R1949 vw.n215 vw.n89 15.5561
R1950 vw.n215 vw.n194 15.5561
R1951 vw.n222 vw.n194 15.5561
R1952 vw.n223 vw.n222 15.5561
R1953 vw.n224 vw.n223 15.5561
R1954 vw.n224 vw.n175 15.5561
R1955 vw.n293 vw.n253 15.5561
R1956 vw.n286 vw.n285 15.5561
R1957 vw.n283 vw.n282 15.5561
R1958 vw.n279 vw.n278 15.5561
R1959 vw.n275 vw.n274 15.5561
R1960 vw.n271 vw.n270 15.5561
R1961 vw.n267 vw.n32 15.5561
R1962 vw.n532 vw.n239 15.5561
R1963 vw.n528 vw.n527 15.5561
R1964 vw.n524 vw.n523 15.5561
R1965 vw.n521 vw.n496 15.5561
R1966 vw.n517 vw.n516 15.5561
R1967 vw.n514 vw.n503 15.5561
R1968 vw.n510 vw.n31 15.5561
R1969 vw.n451 vw.n450 15.5561
R1970 vw.n448 vw.n416 15.5561
R1971 vw.n444 vw.n443 15.5561
R1972 vw.n441 vw.n424 15.5561
R1973 vw.n437 vw.n436 15.5561
R1974 vw.n434 vw.n26 15.5561
R1975 vw.n689 vw.n26 15.5561
R1976 vw.n463 vw.n461 15.5561
R1977 vw.n469 vw.n304 15.5561
R1978 vw.n473 vw.n471 15.5561
R1979 vw.n479 vw.n300 15.5561
R1980 vw.n483 vw.n481 15.5561
R1981 vw.n491 vw.n296 15.5561
R1982 vw.n491 vw.n29 15.5561
R1983 vw.n360 vw.n358 15.5561
R1984 vw.n366 vw.n350 15.5561
R1985 vw.n370 vw.n368 15.5561
R1986 vw.n376 vw.n346 15.5561
R1987 vw.n380 vw.n378 15.5561
R1988 vw.n386 vw.n342 15.5561
R1989 vw.n413 vw.n320 15.5561
R1990 vw.n325 vw.n324 15.5561
R1991 vw.n327 vw.n326 15.5561
R1992 vw.n331 vw.n330 15.5561
R1993 vw.n333 vw.n332 15.5561
R1994 vw.n337 vw.n336 15.5561
R1995 vw.n338 vw.n312 15.5561
R1996 vw.n604 vw.n134 14.3461
R1997 vw.n541 vw.n172 12.9116
R1998 vw.n625 vw.n624 12.9116
R1999 vw.n193 vw.n182 10.7597
R2000 vw.n648 vw.n95 10.7597
R2001 vw.n493 vw.n492 10.0424
R2002 vw.n152 vw.n22 6.52425
R2003 vw.n21 vw.n20 6.39977
R2004 vw.n493 vw.n250 5.6489
R2005 vw.n297 vw.n296 5.2005
R2006 vw.n484 vw.n483 5.2005
R2007 vw.n481 vw.n299 5.2005
R2008 vw.n479 vw.n478 5.2005
R2009 vw.n301 vw.n300 5.2005
R2010 vw.n474 vw.n473 5.2005
R2011 vw.n471 vw.n303 5.2005
R2012 vw.n469 vw.n468 5.2005
R2013 vw.n434 vw.n433 5.2005
R2014 vw.n436 vw.n429 5.2005
R2015 vw.n438 vw.n437 5.2005
R2016 vw.n439 vw.n424 5.2005
R2017 vw.n441 vw.n440 5.2005
R2018 vw.n443 vw.n421 5.2005
R2019 vw.n445 vw.n444 5.2005
R2020 vw.n446 vw.n416 5.2005
R2021 vw.n511 vw.n510 5.2005
R2022 vw.n512 vw.n503 5.2005
R2023 vw.n514 vw.n513 5.2005
R2024 vw.n516 vw.n501 5.2005
R2025 vw.n518 vw.n517 5.2005
R2026 vw.n519 vw.n496 5.2005
R2027 vw.n521 vw.n520 5.2005
R2028 vw.n523 vw.n245 5.2005
R2029 vw.n268 vw.n267 5.2005
R2030 vw.n270 vw.n269 5.2005
R2031 vw.n272 vw.n271 5.2005
R2032 vw.n274 vw.n273 5.2005
R2033 vw.n276 vw.n275 5.2005
R2034 vw.n278 vw.n277 5.2005
R2035 vw.n280 vw.n279 5.2005
R2036 vw.n282 vw.n281 5.2005
R2037 vw.n489 vw.n29 5.2005
R2038 vw.n688 vw.n29 5.2005
R2039 vw.n491 vw.n490 5.2005
R2040 vw.n492 vw.n491 5.2005
R2041 vw.n690 vw.n689 5.2005
R2042 vw.n689 vw.n688 5.2005
R2043 vw.n26 vw.n25 5.2005
R2044 vw.n492 vw.n26 5.2005
R2045 vw.n226 vw.n175 5.2005
R2046 vw.n233 vw.n175 5.2005
R2047 vw.n225 vw.n224 5.2005
R2048 vw.n224 vw.n174 5.2005
R2049 vw.n223 vw.n181 5.2005
R2050 vw.n223 vw.n96 5.2005
R2051 vw.n222 vw.n221 5.2005
R2052 vw.n222 vw.n95 5.2005
R2053 vw.n195 vw.n194 5.2005
R2054 vw.n194 vw.n193 5.2005
R2055 vw.n216 vw.n215 5.2005
R2056 vw.n215 vw.n90 5.2005
R2057 vw.n214 vw.n89 5.2005
R2058 vw.n656 vw.n89 5.2005
R2059 vw.n213 vw.n212 5.2005
R2060 vw.n212 vw.n88 5.2005
R2061 vw.n197 vw.n76 5.2005
R2062 vw.n662 vw.n76 5.2005
R2063 vw.n208 vw.n207 5.2005
R2064 vw.n207 vw.n75 5.2005
R2065 vw.n206 vw.n205 5.2005
R2066 vw.n206 vw.n51 5.2005
R2067 vw.n204 vw.n50 5.2005
R2068 vw.n671 vw.n50 5.2005
R2069 vw.n201 vw.n200 5.2005
R2070 vw.n200 vw.n48 5.2005
R2071 vw.n199 vw.n40 5.2005
R2072 vw.n66 vw.n40 5.2005
R2073 vw.n232 vw.n231 5.2005
R2074 vw.n233 vw.n232 5.2005
R2075 vw.n178 vw.n176 5.2005
R2076 vw.n176 vw.n174 5.2005
R2077 vw.n189 vw.n188 5.2005
R2078 vw.n188 vw.n96 5.2005
R2079 vw.n190 vw.n183 5.2005
R2080 vw.n183 vw.n95 5.2005
R2081 vw.n192 vw.n191 5.2005
R2082 vw.n193 vw.n192 5.2005
R2083 vw.n87 vw.n86 5.2005
R2084 vw.n90 vw.n87 5.2005
R2085 vw.n658 vw.n657 5.2005
R2086 vw.n657 vw.n656 5.2005
R2087 vw.n659 vw.n79 5.2005
R2088 vw.n88 vw.n79 5.2005
R2089 vw.n661 vw.n660 5.2005
R2090 vw.n662 vw.n661 5.2005
R2091 vw.n80 vw.n78 5.2005
R2092 vw.n78 vw.n75 5.2005
R2093 vw.n47 vw.n46 5.2005
R2094 vw.n51 vw.n47 5.2005
R2095 vw.n673 vw.n672 5.2005
R2096 vw.n672 vw.n671 5.2005
R2097 vw.n674 vw.n44 5.2005
R2098 vw.n48 vw.n44 5.2005
R2099 vw.n675 vw.n41 5.2005
R2100 vw.n66 vw.n41 5.2005
R2101 vw.n587 vw.n145 5.2005
R2102 vw.n597 vw.n145 5.2005
R2103 vw.n586 vw.n585 5.2005
R2104 vw.n585 vw.n584 5.2005
R2105 vw.n583 vw.n135 5.2005
R2106 vw.n603 vw.n135 5.2005
R2107 vw.n159 vw.n155 5.2005
R2108 vw.n159 vw.n134 5.2005
R2109 vw.n579 vw.n578 5.2005
R2110 vw.n578 vw.n577 5.2005
R2111 vw.n158 vw.n157 5.2005
R2112 vw.n566 vw.n158 5.2005
R2113 vw.n565 vw.n564 5.2005
R2114 vw.n568 vw.n565 5.2005
R2115 vw.n165 vw.n164 5.2005
R2116 vw.n164 vw.n127 5.2005
R2117 vw.n560 vw.n125 5.2005
R2118 vw.n618 vw.n125 5.2005
R2119 vw.n559 vw.n558 5.2005
R2120 vw.n558 vw.n115 5.2005
R2121 vw.n557 vw.n114 5.2005
R2122 vw.n624 vw.n114 5.2005
R2123 vw.n171 vw.n167 5.2005
R2124 vw.n171 vw.n113 5.2005
R2125 vw.n553 vw.n552 5.2005
R2126 vw.n552 vw.n551 5.2005
R2127 vw.n170 vw.n169 5.2005
R2128 vw.n541 vw.n170 5.2005
R2129 vw.n599 vw.n598 5.2005
R2130 vw.n598 vw.n597 5.2005
R2131 vw.n600 vw.n138 5.2005
R2132 vw.n584 vw.n138 5.2005
R2133 vw.n602 vw.n601 5.2005
R2134 vw.n603 vw.n602 5.2005
R2135 vw.n139 vw.n137 5.2005
R2136 vw.n137 vw.n134 5.2005
R2137 vw.n576 vw.n575 5.2005
R2138 vw.n577 vw.n576 5.2005
R2139 vw.n162 vw.n161 5.2005
R2140 vw.n566 vw.n161 5.2005
R2141 vw.n570 vw.n569 5.2005
R2142 vw.n569 vw.n568 5.2005
R2143 vw.n123 vw.n122 5.2005
R2144 vw.n127 vw.n123 5.2005
R2145 vw.n620 vw.n619 5.2005
R2146 vw.n619 vw.n618 5.2005
R2147 vw.n621 vw.n117 5.2005
R2148 vw.n117 vw.n115 5.2005
R2149 vw.n623 vw.n622 5.2005
R2150 vw.n624 vw.n623 5.2005
R2151 vw.n118 vw.n116 5.2005
R2152 vw.n116 vw.n113 5.2005
R2153 vw.n550 vw.n549 5.2005
R2154 vw.n551 vw.n550 5.2005
R2155 vw.n543 vw.n542 5.2005
R2156 vw.n542 vw.n541 5.2005
R2157 vw.n508 vw.n31 5.2005
R2158 vw.n492 vw.n31 5.2005
R2159 vw.n266 vw.n32 5.2005
R2160 vw.n492 vw.n32 5.2005
R2161 vw.n74 vw.n73 5.2005
R2162 vw.n74 vw.n51 5.2005
R2163 vw.n72 vw.n49 5.2005
R2164 vw.n671 vw.n49 5.2005
R2165 vw.n60 vw.n58 5.2005
R2166 vw.n60 vw.n48 5.2005
R2167 vw.n68 vw.n67 5.2005
R2168 vw.n67 vw.n66 5.2005
R2169 vw.n59 vw.n37 5.2005
R2170 vw.n39 vw.n37 5.2005
R2171 vw.n668 vw.n53 5.2005
R2172 vw.n53 vw.n51 5.2005
R2173 vw.n670 vw.n669 5.2005
R2174 vw.n671 vw.n670 5.2005
R2175 vw.n54 vw.n52 5.2005
R2176 vw.n52 vw.n48 5.2005
R2177 vw.n65 vw.n64 5.2005
R2178 vw.n66 vw.n65 5.2005
R2179 vw.n61 vw.n38 5.2005
R2180 vw.n39 vw.n38 5.2005
R2181 vw.n650 vw.n649 5.2005
R2182 vw.n649 vw.n648 5.2005
R2183 vw.n651 vw.n91 5.2005
R2184 vw.n182 vw.n91 5.2005
R2185 vw.n647 vw.n646 5.2005
R2186 vw.n648 vw.n647 5.2005
R2187 vw.n97 vw.n92 5.2005
R2188 vw.n182 vw.n92 5.2005
R2189 vw.n630 vw.n104 5.2005
R2190 vw.n637 vw.n104 5.2005
R2191 vw.n629 vw.n101 5.2005
R2192 vw.n638 vw.n101 5.2005
R2193 vw.n636 vw.n635 5.2005
R2194 vw.n637 vw.n636 5.2005
R2195 vw.n107 vw.n102 5.2005
R2196 vw.n638 vw.n102 5.2005
R2197 vw.n610 vw.n126 5.2005
R2198 vw.n617 vw.n126 5.2005
R2199 vw.n609 vw.n111 5.2005
R2200 vw.n124 vw.n111 5.2005
R2201 vw.n616 vw.n615 5.2005
R2202 vw.n617 vw.n616 5.2005
R2203 vw.n129 vw.n112 5.2005
R2204 vw.n124 vw.n112 5.2005
R2205 vw.n150 vw.n147 5.2005
R2206 vw.n147 vw.n144 5.2005
R2207 vw.n149 vw.n132 5.2005
R2208 vw.n136 vw.n132 5.2005
R2209 vw.n591 vw.n148 5.2005
R2210 vw.n148 vw.n144 5.2005
R2211 vw.n590 vw.n133 5.2005
R2212 vw.n136 vw.n133 5.2005
R2213 vw.n305 vw.n304 5.2005
R2214 vw.n464 vw.n463 5.2005
R2215 vw.n461 vw.n307 5.2005
R2216 vw.n459 vw.n458 5.2005
R2217 vw.n448 vw.n447 5.2005
R2218 vw.n450 vw.n415 5.2005
R2219 vw.n451 vw.n310 5.2005
R2220 vw.n454 vw.n453 5.2005
R2221 vw.n525 vw.n524 5.2005
R2222 vw.n527 vw.n526 5.2005
R2223 vw.n529 vw.n528 5.2005
R2224 vw.n530 vw.n239 5.2005
R2225 vw.n532 vw.n531 5.2005
R2226 vw.n533 vw.n532 5.2005
R2227 vw.n284 vw.n283 5.2005
R2228 vw.n287 vw.n286 5.2005
R2229 vw.n285 vw.n256 5.2005
R2230 vw.n291 vw.n253 5.2005
R2231 vw.n293 vw.n292 5.2005
R2232 vw.n294 vw.n293 5.2005
R2233 vw.n388 vw.n341 5.2005
R2234 vw.n386 vw.n385 5.2005
R2235 vw.n343 vw.n342 5.2005
R2236 vw.n381 vw.n380 5.2005
R2237 vw.n378 vw.n345 5.2005
R2238 vw.n376 vw.n375 5.2005
R2239 vw.n347 vw.n346 5.2005
R2240 vw.n371 vw.n370 5.2005
R2241 vw.n368 vw.n349 5.2005
R2242 vw.n366 vw.n365 5.2005
R2243 vw.n351 vw.n350 5.2005
R2244 vw.n361 vw.n360 5.2005
R2245 vw.n358 vw.n353 5.2005
R2246 vw.n356 vw.n355 5.2005
R2247 vw.n339 vw.n312 5.2005
R2248 vw.n414 vw.n312 5.2005
R2249 vw.n394 vw.n338 5.2005
R2250 vw.n395 vw.n337 5.2005
R2251 vw.n396 vw.n336 5.2005
R2252 vw.n334 vw.n333 5.2005
R2253 vw.n400 vw.n332 5.2005
R2254 vw.n401 vw.n331 5.2005
R2255 vw.n402 vw.n330 5.2005
R2256 vw.n328 vw.n327 5.2005
R2257 vw.n406 vw.n326 5.2005
R2258 vw.n407 vw.n325 5.2005
R2259 vw.n408 vw.n324 5.2005
R2260 vw.n321 vw.n320 5.2005
R2261 vw.n413 vw.n412 5.2005
R2262 vw.n414 vw.n413 5.2005
R2263 vw.n594 vw.n151 5.20011
R2264 vw.n606 vw.n131 5.20011
R2265 vw.n612 vw.n611 5.20011
R2266 vw.n632 vw.n631 5.20011
R2267 vw.n643 vw.n93 5.20011
R2268 vw.n653 vw.n652 5.20011
R2269 vw.n641 vw.n100 5.19229
R2270 vw.n665 vw.n57 5.19017
R2271 vw.n682 vw.n36 5.18235
R2272 vw.n228 vw.n227 5.17941
R2273 vw.n677 vw.n676 5.17941
R2274 vw.n677 vw.n42 5.17941
R2275 vw.n685 vw.n33 5.17941
R2276 vw.n545 vw.n168 5.17941
R2277 vw.n546 vw.n545 5.17941
R2278 vw.n255 vw.n254 5.17941
R2279 vw.n254 vw.n240 5.17941
R2280 vw.n488 vw.n23 5.17941
R2281 vw.n456 vw.n455 5.17941
R2282 vw.n457 vw.n456 5.17941
R2283 vw.n411 vw.n322 5.17941
R2284 vw.n390 vw.n340 5.17941
R2285 vw.n354 vw.n322 5.17159
R2286 vw.n229 vw.n22 5.15985
R2287 vw.n693 vw.n692 5.15985
R2288 vw.n391 vw.n21 5.15985
R2289 vw.n608 vw.n110 5.07
R2290 vw.n666 vw.n665 4.96517
R2291 vw.n683 vw.n682 4.96517
R2292 vw.n685 vw.n684 4.95441
R2293 vw.n607 vw.n606 4.95441
R2294 vw.n613 vw.n612 4.95441
R2295 vw.n628 vw.n627 4.95441
R2296 vw.n633 vw.n632 4.95441
R2297 vw.n642 vw.n641 4.95441
R2298 vw.n644 vw.n643 4.95441
R2299 vw.n653 vw.n56 4.95441
R2300 vw.n593 vw.n592 4.7462
R2301 vw.n230 vw.n229 4.7255
R2302 vw.n589 vw.n588 4.7255
R2303 vw.n152 vw.n142 4.7255
R2304 vw.n692 vw.n691 4.7255
R2305 vw.n392 vw.n391 4.7255
R2306 vw.n674 vw.n43 4.5005
R2307 vw.n673 vw.n45 4.5005
R2308 vw.n81 vw.n46 4.5005
R2309 vw.n82 vw.n80 4.5005
R2310 vw.n660 vw.n83 4.5005
R2311 vw.n659 vw.n84 4.5005
R2312 vw.n658 vw.n85 4.5005
R2313 vw.n184 vw.n86 4.5005
R2314 vw.n191 vw.n185 4.5005
R2315 vw.n190 vw.n186 4.5005
R2316 vw.n189 vw.n187 4.5005
R2317 vw.n179 vw.n178 4.5005
R2318 vw.n231 vw.n230 4.5005
R2319 vw.n676 vw.n675 4.5005
R2320 vw.n202 vw.n201 4.5005
R2321 vw.n204 vw.n203 4.5005
R2322 vw.n205 vw.n198 4.5005
R2323 vw.n209 vw.n208 4.5005
R2324 vw.n210 vw.n197 4.5005
R2325 vw.n213 vw.n211 4.5005
R2326 vw.n214 vw.n196 4.5005
R2327 vw.n217 vw.n216 4.5005
R2328 vw.n218 vw.n195 4.5005
R2329 vw.n221 vw.n220 4.5005
R2330 vw.n219 vw.n181 4.5005
R2331 vw.n225 vw.n180 4.5005
R2332 vw.n227 vw.n226 4.5005
R2333 vw.n199 vw.n42 4.5005
R2334 vw.n69 vw.n68 4.5005
R2335 vw.n70 vw.n58 4.5005
R2336 vw.n72 vw.n71 4.5005
R2337 vw.n73 vw.n57 4.5005
R2338 vw.n59 vw.n36 4.5005
R2339 vw.n554 vw.n553 4.5005
R2340 vw.n555 vw.n167 4.5005
R2341 vw.n557 vw.n556 4.5005
R2342 vw.n559 vw.n166 4.5005
R2343 vw.n561 vw.n560 4.5005
R2344 vw.n562 vw.n165 4.5005
R2345 vw.n564 vw.n563 4.5005
R2346 vw.n157 vw.n156 4.5005
R2347 vw.n580 vw.n579 4.5005
R2348 vw.n581 vw.n155 4.5005
R2349 vw.n583 vw.n582 4.5005
R2350 vw.n586 vw.n154 4.5005
R2351 vw.n588 vw.n587 4.5005
R2352 vw.n169 vw.n168 4.5005
R2353 vw.n549 vw.n548 4.5005
R2354 vw.n547 vw.n118 4.5005
R2355 vw.n622 vw.n119 4.5005
R2356 vw.n621 vw.n120 4.5005
R2357 vw.n620 vw.n121 4.5005
R2358 vw.n163 vw.n122 4.5005
R2359 vw.n571 vw.n570 4.5005
R2360 vw.n572 vw.n162 4.5005
R2361 vw.n575 vw.n574 4.5005
R2362 vw.n573 vw.n139 4.5005
R2363 vw.n601 vw.n140 4.5005
R2364 vw.n600 vw.n141 4.5005
R2365 vw.n599 vw.n142 4.5005
R2366 vw.n546 vw.n543 4.5005
R2367 vw.n151 vw.n150 4.5005
R2368 vw.n149 vw.n131 4.5005
R2369 vw.n611 vw.n610 4.5005
R2370 vw.n609 vw.n608 4.5005
R2371 vw.n631 vw.n630 4.5005
R2372 vw.n629 vw.n100 4.5005
R2373 vw.n650 vw.n93 4.5005
R2374 vw.n652 vw.n651 4.5005
R2375 vw.n646 vw.n645 4.5005
R2376 vw.n98 vw.n97 4.5005
R2377 vw.n635 vw.n634 4.5005
R2378 vw.n107 vw.n99 4.5005
R2379 vw.n615 vw.n614 4.5005
R2380 vw.n129 vw.n108 4.5005
R2381 vw.n592 vw.n591 4.5005
R2382 vw.n590 vw.n130 4.5005
R2383 vw.n64 vw.n63 4.5005
R2384 vw.n62 vw.n54 4.5005
R2385 vw.n669 vw.n55 4.5005
R2386 vw.n668 vw.n667 4.5005
R2387 vw.n61 vw.n35 4.5005
R2388 vw.n291 vw.n290 4.5005
R2389 vw.n289 vw.n256 4.5005
R2390 vw.n288 vw.n287 4.5005
R2391 vw.n284 vw.n257 4.5005
R2392 vw.n281 vw.n258 4.5005
R2393 vw.n280 vw.n259 4.5005
R2394 vw.n277 vw.n260 4.5005
R2395 vw.n276 vw.n261 4.5005
R2396 vw.n273 vw.n262 4.5005
R2397 vw.n272 vw.n263 4.5005
R2398 vw.n269 vw.n264 4.5005
R2399 vw.n268 vw.n265 4.5005
R2400 vw.n266 vw.n34 4.5005
R2401 vw.n292 vw.n255 4.5005
R2402 vw.n530 vw.n241 4.5005
R2403 vw.n529 vw.n242 4.5005
R2404 vw.n526 vw.n243 4.5005
R2405 vw.n525 vw.n244 4.5005
R2406 vw.n497 vw.n245 4.5005
R2407 vw.n520 vw.n498 4.5005
R2408 vw.n519 vw.n499 4.5005
R2409 vw.n518 vw.n500 4.5005
R2410 vw.n504 vw.n501 4.5005
R2411 vw.n513 vw.n505 4.5005
R2412 vw.n512 vw.n506 4.5005
R2413 vw.n511 vw.n507 4.5005
R2414 vw.n508 vw.n33 4.5005
R2415 vw.n531 vw.n240 4.5005
R2416 vw.n310 vw.n309 4.5005
R2417 vw.n417 vw.n415 4.5005
R2418 vw.n447 vw.n418 4.5005
R2419 vw.n446 vw.n419 4.5005
R2420 vw.n445 vw.n420 4.5005
R2421 vw.n425 vw.n421 4.5005
R2422 vw.n440 vw.n426 4.5005
R2423 vw.n439 vw.n427 4.5005
R2424 vw.n438 vw.n428 4.5005
R2425 vw.n431 vw.n429 4.5005
R2426 vw.n433 vw.n432 4.5005
R2427 vw.n25 vw.n24 4.5005
R2428 vw.n691 vw.n690 4.5005
R2429 vw.n455 vw.n454 4.5005
R2430 vw.n307 vw.n306 4.5005
R2431 vw.n465 vw.n464 4.5005
R2432 vw.n466 vw.n305 4.5005
R2433 vw.n468 vw.n467 4.5005
R2434 vw.n303 vw.n302 4.5005
R2435 vw.n475 vw.n474 4.5005
R2436 vw.n476 vw.n301 4.5005
R2437 vw.n478 vw.n477 4.5005
R2438 vw.n299 vw.n298 4.5005
R2439 vw.n485 vw.n484 4.5005
R2440 vw.n486 vw.n297 4.5005
R2441 vw.n490 vw.n487 4.5005
R2442 vw.n489 vw.n488 4.5005
R2443 vw.n458 vw.n457 4.5005
R2444 vw.n410 vw.n321 4.5005
R2445 vw.n409 vw.n408 4.5005
R2446 vw.n407 vw.n323 4.5005
R2447 vw.n406 vw.n405 4.5005
R2448 vw.n404 vw.n328 4.5005
R2449 vw.n403 vw.n402 4.5005
R2450 vw.n401 vw.n329 4.5005
R2451 vw.n400 vw.n399 4.5005
R2452 vw.n398 vw.n334 4.5005
R2453 vw.n397 vw.n396 4.5005
R2454 vw.n395 vw.n335 4.5005
R2455 vw.n394 vw.n393 4.5005
R2456 vw.n392 vw.n339 4.5005
R2457 vw.n412 vw.n411 4.5005
R2458 vw.n353 vw.n352 4.5005
R2459 vw.n362 vw.n361 4.5005
R2460 vw.n363 vw.n351 4.5005
R2461 vw.n365 vw.n364 4.5005
R2462 vw.n349 vw.n348 4.5005
R2463 vw.n372 vw.n371 4.5005
R2464 vw.n373 vw.n347 4.5005
R2465 vw.n375 vw.n374 4.5005
R2466 vw.n345 vw.n344 4.5005
R2467 vw.n382 vw.n381 4.5005
R2468 vw.n383 vw.n343 4.5005
R2469 vw.n385 vw.n384 4.5005
R2470 vw.n341 vw.n340 4.5005
R2471 vw.n355 vw.n354 4.5005
R2472 vw.n637 vw.n105 3.5869
R2473 vw.n285 vw.n252 3.11744
R2474 vw.n283 vw.n251 3.11744
R2475 vw.n279 vw.n246 3.11744
R2476 vw.n275 vw.n247 3.11744
R2477 vw.n271 vw.n248 3.11744
R2478 vw.n267 vw.n249 3.11744
R2479 vw.n528 vw.n237 3.11744
R2480 vw.n524 vw.n236 3.11744
R2481 vw.n522 vw.n521 3.11744
R2482 vw.n517 vw.n502 3.11744
R2483 vw.n515 vw.n514 3.11744
R2484 vw.n510 vw.n509 3.11744
R2485 vw.n452 vw.n451 3.11744
R2486 vw.n449 vw.n448 3.11744
R2487 vw.n444 vw.n422 3.11744
R2488 vw.n442 vw.n441 3.11744
R2489 vw.n437 vw.n430 3.11744
R2490 vw.n435 vw.n434 3.11744
R2491 vw.n461 vw.n460 3.11744
R2492 vw.n462 vw.n304 3.11744
R2493 vw.n471 vw.n470 3.11744
R2494 vw.n472 vw.n300 3.11744
R2495 vw.n481 vw.n480 3.11744
R2496 vw.n482 vw.n296 3.11744
R2497 vw.n483 vw.n482 3.11744
R2498 vw.n480 vw.n479 3.11744
R2499 vw.n473 vw.n472 3.11744
R2500 vw.n470 vw.n469 3.11744
R2501 vw.n436 vw.n435 3.11744
R2502 vw.n430 vw.n424 3.11744
R2503 vw.n443 vw.n442 3.11744
R2504 vw.n422 vw.n416 3.11744
R2505 vw.n509 vw.n503 3.11744
R2506 vw.n516 vw.n515 3.11744
R2507 vw.n502 vw.n496 3.11744
R2508 vw.n523 vw.n522 3.11744
R2509 vw.n270 vw.n249 3.11744
R2510 vw.n274 vw.n248 3.11744
R2511 vw.n278 vw.n247 3.11744
R2512 vw.n282 vw.n246 3.11744
R2513 vw.n463 vw.n462 3.11744
R2514 vw.n460 vw.n459 3.11744
R2515 vw.n450 vw.n449 3.11744
R2516 vw.n453 vw.n452 3.11744
R2517 vw.n527 vw.n236 3.11744
R2518 vw.n239 vw.n237 3.11744
R2519 vw.n286 vw.n251 3.11744
R2520 vw.n253 vw.n252 3.11744
R2521 vw.n357 vw.n356 3.11744
R2522 vw.n360 vw.n359 3.11744
R2523 vw.n367 vw.n366 3.11744
R2524 vw.n370 vw.n369 3.11744
R2525 vw.n377 vw.n376 3.11744
R2526 vw.n380 vw.n379 3.11744
R2527 vw.n387 vw.n386 3.11744
R2528 vw.n388 vw.n387 3.11744
R2529 vw.n379 vw.n342 3.11744
R2530 vw.n378 vw.n377 3.11744
R2531 vw.n369 vw.n346 3.11744
R2532 vw.n368 vw.n367 3.11744
R2533 vw.n359 vw.n350 3.11744
R2534 vw.n358 vw.n357 3.11744
R2535 vw.n324 vw.n318 3.11744
R2536 vw.n326 vw.n317 3.11744
R2537 vw.n330 vw.n316 3.11744
R2538 vw.n332 vw.n315 3.11744
R2539 vw.n336 vw.n314 3.11744
R2540 vw.n338 vw.n313 3.11744
R2541 vw.n337 vw.n313 3.11744
R2542 vw.n333 vw.n314 3.11744
R2543 vw.n331 vw.n315 3.11744
R2544 vw.n327 vw.n316 3.11744
R2545 vw.n325 vw.n317 3.11744
R2546 vw.n320 vw.n318 3.11744
R2547 vw.n88 vw.n77 2.86962
R2548 vw.n639 vw.n103 1.43506
R2549 vw.n693 vw.n22 1.3649
R2550 vw.n482 vw.n295 1.04278
R2551 vw.n480 vw.n295 1.04278
R2552 vw.n472 vw.n295 1.04278
R2553 vw.n470 vw.n295 1.04278
R2554 vw.n435 vw.n423 1.04278
R2555 vw.n430 vw.n423 1.04278
R2556 vw.n442 vw.n423 1.04278
R2557 vw.n423 vw.n422 1.04278
R2558 vw.n509 vw.n495 1.04278
R2559 vw.n515 vw.n495 1.04278
R2560 vw.n502 vw.n495 1.04278
R2561 vw.n522 vw.n495 1.04278
R2562 vw.n494 vw.n249 1.04278
R2563 vw.n494 vw.n248 1.04278
R2564 vw.n494 vw.n247 1.04278
R2565 vw.n494 vw.n246 1.04278
R2566 vw.n462 vw.n250 1.04278
R2567 vw.n460 vw.n250 1.04278
R2568 vw.n449 vw.n414 1.04278
R2569 vw.n452 vw.n414 1.04278
R2570 vw.n533 vw.n236 1.04278
R2571 vw.n533 vw.n237 1.04278
R2572 vw.n294 vw.n251 1.04278
R2573 vw.n294 vw.n252 1.04278
R2574 vw.n387 vw.n250 1.04278
R2575 vw.n379 vw.n250 1.04278
R2576 vw.n377 vw.n250 1.04278
R2577 vw.n369 vw.n250 1.04278
R2578 vw.n367 vw.n250 1.04278
R2579 vw.n359 vw.n250 1.04278
R2580 vw.n357 vw.n250 1.04278
R2581 vw.n414 vw.n313 1.04278
R2582 vw.n414 vw.n314 1.04278
R2583 vw.n414 vw.n315 1.04278
R2584 vw.n414 vw.n316 1.04278
R2585 vw.n414 vw.n317 1.04278
R2586 vw.n414 vw.n318 1.04278
R2587 vw vw.n21 0.7592
R2588 vw.n27 vw.n23 0.743357
R2589 vw.n30 vw.n27 0.743357
R2590 vw.n678 vw.n677 0.743357
R2591 vw.n679 vw.n678 0.743357
R2592 vw.n228 vw.n177 0.743357
R2593 vw.n177 vw.n103 0.743357
R2594 vw.n545 vw.n544 0.743357
R2595 vw.n544 vw.n105 0.743357
R2596 vw.n153 vw.n143 0.743357
R2597 vw.n596 vw.n143 0.743357
R2598 vw.n686 vw.n685 0.743357
R2599 vw.n687 vw.n686 0.743357
R2600 vw.n682 vw.n681 0.743357
R2601 vw.n681 vw.n680 0.743357
R2602 vw.n665 vw.n664 0.743357
R2603 vw.n664 vw.n663 0.743357
R2604 vw.n654 vw.n653 0.743357
R2605 vw.n655 vw.n654 0.743357
R2606 vw.n643 vw.n94 0.743357
R2607 vw.n173 vw.n94 0.743357
R2608 vw.n641 vw.n640 0.743357
R2609 vw.n640 vw.n639 0.743357
R2610 vw.n632 vw.n106 0.743357
R2611 vw.n172 vw.n106 0.743357
R2612 vw.n627 vw.n626 0.743357
R2613 vw.n626 vw.n625 0.743357
R2614 vw.n612 vw.n128 0.743357
R2615 vw.n567 vw.n128 0.743357
R2616 vw.n606 vw.n605 0.743357
R2617 vw.n605 vw.n604 0.743357
R2618 vw.n595 vw.n594 0.743357
R2619 vw.n596 vw.n595 0.743357
R2620 vw.n456 vw.n308 0.743357
R2621 vw.n311 vw.n308 0.743357
R2622 vw.n254 vw.n238 0.743357
R2623 vw.n238 vw.n235 0.743357
R2624 vw.n322 vw.n319 0.743357
R2625 vw.n319 vw.n311 0.743357
R2626 vw.n390 vw.n389 0.743357
R2627 vw.n389 vw.n311 0.743357
R2628 vw vw.n693 0.6026
R2629 vw.n9 vw.n8 0.563
R2630 vw.n10 vw.n3 0.563
R2631 vw.n12 vw.n11 0.563
R2632 vw.n13 vw.n2 0.563
R2633 vw.n15 vw.n14 0.563
R2634 vw.n16 vw.n1 0.563
R2635 vw.n18 vw.n17 0.563
R2636 vw.n19 vw.n0 0.563
R2637 vw.n229 vw.n228 0.454413
R2638 vw.n153 vw.n152 0.454413
R2639 vw.n589 vw.n153 0.454413
R2640 vw.n594 vw.n593 0.454413
R2641 vw.n692 vw.n23 0.454413
R2642 vw.n391 vw.n390 0.454413
R2643 vw.n593 vw.n589 0.427022
R2644 vw.n644 vw.n642 0.4073
R2645 vw.n633 vw.n628 0.4073
R2646 vw.n613 vw.n607 0.4073
R2647 vw.n666 vw.n56 0.402841
R2648 vw.n684 vw.n683 0.402841
R2649 vw.n20 vw 0.28475
R2650 vw.n98 vw.n56 0.2462
R2651 vw.n645 vw.n644 0.2462
R2652 vw.n642 vw.n99 0.2462
R2653 vw.n634 vw.n633 0.2462
R2654 vw.n628 vw.n108 0.2462
R2655 vw.n614 vw.n613 0.2462
R2656 vw.n607 vw.n130 0.2462
R2657 vw.n684 vw.n34 0.2255
R2658 vw.n683 vw.n35 0.203203
R2659 vw.n667 vw.n666 0.203203
R2660 vw.n675 vw.n674 0.1445
R2661 vw.n674 vw.n673 0.1445
R2662 vw.n673 vw.n46 0.1445
R2663 vw.n80 vw.n46 0.1445
R2664 vw.n660 vw.n80 0.1445
R2665 vw.n660 vw.n659 0.1445
R2666 vw.n659 vw.n658 0.1445
R2667 vw.n658 vw.n86 0.1445
R2668 vw.n191 vw.n86 0.1445
R2669 vw.n191 vw.n190 0.1445
R2670 vw.n190 vw.n189 0.1445
R2671 vw.n189 vw.n178 0.1445
R2672 vw.n231 vw.n178 0.1445
R2673 vw.n676 vw.n43 0.1445
R2674 vw.n45 vw.n43 0.1445
R2675 vw.n81 vw.n45 0.1445
R2676 vw.n82 vw.n81 0.1445
R2677 vw.n83 vw.n82 0.1445
R2678 vw.n84 vw.n83 0.1445
R2679 vw.n85 vw.n84 0.1445
R2680 vw.n184 vw.n85 0.1445
R2681 vw.n185 vw.n184 0.1445
R2682 vw.n186 vw.n185 0.1445
R2683 vw.n187 vw.n186 0.1445
R2684 vw.n187 vw.n179 0.1445
R2685 vw.n230 vw.n179 0.1445
R2686 vw.n202 vw.n42 0.1445
R2687 vw.n203 vw.n202 0.1445
R2688 vw.n203 vw.n198 0.1445
R2689 vw.n209 vw.n198 0.1445
R2690 vw.n210 vw.n209 0.1445
R2691 vw.n211 vw.n210 0.1445
R2692 vw.n211 vw.n196 0.1445
R2693 vw.n217 vw.n196 0.1445
R2694 vw.n218 vw.n217 0.1445
R2695 vw.n220 vw.n218 0.1445
R2696 vw.n220 vw.n219 0.1445
R2697 vw.n219 vw.n180 0.1445
R2698 vw.n227 vw.n180 0.1445
R2699 vw.n201 vw.n199 0.1445
R2700 vw.n204 vw.n201 0.1445
R2701 vw.n205 vw.n204 0.1445
R2702 vw.n208 vw.n205 0.1445
R2703 vw.n208 vw.n197 0.1445
R2704 vw.n213 vw.n197 0.1445
R2705 vw.n214 vw.n213 0.1445
R2706 vw.n216 vw.n214 0.1445
R2707 vw.n216 vw.n195 0.1445
R2708 vw.n221 vw.n195 0.1445
R2709 vw.n221 vw.n181 0.1445
R2710 vw.n225 vw.n181 0.1445
R2711 vw.n226 vw.n225 0.1445
R2712 vw.n292 vw.n291 0.1445
R2713 vw.n291 vw.n256 0.1445
R2714 vw.n287 vw.n256 0.1445
R2715 vw.n287 vw.n284 0.1445
R2716 vw.n284 vw.n281 0.1445
R2717 vw.n281 vw.n280 0.1445
R2718 vw.n280 vw.n277 0.1445
R2719 vw.n277 vw.n276 0.1445
R2720 vw.n276 vw.n273 0.1445
R2721 vw.n273 vw.n272 0.1445
R2722 vw.n272 vw.n269 0.1445
R2723 vw.n269 vw.n268 0.1445
R2724 vw.n268 vw.n266 0.1445
R2725 vw.n64 vw.n61 0.1445
R2726 vw.n64 vw.n54 0.1445
R2727 vw.n669 vw.n54 0.1445
R2728 vw.n669 vw.n668 0.1445
R2729 vw.n68 vw.n59 0.1445
R2730 vw.n68 vw.n58 0.1445
R2731 vw.n72 vw.n58 0.1445
R2732 vw.n73 vw.n72 0.1445
R2733 vw.n69 vw.n36 0.1445
R2734 vw.n70 vw.n69 0.1445
R2735 vw.n71 vw.n70 0.1445
R2736 vw.n71 vw.n57 0.1445
R2737 vw.n591 vw.n590 0.1445
R2738 vw.n615 vw.n129 0.1445
R2739 vw.n635 vw.n107 0.1445
R2740 vw.n646 vw.n97 0.1445
R2741 vw.n150 vw.n149 0.1445
R2742 vw.n549 vw.n543 0.1445
R2743 vw.n549 vw.n118 0.1445
R2744 vw.n622 vw.n118 0.1445
R2745 vw.n622 vw.n621 0.1445
R2746 vw.n621 vw.n620 0.1445
R2747 vw.n620 vw.n122 0.1445
R2748 vw.n570 vw.n122 0.1445
R2749 vw.n570 vw.n162 0.1445
R2750 vw.n575 vw.n162 0.1445
R2751 vw.n575 vw.n139 0.1445
R2752 vw.n601 vw.n139 0.1445
R2753 vw.n601 vw.n600 0.1445
R2754 vw.n600 vw.n599 0.1445
R2755 vw.n553 vw.n169 0.1445
R2756 vw.n553 vw.n167 0.1445
R2757 vw.n557 vw.n167 0.1445
R2758 vw.n559 vw.n557 0.1445
R2759 vw.n560 vw.n559 0.1445
R2760 vw.n560 vw.n165 0.1445
R2761 vw.n564 vw.n165 0.1445
R2762 vw.n564 vw.n157 0.1445
R2763 vw.n579 vw.n157 0.1445
R2764 vw.n579 vw.n155 0.1445
R2765 vw.n583 vw.n155 0.1445
R2766 vw.n586 vw.n583 0.1445
R2767 vw.n587 vw.n586 0.1445
R2768 vw.n554 vw.n168 0.1445
R2769 vw.n555 vw.n554 0.1445
R2770 vw.n556 vw.n555 0.1445
R2771 vw.n556 vw.n166 0.1445
R2772 vw.n561 vw.n166 0.1445
R2773 vw.n562 vw.n561 0.1445
R2774 vw.n563 vw.n562 0.1445
R2775 vw.n563 vw.n156 0.1445
R2776 vw.n580 vw.n156 0.1445
R2777 vw.n581 vw.n580 0.1445
R2778 vw.n582 vw.n581 0.1445
R2779 vw.n582 vw.n154 0.1445
R2780 vw.n588 vw.n154 0.1445
R2781 vw.n548 vw.n546 0.1445
R2782 vw.n548 vw.n547 0.1445
R2783 vw.n547 vw.n119 0.1445
R2784 vw.n120 vw.n119 0.1445
R2785 vw.n121 vw.n120 0.1445
R2786 vw.n163 vw.n121 0.1445
R2787 vw.n571 vw.n163 0.1445
R2788 vw.n572 vw.n571 0.1445
R2789 vw.n574 vw.n572 0.1445
R2790 vw.n574 vw.n573 0.1445
R2791 vw.n573 vw.n140 0.1445
R2792 vw.n141 vw.n140 0.1445
R2793 vw.n142 vw.n141 0.1445
R2794 vw.n151 vw.n131 0.1445
R2795 vw.n610 vw.n609 0.1445
R2796 vw.n611 vw.n608 0.1445
R2797 vw.n630 vw.n629 0.1445
R2798 vw.n631 vw.n100 0.1445
R2799 vw.n651 vw.n650 0.1445
R2800 vw.n652 vw.n93 0.1445
R2801 vw.n645 vw.n98 0.1445
R2802 vw.n634 vw.n99 0.1445
R2803 vw.n614 vw.n108 0.1445
R2804 vw.n592 vw.n130 0.1445
R2805 vw.n290 vw.n255 0.1445
R2806 vw.n290 vw.n289 0.1445
R2807 vw.n289 vw.n288 0.1445
R2808 vw.n288 vw.n257 0.1445
R2809 vw.n258 vw.n257 0.1445
R2810 vw.n259 vw.n258 0.1445
R2811 vw.n260 vw.n259 0.1445
R2812 vw.n261 vw.n260 0.1445
R2813 vw.n262 vw.n261 0.1445
R2814 vw.n263 vw.n262 0.1445
R2815 vw.n264 vw.n263 0.1445
R2816 vw.n265 vw.n264 0.1445
R2817 vw.n265 vw.n34 0.1445
R2818 vw.n241 vw.n240 0.1445
R2819 vw.n242 vw.n241 0.1445
R2820 vw.n243 vw.n242 0.1445
R2821 vw.n244 vw.n243 0.1445
R2822 vw.n497 vw.n244 0.1445
R2823 vw.n498 vw.n497 0.1445
R2824 vw.n499 vw.n498 0.1445
R2825 vw.n500 vw.n499 0.1445
R2826 vw.n504 vw.n500 0.1445
R2827 vw.n505 vw.n504 0.1445
R2828 vw.n506 vw.n505 0.1445
R2829 vw.n507 vw.n506 0.1445
R2830 vw.n507 vw.n33 0.1445
R2831 vw.n531 vw.n530 0.1445
R2832 vw.n530 vw.n529 0.1445
R2833 vw.n529 vw.n526 0.1445
R2834 vw.n526 vw.n525 0.1445
R2835 vw.n525 vw.n245 0.1445
R2836 vw.n520 vw.n245 0.1445
R2837 vw.n520 vw.n519 0.1445
R2838 vw.n519 vw.n518 0.1445
R2839 vw.n518 vw.n501 0.1445
R2840 vw.n513 vw.n501 0.1445
R2841 vw.n513 vw.n512 0.1445
R2842 vw.n512 vw.n511 0.1445
R2843 vw.n511 vw.n508 0.1445
R2844 vw.n454 vw.n310 0.1445
R2845 vw.n415 vw.n310 0.1445
R2846 vw.n447 vw.n415 0.1445
R2847 vw.n447 vw.n446 0.1445
R2848 vw.n446 vw.n445 0.1445
R2849 vw.n445 vw.n421 0.1445
R2850 vw.n440 vw.n421 0.1445
R2851 vw.n440 vw.n439 0.1445
R2852 vw.n439 vw.n438 0.1445
R2853 vw.n438 vw.n429 0.1445
R2854 vw.n433 vw.n429 0.1445
R2855 vw.n433 vw.n25 0.1445
R2856 vw.n690 vw.n25 0.1445
R2857 vw.n455 vw.n309 0.1445
R2858 vw.n417 vw.n309 0.1445
R2859 vw.n418 vw.n417 0.1445
R2860 vw.n419 vw.n418 0.1445
R2861 vw.n420 vw.n419 0.1445
R2862 vw.n425 vw.n420 0.1445
R2863 vw.n426 vw.n425 0.1445
R2864 vw.n427 vw.n426 0.1445
R2865 vw.n428 vw.n427 0.1445
R2866 vw.n431 vw.n428 0.1445
R2867 vw.n432 vw.n431 0.1445
R2868 vw.n432 vw.n24 0.1445
R2869 vw.n691 vw.n24 0.1445
R2870 vw.n457 vw.n306 0.1445
R2871 vw.n465 vw.n306 0.1445
R2872 vw.n466 vw.n465 0.1445
R2873 vw.n467 vw.n466 0.1445
R2874 vw.n467 vw.n302 0.1445
R2875 vw.n475 vw.n302 0.1445
R2876 vw.n476 vw.n475 0.1445
R2877 vw.n477 vw.n476 0.1445
R2878 vw.n477 vw.n298 0.1445
R2879 vw.n485 vw.n298 0.1445
R2880 vw.n486 vw.n485 0.1445
R2881 vw.n487 vw.n486 0.1445
R2882 vw.n488 vw.n487 0.1445
R2883 vw.n458 vw.n307 0.1445
R2884 vw.n464 vw.n307 0.1445
R2885 vw.n464 vw.n305 0.1445
R2886 vw.n468 vw.n305 0.1445
R2887 vw.n468 vw.n303 0.1445
R2888 vw.n474 vw.n303 0.1445
R2889 vw.n474 vw.n301 0.1445
R2890 vw.n478 vw.n301 0.1445
R2891 vw.n478 vw.n299 0.1445
R2892 vw.n484 vw.n299 0.1445
R2893 vw.n484 vw.n297 0.1445
R2894 vw.n490 vw.n297 0.1445
R2895 vw.n490 vw.n489 0.1445
R2896 vw.n355 vw.n353 0.1445
R2897 vw.n361 vw.n353 0.1445
R2898 vw.n361 vw.n351 0.1445
R2899 vw.n365 vw.n351 0.1445
R2900 vw.n365 vw.n349 0.1445
R2901 vw.n371 vw.n349 0.1445
R2902 vw.n371 vw.n347 0.1445
R2903 vw.n375 vw.n347 0.1445
R2904 vw.n375 vw.n345 0.1445
R2905 vw.n381 vw.n345 0.1445
R2906 vw.n381 vw.n343 0.1445
R2907 vw.n385 vw.n343 0.1445
R2908 vw.n385 vw.n341 0.1445
R2909 vw.n412 vw.n321 0.1445
R2910 vw.n408 vw.n321 0.1445
R2911 vw.n408 vw.n407 0.1445
R2912 vw.n407 vw.n406 0.1445
R2913 vw.n406 vw.n328 0.1445
R2914 vw.n402 vw.n328 0.1445
R2915 vw.n402 vw.n401 0.1445
R2916 vw.n401 vw.n400 0.1445
R2917 vw.n400 vw.n334 0.1445
R2918 vw.n396 vw.n334 0.1445
R2919 vw.n396 vw.n395 0.1445
R2920 vw.n395 vw.n394 0.1445
R2921 vw.n394 vw.n339 0.1445
R2922 vw.n411 vw.n410 0.1445
R2923 vw.n410 vw.n409 0.1445
R2924 vw.n409 vw.n323 0.1445
R2925 vw.n405 vw.n323 0.1445
R2926 vw.n405 vw.n404 0.1445
R2927 vw.n404 vw.n403 0.1445
R2928 vw.n403 vw.n329 0.1445
R2929 vw.n399 vw.n329 0.1445
R2930 vw.n399 vw.n398 0.1445
R2931 vw.n398 vw.n397 0.1445
R2932 vw.n397 vw.n335 0.1445
R2933 vw.n393 vw.n335 0.1445
R2934 vw.n393 vw.n392 0.1445
R2935 vw.n354 vw.n352 0.1445
R2936 vw.n362 vw.n352 0.1445
R2937 vw.n363 vw.n362 0.1445
R2938 vw.n364 vw.n363 0.1445
R2939 vw.n364 vw.n348 0.1445
R2940 vw.n372 vw.n348 0.1445
R2941 vw.n373 vw.n372 0.1445
R2942 vw.n374 vw.n373 0.1445
R2943 vw.n374 vw.n344 0.1445
R2944 vw.n382 vw.n344 0.1445
R2945 vw.n383 vw.n382 0.1445
R2946 vw.n384 vw.n383 0.1445
R2947 vw.n384 vw.n340 0.1445
R2948 vw.n63 vw.n35 0.13023
R2949 vw.n63 vw.n62 0.13023
R2950 vw.n62 vw.n55 0.13023
R2951 vw.n667 vw.n55 0.13023
R2952 vw.n627 vw.n110 0.122783
R2953 vw.n7 vw.n5 0.0732989
R2954 vw.n9 vw.n5 0.046062
R2955 vw.n11 vw.n10 0.03175
R2956 vw.n17 vw.n16 0.03175
R2957 vw.n12 vw.n3 0.03175
R2958 vw.n18 vw.n1 0.03175
R2959 vw.n20 vw.n0 0.00847797
R2960 vw.n10 vw.n9 0.0055
R2961 vw.n11 vw.n2 0.0055
R2962 vw.n15 vw.n2 0.0055
R2963 vw.n16 vw.n15 0.0055
R2964 vw.n17 vw.n0 0.0055
R2965 vw.n8 vw.n3 0.0055
R2966 vw.n13 vw.n12 0.0055
R2967 vw.n14 vw.n13 0.0055
R2968 vw.n14 vw.n1 0.0055
R2969 vw.n19 vw.n18 0.0055
R2970 vw.n8 vw.n7 0.00396875
R2971 vw vw.n19 0.003
R2972 vb_itd vb_itd.n0 5.34231
R2973 vb_pot vb_pot.n0 6.23674
R2974 vpost vpost.n0 24.608
R2975 vpre vpre.n0 24.608
R2976 vb_idep vb_idep.n0 18.7425
R2977 vb_itp vb_itp.n0 4.99353
R2978 nvpre nvpre.n0 24.608
R2979 nvpost nvpost.n0 24.608
C0 nvpre xm7_0/a_63_n131# 0
C1 xmcm_chain_4_0/a_n1000_n339# vpost 0
C2 xm1_0/a_63_n131# avdd 1.1665f
C3 xm9_0/a_63_n131# xmcm_chain_3_0/a_1000_n131# 0
C4 xmcm_chain_1_0/a_1000_n131# xm7_0/a_63_n131# 0.00601f
C5 xm8_0/a_63_n131# xm7_0/a_63_n131# 0.13673f
C6 xm9_0/a_63_n131# vb_itp 0.02002f
C7 xmcm_chain_1_0/a_1000_n131# vb_itd 0.05658f
C8 nvpost xm7_0/a_63_n131# 0.00625f
C9 vb_itp avdd 0.05892f
C10 xm9_0/a_63_n131# xm4_0/a_63_n131# 0.0142f
C11 xm4_0/a_63_n131# avdd 0
C12 vb_pot xm7_0/a_63_n131# 0.01448f
C13 Iout xm8_0/a_63_n131# 0
C14 vb_itd vb_pot 0.00689f
C15 xmcm_chain_2_0/a_1000_n131# xm7_0/a_63_n131# 0
C16 xm9_0/a_63_n131# avdd 0.86205f
C17 vb_itd vb_idep 0.00343f
C18 vb_itp nvpre 0.00736f
C19 xm1_0/a_63_n131# nvpost 0.00559f
C20 xmcm_chain_4_0/a_n1000_n339# vb_itd 0.0203f
C21 xmcm_chain_1_0/a_1000_n131# xmcm_chain_3_0/a_1000_n131# 0.04858f
C22 xm8_0/a_63_n131# vb_itp 0
C23 xmcm_chain_1_0/a_1000_n131# xmcm_chain_4_0/a_1000_n131# 0.01434f
C24 vpre xm4_0/a_63_n131# 0
C25 xm9_0/a_63_n131# nvpre 0
C26 xmcm_chain_1_0/a_1000_n131# xm4_0/a_63_n131# 0
C27 nvpre avdd 0.03715f
C28 xmcm_chain_3_0/a_1000_n131# vb_pot 0
C29 xmcm_chain_1_0/a_1000_n131# xm9_0/a_63_n131# 0.00444f
C30 xm9_0/a_63_n131# xm8_0/a_63_n131# 0
C31 xmcm_chain_2_0/a_1000_n131# xmcm_chain_3_0/a_1000_n131# 0.04151f
C32 xmcm_chain_1_0/a_1000_n131# avdd 0.01135f
C33 xm8_0/a_63_n131# avdd 0.83436f
C34 nvpost avdd 0.04809f
C35 vpost xm7_0/a_63_n131# 0
C36 xmcm_chain_2_0/a_1000_n131# xmcm_chain_4_0/a_1000_n131# 0.00555f
C37 xmcm_chain_4_0/a_n1000_n339# xmcm_chain_3_0/a_1000_n131# 0.15956f
C38 xmcm_chain_2_0/a_1000_n131# xm4_0/a_63_n131# 0
C39 xm9_0/a_63_n131# vb_pot 0
C40 xm9_0/a_63_n131# vb_idep 0.10503f
C41 vb_idep avdd 0.10619f
C42 xmcm_chain_2_0/a_1000_n131# xm9_0/a_63_n131# 0.00189f
C43 xmcm_chain_4_0/a_1000_n131# xmcm_chain_4_0/a_n1000_n339# 0.12631f
C44 xmcm_chain_4_0/a_n1000_n339# xm4_0/a_63_n131# 0
C45 xm8_0/a_63_n131# nvpre 0.03214f
C46 xm9_0/a_63_n131# xmcm_chain_4_0/a_n1000_n339# 0.00198f
C47 vpre xmcm_chain_1_0/a_1000_n131# 0
C48 xm8_0/a_63_n131# nvpost 0.00736f
C49 vpost xmcm_chain_3_0/a_1000_n131# 0
C50 vb_itd xm7_0/a_63_n131# 0
C51 xmcm_chain_1_0/a_1000_n131# vb_pot 0.00218f
C52 vpre xmcm_chain_2_0/a_1000_n131# 0
C53 xmcm_chain_1_0/a_1000_n131# vb_idep 0
C54 xmcm_chain_1_0/a_1000_n131# xmcm_chain_2_0/a_1000_n131# 0.07902f
C55 Iout xm7_0/a_63_n131# 0
C56 xm9_0/a_63_n131# vpost 0.02214f
C57 vpre xmcm_chain_4_0/a_n1000_n339# 0
C58 xmcm_chain_1_0/a_1000_n131# xmcm_chain_4_0/a_n1000_n339# 0.04758f
C59 xmcm_chain_2_0/a_1000_n131# vb_pot 0.00131f
C60 xm1_0/a_63_n131# xm7_0/a_63_n131# 0.07138f
C61 xmcm_chain_4_0/a_n1000_n339# vb_pot 0.00454f
C62 xmcm_chain_3_0/a_1000_n131# xm7_0/a_63_n131# 0
C63 vb_itd xmcm_chain_3_0/a_1000_n131# 0.00376f
C64 xmcm_chain_2_0/a_1000_n131# xmcm_chain_4_0/a_n1000_n339# 0.12554f
C65 xm1_0/a_63_n131# Iout 0
C66 xmcm_chain_4_0/a_1000_n131# vb_itd 0.0025f
C67 xmcm_chain_1_0/a_1000_n131# vpost 0
C68 xm9_0/a_63_n131# xm7_0/a_63_n131# 0.47751f
C69 avdd xm7_0/a_63_n131# 0.8372f
C70 xm9_0/a_63_n131# vb_itd 0
C71 vb_itd avdd 0.02038f
C72 vpost vb_pot 0.00676f
C73 Iout avdd 0.08486f
C74 xmcm_chain_2_0/a_1000_n131# vpost 0
C75 xm1_0/a_63_n131# xm4_0/a_63_n131# 0.01204f
C76 xmcm_chain_4_0/a_1000_n131# xmcm_chain_3_0/a_1000_n131# 0.04151f
C77 vpost.n0 vw 0.00112f
C78 vb_pot.n0 vw 0.00359f
C79 vb_itd.n0 vw 0.00142f
C80 vw.n0 vw 0
C81 vw.n1 vw 0
C82 vw.n2 vw 0
C83 vw.n3 vw 0
C84 vw.n4 vw 0
C85 vw.n5 vw 0
C86 vw.n6 vw 0
C87 vw.n7 vw 0
C88 vw.n8 vw 0
C89 vw.n9 vw 0
C90 vw.n10 vw 0
C91 vw.n11 vw 0
C92 vw.n12 vw 0
C93 vw.n13 vw 0
C94 vw.n14 vw 0
C95 vw.n15 vw 0
C96 vw.n16 vw 0
C97 vw.n17 vw 0
C98 vw.n18 vw 0
C99 vw.n19 vw 0
C100 vw.n20 vw 0
C101 vw.n21 vw 0
C102 vw.n22 vw 0
C103 vw.n23 vw 0
C104 vw.n24 vw 0
C105 vw.n25 vw 0
C106 vw.n26 vw 0
C107 vw.n27 vw 0
C108 vw.n28 vw 0
C109 vw.n29 vw 0
C110 vw.n30 vw 0
C111 vw.n31 vw 0
C112 vw.n32 vw 0
C113 vw.n33 vw 0
C114 vw.n34 vw 0
C115 vw.n35 vw 0
C116 vw.n36 vw 0
C117 vw.n37 vw 0
C118 vw.n38 vw 0
C119 vw.n39 vw 0
C120 vw.n40 vw 0
C121 vw.n41 vw 0
C122 vw.n42 vw 0
C123 vw.n43 vw 0
C124 vw.n44 vw 0
C125 vw.n45 vw 0
C126 vw.n46 vw 0
C127 vw.n47 vw 0
C128 vw.n48 vw 0
C129 vw.n49 vw 0
C130 vw.n50 vw 0
C131 vw.n51 vw 0
C132 vw.n52 vw 0
C133 vw.n53 vw 0
C134 vw.n54 vw 0
C135 vw.n55 vw 0
C136 vw.n56 vw 0
C137 vw.n57 vw 0
C138 vw.n58 vw 0
C139 vw.n59 vw 0
C140 vw.n60 vw 0
C141 vw.n61 vw 0
C142 vw.n62 vw 0
C143 vw.n63 vw 0
C144 vw.n64 vw 0
C145 vw.n65 vw 0
C146 vw.n66 vw 0
C147 vw.n67 vw 0
C148 vw.n68 vw 0
C149 vw.n69 vw 0
C150 vw.n70 vw 0
C151 vw.n71 vw 0
C152 vw.n72 vw 0
C153 vw.n73 vw 0
C154 vw.n74 vw 0
C155 vw.n75 vw 0
C156 vw.n76 vw 0
C157 vw.n77 vw 0
C158 vw.n78 vw 0
C159 vw.n79 vw 0
C160 vw.n80 vw 0
C161 vw.n81 vw 0
C162 vw.n82 vw 0
C163 vw.n83 vw 0
C164 vw.n84 vw 0
C165 vw.n85 vw 0
C166 vw.n86 vw 0
C167 vw.n87 vw 0
C168 vw.n88 vw 0
C169 vw.n89 vw 0
C170 vw.n90 vw 0
C171 vw.n91 vw 0
C172 vw.n92 vw 0
C173 vw.n93 vw 0
C174 vw.n94 vw 0
C175 vw.n95 vw 0
C176 vw.n96 vw 0
C177 vw.n97 vw 0
C178 vw.n98 vw 0
C179 vw.n99 vw 0
C180 vw.n100 vw 0
C181 vw.n101 vw 0
C182 vw.n102 vw 0
C183 vw.n103 vw 0
C184 vw.n104 vw 0
C185 vw.n105 vw 0
C186 vw.n106 vw 0
C187 vw.n107 vw 0
C188 vw.n108 vw 0
C189 vw.n109 vw 0
C190 vw.n110 vw 0
C191 vw.n111 vw 0
C192 vw.n112 vw 0
C193 vw.n113 vw 0
C194 vw.n114 vw 0
C195 vw.n115 vw 0
C196 vw.n116 vw 0
C197 vw.n117 vw 0
C198 vw.n118 vw 0
C199 vw.n119 vw 0
C200 vw.n120 vw 0
C201 vw.n121 vw 0
C202 vw.n122 vw 0
C203 vw.n123 vw 0
C204 vw.n124 vw 0
C205 vw.n125 vw 0
C206 vw.n126 vw 0
C207 vw.n127 vw 0
C208 vw.n128 vw 0
C209 vw.n129 vw 0
C210 vw.n130 vw 0
C211 vw.n131 vw 0
C212 vw.n132 vw 0
C213 vw.n133 vw 0
C214 vw.n134 vw 0
C215 vw.n135 vw 0
C216 vw.n136 vw 0
C217 vw.n137 vw 0
C218 vw.n138 vw 0
C219 vw.n139 vw 0
C220 vw.n140 vw 0
C221 vw.n141 vw 0
C222 vw.n142 vw 0
C223 vw.n143 vw 0
C224 vw.n144 vw 0
C225 vw.n145 vw 0
C226 vw.n146 vw 0
C227 vw.n147 vw 0
C228 vw.n148 vw 0
C229 vw.n149 vw 0
C230 vw.n150 vw 0
C231 vw.n151 vw 0
C232 vw.n152 vw 0
C233 vw.n153 vw 0
C234 vw.n154 vw 0
C235 vw.n155 vw 0
C236 vw.n156 vw 0
C237 vw.n157 vw 0
C238 vw.n158 vw 0
C239 vw.n159 vw 0
C240 vw.n160 vw 0
C241 vw.n161 vw 0
C242 vw.n162 vw 0
C243 vw.n163 vw 0
C244 vw.n164 vw 0
C245 vw.n165 vw 0
C246 vw.n166 vw 0
C247 vw.n167 vw 0
C248 vw.n168 vw 0
C249 vw.n169 vw 0
C250 vw.n170 vw 0
C251 vw.n171 vw 0
C252 vw.n172 vw 0
C253 vw.n173 vw 0
C254 vw.n174 vw 0
C255 vw.n175 vw 0
C256 vw.n176 vw 0
C257 vw.n177 vw 0
C258 vw.n178 vw 0
C259 vw.n179 vw 0
C260 vw.n180 vw 0
C261 vw.n181 vw 0
C262 vw.n182 vw 0
C263 vw.n183 vw 0
C264 vw.n184 vw 0
C265 vw.n185 vw 0
C266 vw.n186 vw 0
C267 vw.n187 vw 0
C268 vw.n188 vw 0
C269 vw.n189 vw 0
C270 vw.n190 vw 0
C271 vw.n191 vw 0
C272 vw.n192 vw 0
C273 vw.n193 vw 0
C274 vw.n194 vw 0
C275 vw.n195 vw 0
C276 vw.n196 vw 0
C277 vw.n197 vw 0
C278 vw.n198 vw 0
C279 vw.n199 vw 0
C280 vw.n200 vw 0
C281 vw.n201 vw 0
C282 vw.n202 vw 0
C283 vw.n203 vw 0
C284 vw.n204 vw 0
C285 vw.n205 vw 0
C286 vw.n206 vw 0
C287 vw.n207 vw 0
C288 vw.n208 vw 0
C289 vw.n209 vw 0
C290 vw.n210 vw 0
C291 vw.n211 vw 0
C292 vw.n212 vw 0
C293 vw.n213 vw 0
C294 vw.n214 vw 0
C295 vw.n215 vw 0
C296 vw.n216 vw 0
C297 vw.n217 vw 0
C298 vw.n218 vw 0
C299 vw.n219 vw 0
C300 vw.n220 vw 0
C301 vw.n221 vw 0
C302 vw.n222 vw 0
C303 vw.n223 vw 0
C304 vw.n224 vw 0
C305 vw.n225 vw 0
C306 vw.n226 vw 0
C307 vw.n227 vw 0
C308 vw.n228 vw 0
C309 vw.n229 vw 0
C310 vw.n230 vw 0
C311 vw.n231 vw 0
C312 vw.n232 vw 0
C313 vw.n233 vw 0
C314 vw.n234 vw 0
C315 vw.n235 vw 0
C316 vw.n238 vw 0
C317 vw.n239 vw 0
C318 vw.n240 vw 0
C319 vw.n241 vw 0
C320 vw.n242 vw 0
C321 vw.n243 vw 0
C322 vw.n244 vw 0
C323 vw.n245 vw 0
C324 vw.n250 vw 0
C325 vw.n253 vw 0
C326 vw.n254 vw 0
C327 vw.n255 vw 0
C328 vw.n256 vw 0
C329 vw.n257 vw 0
C330 vw.n258 vw 0
C331 vw.n259 vw 0
C332 vw.n260 vw 0
C333 vw.n261 vw 0
C334 vw.n262 vw 0
C335 vw.n263 vw 0
C336 vw.n264 vw 0
C337 vw.n265 vw 0
C338 vw.n266 vw 0
C339 vw.n267 vw 0
C340 vw.n268 vw 0
C341 vw.n269 vw 0
C342 vw.n270 vw 0
C343 vw.n271 vw 0
C344 vw.n272 vw 0
C345 vw.n273 vw 0
C346 vw.n274 vw 0
C347 vw.n275 vw 0
C348 vw.n276 vw 0
C349 vw.n277 vw 0
C350 vw.n278 vw 0
C351 vw.n279 vw 0
C352 vw.n280 vw 0
C353 vw.n281 vw 0
C354 vw.n282 vw 0
C355 vw.n283 vw 0
C356 vw.n284 vw 0
C357 vw.n285 vw 0
C358 vw.n286 vw 0
C359 vw.n287 vw 0
C360 vw.n288 vw 0
C361 vw.n289 vw 0
C362 vw.n290 vw 0
C363 vw.n291 vw 0
C364 vw.n292 vw 0
C365 vw.n293 vw 0
C366 vw.n294 vw 0
C367 vw.n295 vw 0
C368 vw.n296 vw 0
C369 vw.n297 vw 0
C370 vw.n298 vw 0
C371 vw.n299 vw 0
C372 vw.n300 vw 0
C373 vw.n301 vw 0
C374 vw.n302 vw 0
C375 vw.n303 vw 0
C376 vw.n304 vw 0
C377 vw.n305 vw 0
C378 vw.n306 vw 0
C379 vw.n307 vw 0
C380 vw.n308 vw 0
C381 vw.n309 vw 0
C382 vw.n310 vw 0
C383 vw.n311 vw 0
C384 vw.n312 vw 0
C385 vw.n319 vw 0
C386 vw.n320 vw 0
C387 vw.n321 vw 0
C388 vw.n322 vw 0
C389 vw.n323 vw 0
C390 vw.n324 vw 0
C391 vw.n325 vw 0
C392 vw.n326 vw 0
C393 vw.n327 vw 0
C394 vw.n328 vw 0
C395 vw.n329 vw 0
C396 vw.n330 vw 0
C397 vw.n331 vw 0
C398 vw.n332 vw 0
C399 vw.n333 vw 0
C400 vw.n334 vw 0
C401 vw.n335 vw 0
C402 vw.n336 vw 0
C403 vw.n337 vw 0
C404 vw.n338 vw 0
C405 vw.n339 vw 0
C406 vw.n340 vw 0
C407 vw.n341 vw 0
C408 vw.n342 vw 0
C409 vw.n343 vw 0
C410 vw.n344 vw 0
C411 vw.n345 vw 0
C412 vw.n346 vw 0
C413 vw.n347 vw 0
C414 vw.n348 vw 0
C415 vw.n349 vw 0
C416 vw.n350 vw 0
C417 vw.n351 vw 0
C418 vw.n352 vw 0
C419 vw.n353 vw 0
C420 vw.n354 vw 0
C421 vw.n355 vw 0
C422 vw.n356 vw 0
C423 vw.n358 vw 0
C424 vw.n360 vw 0
C425 vw.n361 vw 0
C426 vw.n362 vw 0
C427 vw.n363 vw 0
C428 vw.n364 vw 0
C429 vw.n365 vw 0
C430 vw.n366 vw 0
C431 vw.n368 vw 0
C432 vw.n370 vw 0
C433 vw.n371 vw 0
C434 vw.n372 vw 0
C435 vw.n373 vw 0
C436 vw.n374 vw 0
C437 vw.n375 vw 0
C438 vw.n376 vw 0
C439 vw.n378 vw 0
C440 vw.n380 vw 0
C441 vw.n381 vw 0
C442 vw.n382 vw 0
C443 vw.n383 vw 0
C444 vw.n384 vw 0
C445 vw.n385 vw 0
C446 vw.n386 vw 0
C447 vw.n388 vw 0
C448 vw.n389 vw 0
C449 vw.n390 vw 0
C450 vw.n391 vw 0
C451 vw.n392 vw 0
C452 vw.n393 vw 0
C453 vw.n394 vw 0
C454 vw.n395 vw 0
C455 vw.n396 vw 0
C456 vw.n397 vw 0
C457 vw.n398 vw 0
C458 vw.n399 vw 0
C459 vw.n400 vw 0
C460 vw.n401 vw 0
C461 vw.n402 vw 0
C462 vw.n403 vw 0
C463 vw.n404 vw 0
C464 vw.n405 vw 0
C465 vw.n406 vw 0
C466 vw.n407 vw 0
C467 vw.n408 vw 0
C468 vw.n409 vw 0
C469 vw.n410 vw 0
C470 vw.n411 vw 0
C471 vw.n412 vw 0
C472 vw.n413 vw 0
C473 vw.n414 vw 0
C474 vw.n415 vw 0
C475 vw.n416 vw 0
C476 vw.n417 vw 0
C477 vw.n418 vw 0
C478 vw.n419 vw 0
C479 vw.n420 vw 0
C480 vw.n421 vw 0
C481 vw.n423 vw 0
C482 vw.n424 vw 0
C483 vw.n425 vw 0
C484 vw.n426 vw 0
C485 vw.n427 vw 0
C486 vw.n428 vw 0
C487 vw.n429 vw 0
C488 vw.n431 vw 0
C489 vw.n432 vw 0
C490 vw.n433 vw 0
C491 vw.n434 vw 0
C492 vw.n436 vw 0
C493 vw.n437 vw 0
C494 vw.n438 vw 0
C495 vw.n439 vw 0
C496 vw.n440 vw 0
C497 vw.n441 vw 0
C498 vw.n443 vw 0
C499 vw.n444 vw 0
C500 vw.n445 vw 0
C501 vw.n446 vw 0
C502 vw.n447 vw 0
C503 vw.n448 vw 0
C504 vw.n450 vw 0
C505 vw.n451 vw 0
C506 vw.n453 vw 0
C507 vw.n454 vw 0
C508 vw.n455 vw 0
C509 vw.n456 vw 0
C510 vw.n457 vw 0
C511 vw.n458 vw 0
C512 vw.n459 vw 0
C513 vw.n461 vw 0
C514 vw.n463 vw 0
C515 vw.n464 vw 0
C516 vw.n465 vw 0
C517 vw.n466 vw 0
C518 vw.n467 vw 0
C519 vw.n468 vw 0
C520 vw.n469 vw 0
C521 vw.n471 vw 0
C522 vw.n473 vw 0
C523 vw.n474 vw 0
C524 vw.n475 vw 0
C525 vw.n476 vw 0
C526 vw.n477 vw 0
C527 vw.n478 vw 0
C528 vw.n479 vw 0
C529 vw.n481 vw 0
C530 vw.n483 vw 0
C531 vw.n484 vw 0
C532 vw.n485 vw 0
C533 vw.n486 vw 0
C534 vw.n487 vw 0
C535 vw.n488 vw 0
C536 vw.n489 vw 0
C537 vw.n490 vw 0
C538 vw.n491 vw 0
C539 vw.n492 vw 0
C540 vw.n493 vw 0
C541 vw.n494 vw 0
C542 vw.n495 vw 0
C543 vw.n496 vw 0
C544 vw.n497 vw 0
C545 vw.n498 vw 0
C546 vw.n499 vw 0
C547 vw.n500 vw 0
C548 vw.n501 vw 0
C549 vw.n503 vw 0
C550 vw.n504 vw 0
C551 vw.n505 vw 0
C552 vw.n506 vw 0
C553 vw.n507 vw 0
C554 vw.n508 vw 0
C555 vw.n510 vw 0
C556 vw.n511 vw 0
C557 vw.n512 vw 0
C558 vw.n513 vw 0
C559 vw.n514 vw 0
C560 vw.n516 vw 0
C561 vw.n517 vw 0
C562 vw.n518 vw 0
C563 vw.n519 vw 0
C564 vw.n520 vw 0
C565 vw.n521 vw 0
C566 vw.n523 vw 0
C567 vw.n524 vw 0
C568 vw.n525 vw 0
C569 vw.n526 vw 0
C570 vw.n527 vw 0
C571 vw.n528 vw 0
C572 vw.n529 vw 0
C573 vw.n530 vw 0
C574 vw.n531 vw 0
C575 vw.n532 vw 0
C576 vw.n533 vw 0
C577 vw.n534 vw 0
C578 vw.n535 vw 0
C579 vw.n536 vw 0
C580 vw.n537 vw 0
C581 vw.n538 vw 0
C582 vw.n539 vw 0
C583 vw.n540 vw 0
C584 vw.n541 vw 0
C585 vw.n542 vw 0
C586 vw.n543 vw 0
C587 vw.n544 vw 0
C588 vw.n545 vw 0
C589 vw.n546 vw 0
C590 vw.n547 vw 0
C591 vw.n548 vw 0
C592 vw.n549 vw 0
C593 vw.n550 vw 0
C594 vw.n551 vw 0
C595 vw.n552 vw 0
C596 vw.n553 vw 0
C597 vw.n554 vw 0
C598 vw.n555 vw 0
C599 vw.n556 vw 0
C600 vw.n557 vw 0
C601 vw.n558 vw 0
C602 vw.n559 vw 0
C603 vw.n560 vw 0
C604 vw.n561 vw 0
C605 vw.n562 vw 0
C606 vw.n563 vw 0
C607 vw.n564 vw 0
C608 vw.n565 vw 0
C609 vw.n566 vw 0
C610 vw.n567 vw 0
C611 vw.n568 vw 0
C612 vw.n569 vw 0
C613 vw.n570 vw 0
C614 vw.n571 vw 0
C615 vw.n572 vw 0
C616 vw.n573 vw 0
C617 vw.n574 vw 0
C618 vw.n575 vw 0
C619 vw.n576 vw 0
C620 vw.n577 vw 0
C621 vw.n578 vw 0
C622 vw.n579 vw 0
C623 vw.n580 vw 0
C624 vw.n581 vw 0
C625 vw.n582 vw 0
C626 vw.n583 vw 0
C627 vw.n584 vw 0
C628 vw.n585 vw 0
C629 vw.n586 vw 0
C630 vw.n587 vw 0
C631 vw.n588 vw 0
C632 vw.n589 vw 0
C633 vw.n590 vw 0
C634 vw.n591 vw 0
C635 vw.n592 vw 0
C636 vw.n593 vw 0
C637 vw.n594 vw 0
C638 vw.n595 vw 0
C639 vw.n596 vw 0
C640 vw.n597 vw 0
C641 vw.n598 vw 0
C642 vw.n599 vw 0
C643 vw.n600 vw 0
C644 vw.n601 vw 0
C645 vw.n602 vw 0
C646 vw.n603 vw 0
C647 vw.n604 vw 0
C648 vw.n605 vw 0
C649 vw.n606 vw 0
C650 vw.n607 vw 0
C651 vw.n608 vw 0
C652 vw.n609 vw 0
C653 vw.n610 vw 0
C654 vw.n611 vw 0
C655 vw.n612 vw 0
C656 vw.n613 vw 0
C657 vw.n614 vw 0
C658 vw.n615 vw 0
C659 vw.n616 vw 0
C660 vw.n617 vw 0
C661 vw.n618 vw 0
C662 vw.n619 vw 0
C663 vw.n620 vw 0
C664 vw.n621 vw 0
C665 vw.n622 vw 0
C666 vw.n623 vw 0
C667 vw.n624 vw 0
C668 vw.n625 vw 0
C669 vw.n626 vw 0
C670 vw.n627 vw 0
C671 vw.n628 vw 0
C672 vw.n629 vw 0
C673 vw.n630 vw 0
C674 vw.n631 vw 0
C675 vw.n632 vw 0
C676 vw.n633 vw 0
C677 vw.n634 vw 0
C678 vw.n635 vw 0
C679 vw.n636 vw 0
C680 vw.n637 vw 0
C681 vw.n638 vw 0
C682 vw.n639 vw 0
C683 vw.n640 vw 0
C684 vw.n641 vw 0
C685 vw.n642 vw 0
C686 vw.n643 vw 0
C687 vw.n644 vw 0
C688 vw.n645 vw 0
C689 vw.n646 vw 0
C690 vw.n647 vw 0
C691 vw.n648 vw 0
C692 vw.n649 vw 0
C693 vw.n650 vw 0
C694 vw.n651 vw 0
C695 vw.n652 vw 0
C696 vw.n653 vw 0
C697 vw.n654 vw 0
C698 vw.n655 vw 0
C699 vw.n656 vw 0
C700 vw.n657 vw 0
C701 vw.n658 vw 0
C702 vw.n659 vw 0
C703 vw.n660 vw 0
C704 vw.n661 vw 0
C705 vw.n662 vw 0
C706 vw.n663 vw 0
C707 vw.n664 vw 0
C708 vw.n665 vw 0
C709 vw.n666 vw 0
C710 vw.n667 vw 0
C711 vw.n668 vw 0
C712 vw.n669 vw 0
C713 vw.n670 vw 0
C714 vw.n671 vw 0
C715 vw.n672 vw 0
C716 vw.n673 vw 0
C717 vw.n674 vw 0
C718 vw.n675 vw 0
C719 vw.n676 vw 0
C720 vw.n677 vw 0
C721 vw.n678 vw 0
C722 vw.n679 vw 0
C723 vw.n680 vw 0
C724 vw.n681 vw 0
C725 vw.n682 vw 0
C726 vw.n683 vw 0
C727 vw.n684 vw 0
C728 vw.n685 vw 0
C729 vw.n686 vw 0
C730 vw.n687 vw 0
C731 vw.n688 vw 0
C732 vw.n689 vw 0
C733 vw.n690 vw 0
C734 vw.n691 vw 0
C735 vw.n692 vw 0
C736 vw.n693 vw 0
C737 avdd.n0 vw 0.03938f
C738 avdd.n1 vw 0
C739 avdd.n2 vw 0
C740 avdd.n3 vw 0
C741 avdd.n4 vw 0
C742 avdd.n5 vw 0.00719f
C743 avdd.n6 vw 0.00418f
C744 avdd.n7 vw 0
C745 avdd.n8 vw 0
C746 avdd.n9 vw 0
C747 avdd.n10 vw 0
C748 avdd.n11 vw 0
C749 avdd.n12 vw 0.00418f
C750 avdd.n13 vw 0
C751 avdd.n14 vw 0
C752 avdd.n15 vw 0
C753 avdd.n16 vw 0
C754 avdd.n17 vw 0
C755 avdd.n18 vw 0.00418f
C756 avdd.n19 vw 0
C757 avdd.n20 vw 0
C758 avdd.n21 vw 0
C759 avdd.n22 vw 0
C760 avdd.n23 vw 0
C761 avdd.n24 vw 0.00418f
C762 avdd.n25 vw 0
C763 avdd.n26 vw 0
C764 avdd.n27 vw 0
C765 avdd.n28 vw 0
C766 avdd.n29 vw 0
C767 avdd.n30 vw 0.00418f
C768 avdd.n31 vw 0
C769 avdd.n32 vw 0
C770 avdd.n33 vw 0
C771 avdd.n34 vw 0
C772 avdd.n35 vw 0
C773 avdd.n36 vw 0.00418f
C774 avdd.n37 vw 0
C775 avdd.n38 vw 0
C776 avdd.n39 vw 0
C777 avdd.n40 vw 0
C778 avdd.n41 vw 0
C779 avdd.n42 vw 0.00418f
C780 avdd.n43 vw 0
C781 avdd.n44 vw 0
C782 avdd.n45 vw 0
C783 avdd.n46 vw 0
C784 avdd.n47 vw 0
C785 avdd.n48 vw 0.00418f
C786 avdd.n49 vw 0
C787 avdd.n50 vw 0
C788 avdd.n51 vw 0
C789 avdd.n52 vw 0
C790 avdd.n53 vw 0
C791 avdd.n54 vw 0.00418f
C792 avdd.n55 vw 0
C793 avdd.n56 vw 0
C794 avdd.n57 vw 0
C795 avdd.n58 vw 0
C796 avdd.n59 vw 0
C797 avdd.n60 vw 0.00568f
C798 avdd.n61 vw 0
C799 avdd.n62 vw 0
C800 avdd.n64 vw 0.00719f
C801 avdd.n65 vw 0.01023f
C802 avdd.n66 vw 0.00116f
C803 avdd.n67 vw 0
C804 avdd.n68 vw 0
C805 avdd.n69 vw 0
C806 avdd.n70 vw 0.00418f
C807 avdd.n71 vw 0
C808 avdd.n72 vw 0
C809 avdd.n73 vw 0
C810 avdd.n74 vw 0
C811 avdd.n75 vw 0
C812 avdd.n76 vw 0
C813 avdd.n77 vw 0
C814 avdd.n78 vw 0.00418f
C815 avdd.n79 vw 0
C816 avdd.n80 vw 0
C817 avdd.n81 vw 0
C818 avdd.n82 vw 0
C819 avdd.n83 vw 0
C820 avdd.n84 vw 0
C821 avdd.n85 vw 0
C822 avdd.n86 vw 0.00418f
C823 avdd.n87 vw 0
C824 avdd.n88 vw 0
C825 avdd.n89 vw 0
C826 avdd.n90 vw 0
C827 avdd.n91 vw 0
C828 avdd.n92 vw 0
C829 avdd.n93 vw 0
C830 avdd.n94 vw 0.00418f
C831 avdd.n95 vw 0
C832 avdd.n96 vw 0
C833 avdd.n97 vw 0
C834 avdd.n98 vw 0
C835 avdd.n99 vw 0
C836 avdd.n100 vw 0
C837 avdd.n101 vw 0
C838 avdd.n102 vw 0.00418f
C839 avdd.n103 vw 0
C840 avdd.n104 vw 0
C841 avdd.n105 vw 0
C842 avdd.n106 vw 0
C843 avdd.n107 vw 0
C844 avdd.n108 vw 0
C845 avdd.n109 vw 0
C846 avdd.n110 vw 0.00418f
C847 avdd.n111 vw 0
C848 avdd.n112 vw 0
C849 avdd.n113 vw 0
C850 avdd.n114 vw 0
C851 avdd.n115 vw 0
C852 avdd.n116 vw 0
C853 avdd.n117 vw 0
C854 avdd.n118 vw 0.00418f
C855 avdd.n119 vw 0
C856 avdd.n120 vw 0
C857 avdd.n121 vw 0
C858 avdd.n122 vw 0
C859 avdd.n123 vw 0
C860 avdd.n124 vw 0
C861 avdd.n125 vw 0
C862 avdd.n126 vw 0.00418f
C863 avdd.n127 vw 0
C864 avdd.n128 vw 0
C865 avdd.n129 vw 0
C866 avdd.n130 vw 0
C867 avdd.n131 vw 0
C868 avdd.n132 vw 0
C869 avdd.n133 vw 0
C870 avdd.n134 vw 0.00418f
C871 avdd.n135 vw 0
C872 avdd.n136 vw 0
C873 avdd.n137 vw 0
C874 avdd.n138 vw 0
C875 avdd.n139 vw 0.00159f
C876 avdd.n140 vw 0
C877 avdd.n141 vw 0
C878 avdd.n142 vw 0.00124f
C879 avdd.n143 vw 0.00983f
C880 avdd.n144 vw 0
C881 avdd.n145 vw 0
C882 avdd.n146 vw 0.00399f
C883 avdd.n147 vw 0.00124f
C884 avdd.n148 vw 0
C885 avdd.n149 vw 0.0068f
C886 avdd.n150 vw 0
C887 avdd.n151 vw 0
C888 avdd.n152 vw 0
C889 avdd.n153 vw 0
C890 avdd.n154 vw 0
C891 avdd.n155 vw 0
C892 avdd.n156 vw 0.00983f
C893 avdd.n157 vw 0
C894 avdd.n158 vw 0.00231f
C895 avdd.n159 vw 0
C896 avdd.n160 vw 0.0068f
C897 avdd.n161 vw 0
C898 avdd.n162 vw 0
C899 avdd.n163 vw 0
C900 avdd.n164 vw 0
C901 avdd.n165 vw 0.00219f
C902 avdd.n166 vw 0.00124f
C903 avdd.n167 vw 0
C904 avdd.n168 vw 0.0068f
C905 avdd.n169 vw 0
C906 avdd.n170 vw 0
C907 avdd.n171 vw 0
C908 avdd.n172 vw 0.00311f
C909 avdd.n173 vw 0.00354f
C910 avdd.n174 vw 0.00124f
C911 avdd.n175 vw 0
C912 avdd.n176 vw 0.0068f
C913 avdd.n177 vw 0
C914 avdd.n178 vw 0
C915 avdd.n179 vw 0
C916 avdd.n180 vw 0.00102f
C917 avdd.n181 vw 0.00102f
C918 avdd.n182 vw 0
C919 avdd.n183 vw 0
C920 avdd.n184 vw 0
C921 avdd.n185 vw 0.00568f
C922 avdd.n187 vw 0
C923 avdd.n188 vw 0
C924 avdd.n189 vw 0
C925 avdd.n190 vw 0.00648f
C926 avdd.n191 vw 0.00159f
C927 avdd.n192 vw 0
C928 avdd.n193 vw 0
C929 avdd.n194 vw 0.00124f
C930 avdd.n195 vw 0.0068f
C931 avdd.n196 vw 0
C932 avdd.n197 vw 0
C933 avdd.n198 vw 0
C934 avdd.n199 vw 0.00356f
C935 avdd.n200 vw 0
C936 avdd.n201 vw 0
C937 avdd.n202 vw 0.0068f
C938 avdd.n203 vw 0.00124f
C939 avdd.n204 vw 0
C940 avdd.n205 vw 0
C941 avdd.n206 vw 0
C942 avdd.n207 vw 0
C943 avdd.n208 vw 0
C944 avdd.n209 vw 0
C945 avdd.n210 vw 0.00219f
C946 avdd.n211 vw 0
C947 avdd.n212 vw 0
C948 avdd.n213 vw 0
C949 avdd.n214 vw 0.0068f
C950 avdd.n215 vw 0.00983f
C951 avdd.n216 vw 0.00124f
C952 avdd.n217 vw 0.00653f
C953 avdd.n218 vw 0.00311f
C954 avdd.n219 vw 0
C955 avdd.n220 vw 0
C956 avdd.n221 vw 0
C957 avdd.n222 vw 0
C958 avdd.n223 vw 0.00124f
C959 avdd.n224 vw 0.00983f
C960 avdd.n225 vw 0.0068f
C961 avdd.n226 vw 0
C962 avdd.n227 vw 0
C963 avdd.n228 vw 0
C964 avdd.n229 vw 0
C965 avdd.n230 vw 0.00567f
C966 avdd.n231 vw 0.02158f
C967 avdd.n232 vw 0.00159f
C968 avdd.n233 vw 0
C969 avdd.n234 vw 0
C970 avdd.n235 vw 0
C971 avdd.n236 vw 0.00719f
C972 avdd.n237 vw 0.00418f
C973 avdd.n238 vw 0
C974 avdd.n239 vw 0
C975 avdd.n240 vw 0
C976 avdd.n241 vw 0
C977 avdd.n242 vw 0
C978 avdd.n243 vw 0.00418f
C979 avdd.n244 vw 0
C980 avdd.n245 vw 0
C981 avdd.n246 vw 0
C982 avdd.n247 vw 0
C983 avdd.n248 vw 0
C984 avdd.n249 vw 0.00418f
C985 avdd.n250 vw 0
C986 avdd.n251 vw 0
C987 avdd.n252 vw 0.0055f
C988 avdd.n253 vw 0.00719f
C989 avdd.n254 vw 0.00105f
C990 avdd.n255 vw 0
C991 avdd.n256 vw 0
C992 avdd.n257 vw 0.00568f
C993 avdd.n259 vw 0
C994 avdd.n260 vw 0
C995 avdd.n261 vw 0
C996 avdd.n262 vw 0
C997 avdd.n263 vw 0
C998 avdd.n264 vw 0
C999 avdd.n265 vw 0
C1000 avdd.n266 vw 0.00418f
C1001 avdd.n267 vw 0
C1002 avdd.n268 vw 0
C1003 avdd.n269 vw 0
C1004 avdd.n270 vw 0
C1005 avdd.n271 vw 0
C1006 avdd.n272 vw 0
C1007 avdd.n273 vw 0
C1008 avdd.n274 vw 0.00418f
C1009 avdd.n275 vw 0
C1010 avdd.n276 vw 0
C1011 avdd.n277 vw 0
C1012 avdd.n278 vw 0
C1013 avdd.n279 vw 0
C1014 avdd.n280 vw 0
C1015 avdd.n281 vw 0
C1016 avdd.n282 vw 0.00568f
C1017 avdd.n284 vw 0
C1018 avdd.n285 vw 0
C1019 avdd.n286 vw 0
C1020 avdd.n287 vw 0.00567f
C1021 avdd.n288 vw 0.00682f
C1022 avdd.n289 vw 0.00438f
C1023 avdd.n290 vw 0
C1024 avdd.n291 vw 0
C1025 avdd.n292 vw 0
C1026 avdd.n293 vw 0.00279f
C1027 avdd.n296 vw 0.00279f
C1028 avdd.n299 vw 0
C1029 avdd.n300 vw 0
C1030 avdd.n301 vw 0
C1031 avdd.n302 vw 0.00157f
C1032 avdd.n303 vw 0
C1033 avdd.n304 vw 0.00157f
C1034 avdd.n305 vw 0
C1035 avdd.n306 vw 0
C1036 avdd.n307 vw 0
C1037 avdd.n308 vw 0
C1038 avdd.n309 vw 0
C1039 avdd.n310 vw 0
C1040 avdd.n311 vw 0.00234f
C1041 avdd.n312 vw 0.01081f
C1042 avdd.n313 vw 0.00125f
C1043 avdd.n314 vw 0
C1044 avdd.n315 vw 0
C1045 avdd.n316 vw 0
C1046 avdd.n317 vw 0
C1047 avdd.n318 vw 0
C1048 avdd.n319 vw 0
C1049 avdd.n320 vw 0
C1050 avdd.n321 vw 0.00125f
C1051 avdd.n322 vw 0
C1052 avdd.n323 vw 0.00157f
C1053 avdd.n324 vw 0.02515f
C1054 avdd.n325 vw 0.0446f
C1055 avdd.n326 vw 0.02515f
C1056 avdd.n327 vw 0.00157f
C1057 avdd.n328 vw 0
C1058 avdd.n329 vw 0
C1059 avdd.n330 vw 0.00523f
C1060 avdd.n331 vw 0.0071f
C1061 avss.n0 vw 0.00617f
C1062 avss.n1 vw 0.00122f
C1063 avss.n2 vw 0
C1064 avss.n3 vw 0
C1065 avss.n4 vw 0
C1066 avss.n5 vw 0
C1067 avss.n6 vw 0.06253f
C1068 avss.n15 vw 0
C1069 avss.n16 vw 0
C1070 avss.n17 vw 0
C1071 avss.n18 vw 0
C1072 avss.n19 vw 0
C1073 avss.n20 vw 0
C1074 avss.n21 vw 0
C1075 avss.n22 vw 0
C1076 avss.n23 vw 0
C1077 avss.n24 vw 0
C1078 avss.n25 vw 0
C1079 avss.n26 vw 0
C1080 avss.n27 vw 0
C1081 avss.n28 vw 0
C1082 avss.n29 vw 0
C1083 avss.n30 vw 0
C1084 avss.n31 vw 0
C1085 avss.n32 vw 0
C1086 avss.n33 vw 0
C1087 avss.n34 vw 0
C1088 avss.n35 vw 0.03551f
C1089 avss.n37 vw 0
C1090 avss.n40 vw 0
C1091 avss.n43 vw 0
C1092 avss.n46 vw 0
C1093 avss.n47 vw 0
C1094 avss.n48 vw 0
C1095 avss.n49 vw 0
C1096 avss.n50 vw 0
C1097 avss.n51 vw 0
C1098 avss.n52 vw 0
C1099 avss.n53 vw 0.01129f
C1100 avss.n54 vw 0
C1101 avss.n55 vw 0
C1102 avss.n56 vw 0
C1103 avss.n57 vw 0
C1104 avss.n58 vw 0
C1105 avss.n59 vw 0
C1106 avss.n61 vw 0
C1107 avss.n62 vw 0
C1108 avss.n63 vw 0
C1109 avss.n64 vw 0
C1110 avss.n65 vw 0
C1111 avss.n66 vw 0
C1112 avss.n68 vw 0
C1113 avss.n69 vw 0
C1114 avss.n70 vw 0.00908f
C1115 avss.n71 vw 0
C1116 avss.n72 vw 0
C1117 avss.n73 vw 0
C1118 avss.n74 vw 0
C1119 avss.n75 vw 0
C1120 avss.n76 vw 0
C1121 avss.n77 vw 0
C1122 avss.n78 vw 0
C1123 avss.n79 vw 0
C1124 avss.n86 vw 0
C1125 avss.n87 vw 0
C1126 avss.n88 vw 0
C1127 avss.n89 vw 0
C1128 avss.n90 vw 0
C1129 avss.n91 vw 0
C1130 avss.n92 vw 0
C1131 avss.n93 vw 0.06253f
C1132 avss.n95 vw 0
C1133 avss.n96 vw 0
C1134 avss.n97 vw 0
C1135 avss.n98 vw 0
C1136 avss.n99 vw 0
C1137 avss.n100 vw 0.00908f
C1138 avss.n101 vw 0.05177f
C1139 avss.n102 vw 0.01288f
C1140 avss.n103 vw 0.00908f
C1141 avss.n104 vw 0.00898f
C1142 avss.n105 vw 0
C1143 avss.n106 vw 0.00728f
C1144 avss.n107 vw 0
C1145 avss.n108 vw 0
C1146 avss.n109 vw 0
C1147 avss.n110 vw 0
C1148 avss.n111 vw 0
C1149 avss.n112 vw 0
C1150 avss.n113 vw 0
C1151 avss.n114 vw 0
C1152 avss.n115 vw 0.00647f
C1153 avss.n116 vw 0
C1154 avss.n117 vw 0
C1155 avss.n118 vw 0.00647f
C1156 avss.n119 vw 0
C1157 avss.n120 vw 0
C1158 avss.n121 vw 0
C1159 avss.n122 vw 0.00122f
C1160 avss.n123 vw 0
C1161 avss.n124 vw 0
C1162 avss.n125 vw 0
C1163 avss.n126 vw 0
C1164 avss.n127 vw 0
C1165 avss.n128 vw 0.00647f
C1166 avss.n129 vw 0.04782f
C1167 avss.n130 vw 0
C1168 avss.n131 vw 0.00787f
C1169 avss.n132 vw 0.00122f
C1170 avss.n133 vw 0
C1171 avss.n134 vw 0
C1172 avss.n135 vw 0
C1173 avss.n136 vw 0
C1174 avss.n137 vw 0.00761f
C1175 avss.n138 vw 0
C1176 avss.n139 vw 0
C1177 avss.n140 vw 0
C1178 avss.n141 vw 0
C1179 avss.n142 vw 0
C1180 avss.n143 vw 0.00647f
C1181 avss.n144 vw 0.00647f
C1182 avss.n145 vw 0
C1183 avss.n146 vw 0
C1184 avss.n147 vw 0
C1185 avss.n148 vw 0
C1186 avss.n149 vw 0
C1187 avss.n150 vw 0.0106f
C1188 avss.n151 vw 0
C1189 avss.n152 vw 0
C1190 avss.n153 vw 0.00647f
C1191 avss.n154 vw 0
C1192 avss.n155 vw 0
C1193 avss.n156 vw 0
C1194 avss.n157 vw 0
C1195 avss.n158 vw 0
C1196 avss.n159 vw 0
C1197 avss.n160 vw 0
C1198 avss.n161 vw 0.00898f
C1199 avss.n162 vw 0
C1200 avss.n163 vw 0.01048f
C1201 avss.n164 vw 0
C1202 avss.n165 vw 0
C1203 avss.n166 vw 0
C1204 avss.n167 vw 0
C1205 avss.n168 vw 0.00176f
C1206 avss.n169 vw 0
C1207 avss.n170 vw 0
C1208 avss.n171 vw 0.00898f
C1209 avss.n172 vw 0
C1210 avss.n173 vw 0.01048f
C1211 avss.n174 vw 0
C1212 avss.n175 vw 0
C1213 avss.n176 vw 0
C1214 avss.n177 vw 0
C1215 avss.n178 vw 0
C1216 avss.n179 vw 0
C1217 avss.n180 vw 0
C1218 avss.n181 vw 0
C1219 avss.n182 vw 0.00647f
C1220 avss.n183 vw 0
C1221 avss.n184 vw 0
C1222 avss.n185 vw 0.00894f
C1223 avss.n186 vw 0
C1224 avss.n187 vw 0
C1225 avss.n188 vw 0
C1226 avss.n189 vw 0
C1227 avss.n190 vw 0
C1228 avss.n191 vw 0
C1229 avss.n192 vw 0
C1230 avss.n193 vw 0
C1231 avss.n194 vw 0
C1232 avss.n195 vw 0.00647f
C1233 avss.n196 vw 0.01101f
C1234 avss.n197 vw 0
C1235 avss.n198 vw 0
C1236 avss.n199 vw 0
C1237 avss.n200 vw 0.00167f
C1238 avss.n201 vw 0
C1239 avss.n202 vw 0
C1240 avss.n203 vw 0
C1241 avss.n204 vw 0
C1242 avss.n205 vw 0
C1243 avss.n206 vw 0.00898f
C1244 avss.n207 vw 0
C1245 avss.n208 vw 0
C1246 avss.n209 vw 0
C1247 avss.n210 vw 0
C1248 avss.n211 vw 0
C1249 avss.n212 vw 0
C1250 avss.n213 vw 0
C1251 avss.n214 vw 0
C1252 avss.n215 vw 0
C1253 avss.n216 vw 0
C1254 avss.n217 vw 0
C1255 avss.n218 vw 0
C1256 avss.n219 vw 0
C1257 avss.n220 vw 0
C1258 avss.n221 vw 0
C1259 avss.n222 vw 0
C1260 avss.n223 vw 0
C1261 avss.n224 vw 0
C1262 avss.n225 vw 0
C1263 avss.n226 vw 0
C1264 avss.n227 vw 0
C1265 avss.n228 vw 0
C1266 avss.n229 vw 0
C1267 avss.n230 vw 0
C1268 avss.n231 vw 0
C1269 avss.n232 vw 0
C1270 avss.n233 vw 0
C1271 avss.n234 vw 0
C1272 avss.n235 vw 0.00874f
C1273 avss.n236 vw 0.00647f
C1274 avss.n237 vw 0
C1275 avss.n238 vw 0
C1276 avss.n239 vw 0
C1277 avss.n240 vw 0
C1278 avss.n241 vw 0
C1279 avss.n242 vw 0
C1280 avss.n243 vw 0
C1281 avss.n244 vw 0
C1282 avss.n245 vw 0.00166f
C1283 avss.n246 vw 0
C1284 avss.n247 vw 0
C1285 avss.n248 vw 0
C1286 avss.n249 vw 0
C1287 avss.n250 vw 0
C1288 avss.n251 vw 0.00166f
C1289 avss.n252 vw 0
C1290 avss.n253 vw 0
C1291 avss.n254 vw 0
C1292 avss.n255 vw 0
C1293 avss.n256 vw 0.00647f
C1294 avss.n257 vw 0.00647f
C1295 avss.n258 vw 0
C1296 avss.n259 vw 0
C1297 avss.n260 vw 0
C1298 avss.n261 vw 0
C1299 avss.n262 vw 0
C1300 avss.n263 vw 0.0072f
C1301 avss.n264 vw 0.00647f
C1302 avss.n265 vw 0
C1303 avss.n266 vw 0
C1304 avss.n267 vw 0
C1305 avss.n268 vw 0
C1306 avss.n269 vw 0
C1307 avss.n270 vw 0
C1308 avss.n271 vw 0.00166f
C1309 avss.n272 vw 0
C1310 avss.n273 vw 0
C1311 avss.n274 vw 0
C1312 avss.n275 vw 0
C1313 avss.n276 vw 0.00668f
C1314 avss.n277 vw 0.01768f
C1315 avss.n278 vw 0.01129f
C1316 avss.n279 vw 0
C1317 avss.n280 vw 0.00281f
C1318 avss.n281 vw 0
C1319 avss.n282 vw 0
C1320 avss.n283 vw 0
C1321 avss.n284 vw 0
C1322 avss.n285 vw 0
C1323 avss.n286 vw 0
C1324 avss.n287 vw 0.01028f
C1325 avss.n288 vw 0
C1326 avss.n289 vw 0
C1327 avss.n290 vw 0
C1328 avss.n291 vw 0
C1329 avss.n292 vw 0
C1330 avss.n293 vw 0
C1331 avss.n294 vw 0
C1332 avss.n295 vw 0.00664f
C1333 avss.n296 vw 0
C1334 avss.n297 vw 0
C1335 avss.n298 vw 0
C1336 avss.n299 vw 0
C1337 avss.n300 vw 0
C1338 avss.n301 vw 0
C1339 avss.n302 vw 0.01295f
C1340 avss.n303 vw 0
C1341 avss.n304 vw 0
C1342 avss.n305 vw 0
C1343 avss.n306 vw 0
C1344 avss.n307 vw 0
C1345 avss.n308 vw 0.01295f
C1346 avss.n309 vw 0
C1347 avss.n310 vw 0
C1348 avss.n311 vw 0
C1349 avss.n312 vw 0
C1350 avss.n313 vw 0
C1351 avss.n314 vw 0
C1352 avss.n315 vw 0.01028f
C1353 avss.n316 vw 0.00558f
C1354 avss.n317 vw 0
C1355 avss.n318 vw 0
C1356 avss.n319 vw 0
C1357 avss.n320 vw 0
C1358 avss.n321 vw 0
C1359 avss.n322 vw 0
C1360 avss.n323 vw 0
C1361 avss.n324 vw 0
C1362 avss.n327 vw 0
C1363 avss.n328 vw 0
C1364 avss.n329 vw 0
C1365 avss.n330 vw 0
C1366 avss.n331 vw 0
C1367 avss.n332 vw 0
C1368 avss.n333 vw 0
C1369 avss.n334 vw 0
C1370 avss.n335 vw 0
C1371 avss.n336 vw 0.00167f
C1372 avss.n337 vw 0
C1373 avss.n338 vw 0
C1374 avss.n339 vw 0
C1375 avss.n340 vw 0
C1376 avss.n341 vw 0
C1377 avss.n342 vw 0
C1378 avss.n343 vw 0
C1379 avss.n344 vw 0
C1380 avss.n345 vw 0
C1381 avss.n346 vw 0
C1382 avss.n347 vw 0
C1383 avss.n348 vw 0
C1384 avss.n349 vw 0
C1385 avss.n350 vw 0
C1386 avss.n351 vw 0
C1387 avss.n352 vw 0
C1388 avss.n353 vw 0
C1389 avss.n354 vw 0
C1390 avss.n355 vw 0
C1391 avss.n356 vw 0
C1392 avss.n357 vw 0
C1393 avss.n358 vw 0
C1394 avss.n359 vw 0
C1395 avss.n360 vw 0
C1396 avss.n362 vw 0.03093f
C1397 avss.n364 vw 0
C1398 avss.n365 vw 0
C1399 avss.n366 vw 0
C1400 avss.n367 vw 0
C1401 avss.n368 vw 0
C1402 avss.n369 vw 0.00141f
C1403 avss.n370 vw 0.00122f
C1404 avss.n371 vw 0
C1405 avss.n372 vw 0.01797f
C1406 avss.n373 vw 0.01797f
C1407 avss.n374 vw 0
C1408 avss.n375 vw 0
C1409 avss.n376 vw 0
C1410 avss.n377 vw 0
C1411 avss.n378 vw 0
C1412 avss.n379 vw 0
C1413 avss.n380 vw 0
C1414 avss.n381 vw 0
C1415 avss.n382 vw 0.00167f
C1416 avss.n383 vw 0
C1417 avss.n384 vw 0.01028f
C1418 avss.n385 vw 0
C1419 avss.n386 vw 0.00351f
C1420 avss.n387 vw 0
C1421 avss.n388 vw 0
C1422 avss.n389 vw 0
C1423 avss.n390 vw 0
C1424 avss.n391 vw 0
C1425 avss.n392 vw 0
C1426 avss.n393 vw 0
C1427 avss.n394 vw 0
C1428 avss.n395 vw 0
C1429 avss.n396 vw 0
C1430 avss.n397 vw 0
C1431 avss.n398 vw 0.01028f
C1432 avss.n399 vw 0
C1433 avss.n400 vw 0
C1434 avss.n401 vw 0
C1435 avss.n402 vw 0
C1436 avss.n403 vw 0
C1437 avss.n404 vw 0
C1438 avss.n405 vw 0
C1439 avss.n406 vw 0
C1440 avss.n407 vw 0
C1441 avss.n408 vw 0
C1442 avss.n409 vw 0.01295f
C1443 avss.n410 vw 0
C1444 avss.n411 vw 0
C1445 avss.n412 vw 0
C1446 avss.n413 vw 0
C1447 avss.n414 vw 0
C1448 avss.n415 vw 0
C1449 avss.n416 vw 0
C1450 avss.n417 vw 0
C1451 avss.n418 vw 0.01295f
C1452 avss.n419 vw 0
C1453 avss.n420 vw 0
C1454 avss.n421 vw 0
C1455 avss.n422 vw 0
C1456 avss.n423 vw 0
C1457 avss.n424 vw 0
C1458 avss.n425 vw 0
C1459 avss.n426 vw 0
C1460 avss.n427 vw 0
C1461 avss.n428 vw 0
C1462 avss.n429 vw 0
C1463 avss.n430 vw 0
C1464 avss.n431 vw 0
C1465 avss.n432 vw 0.00647f
C1466 avss.n433 vw 0.00882f
C1467 avss.n434 vw 0
C1468 avss.n435 vw 0
C1469 avss.n436 vw 0
C1470 avss.n437 vw 0
C1471 avss.n438 vw 0
C1472 avss.n439 vw 0.00898f
C1473 avss.n440 vw 0.00647f
C1474 avss.n441 vw 0
C1475 avss.n442 vw 0.00169f
C1476 avss.n443 vw 0
C1477 avss.n444 vw 0
C1478 avss.n445 vw 0.00166f
C1479 avss.n446 vw 0
C1480 avss.n447 vw 0
C1481 avss.n448 vw 0
C1482 avss.n449 vw 0
C1483 avss.n450 vw 0
C1484 avss.n451 vw 0.00166f
C1485 avss.n452 vw 0
C1486 avss.n453 vw 0
C1487 avss.n454 vw 0
C1488 avss.n455 vw 0
C1489 avss.n456 vw 0
C1490 avss.n457 vw 0.00647f
C1491 avss.n458 vw 0.00708f
C1492 avss.n459 vw 0
C1493 avss.n460 vw 0
C1494 avss.n461 vw 0
C1495 avss.n462 vw 0
C1496 avss.n463 vw 0
C1497 avss.n464 vw 0
C1498 avss.n465 vw 0
C1499 avss.n466 vw 0.01121f
C1500 avss.n467 vw 0
C1501 avss.n468 vw 0
C1502 avss.n469 vw 0
C1503 avss.n470 vw 0
C1504 avss.n471 vw 0
C1505 avss.n472 vw 0
C1506 avss.n473 vw 0
C1507 avss.n474 vw 0.00785f
C1508 avss.n475 vw 0
C1509 avss.n476 vw 0
C1510 avss.n477 vw 0
C1511 avss.n478 vw 0.00141f
C1512 avss.n479 vw 0.01663f
C1513 avss.n480 vw 0.00292f
C1514 avss.n481 vw 0
C1515 avss.n482 vw 0
C1516 avss.n483 vw 0
C1517 avss.n484 vw 0.01121f
C1518 avss.n485 vw 0
C1519 avss.n486 vw 0
C1520 avss.n487 vw 0
C1521 avss.n488 vw 0
C1522 avss.n489 vw 0
C1523 avss.n490 vw 0
C1524 avss.n491 vw 0
C1525 avss.n492 vw 0
C1526 avss.n493 vw 0
C1527 avss.n494 vw 0.00647f
C1528 avss.n495 vw 0.01121f
C1529 avss.n496 vw 0
C1530 avss.n497 vw 0
C1531 avss.n498 vw 0
C1532 avss.n499 vw 0
C1533 avss.n500 vw 0
C1534 avss.n501 vw 0.00817f
C1535 avss.n502 vw 0.00908f
C1536 avss.n503 vw 0.00768f
C1537 avss.n504 vw 0.00798f
C1538 avss.n505 vw 0.00628f
C1539 avss.n506 vw 0.12074f
C1540 avss.n507 vw 0.07612f
C1541 avss.n508 vw 0.30781f
C1542 avss.n510 vw 0
C1543 avss.n511 vw 0
C1544 avss.n512 vw 0
C1545 avss.n513 vw 0
C1546 avss.n514 vw 0
C1547 avss.n515 vw 0
C1548 avss.n516 vw 0
C1549 avss.n517 vw 0
C1550 avss.n518 vw 0
C1551 avss.n519 vw 0
C1552 avss.n520 vw 0
C1553 avss.n521 vw 0
C1554 avss.n522 vw 0
C1555 avss.n523 vw 0
C1556 avss.n524 vw 0
C1557 avss.n525 vw 0
C1558 avss.n526 vw 0
C1559 avss.n527 vw 0
C1560 avss.n528 vw 0
C1561 avss.n529 vw 0
C1562 avss.n530 vw 0
C1563 avss.n531 vw 0
C1564 avss.n532 vw 0
C1565 avss.n533 vw 0
C1566 avss.n534 vw 0
C1567 avss.n535 vw 0
C1568 avss.n536 vw 0
C1569 avss.n537 vw 0
C1570 avss.n539 vw 0.58115f
C1571 avss.n540 vw 0
C1572 avss.n541 vw 0
C1573 avss.n542 vw 0
C1574 avss.n543 vw 0.00167f
C1575 avss.n544 vw 0
C1576 avss.n545 vw 0
C1577 avss.n546 vw 0
C1578 avss.n547 vw 0
C1579 avss.n548 vw 0
C1580 avss.n549 vw 0
C1581 avss.n550 vw 0
C1582 avss.n551 vw 0
C1583 avss.n552 vw 0
C1584 avss.n553 vw 0
C1585 avss.n554 vw 0.06006f
C1586 avss.n556 vw 0
C1587 avss.n557 vw 0
C1588 avss.n558 vw 0
C1589 avss.n559 vw 0
C1590 avss.n560 vw 0
C1591 avss.n561 vw 0
C1592 avss.n562 vw 0
C1593 avss.n563 vw 0
C1594 avss.n564 vw 0
C1595 avss.n565 vw 0
C1596 avss.n566 vw 0
C1597 avss.n567 vw 0
C1598 avss.n568 vw 0
C1599 avss.n569 vw 0
C1600 avss.n570 vw 0
C1601 avss.n571 vw 0
C1602 avss.n572 vw 0
C1603 avss.n573 vw 0
C1604 avss.n575 vw 0.01626f
C1605 avss.n576 vw 0.02099f
C1606 avss.n578 vw 0
C1607 avss.n579 vw 0
C1608 avss.n580 vw 0
C1609 avss.n581 vw 0
C1610 avss.n582 vw 0.00166f
C1611 avss.n583 vw 0
C1612 avss.n584 vw 0
C1613 avss.n585 vw 0
C1614 avss.n586 vw 0
C1615 avss.n587 vw 0.00526f
C1616 avss.n588 vw 0
C1617 avss.n589 vw 0
C1618 avss.n590 vw 0
C1619 avss.n591 vw 0
C1620 avss.n592 vw 0
C1621 avss.n593 vw 0
C1622 avss.n595 vw 0
C1623 avss.n596 vw 0
C1624 avss.n597 vw 0
C1625 avss.n598 vw 0
C1626 avss.n599 vw 0
C1627 avss.n600 vw 0
C1628 avss.n602 vw 0
C1629 avss.n603 vw 0
C1630 avss.n604 vw 0
C1631 avss.n605 vw 0
C1632 avss.n606 vw 0
C1633 avss.n607 vw 0
C1634 avss.n609 vw 0.03213f
C1635 avss.n611 vw 0
C1636 avss.n612 vw 0
C1637 avss.n613 vw 0
C1638 avss.n614 vw 0
C1639 avss.n615 vw 0
C1640 avss.n616 vw 0
C1641 avss.n617 vw 0
C1642 avss.n618 vw 0
C1643 avss.n619 vw 0
C1644 avss.n620 vw 0
C1645 avss.n621 vw 0
C1646 avss.n622 vw 0
C1647 avss.n623 vw 0
C1648 avss.n624 vw 0
C1649 avss.n625 vw 0
C1650 avss.n626 vw 0
C1651 avss.n627 vw 0
C1652 avss.n628 vw 0
C1653 avss.n629 vw 0
C1654 avss.n630 vw 0
C1655 avss.n631 vw 0
C1656 avss.n632 vw 0
C1657 avss.n633 vw 0.0061f
C1658 avss.n634 vw 0
C1659 avss.n635 vw 0
C1660 avss.n636 vw 0
C1661 avss.n637 vw 0
C1662 avss.n638 vw 0
C1663 avss.n639 vw 0
C1664 avss.n640 vw 0
C1665 avss.n641 vw 0
C1666 avss.n642 vw 0
C1667 avss.n643 vw 0
C1668 avss.n644 vw 0
C1669 avss.n645 vw 0
C1670 avss.n646 vw 0
C1671 avss.n647 vw 0
C1672 avss.n648 vw 0
C1673 avss.n649 vw 0
C1674 avss.n650 vw 0
C1675 avss.n651 vw 0
C1676 avss.n652 vw 0
C1677 avss.n653 vw 0
C1678 avss.n654 vw 0
C1679 avss.n655 vw 0
C1680 avss.n656 vw 0
C1681 avss.n657 vw 0
C1682 avss.n658 vw 0
C1683 avss.n659 vw 0
C1684 avss.n660 vw 0
C1685 avss.n661 vw 0
C1686 avss.n662 vw 0
C1687 avss.n663 vw 0
C1688 avss.n664 vw 0
C1689 avss.n665 vw 0
C1690 avss.n666 vw 0
C1691 avss.n667 vw 0
C1692 avss.n668 vw 0.14243f
C1693 avss.n669 vw 0
C1694 avss.n670 vw 0
C1695 avss.n671 vw 0
C1696 avss.n672 vw 0.00141f
C1697 avss.n673 vw 0.02108f
C1698 avss.n674 vw 0.02984f
C1699 avss.n675 vw 0.00823f
C1700 avss.n676 vw 0.02984f
C1701 avss.n677 vw 0.00519f
C1702 avss.n678 vw 0.30728f
C1703 avss.n679 vw 0.03601f
C1704 avss.n680 vw 0.24598f
C1705 avss.n681 vw 0.06326f
C1706 avss.n682 vw 0.00697f
C1707 avss.n683 vw 0.02984f
C1708 avss.n684 vw 0.02984f
C1709 avss.n685 vw 0.02984f
C1710 avss.n686 vw 0.00823f
C1711 avss.n687 vw 0.00823f
C1712 avss.n688 vw 0.00823f
C1713 avss.n689 vw 0.02984f
C1714 avss.n690 vw 0.02984f
C1715 avss.n691 vw 0.02984f
C1716 avss.n692 vw 0.0113f
C1717 avss.n693 vw 0.0465f
C1718 xmcm_chain_3_0/a_1000_n131# vw -0.20444f
C1719 xm8_0/a_63_n131# vw -0.87072f
C1720 vb_itp vw -0.02509f
C1721 vb_pot vw 0.03105f
C1722 avdd vw -15.90386f
C1723 nvpost vw -0.01768f
C1724 vpost vw 0.00814f
C1725 vb_itd vw -0.00531f
C1726 xm7_0/a_63_n131# vw -1.03656f
C1727 vb_idep vw -0.01078f
C1728 xmcm_chain_4_0/a_n1000_n339# vw -1.23486f
C1729 nvpre vw -0.03076f
C1730 xm4_0/a_63_n131# vw 0.06071f
C1731 vpre vw 0.0388f
C1732 xmcm_chain_1_0/a_1000_n131# vw 2.79772f
C1733 xm9_0/a_63_n131# vw -3.64406f
C1734 xmcm_chain_4_0/a_1000_n131# vw -0.14249f
C1735 Iout vw 0.0753f
C1736 xmcm_chain_2_0/a_1000_n131# vw -0.20412f
C1737 xm1_0/a_63_n131# vw -0.66972f
.ends
