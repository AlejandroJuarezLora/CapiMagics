* NGSPICE file created from stdp.ext - technology: gf180mcuD

.subckt xm5 a_n1500_n339# a_n1620_n131# w_n1886_n560# a_1500_n131# VSUBS
X0 a_1500_n131# a_n1500_n339# a_n1620_n131# w_n1886_n560# pfet_03v3 ad=0.3p pd=2.2u as=0.3p ps=2.2u w=0.5u l=15u
C0 a_n1500_n339# a_1500_n131# 0.06934f
C1 a_n1620_n131# w_n1886_n560# 0.45972f
C2 a_n1500_n339# w_n1886_n560# 6.38155f
C3 a_n1500_n339# a_n1620_n131# 0.6108f
C4 w_n1886_n560# a_1500_n131# 1.82938f
C5 a_n1620_n131# a_1500_n131# 1.44038f
C6 a_1500_n131# VSUBS 0.06141f
C7 a_n1620_n131# VSUBS 0.05599f
C8 a_n1500_n339# VSUBS 0.30906f
C9 w_n1886_n560# VSUBS 15.2029f
.ends

.subckt xm3 a_63_n131# a_n393_n504# a_n63_n339# a_n183_n131#
X0 a_63_n131# a_n63_n339# a_n183_n131# a_n393_n504# nfet_03v3 ad=0.3p pd=2.2u as=0.3p ps=2.2u w=0.5u l=0.63u
C0 a_n183_n131# a_n63_n339# 0.04027f
C1 a_n63_n339# a_63_n131# 0.01741f
C2 a_n183_n131# a_63_n131# 0.33209f
C3 a_63_n131# a_n393_n504# 0.53054f
C4 a_n183_n131# a_n393_n504# 0.26905f
C5 a_n63_n339# a_n393_n504# 0.50927f
.ends

.subckt xm1 a_63_n131# a_n63_n339# w_n449_n560# a_n183_n131# VSUBS
X0 a_63_n131# a_n63_n339# a_n183_n131# w_n449_n560# pfet_03v3 ad=0.3p pd=2.2u as=0.3p ps=2.2u w=0.5u l=0.63u
C0 a_63_n131# w_n449_n560# 0.48511f
C1 a_n63_n339# a_63_n131# 0.01741f
C2 a_n63_n339# w_n449_n560# 0.45684f
C3 a_63_n131# a_n183_n131# 0.33209f
C4 w_n449_n560# a_n183_n131# 0.2249f
C5 a_n63_n339# a_n183_n131# 0.04027f
C6 a_63_n131# VSUBS 0.04546f
C7 a_n183_n131# VSUBS 0.04416f
C8 a_n63_n339# VSUBS 0.05243f
C9 w_n449_n560# VSUBS 3.76898f
.ends

.subckt xmcm_chain_4 a_n1120_n131# a_n1330_n504# a_1000_n131# a_n1000_n339#
X0 a_1000_n131# a_n1000_n339# a_n1120_n131# a_n1330_n504# nfet_03v3 ad=0.3p pd=2.2u as=0.3p ps=2.2u w=0.5u l=10u
C0 a_n1120_n131# a_n1000_n339# 0.42273f
C1 a_n1000_n339# a_1000_n131# 0.06176f
C2 a_n1120_n131# a_1000_n131# 1.01551f
C3 a_1000_n131# a_n1330_n504# 1.43795f
C4 a_n1120_n131# a_n1330_n504# 0.4423f
C5 a_n1000_n339# a_n1330_n504# 4.53847f
.ends

.subckt cpot m4_n700_n700# m4_n500_n500# VSUBS
X0 m4_n500_n500# m4_n700_n700# cap_mim_2f0_m4m5_noshield c_width=5u c_length=5u
X1 m4_n500_n500# m4_n700_n700# cap_mim_2f0_m4m5_noshield c_width=5u c_length=5u
C0 m4_n500_n500# m4_n700_n700# 1.99903f
C1 m4_n500_n500# VSUBS 1.68062f
C2 m4_n700_n700# VSUBS 1.59113f
.ends

.subckt xm8 a_63_n131# a_n63_n339# w_n449_n560# a_n183_n131# VSUBS
X0 a_63_n131# a_n63_n339# a_n183_n131# w_n449_n560# pfet_03v3 ad=0.3p pd=2.2u as=0.3p ps=2.2u w=0.5u l=0.63u
C0 a_63_n131# w_n449_n560# 0.48511f
C1 a_n63_n339# a_63_n131# 0.01741f
C2 a_n63_n339# w_n449_n560# 0.45684f
C3 a_63_n131# a_n183_n131# 0.33209f
C4 w_n449_n560# a_n183_n131# 0.2249f
C5 a_n63_n339# a_n183_n131# 0.04027f
C6 a_63_n131# VSUBS 0.04546f
C7 a_n183_n131# VSUBS 0.04416f
C8 a_n63_n339# VSUBS 0.05243f
C9 w_n449_n560# VSUBS 3.76898f
.ends

.subckt xmcm_chain_2 a_n1120_n131# a_n1330_n504# a_1000_n131# a_n1000_n339#
X0 a_1000_n131# a_n1000_n339# a_n1120_n131# a_n1330_n504# nfet_03v3 ad=0.3p pd=2.2u as=0.3p ps=2.2u w=0.5u l=10u
C0 a_n1120_n131# a_n1000_n339# 0.42273f
C1 a_n1000_n339# a_1000_n131# 0.06176f
C2 a_n1120_n131# a_1000_n131# 1.01551f
C3 a_1000_n131# a_n1330_n504# 1.43795f
C4 a_n1120_n131# a_n1330_n504# 0.4423f
C5 a_n1000_n339# a_n1330_n504# 4.53847f
.ends

.subckt xm16 a_n400_n1101# a_n280_n1309# w_n666_n1529# a_280_n1101# VSUBS
X0 a_280_n1101# a_n280_n1309# a_n400_n1101# w_n666_n1529# pfet_03v3 ad=6.12p pd=21.6u as=6.12p ps=21.6u w=10.2u l=2.8u
C0 a_280_n1101# w_n666_n1529# 1.53123f
C1 a_n280_n1309# a_280_n1101# 0.57005f
C2 a_n280_n1309# w_n666_n1529# 1.30956f
C3 a_280_n1101# a_n400_n1101# 0.72266f
C4 w_n666_n1529# a_n400_n1101# 1.08957f
C5 a_n280_n1309# a_n400_n1101# 0.64393f
C6 a_280_n1101# VSUBS 0.28176f
C7 a_n400_n1101# VSUBS 0.30514f
C8 a_n280_n1309# VSUBS 0.12268f
C9 w_n666_n1529# VSUBS 13.9301f
.ends

.subckt xmcm_chain_0 a_n1120_n131# a_n1330_n504# a_1000_n131# a_n1000_n339#
X0 a_1000_n131# a_n1000_n339# a_n1120_n131# a_n1330_n504# nfet_03v3 ad=0.3p pd=2.2u as=0.3p ps=2.2u w=0.5u l=10u
C0 a_n1120_n131# a_n1000_n339# 0.42273f
C1 a_n1000_n339# a_1000_n131# 0.06176f
C2 a_n1120_n131# a_1000_n131# 1.01551f
C3 a_1000_n131# a_n1330_n504# 1.43795f
C4 a_n1120_n131# a_n1330_n504# 0.4423f
C5 a_n1000_n339# a_n1330_n504# 4.53847f
.ends

.subckt cw m4_n700_n700# m4_n500_n500# VSUBS
X0 m4_n500_n500# m4_n700_n700# cap_mim_2f0_m4m5_noshield c_width=5u c_length=5u
X1 m4_n500_n500# m4_n700_n700# cap_mim_2f0_m4m5_noshield c_width=5u c_length=5u
X2 m4_n500_n500# m4_n700_n700# cap_mim_2f0_m4m5_noshield c_width=5u c_length=5u
X3 m4_n500_n500# m4_n700_n700# cap_mim_2f0_m4m5_noshield c_width=5u c_length=5u
X4 m4_n500_n500# m4_n700_n700# cap_mim_2f0_m4m5_noshield c_width=5u c_length=5u
X5 m4_n500_n500# m4_n700_n700# cap_mim_2f0_m4m5_noshield c_width=5u c_length=5u
X6 m4_n500_n500# m4_n700_n700# cap_mim_2f0_m4m5_noshield c_width=5u c_length=5u
X7 m4_n500_n500# m4_n700_n700# cap_mim_2f0_m4m5_noshield c_width=5u c_length=5u
X8 m4_n500_n500# m4_n700_n700# cap_mim_2f0_m4m5_noshield c_width=5u c_length=5u
X9 m4_n500_n500# m4_n700_n700# cap_mim_2f0_m4m5_noshield c_width=5u c_length=5u
C0 m4_n500_n500# m4_n700_n700# 10.9018f
C1 m4_n500_n500# VSUBS 4.99987f
C2 m4_n700_n700# VSUBS 4.97766f
.ends

.subckt xm4 a_63_n131# a_n393_n504# a_n63_n339# a_n183_n131#
X0 a_63_n131# a_n63_n339# a_n183_n131# a_n393_n504# nfet_03v3 ad=0.3p pd=2.2u as=0.3p ps=2.2u w=0.5u l=0.63u
C0 a_n183_n131# a_n63_n339# 0.04027f
C1 a_n63_n339# a_63_n131# 0.01741f
C2 a_n183_n131# a_63_n131# 0.33209f
C3 a_63_n131# a_n393_n504# 0.53054f
C4 a_n183_n131# a_n393_n504# 0.26905f
C5 a_n63_n339# a_n393_n504# 0.50927f
.ends

.subckt xm12 a_63_n131# a_n393_n504# a_n63_n339# a_n183_n131#
X0 a_63_n131# a_n63_n339# a_n183_n131# a_n393_n504# nfet_03v3 ad=0.3p pd=2.2u as=0.3p ps=2.2u w=0.5u l=0.63u
C0 a_n183_n131# a_n63_n339# 0.04027f
C1 a_n63_n339# a_63_n131# 0.01741f
C2 a_n183_n131# a_63_n131# 0.33209f
C3 a_63_n131# a_n393_n504# 0.53054f
C4 a_n183_n131# a_n393_n504# 0.26905f
C5 a_n63_n339# a_n393_n504# 0.50927f
.ends

.subckt xm2 a_63_n131# a_n63_n339# w_n449_n560# a_n183_n131# VSUBS
X0 a_63_n131# a_n63_n339# a_n183_n131# w_n449_n560# pfet_03v3 ad=0.3p pd=2.2u as=0.3p ps=2.2u w=0.5u l=0.63u
C0 a_63_n131# w_n449_n560# 0.48511f
C1 a_n63_n339# a_63_n131# 0.01741f
C2 a_n63_n339# w_n449_n560# 0.45684f
C3 a_63_n131# a_n183_n131# 0.33209f
C4 w_n449_n560# a_n183_n131# 0.2249f
C5 a_n63_n339# a_n183_n131# 0.04027f
C6 a_63_n131# VSUBS 0.04546f
C7 a_n183_n131# VSUBS 0.04416f
C8 a_n63_n339# VSUBS 0.05243f
C9 w_n449_n560# VSUBS 3.76898f
.ends

.subckt cdep m4_n700_n700# m4_n500_n500# VSUBS
X0 m4_n500_n500# m4_n700_n700# cap_mim_2f0_m4m5_noshield c_width=5u c_length=5u
X1 m4_n500_n500# m4_n700_n700# cap_mim_2f0_m4m5_noshield c_width=5u c_length=5u
C0 m4_n500_n500# m4_n700_n700# 1.99903f
C1 m4_n500_n500# VSUBS 1.68062f
C2 m4_n700_n700# VSUBS 1.59113f
.ends

.subckt xmcm_1 a_n280_n350# a_n400_n141# a_280_n141# a_n610_n515#
X0 a_280_n141# a_n280_n350# a_n400_n141# a_n610_n515# nfet_03v3 ad=0.366p pd=2.42u as=0.366p ps=2.42u w=0.61u l=2.8u
C0 a_n400_n141# a_n280_n350# 0.1455f
C1 a_n280_n350# a_280_n141# 0.04694f
C2 a_n400_n141# a_280_n141# 0.4351f
C3 a_280_n141# a_n610_n515# 0.76826f
C4 a_n400_n141# a_n610_n515# 0.3279f
C5 a_n280_n350# a_n610_n515# 1.4155f
.ends

.subckt xm9 a_63_n131# a_n393_n504# a_n63_n339# a_n183_n131#
X0 a_63_n131# a_n63_n339# a_n183_n131# a_n393_n504# nfet_03v3 ad=0.3p pd=2.2u as=0.3p ps=2.2u w=0.5u l=0.63u
C0 a_n183_n131# a_n63_n339# 0.04027f
C1 a_n63_n339# a_63_n131# 0.01741f
C2 a_n183_n131# a_63_n131# 0.33209f
C3 a_63_n131# a_n393_n504# 0.53054f
C4 a_n183_n131# a_n393_n504# 0.26905f
C5 a_n63_n339# a_n393_n504# 0.50927f
.ends

.subckt xmcm_chain_3 a_n1120_n131# a_n1330_n504# a_1000_n131# a_n1000_n339#
X0 a_1000_n131# a_n1000_n339# a_n1120_n131# a_n1330_n504# nfet_03v3 ad=0.3p pd=2.2u as=0.3p ps=2.2u w=0.5u l=10u
C0 a_n1120_n131# a_n1000_n339# 0.42273f
C1 a_n1000_n339# a_1000_n131# 0.06176f
C2 a_n1120_n131# a_1000_n131# 1.01551f
C3 a_1000_n131# a_n1330_n504# 1.43795f
C4 a_n1120_n131# a_n1330_n504# 0.4423f
C5 a_n1000_n339# a_n1330_n504# 4.53847f
.ends

.subckt xm17 a_n460_n339# w_n846_n560# a_n580_n131# a_460_n131# VSUBS
X0 a_460_n131# a_n460_n339# a_n580_n131# w_n846_n560# pfet_03v3 ad=0.3p pd=2.2u as=0.3p ps=2.2u w=0.5u l=4.6u
C0 a_460_n131# w_n846_n560# 0.87034f
C1 a_n460_n339# a_460_n131# 0.04912f
C2 a_n460_n339# w_n846_n560# 2.05763f
C3 a_460_n131# a_n580_n131# 0.57434f
C4 w_n846_n560# a_n580_n131# 0.30191f
C5 a_n460_n339# a_n580_n131# 0.21491f
C6 a_460_n131# VSUBS 0.04483f
C7 a_n580_n131# VSUBS 0.04363f
C8 a_n460_n339# VSUBS 0.12333f
C9 w_n846_n560# VSUBS 6.90762f
.ends

.subckt xm7 a_63_n131# a_n63_n339# w_n449_n560# a_n183_n131# VSUBS
X0 a_63_n131# a_n63_n339# a_n183_n131# w_n449_n560# pfet_03v3 ad=0.3p pd=2.2u as=0.3p ps=2.2u w=0.5u l=0.63u
C0 a_63_n131# w_n449_n560# 0.48511f
C1 a_n63_n339# a_63_n131# 0.01741f
C2 a_n63_n339# w_n449_n560# 0.45684f
C3 a_63_n131# a_n183_n131# 0.33209f
C4 w_n449_n560# a_n183_n131# 0.2249f
C5 a_n63_n339# a_n183_n131# 0.04027f
C6 a_63_n131# VSUBS 0.04546f
C7 a_n183_n131# VSUBS 0.04416f
C8 a_n63_n339# VSUBS 0.05243f
C9 w_n449_n560# VSUBS 3.76898f
.ends

.subckt xmcm_chain_1 a_n1120_n131# a_n1330_n504# a_1000_n131# a_n1000_n339#
X0 a_1000_n131# a_n1000_n339# a_n1120_n131# a_n1330_n504# nfet_03v3 ad=0.3p pd=2.2u as=0.3p ps=2.2u w=0.5u l=10u
C0 a_n1120_n131# a_n1000_n339# 0.42273f
C1 a_n1000_n339# a_1000_n131# 0.06176f
C2 a_n1120_n131# a_1000_n131# 1.01551f
C3 a_1000_n131# a_n1330_n504# 1.43795f
C4 a_n1120_n131# a_n1330_n504# 0.4423f
C5 a_n1000_n339# a_n1330_n504# 4.53847f
.ends

.subckt stdp avdd avss nvpost nvpre vpost vpre vb_idep vb_itd vb_itp vb_pot vw Iout
Xxm5_0 vw avdd avdd Iout avss xm5
Xxm3_0 vw avss vpre xm4_0/a_63_n131# xm3
Xxm1_0 xm1_0/a_63_n131# xm1_0/a_n63_n339# avdd avdd avss xm1
Xxmcm_chain_4_0 avss avss xmcm_chain_4_0/a_1000_n131# vb_itd xmcm_chain_4
Xcpot_0 xm1_0/a_n63_n339# avdd avss cpot
Xxm8_0 xm8_0/a_63_n131# nvpre avdd xm1_0/a_n63_n339# avss xm8
Xxmcm_chain_2_0 xmcm_chain_3_0/a_1000_n131# avss xmcm_chain_2_0/a_1000_n131# vb_itd
+ xmcm_chain_2
Xxm16_0 avdd vb_idep avdd xm9_0/a_63_n131# avss xm16
Xxmcm_chain_0_0 xmcm_chain_1_0/a_1000_n131# avss xm4_0/a_n63_n339# vb_itd xmcm_chain_0
Xcw_0 avss vw avss cw
Xxm4_0 xm4_0/a_63_n131# avss xm4_0/a_n63_n339# avss xm4
Xxm12_0 xm9_0/a_63_n131# avss vpost xm4_0/a_n63_n339# xm12
Xxm2_0 vw nvpost avdd xm1_0/a_63_n131# avss xm2
Xcdep_0 avss xm4_0/a_n63_n339# avss cdep
Xxmcm_1_0 vb_pot avss xm7_0/a_63_n131# avss xmcm_1
Xxm9_0 xm9_0/a_63_n131# avss xm9_0/a_63_n131# avss xm9
Xxmcm_chain_3_0 xmcm_chain_4_0/a_1000_n131# avss xmcm_chain_3_0/a_1000_n131# vb_itd
+ xmcm_chain_3
Xxm17_0 vb_itp avdd avdd xm1_0/a_n63_n339# avss xm17
Xxm7_0 xm7_0/a_63_n131# xm8_0/a_63_n131# avdd avdd avss xm7
Xxmcm_chain_1_0 xmcm_chain_2_0/a_1000_n131# avss xmcm_chain_1_0/a_1000_n131# vb_itd
+ xmcm_chain_1
R0 vw.n136 vw.n135 18.0159
R1 vw.n136 vw.n134 14.1846
R2 vw.n98 vw.n77 4.5005
R3 vw.n98 vw.n75 4.5005
R4 vw.n98 vw.n78 4.5005
R5 vw.n98 vw.n74 4.5005
R6 vw.n93 vw.n74 4.5005
R7 vw.n84 vw.n75 4.5005
R8 vw.n84 vw.n78 4.5005
R9 vw.n84 vw.n74 4.5005
R10 vw.n96 vw.n75 4.5005
R11 vw.n96 vw.n78 4.5005
R12 vw.n96 vw.n74 4.5005
R13 vw.n98 vw.n79 4.5005
R14 vw.n98 vw.n73 4.5005
R15 vw.n98 vw.n97 4.5005
R16 vw.n93 vw.n79 4.5005
R17 vw.n84 vw.n79 4.5005
R18 vw.n84 vw.n73 4.5005
R19 vw.n95 vw.n84 4.5005
R20 vw.n85 vw.n84 4.5005
R21 vw.n97 vw.n84 4.5005
R22 vw.n82 vw.n79 4.5005
R23 vw.n82 vw.n73 4.5005
R24 vw.n95 vw.n82 4.5005
R25 vw.n97 vw.n82 4.5005
R26 vw.n96 vw.n95 4.5005
R27 vw.n97 vw.n96 4.5005
R28 vw.n107 vw.n59 4.5005
R29 vw.n107 vw.n57 4.5005
R30 vw.n107 vw.n60 4.5005
R31 vw.n107 vw.n56 4.5005
R32 vw.n102 vw.n56 4.5005
R33 vw.n66 vw.n57 4.5005
R34 vw.n66 vw.n60 4.5005
R35 vw.n66 vw.n56 4.5005
R36 vw.n105 vw.n57 4.5005
R37 vw.n105 vw.n60 4.5005
R38 vw.n105 vw.n56 4.5005
R39 vw.n107 vw.n61 4.5005
R40 vw.n107 vw.n55 4.5005
R41 vw.n107 vw.n106 4.5005
R42 vw.n102 vw.n61 4.5005
R43 vw.n66 vw.n61 4.5005
R44 vw.n66 vw.n55 4.5005
R45 vw.n104 vw.n66 4.5005
R46 vw.n67 vw.n66 4.5005
R47 vw.n106 vw.n66 4.5005
R48 vw.n64 vw.n61 4.5005
R49 vw.n64 vw.n55 4.5005
R50 vw.n104 vw.n64 4.5005
R51 vw.n106 vw.n64 4.5005
R52 vw.n105 vw.n104 4.5005
R53 vw.n106 vw.n105 4.5005
R54 vw.n116 vw.n41 4.5005
R55 vw.n116 vw.n39 4.5005
R56 vw.n116 vw.n42 4.5005
R57 vw.n116 vw.n38 4.5005
R58 vw.n111 vw.n38 4.5005
R59 vw.n48 vw.n39 4.5005
R60 vw.n48 vw.n42 4.5005
R61 vw.n48 vw.n38 4.5005
R62 vw.n114 vw.n39 4.5005
R63 vw.n114 vw.n42 4.5005
R64 vw.n114 vw.n38 4.5005
R65 vw.n116 vw.n43 4.5005
R66 vw.n116 vw.n37 4.5005
R67 vw.n116 vw.n115 4.5005
R68 vw.n111 vw.n43 4.5005
R69 vw.n48 vw.n43 4.5005
R70 vw.n48 vw.n37 4.5005
R71 vw.n113 vw.n48 4.5005
R72 vw.n49 vw.n48 4.5005
R73 vw.n115 vw.n48 4.5005
R74 vw.n46 vw.n43 4.5005
R75 vw.n46 vw.n37 4.5005
R76 vw.n113 vw.n46 4.5005
R77 vw.n115 vw.n46 4.5005
R78 vw.n114 vw.n113 4.5005
R79 vw.n115 vw.n114 4.5005
R80 vw.n125 vw.n23 4.5005
R81 vw.n125 vw.n21 4.5005
R82 vw.n125 vw.n24 4.5005
R83 vw.n125 vw.n20 4.5005
R84 vw.n120 vw.n20 4.5005
R85 vw.n30 vw.n21 4.5005
R86 vw.n30 vw.n24 4.5005
R87 vw.n30 vw.n20 4.5005
R88 vw.n123 vw.n21 4.5005
R89 vw.n123 vw.n24 4.5005
R90 vw.n123 vw.n20 4.5005
R91 vw.n125 vw.n25 4.5005
R92 vw.n125 vw.n19 4.5005
R93 vw.n125 vw.n124 4.5005
R94 vw.n120 vw.n25 4.5005
R95 vw.n30 vw.n25 4.5005
R96 vw.n30 vw.n19 4.5005
R97 vw.n122 vw.n30 4.5005
R98 vw.n31 vw.n30 4.5005
R99 vw.n124 vw.n30 4.5005
R100 vw.n28 vw.n25 4.5005
R101 vw.n28 vw.n19 4.5005
R102 vw.n122 vw.n28 4.5005
R103 vw.n124 vw.n28 4.5005
R104 vw.n123 vw.n122 4.5005
R105 vw.n124 vw.n123 4.5005
R106 vw.n134 vw.n5 4.5005
R107 vw.n134 vw.n3 4.5005
R108 vw.n134 vw.n6 4.5005
R109 vw.n134 vw.n2 4.5005
R110 vw.n129 vw.n2 4.5005
R111 vw.n12 vw.n3 4.5005
R112 vw.n12 vw.n6 4.5005
R113 vw.n12 vw.n2 4.5005
R114 vw.n132 vw.n3 4.5005
R115 vw.n132 vw.n6 4.5005
R116 vw.n132 vw.n2 4.5005
R117 vw.n134 vw.n7 4.5005
R118 vw.n134 vw.n1 4.5005
R119 vw.n134 vw.n133 4.5005
R120 vw.n129 vw.n7 4.5005
R121 vw.n12 vw.n7 4.5005
R122 vw.n12 vw.n1 4.5005
R123 vw.n131 vw.n12 4.5005
R124 vw.n13 vw.n12 4.5005
R125 vw.n133 vw.n12 4.5005
R126 vw.n10 vw.n7 4.5005
R127 vw.n10 vw.n1 4.5005
R128 vw.n131 vw.n10 4.5005
R129 vw.n133 vw.n10 4.5005
R130 vw.n132 vw.n131 4.5005
R131 vw.n133 vw.n132 4.5005
R132 vw vw.n136 4.5005
R133 vw.n88 vw.n76 2.25044
R134 vw.n92 vw.n77 2.25044
R135 vw.n88 vw.n87 2.25044
R136 vw.n86 vw.n85 2.25044
R137 vw.n70 vw.n58 2.25044
R138 vw.n101 vw.n59 2.25044
R139 vw.n70 vw.n69 2.25044
R140 vw.n68 vw.n67 2.25044
R141 vw.n52 vw.n40 2.25044
R142 vw.n110 vw.n41 2.25044
R143 vw.n52 vw.n51 2.25044
R144 vw.n50 vw.n49 2.25044
R145 vw.n34 vw.n22 2.25044
R146 vw.n119 vw.n23 2.25044
R147 vw.n34 vw.n33 2.25044
R148 vw.n32 vw.n31 2.25044
R149 vw.n16 vw.n4 2.25044
R150 vw.n128 vw.n5 2.25044
R151 vw.n16 vw.n15 2.25044
R152 vw.n14 vw.n13 2.25044
R153 vw.n93 vw.n91 2.24741
R154 vw.n82 vw.n80 2.24741
R155 vw.n82 vw.n81 2.24741
R156 vw.n96 vw.n89 2.24741
R157 vw.n98 vw.n72 2.24741
R158 vw.n94 vw.n93 2.24741
R159 vw.n93 vw.n83 2.24741
R160 vw.n96 vw.n90 2.24741
R161 vw.n102 vw.n100 2.24741
R162 vw.n64 vw.n62 2.24741
R163 vw.n64 vw.n63 2.24741
R164 vw.n105 vw.n71 2.24741
R165 vw.n107 vw.n54 2.24741
R166 vw.n103 vw.n102 2.24741
R167 vw.n102 vw.n65 2.24741
R168 vw.n105 vw.n99 2.24741
R169 vw.n111 vw.n109 2.24741
R170 vw.n46 vw.n44 2.24741
R171 vw.n46 vw.n45 2.24741
R172 vw.n114 vw.n53 2.24741
R173 vw.n116 vw.n36 2.24741
R174 vw.n112 vw.n111 2.24741
R175 vw.n111 vw.n47 2.24741
R176 vw.n114 vw.n108 2.24741
R177 vw.n120 vw.n118 2.24741
R178 vw.n28 vw.n26 2.24741
R179 vw.n28 vw.n27 2.24741
R180 vw.n123 vw.n35 2.24741
R181 vw.n125 vw.n18 2.24741
R182 vw.n121 vw.n120 2.24741
R183 vw.n120 vw.n29 2.24741
R184 vw.n123 vw.n117 2.24741
R185 vw.n129 vw.n127 2.24741
R186 vw.n10 vw.n8 2.24741
R187 vw.n10 vw.n9 2.24741
R188 vw.n132 vw.n17 2.24741
R189 vw.n134 vw.n0 2.24741
R190 vw.n130 vw.n129 2.24741
R191 vw.n129 vw.n11 2.24741
R192 vw.n132 vw.n126 2.24741
R193 vw.n132 vw.n125 0.0121667
R194 vw.n123 vw.n116 0.0121667
R195 vw.n114 vw.n107 0.0121667
R196 vw.n105 vw.n98 0.0121667
R197 vw.n13 vw.n11 0.0081885
R198 vw.n13 vw.n0 0.0081885
R199 vw.n130 vw.n1 0.0081885
R200 vw.n126 vw.n7 0.0081885
R201 vw.n9 vw.n6 0.0081885
R202 vw.n127 vw.n3 0.0081885
R203 vw.n8 vw.n5 0.0081885
R204 vw.n17 vw.n16 0.0081885
R205 vw.n31 vw.n29 0.0081885
R206 vw.n31 vw.n18 0.0081885
R207 vw.n121 vw.n19 0.0081885
R208 vw.n117 vw.n25 0.0081885
R209 vw.n27 vw.n24 0.0081885
R210 vw.n118 vw.n21 0.0081885
R211 vw.n26 vw.n23 0.0081885
R212 vw.n35 vw.n34 0.0081885
R213 vw.n49 vw.n47 0.0081885
R214 vw.n49 vw.n36 0.0081885
R215 vw.n112 vw.n37 0.0081885
R216 vw.n108 vw.n43 0.0081885
R217 vw.n45 vw.n42 0.0081885
R218 vw.n109 vw.n39 0.0081885
R219 vw.n44 vw.n41 0.0081885
R220 vw.n53 vw.n52 0.0081885
R221 vw.n67 vw.n65 0.0081885
R222 vw.n67 vw.n54 0.0081885
R223 vw.n103 vw.n55 0.0081885
R224 vw.n99 vw.n61 0.0081885
R225 vw.n63 vw.n60 0.0081885
R226 vw.n100 vw.n57 0.0081885
R227 vw.n62 vw.n59 0.0081885
R228 vw.n71 vw.n70 0.0081885
R229 vw.n85 vw.n83 0.0081885
R230 vw.n85 vw.n72 0.0081885
R231 vw.n94 vw.n73 0.0081885
R232 vw.n90 vw.n79 0.0081885
R233 vw.n81 vw.n78 0.0081885
R234 vw.n91 vw.n75 0.0081885
R235 vw.n80 vw.n77 0.0081885
R236 vw.n89 vw.n88 0.0081885
R237 vw.n91 vw.n78 0.0081885
R238 vw.n80 vw.n75 0.0081885
R239 vw.n81 vw.n74 0.0081885
R240 vw.n89 vw.n77 0.0081885
R241 vw.n95 vw.n72 0.0081885
R242 vw.n95 vw.n94 0.0081885
R243 vw.n97 vw.n83 0.0081885
R244 vw.n90 vw.n73 0.0081885
R245 vw.n100 vw.n60 0.0081885
R246 vw.n62 vw.n57 0.0081885
R247 vw.n63 vw.n56 0.0081885
R248 vw.n71 vw.n59 0.0081885
R249 vw.n104 vw.n54 0.0081885
R250 vw.n104 vw.n103 0.0081885
R251 vw.n106 vw.n65 0.0081885
R252 vw.n99 vw.n55 0.0081885
R253 vw.n109 vw.n42 0.0081885
R254 vw.n44 vw.n39 0.0081885
R255 vw.n45 vw.n38 0.0081885
R256 vw.n53 vw.n41 0.0081885
R257 vw.n113 vw.n36 0.0081885
R258 vw.n113 vw.n112 0.0081885
R259 vw.n115 vw.n47 0.0081885
R260 vw.n108 vw.n37 0.0081885
R261 vw.n118 vw.n24 0.0081885
R262 vw.n26 vw.n21 0.0081885
R263 vw.n27 vw.n20 0.0081885
R264 vw.n35 vw.n23 0.0081885
R265 vw.n122 vw.n18 0.0081885
R266 vw.n122 vw.n121 0.0081885
R267 vw.n124 vw.n29 0.0081885
R268 vw.n117 vw.n19 0.0081885
R269 vw.n127 vw.n6 0.0081885
R270 vw.n8 vw.n3 0.0081885
R271 vw.n9 vw.n2 0.0081885
R272 vw.n17 vw.n5 0.0081885
R273 vw.n131 vw.n0 0.0081885
R274 vw.n131 vw.n130 0.0081885
R275 vw.n133 vw.n11 0.0081885
R276 vw.n126 vw.n1 0.0081885
R277 vw.n129 vw.n4 0.00211084
R278 vw.n129 vw.n128 0.00211084
R279 vw.n15 vw.n10 0.00211084
R280 vw.n132 vw.n14 0.00211084
R281 vw.n120 vw.n22 0.00211084
R282 vw.n120 vw.n119 0.00211084
R283 vw.n33 vw.n28 0.00211084
R284 vw.n123 vw.n32 0.00211084
R285 vw.n111 vw.n40 0.00211084
R286 vw.n111 vw.n110 0.00211084
R287 vw.n51 vw.n46 0.00211084
R288 vw.n114 vw.n50 0.00211084
R289 vw.n102 vw.n58 0.00211084
R290 vw.n102 vw.n101 0.00211084
R291 vw.n69 vw.n64 0.00211084
R292 vw.n105 vw.n68 0.00211084
R293 vw.n93 vw.n76 0.00211084
R294 vw.n93 vw.n92 0.00211084
R295 vw.n87 vw.n82 0.00211084
R296 vw.n96 vw.n86 0.00211084
R297 vw.n98 vw.n76 0.00211084
R298 vw.n87 vw.n84 0.00211084
R299 vw.n92 vw.n84 0.00211084
R300 vw.n86 vw.n82 0.00211084
R301 vw.n107 vw.n58 0.00211084
R302 vw.n69 vw.n66 0.00211084
R303 vw.n101 vw.n66 0.00211084
R304 vw.n68 vw.n64 0.00211084
R305 vw.n116 vw.n40 0.00211084
R306 vw.n51 vw.n48 0.00211084
R307 vw.n110 vw.n48 0.00211084
R308 vw.n50 vw.n46 0.00211084
R309 vw.n125 vw.n22 0.00211084
R310 vw.n33 vw.n30 0.00211084
R311 vw.n119 vw.n30 0.00211084
R312 vw.n32 vw.n28 0.00211084
R313 vw.n134 vw.n4 0.00211084
R314 vw.n15 vw.n12 0.00211084
R315 vw.n128 vw.n12 0.00211084
R316 vw.n14 vw.n10 0.00211084
R317 vb_pot vb_pot.n0 14.6787
R318 vb_itp vb_itp.n0 13.9656
R319 vb_itd.n2 vb_itd.n0 19.1486
R320 vb_itd vb_itd.n8 5.43489
R321 vb_itd.n8 vb_itd.n7 4.45298
R322 vb_itd.n6 vb_itd.n5 4.45298
R323 vb_itd.n4 vb_itd.n3 4.45298
R324 vb_itd.n2 vb_itd.n1 4.45298
R325 vb_itd.n4 vb_itd.n2 2.88807
R326 vb_itd.n6 vb_itd.n4 2.88807
R327 vb_itd.n8 vb_itd.n6 2.88807
R328 vb_idep vb_idep.n0 29.1456
R329 vpre vpre.n0 29.063
R330 vpost vpost.n0 41.1716
R331 nvpre nvpre.n0 33.5468
R332 nvpost nvpost.n0 34.1498
R333 avss.n370 avss.n68 19754.3
R334 avss.n532 avss.n370 16287.7
R335 avss.n535 avss.n35 9594.57
R336 avss.n535 avss.n534 9594.57
R337 avss.n534 avss.n533 9594.57
R338 avss.n533 avss.n532 9453.26
R339 avss.n532 avss.n531 8861.76
R340 avss.n641 avss.n35 7913.04
R341 avss.n536 avss.n535 7913.04
R342 avss.n534 avss.n66 7913.04
R343 avss.n533 avss.n67 7913.04
R344 avss.n370 avss.n369 5618.77
R345 avss.n370 avss.n35 3363.04
R346 avss.n333 avss.n80 2283.78
R347 avss.n301 avss.n96 2144.71
R348 avss.n333 avss.n332 1571.32
R349 avss.n236 avss.n147 269.024
R350 avss.n369 avss.n69 195.501
R351 avss.n147 avss.n69 195.501
R352 avss.n244 avss.n110 195.501
R353 avss.n441 avss.n440 178.941
R354 avss.n244 avss.n96 171.69
R355 avss.n531 avss.n371 164.083
R356 avss.n332 avss.n96 139.077
R357 avss.n624 avss.n623 127.907
R358 avss.n439 avss.n66 125.323
R359 avss.n312 avss.n269 103.359
R360 avss.n269 avss.n7 103.359
R361 avss.n662 avss.n7 103.359
R362 avss.n21 avss.n20 103.359
R363 avss.n652 avss.n21 103.359
R364 avss.n652 avss.n651 103.359
R365 avss.n642 avss.n33 103.359
R366 avss.n640 avss.n639 103.359
R367 avss.n633 avss.n46 103.359
R368 avss.n597 avss.n596 103.359
R369 avss.n606 avss.n543 103.359
R370 avss.n615 avss.n58 103.359
R371 avss.n441 avss.n59 103.359
R372 avss.n449 avss.n415 103.359
R373 avss.n458 avss.n408 103.359
R374 avss.n512 avss.n391 103.359
R375 avss.n506 avss.n505 103.359
R376 avss.n499 avss.n479 103.359
R377 avss.n506 avss.n400 93.0238
R378 avss.n479 avss.n67 91.7318
R379 avss.n480 avss.n379 90.4398
R380 avss.n662 avss.n661 89.1478
R381 avss.n20 avss.n9 89.1478
R382 avss.n639 avss.n38 89.1478
R383 avss.n523 avss.n379 88.5018
R384 avss.n381 avss.n380 88.5018
R385 avss.n642 avss.n641 87.8558
R386 avss.n650 avss.n24 86.5638
R387 avss.n561 avss.n560 86.5638
R388 avss.n440 avss.n439 82.6878
R389 avss.n344 avss.n97 77.5199
R390 avss.n560 avss.n24 77.5199
R391 avss.n661 avss.n9 74.9359
R392 avss.n606 avss.n542 69.7679
R393 avss.n522 avss.n378 68.9311
R394 avss.n530 avss.n373 68.9311
R395 avss.n530 avss.n374 68.9311
R396 avss.n524 avss.n378 68.9311
R397 avss.n389 avss.n384 68.9311
R398 avss.n514 avss.n384 68.9311
R399 avss.n447 avss.n387 68.9311
R400 avss.n447 avss.n417 68.9311
R401 avss.n428 avss.n422 68.9311
R402 avss.n442 avss.n422 68.9311
R403 avss.n625 avss.n57 68.9311
R404 avss.n625 avss.n56 68.9311
R405 avss.n573 avss.n55 68.9311
R406 avss.n55 avss.n51 68.9311
R407 avss.n631 avss.n50 68.9311
R408 avss.n50 avss.n48 68.9311
R409 avss.n615 avss.n536 68.476
R410 avss.n562 avss.n559 67.7644
R411 avss.n564 avss.n562 67.7644
R412 avss.n660 avss.n11 67.7644
R413 avss.n660 avss.n10 67.7644
R414 avss.n471 avss.n372 66.6949
R415 avss.n493 avss.n372 66.6949
R416 avss.n438 avss.n414 66.6949
R417 avss.n438 avss.n429 66.6949
R418 avss.n622 avss.n60 66.6949
R419 avss.n622 avss.n61 66.6949
R420 avss.n649 avss.n26 66.6949
R421 avss.n649 avss.n25 66.6949
R422 avss.n345 avss.n13 66.6949
R423 avss.n343 avss.n13 66.6949
R424 avss.n146 avss.n72 66.6949
R425 avss.n368 avss.n72 66.6949
R426 avss.n8 avss.n6 66.6949
R427 avss.n663 avss.n6 66.6949
R428 avss.n300 avss.n245 66.6949
R429 avss.n331 avss.n245 66.6949
R430 avss.n211 avss.n109 66.6949
R431 avss.n164 avss.n109 66.6949
R432 avss.n243 avss.n111 66.6949
R433 avss.n243 avss.n112 66.6949
R434 avss.n449 avss.n448 65.892
R435 avss.n409 avss.n388 65.246
R436 avss.n513 avss.n512 65.246
R437 avss.n97 avss.n68 62.016
R438 avss.n633 avss.n632 61.37
R439 avss.n574 avss.n49 61.37
R440 avss.n623 avss.n59 51.0341
R441 avss.n632 avss.n49 41.9902
R442 avss.n597 avss.n574 41.9902
R443 avss.n415 avss.n66 38.7602
R444 avss.n458 avss.n409 38.1142
R445 avss.n513 avss.n388 38.1142
R446 avss.n448 avss.n408 37.4682
R447 avss.n624 avss.n58 36.1762
R448 avss.n543 avss.n536 34.8842
R449 avss.n596 avss.n542 33.5922
R450 avss.n268 avss.n68 24.5483
R451 avss.n236 avss.n96 23.8116
R452 avss.n312 avss.n268 16.7964
R453 avss.n651 avss.n650 16.7964
R454 avss.n561 avss.n33 16.7964
R455 avss.n522 avss.n373 15.5561
R456 avss.n524 avss.n374 15.5561
R457 avss.n514 avss.n387 15.5561
R458 avss.n417 avss.n389 15.5561
R459 avss.n442 avss.n57 15.5561
R460 avss.n428 avss.n56 15.5561
R461 avss.n631 avss.n51 15.5561
R462 avss.n573 avss.n48 15.5561
R463 avss.n16 avss.n11 15.5561
R464 avss.n653 avss.n16 15.5561
R465 avss.n653 avss.n19 15.5561
R466 avss.n564 avss.n19 15.5561
R467 avss.n552 avss.n10 15.5561
R468 avss.n552 avss.n22 15.5561
R469 avss.n23 avss.n22 15.5561
R470 avss.n559 avss.n23 15.5561
R471 avss.n450 avss.n414 15.5561
R472 avss.n450 avss.n410 15.5561
R473 avss.n457 avss.n410 15.5561
R474 avss.n457 avss.n392 15.5561
R475 avss.n511 avss.n392 15.5561
R476 avss.n511 avss.n393 15.5561
R477 avss.n507 avss.n393 15.5561
R478 avss.n507 avss.n399 15.5561
R479 avss.n481 avss.n399 15.5561
R480 avss.n498 avss.n481 15.5561
R481 avss.n498 avss.n482 15.5561
R482 avss.n494 avss.n482 15.5561
R483 avss.n494 avss.n493 15.5561
R484 avss.n429 avss.n416 15.5561
R485 avss.n416 avss.n407 15.5561
R486 avss.n459 avss.n407 15.5561
R487 avss.n460 avss.n459 15.5561
R488 avss.n460 avss.n390 15.5561
R489 avss.n463 avss.n390 15.5561
R490 avss.n463 avss.n401 15.5561
R491 avss.n504 avss.n401 15.5561
R492 avss.n504 avss.n402 15.5561
R493 avss.n500 avss.n402 15.5561
R494 avss.n500 avss.n478 15.5561
R495 avss.n478 avss.n477 15.5561
R496 avss.n477 avss.n471 15.5561
R497 avss.n29 avss.n26 15.5561
R498 avss.n643 avss.n29 15.5561
R499 avss.n643 avss.n32 15.5561
R500 avss.n638 avss.n32 15.5561
R501 avss.n638 avss.n39 15.5561
R502 avss.n634 avss.n39 15.5561
R503 avss.n634 avss.n45 15.5561
R504 avss.n598 avss.n45 15.5561
R505 avss.n598 avss.n544 15.5561
R506 avss.n605 avss.n544 15.5561
R507 avss.n605 avss.n65 15.5561
R508 avss.n616 avss.n65 15.5561
R509 avss.n616 avss.n61 15.5561
R510 avss.n581 avss.n25 15.5561
R511 avss.n581 avss.n34 15.5561
R512 avss.n36 avss.n34 15.5561
R513 avss.n37 avss.n36 15.5561
R514 avss.n588 avss.n37 15.5561
R515 avss.n588 avss.n47 15.5561
R516 avss.n575 avss.n47 15.5561
R517 avss.n595 avss.n575 15.5561
R518 avss.n595 avss.n541 15.5561
R519 avss.n607 avss.n541 15.5561
R520 avss.n607 avss.n537 15.5561
R521 avss.n614 avss.n537 15.5561
R522 avss.n614 avss.n60 15.5561
R523 avss.n146 avss.n118 15.5561
R524 avss.n139 avss.n138 15.5561
R525 avss.n136 avss.n135 15.5561
R526 avss.n132 avss.n131 15.5561
R527 avss.n128 avss.n127 15.5561
R528 avss.n336 avss.n335 15.5561
R529 avss.n343 avss.n98 15.5561
R530 avss.n368 avss.n73 15.5561
R531 avss.n364 avss.n363 15.5561
R532 avss.n360 avss.n359 15.5561
R533 avss.n357 avss.n81 15.5561
R534 avss.n353 avss.n352 15.5561
R535 avss.n350 avss.n88 15.5561
R536 avss.n346 avss.n345 15.5561
R537 avss.n300 avss.n279 15.5561
R538 avss.n293 avss.n292 15.5561
R539 avss.n290 avss.n289 15.5561
R540 avss.n286 avss.n275 15.5561
R541 avss.n303 avss.n270 15.5561
R542 avss.n311 avss.n270 15.5561
R543 avss.n311 avss.n271 15.5561
R544 avss.n271 avss.n5 15.5561
R545 avss.n663 avss.n5 15.5561
R546 avss.n331 avss.n246 15.5561
R547 avss.n327 avss.n326 15.5561
R548 avss.n323 avss.n322 15.5561
R549 avss.n319 avss.n318 15.5561
R550 avss.n315 avss.n314 15.5561
R551 avss.n314 avss.n313 15.5561
R552 avss.n313 avss.n257 15.5561
R553 avss.n264 avss.n257 15.5561
R554 avss.n264 avss.n8 15.5561
R555 avss.n162 avss.n161 15.5561
R556 avss.n219 avss.n218 15.5561
R557 avss.n158 avss.n157 15.5561
R558 avss.n227 avss.n226 15.5561
R559 avss.n234 avss.n153 15.5561
R560 avss.n238 avss.n115 15.5561
R561 avss.n165 avss.n164 15.5561
R562 avss.n170 avss.n167 15.5561
R563 avss.n173 avss.n172 15.5561
R564 avss.n178 avss.n175 15.5561
R565 avss.n181 avss.n180 15.5561
R566 avss.n186 avss.n183 15.5561
R567 avss.n188 avss.n112 15.5561
R568 avss.n641 avss.n640 15.5044
R569 avss.n523 avss.n381 14.8584
R570 avss.n380 avss.n371 14.8584
R571 avss.n46 avss.n38 14.2124
R572 avss avss.n668 13.5005
R573 avss.n499 avss.n480 12.9204
R574 avss.n505 avss.n67 11.6284
R575 avss.n400 avss.n391 10.3364
R576 avss.n344 avss.n96 9.04443
R577 avss.n490 avss.n1 8.11756
R578 avss.n668 avss.n0 6.68116
R579 avss.n620 avss.n1 5.20876
R580 avss.n667 avss.n666 5.20876
R581 avss.n316 avss.n315 5.2005
R582 avss.n318 avss.n317 5.2005
R583 avss.n320 avss.n319 5.2005
R584 avss.n322 avss.n321 5.2005
R585 avss.n324 avss.n323 5.2005
R586 avss.n326 avss.n325 5.2005
R587 avss.n328 avss.n327 5.2005
R588 avss.n329 avss.n246 5.2005
R589 avss.n331 avss.n330 5.2005
R590 avss.n332 avss.n331 5.2005
R591 avss.n304 avss.n303 5.2005
R592 avss.n275 avss.n274 5.2005
R593 avss.n287 avss.n286 5.2005
R594 avss.n289 avss.n288 5.2005
R595 avss.n291 avss.n290 5.2005
R596 avss.n294 avss.n293 5.2005
R597 avss.n292 avss.n282 5.2005
R598 avss.n298 avss.n279 5.2005
R599 avss.n300 avss.n299 5.2005
R600 avss.n301 avss.n300 5.2005
R601 avss.n347 avss.n346 5.2005
R602 avss.n348 avss.n88 5.2005
R603 avss.n350 avss.n349 5.2005
R604 avss.n352 avss.n86 5.2005
R605 avss.n354 avss.n353 5.2005
R606 avss.n355 avss.n81 5.2005
R607 avss.n357 avss.n356 5.2005
R608 avss.n359 avss.n79 5.2005
R609 avss.n341 avss.n98 5.2005
R610 avss.n335 avss.n99 5.2005
R611 avss.n337 avss.n336 5.2005
R612 avss.n127 avss.n101 5.2005
R613 avss.n129 avss.n128 5.2005
R614 avss.n131 avss.n130 5.2005
R615 avss.n133 avss.n132 5.2005
R616 avss.n135 avss.n134 5.2005
R617 avss.n263 avss.n8 5.2005
R618 avss.n662 avss.n8 5.2005
R619 avss.n265 avss.n264 5.2005
R620 avss.n264 avss.n7 5.2005
R621 avss.n266 avss.n257 5.2005
R622 avss.n269 avss.n257 5.2005
R623 avss.n313 avss.n267 5.2005
R624 avss.n313 avss.n312 5.2005
R625 avss.n314 avss.n256 5.2005
R626 avss.n314 avss.n97 5.2005
R627 avss.n664 avss.n663 5.2005
R628 avss.n663 avss.n662 5.2005
R629 avss.n5 avss.n4 5.2005
R630 avss.n7 avss.n5 5.2005
R631 avss.n309 avss.n271 5.2005
R632 avss.n271 avss.n269 5.2005
R633 avss.n311 avss.n310 5.2005
R634 avss.n312 avss.n311 5.2005
R635 avss.n272 avss.n270 5.2005
R636 avss.n270 avss.n97 5.2005
R637 avss.n612 avss.n60 5.2005
R638 avss.n60 avss.n58 5.2005
R639 avss.n614 avss.n613 5.2005
R640 avss.n615 avss.n614 5.2005
R641 avss.n538 avss.n537 5.2005
R642 avss.n543 avss.n537 5.2005
R643 avss.n608 avss.n607 5.2005
R644 avss.n607 avss.n606 5.2005
R645 avss.n541 avss.n540 5.2005
R646 avss.n596 avss.n541 5.2005
R647 avss.n595 avss.n594 5.2005
R648 avss.n597 avss.n595 5.2005
R649 avss.n576 avss.n575 5.2005
R650 avss.n575 avss.n49 5.2005
R651 avss.n590 avss.n47 5.2005
R652 avss.n633 avss.n47 5.2005
R653 avss.n589 avss.n588 5.2005
R654 avss.n588 avss.n46 5.2005
R655 avss.n587 avss.n37 5.2005
R656 avss.n639 avss.n37 5.2005
R657 avss.n578 avss.n36 5.2005
R658 avss.n640 avss.n36 5.2005
R659 avss.n583 avss.n34 5.2005
R660 avss.n642 avss.n34 5.2005
R661 avss.n582 avss.n581 5.2005
R662 avss.n581 avss.n33 5.2005
R663 avss.n580 avss.n25 5.2005
R664 avss.n560 avss.n25 5.2005
R665 avss.n618 avss.n61 5.2005
R666 avss.n61 avss.n58 5.2005
R667 avss.n617 avss.n616 5.2005
R668 avss.n616 avss.n615 5.2005
R669 avss.n65 avss.n64 5.2005
R670 avss.n543 avss.n65 5.2005
R671 avss.n605 avss.n604 5.2005
R672 avss.n606 avss.n605 5.2005
R673 avss.n545 avss.n544 5.2005
R674 avss.n596 avss.n544 5.2005
R675 avss.n599 avss.n598 5.2005
R676 avss.n598 avss.n597 5.2005
R677 avss.n45 avss.n44 5.2005
R678 avss.n49 avss.n45 5.2005
R679 avss.n635 avss.n634 5.2005
R680 avss.n634 avss.n633 5.2005
R681 avss.n636 avss.n39 5.2005
R682 avss.n46 avss.n39 5.2005
R683 avss.n638 avss.n637 5.2005
R684 avss.n639 avss.n638 5.2005
R685 avss.n32 avss.n31 5.2005
R686 avss.n640 avss.n32 5.2005
R687 avss.n644 avss.n643 5.2005
R688 avss.n643 avss.n642 5.2005
R689 avss.n645 avss.n29 5.2005
R690 avss.n33 avss.n29 5.2005
R691 avss.n646 avss.n26 5.2005
R692 avss.n560 avss.n26 5.2005
R693 avss.n475 avss.n471 5.2005
R694 avss.n471 avss.n371 5.2005
R695 avss.n477 avss.n476 5.2005
R696 avss.n477 avss.n381 5.2005
R697 avss.n478 avss.n470 5.2005
R698 avss.n478 avss.n379 5.2005
R699 avss.n501 avss.n500 5.2005
R700 avss.n500 avss.n499 5.2005
R701 avss.n502 avss.n402 5.2005
R702 avss.n479 avss.n402 5.2005
R703 avss.n504 avss.n503 5.2005
R704 avss.n505 avss.n504 5.2005
R705 avss.n403 avss.n401 5.2005
R706 avss.n506 avss.n401 5.2005
R707 avss.n464 avss.n463 5.2005
R708 avss.n463 avss.n391 5.2005
R709 avss.n462 avss.n390 5.2005
R710 avss.n512 avss.n390 5.2005
R711 avss.n461 avss.n460 5.2005
R712 avss.n460 avss.n388 5.2005
R713 avss.n459 avss.n405 5.2005
R714 avss.n459 avss.n458 5.2005
R715 avss.n433 avss.n407 5.2005
R716 avss.n408 avss.n407 5.2005
R717 avss.n434 avss.n416 5.2005
R718 avss.n449 avss.n416 5.2005
R719 avss.n435 avss.n429 5.2005
R720 avss.n429 avss.n415 5.2005
R721 avss.n493 avss.n492 5.2005
R722 avss.n493 avss.n371 5.2005
R723 avss.n495 avss.n494 5.2005
R724 avss.n494 avss.n381 5.2005
R725 avss.n496 avss.n482 5.2005
R726 avss.n482 avss.n379 5.2005
R727 avss.n498 avss.n497 5.2005
R728 avss.n499 avss.n498 5.2005
R729 avss.n483 avss.n481 5.2005
R730 avss.n481 avss.n479 5.2005
R731 avss.n399 avss.n398 5.2005
R732 avss.n505 avss.n399 5.2005
R733 avss.n508 avss.n507 5.2005
R734 avss.n507 avss.n506 5.2005
R735 avss.n509 avss.n393 5.2005
R736 avss.n393 avss.n391 5.2005
R737 avss.n511 avss.n510 5.2005
R738 avss.n512 avss.n511 5.2005
R739 avss.n394 avss.n392 5.2005
R740 avss.n392 avss.n388 5.2005
R741 avss.n457 avss.n456 5.2005
R742 avss.n458 avss.n457 5.2005
R743 avss.n411 avss.n410 5.2005
R744 avss.n410 avss.n408 5.2005
R745 avss.n451 avss.n450 5.2005
R746 avss.n450 avss.n449 5.2005
R747 avss.n414 avss.n413 5.2005
R748 avss.n415 avss.n414 5.2005
R749 avss.n345 avss.n94 5.2005
R750 avss.n345 avss.n344 5.2005
R751 avss.n343 avss.n342 5.2005
R752 avss.n344 avss.n343 5.2005
R753 avss.n559 avss.n558 5.2005
R754 avss.n559 avss.n24 5.2005
R755 avss.n557 avss.n23 5.2005
R756 avss.n651 avss.n23 5.2005
R757 avss.n549 avss.n22 5.2005
R758 avss.n652 avss.n22 5.2005
R759 avss.n553 avss.n552 5.2005
R760 avss.n552 avss.n21 5.2005
R761 avss.n551 avss.n10 5.2005
R762 avss.n20 avss.n10 5.2005
R763 avss.n565 avss.n564 5.2005
R764 avss.n564 avss.n24 5.2005
R765 avss.n19 avss.n18 5.2005
R766 avss.n651 avss.n19 5.2005
R767 avss.n654 avss.n653 5.2005
R768 avss.n653 avss.n652 5.2005
R769 avss.n655 avss.n16 5.2005
R770 avss.n21 avss.n16 5.2005
R771 avss.n656 avss.n11 5.2005
R772 avss.n20 avss.n11 5.2005
R773 avss.n573 avss.n572 5.2005
R774 avss.n574 avss.n573 5.2005
R775 avss.n547 avss.n48 5.2005
R776 avss.n632 avss.n48 5.2005
R777 avss.n629 avss.n51 5.2005
R778 avss.n574 avss.n51 5.2005
R779 avss.n631 avss.n630 5.2005
R780 avss.n632 avss.n631 5.2005
R781 avss.n428 avss.n427 5.2005
R782 avss.n441 avss.n428 5.2005
R783 avss.n424 avss.n56 5.2005
R784 avss.n59 avss.n56 5.2005
R785 avss.n443 avss.n442 5.2005
R786 avss.n442 avss.n441 5.2005
R787 avss.n423 avss.n57 5.2005
R788 avss.n59 avss.n57 5.2005
R789 avss.n418 avss.n389 5.2005
R790 avss.n513 avss.n389 5.2005
R791 avss.n419 avss.n417 5.2005
R792 avss.n417 avss.n409 5.2005
R793 avss.n515 avss.n514 5.2005
R794 avss.n514 avss.n513 5.2005
R795 avss.n387 avss.n386 5.2005
R796 avss.n409 avss.n387 5.2005
R797 avss.n526 avss.n374 5.2005
R798 avss.n380 avss.n374 5.2005
R799 avss.n525 avss.n524 5.2005
R800 avss.n524 avss.n523 5.2005
R801 avss.n522 avss.n521 5.2005
R802 avss.n523 avss.n522 5.2005
R803 avss.n382 avss.n373 5.2005
R804 avss.n380 avss.n373 5.2005
R805 avss.n361 avss.n360 5.2005
R806 avss.n363 avss.n362 5.2005
R807 avss.n365 avss.n364 5.2005
R808 avss.n366 avss.n73 5.2005
R809 avss.n368 avss.n367 5.2005
R810 avss.n369 avss.n368 5.2005
R811 avss.n137 avss.n136 5.2005
R812 avss.n140 avss.n139 5.2005
R813 avss.n138 avss.n121 5.2005
R814 avss.n144 avss.n118 5.2005
R815 avss.n146 avss.n145 5.2005
R816 avss.n147 avss.n146 5.2005
R817 avss.n240 avss.n111 5.2005
R818 avss.n239 avss.n238 5.2005
R819 avss.n115 avss.n114 5.2005
R820 avss.n234 avss.n233 5.2005
R821 avss.n154 avss.n153 5.2005
R822 avss.n228 avss.n227 5.2005
R823 avss.n226 avss.n225 5.2005
R824 avss.n224 avss.n158 5.2005
R825 avss.n157 avss.n156 5.2005
R826 avss.n220 avss.n219 5.2005
R827 avss.n218 avss.n217 5.2005
R828 avss.n216 avss.n162 5.2005
R829 avss.n161 avss.n160 5.2005
R830 avss.n212 avss.n211 5.2005
R831 avss.n189 avss.n112 5.2005
R832 avss.n112 avss.n110 5.2005
R833 avss.n190 avss.n188 5.2005
R834 avss.n186 avss.n184 5.2005
R835 avss.n194 avss.n183 5.2005
R836 avss.n195 avss.n181 5.2005
R837 avss.n196 avss.n180 5.2005
R838 avss.n178 avss.n176 5.2005
R839 avss.n200 avss.n175 5.2005
R840 avss.n201 avss.n173 5.2005
R841 avss.n202 avss.n172 5.2005
R842 avss.n170 avss.n168 5.2005
R843 avss.n206 avss.n167 5.2005
R844 avss.n207 avss.n165 5.2005
R845 avss.n208 avss.n164 5.2005
R846 avss.n164 avss.n110 5.2005
R847 avss.n529 avss.n375 5.20011
R848 avss.n621 avss.n62 5.17941
R849 avss.n648 avss.n647 5.17941
R850 avss.n648 avss.n27 5.17941
R851 avss.n437 avss.n436 5.17941
R852 avss.n437 avss.n412 5.17941
R853 avss.n120 avss.n119 5.17941
R854 avss.n119 avss.n74 5.17941
R855 avss.n262 avss.n2 5.17941
R856 avss.n281 avss.n280 5.17941
R857 avss.n280 avss.n247 5.17941
R858 avss.n210 avss.n209 5.17941
R859 avss.n242 avss.n241 5.17941
R860 avss.n213 avss.n210 5.17159
R861 avss.n567 avss.n566 4.76902
R862 avss.n569 avss.n548 4.769
R863 avss.n627 avss.n53 4.75136
R864 avss.n517 avss.n377 4.75136
R865 avss.n421 avss.n420 4.75136
R866 avss.n519 avss.n383 4.75136
R867 avss.n445 avss.n385 4.75136
R868 avss.n571 avss.n54 4.75136
R869 avss.n570 avss.n569 4.75136
R870 avss.n567 avss.n52 4.75135
R871 avss.n445 avss.n444 4.75135
R872 avss.n520 avss.n519 4.75135
R873 avss.n517 avss.n516 4.75135
R874 avss.n426 avss.n421 4.75135
R875 avss.n425 avss.n54 4.75135
R876 avss.n628 avss.n627 4.75135
R877 avss.n528 avss.n527 4.7462
R878 avss.n658 avss.n14 4.73124
R879 avss.n93 avss.n12 4.73124
R880 avss.n550 avss.n12 4.73067
R881 avss.n658 avss.n657 4.73067
R882 avss.n620 avss.n619 4.7255
R883 avss.n474 avss.n376 4.7255
R884 avss.n491 avss.n490 4.7255
R885 avss.n666 avss.n665 4.7255
R886 avss.n185 avss.n0 4.7255
R887 avss.n645 avss.n28 4.5005
R888 avss.n644 avss.n30 4.5005
R889 avss.n40 avss.n31 4.5005
R890 avss.n637 avss.n41 4.5005
R891 avss.n636 avss.n42 4.5005
R892 avss.n635 avss.n43 4.5005
R893 avss.n546 avss.n44 4.5005
R894 avss.n600 avss.n599 4.5005
R895 avss.n601 avss.n545 4.5005
R896 avss.n604 avss.n603 4.5005
R897 avss.n602 avss.n64 4.5005
R898 avss.n617 avss.n63 4.5005
R899 avss.n619 avss.n618 4.5005
R900 avss.n647 avss.n646 4.5005
R901 avss.n582 avss.n579 4.5005
R902 avss.n584 avss.n583 4.5005
R903 avss.n585 avss.n578 4.5005
R904 avss.n587 avss.n586 4.5005
R905 avss.n589 avss.n577 4.5005
R906 avss.n591 avss.n590 4.5005
R907 avss.n592 avss.n576 4.5005
R908 avss.n594 avss.n593 4.5005
R909 avss.n540 avss.n539 4.5005
R910 avss.n609 avss.n608 4.5005
R911 avss.n610 avss.n538 4.5005
R912 avss.n613 avss.n611 4.5005
R913 avss.n612 avss.n62 4.5005
R914 avss.n580 avss.n27 4.5005
R915 avss.n655 avss.n15 4.5005
R916 avss.n654 avss.n17 4.5005
R917 avss.n563 avss.n18 4.5005
R918 avss.n566 avss.n565 4.5005
R919 avss.n657 avss.n656 4.5005
R920 avss.n444 avss.n443 4.5005
R921 avss.n423 avss.n53 4.5005
R922 avss.n527 avss.n526 4.5005
R923 avss.n525 avss.n377 4.5005
R924 avss.n434 avss.n430 4.5005
R925 avss.n433 avss.n432 4.5005
R926 avss.n431 avss.n405 4.5005
R927 avss.n461 avss.n406 4.5005
R928 avss.n462 avss.n404 4.5005
R929 avss.n465 avss.n464 4.5005
R930 avss.n466 avss.n403 4.5005
R931 avss.n503 avss.n467 4.5005
R932 avss.n502 avss.n468 4.5005
R933 avss.n501 avss.n469 4.5005
R934 avss.n472 avss.n470 4.5005
R935 avss.n476 avss.n473 4.5005
R936 avss.n475 avss.n474 4.5005
R937 avss.n436 avss.n435 4.5005
R938 avss.n452 avss.n451 4.5005
R939 avss.n453 avss.n411 4.5005
R940 avss.n456 avss.n455 4.5005
R941 avss.n454 avss.n394 4.5005
R942 avss.n510 avss.n395 4.5005
R943 avss.n509 avss.n396 4.5005
R944 avss.n508 avss.n397 4.5005
R945 avss.n484 avss.n398 4.5005
R946 avss.n485 avss.n483 4.5005
R947 avss.n497 avss.n486 4.5005
R948 avss.n496 avss.n487 4.5005
R949 avss.n495 avss.n488 4.5005
R950 avss.n492 avss.n491 4.5005
R951 avss.n413 avss.n412 4.5005
R952 avss.n521 avss.n520 4.5005
R953 avss.n382 avss.n375 4.5005
R954 avss.n418 avss.n383 4.5005
R955 avss.n420 avss.n419 4.5005
R956 avss.n516 avss.n515 4.5005
R957 avss.n386 avss.n385 4.5005
R958 avss.n427 avss.n426 4.5005
R959 avss.n425 avss.n424 4.5005
R960 avss.n572 avss.n571 4.5005
R961 avss.n570 avss.n547 4.5005
R962 avss.n629 avss.n628 4.5005
R963 avss.n630 avss.n52 4.5005
R964 avss.n554 avss.n553 4.5005
R965 avss.n555 avss.n549 4.5005
R966 avss.n557 avss.n556 4.5005
R967 avss.n558 avss.n548 4.5005
R968 avss.n551 avss.n550 4.5005
R969 avss.n144 avss.n143 4.5005
R970 avss.n142 avss.n121 4.5005
R971 avss.n141 avss.n140 4.5005
R972 avss.n137 avss.n122 4.5005
R973 avss.n134 avss.n123 4.5005
R974 avss.n133 avss.n124 4.5005
R975 avss.n130 avss.n125 4.5005
R976 avss.n129 avss.n126 4.5005
R977 avss.n101 avss.n100 4.5005
R978 avss.n338 avss.n337 4.5005
R979 avss.n339 avss.n99 4.5005
R980 avss.n341 avss.n340 4.5005
R981 avss.n342 avss.n14 4.5005
R982 avss.n145 avss.n120 4.5005
R983 avss.n366 avss.n75 4.5005
R984 avss.n365 avss.n76 4.5005
R985 avss.n362 avss.n77 4.5005
R986 avss.n361 avss.n78 4.5005
R987 avss.n82 avss.n79 4.5005
R988 avss.n356 avss.n83 4.5005
R989 avss.n355 avss.n84 4.5005
R990 avss.n354 avss.n85 4.5005
R991 avss.n89 avss.n86 4.5005
R992 avss.n349 avss.n90 4.5005
R993 avss.n348 avss.n91 4.5005
R994 avss.n347 avss.n92 4.5005
R995 avss.n94 avss.n93 4.5005
R996 avss.n367 avss.n74 4.5005
R997 avss.n298 avss.n297 4.5005
R998 avss.n296 avss.n282 4.5005
R999 avss.n295 avss.n294 4.5005
R1000 avss.n291 avss.n283 4.5005
R1001 avss.n288 avss.n284 4.5005
R1002 avss.n287 avss.n285 4.5005
R1003 avss.n274 avss.n273 4.5005
R1004 avss.n305 avss.n304 4.5005
R1005 avss.n306 avss.n272 4.5005
R1006 avss.n310 avss.n307 4.5005
R1007 avss.n309 avss.n308 4.5005
R1008 avss.n4 avss.n3 4.5005
R1009 avss.n665 avss.n664 4.5005
R1010 avss.n299 avss.n281 4.5005
R1011 avss.n329 avss.n248 4.5005
R1012 avss.n328 avss.n249 4.5005
R1013 avss.n325 avss.n250 4.5005
R1014 avss.n324 avss.n251 4.5005
R1015 avss.n321 avss.n252 4.5005
R1016 avss.n320 avss.n253 4.5005
R1017 avss.n317 avss.n254 4.5005
R1018 avss.n316 avss.n255 4.5005
R1019 avss.n258 avss.n256 4.5005
R1020 avss.n267 avss.n259 4.5005
R1021 avss.n266 avss.n260 4.5005
R1022 avss.n265 avss.n261 4.5005
R1023 avss.n263 avss.n262 4.5005
R1024 avss.n330 avss.n247 4.5005
R1025 avss.n207 avss.n163 4.5005
R1026 avss.n206 avss.n205 4.5005
R1027 avss.n204 avss.n168 4.5005
R1028 avss.n203 avss.n202 4.5005
R1029 avss.n201 avss.n169 4.5005
R1030 avss.n200 avss.n199 4.5005
R1031 avss.n198 avss.n176 4.5005
R1032 avss.n197 avss.n196 4.5005
R1033 avss.n195 avss.n177 4.5005
R1034 avss.n194 avss.n193 4.5005
R1035 avss.n192 avss.n184 4.5005
R1036 avss.n191 avss.n190 4.5005
R1037 avss.n189 avss.n185 4.5005
R1038 avss.n209 avss.n208 4.5005
R1039 avss.n214 avss.n160 4.5005
R1040 avss.n216 avss.n215 4.5005
R1041 avss.n217 avss.n159 4.5005
R1042 avss.n221 avss.n220 4.5005
R1043 avss.n222 avss.n156 4.5005
R1044 avss.n224 avss.n223 4.5005
R1045 avss.n225 avss.n155 4.5005
R1046 avss.n229 avss.n228 4.5005
R1047 avss.n230 avss.n154 4.5005
R1048 avss.n233 avss.n232 4.5005
R1049 avss.n231 avss.n114 4.5005
R1050 avss.n239 avss.n113 4.5005
R1051 avss.n241 avss.n240 4.5005
R1052 avss.n213 avss.n212 4.5005
R1053 avss.n138 avss.n117 3.11744
R1054 avss.n136 avss.n116 3.11744
R1055 avss.n132 avss.n103 3.11744
R1056 avss.n128 avss.n104 3.11744
R1057 avss.n336 avss.n102 3.11744
R1058 avss.n334 avss.n98 3.11744
R1059 avss.n364 avss.n71 3.11744
R1060 avss.n360 avss.n70 3.11744
R1061 avss.n358 avss.n357 3.11744
R1062 avss.n353 avss.n87 3.11744
R1063 avss.n351 avss.n350 3.11744
R1064 avss.n346 avss.n95 3.11744
R1065 avss.n292 avss.n278 3.11744
R1066 avss.n290 avss.n277 3.11744
R1067 avss.n286 avss.n276 3.11744
R1068 avss.n303 avss.n302 3.11744
R1069 avss.n327 avss.n108 3.11744
R1070 avss.n323 avss.n107 3.11744
R1071 avss.n319 avss.n106 3.11744
R1072 avss.n315 avss.n105 3.11744
R1073 avss.n318 avss.n105 3.11744
R1074 avss.n322 avss.n106 3.11744
R1075 avss.n326 avss.n107 3.11744
R1076 avss.n246 avss.n108 3.11744
R1077 avss.n302 avss.n275 3.11744
R1078 avss.n289 avss.n276 3.11744
R1079 avss.n293 avss.n277 3.11744
R1080 avss.n279 avss.n278 3.11744
R1081 avss.n95 avss.n88 3.11744
R1082 avss.n352 avss.n351 3.11744
R1083 avss.n87 avss.n81 3.11744
R1084 avss.n359 avss.n358 3.11744
R1085 avss.n335 avss.n334 3.11744
R1086 avss.n127 avss.n102 3.11744
R1087 avss.n131 avss.n104 3.11744
R1088 avss.n135 avss.n103 3.11744
R1089 avss.n363 avss.n70 3.11744
R1090 avss.n73 avss.n71 3.11744
R1091 avss.n139 avss.n116 3.11744
R1092 avss.n118 avss.n117 3.11744
R1093 avss.n211 avss.n148 3.11744
R1094 avss.n162 avss.n149 3.11744
R1095 avss.n219 avss.n150 3.11744
R1096 avss.n158 avss.n151 3.11744
R1097 avss.n227 avss.n152 3.11744
R1098 avss.n235 avss.n234 3.11744
R1099 avss.n238 avss.n237 3.11744
R1100 avss.n237 avss.n111 3.11744
R1101 avss.n235 avss.n115 3.11744
R1102 avss.n153 avss.n152 3.11744
R1103 avss.n226 avss.n151 3.11744
R1104 avss.n157 avss.n150 3.11744
R1105 avss.n218 avss.n149 3.11744
R1106 avss.n161 avss.n148 3.11744
R1107 avss.n167 avss.n166 3.11744
R1108 avss.n172 avss.n171 3.11744
R1109 avss.n175 avss.n174 3.11744
R1110 avss.n180 avss.n179 3.11744
R1111 avss.n183 avss.n182 3.11744
R1112 avss.n188 avss.n187 3.11744
R1113 avss.n187 avss.n186 3.11744
R1114 avss.n182 avss.n181 3.11744
R1115 avss.n179 avss.n178 3.11744
R1116 avss.n174 avss.n173 3.11744
R1117 avss.n171 avss.n170 3.11744
R1118 avss.n166 avss.n165 3.11744
R1119 avss.n667 avss.n1 2.9093
R1120 avss.n668 avss.n667 1.4297
R1121 avss.n332 avss.n105 1.04278
R1122 avss.n332 avss.n106 1.04278
R1123 avss.n332 avss.n107 1.04278
R1124 avss.n332 avss.n108 1.04278
R1125 avss.n302 avss.n301 1.04278
R1126 avss.n301 avss.n276 1.04278
R1127 avss.n301 avss.n277 1.04278
R1128 avss.n301 avss.n278 1.04278
R1129 avss.n95 avss.n80 1.04278
R1130 avss.n351 avss.n80 1.04278
R1131 avss.n87 avss.n80 1.04278
R1132 avss.n358 avss.n80 1.04278
R1133 avss.n334 avss.n333 1.04278
R1134 avss.n333 avss.n102 1.04278
R1135 avss.n333 avss.n104 1.04278
R1136 avss.n333 avss.n103 1.04278
R1137 avss.n369 avss.n70 1.04278
R1138 avss.n369 avss.n71 1.04278
R1139 avss.n147 avss.n116 1.04278
R1140 avss.n147 avss.n117 1.04278
R1141 avss.n237 avss.n236 1.04278
R1142 avss.n236 avss.n235 1.04278
R1143 avss.n236 avss.n152 1.04278
R1144 avss.n236 avss.n151 1.04278
R1145 avss.n236 avss.n150 1.04278
R1146 avss.n236 avss.n149 1.04278
R1147 avss.n236 avss.n148 1.04278
R1148 avss.n187 avss.n110 1.04278
R1149 avss.n182 avss.n110 1.04278
R1150 avss.n179 avss.n110 1.04278
R1151 avss.n174 avss.n110 1.04278
R1152 avss.n171 avss.n110 1.04278
R1153 avss.n166 avss.n110 1.04278
R1154 avss.n6 avss.n2 0.743357
R1155 avss.n9 avss.n6 0.743357
R1156 avss.n649 avss.n648 0.743357
R1157 avss.n650 avss.n649 0.743357
R1158 avss.n622 avss.n621 0.743357
R1159 avss.n623 avss.n622 0.743357
R1160 avss.n438 avss.n437 0.743357
R1161 avss.n439 avss.n438 0.743357
R1162 avss.n489 avss.n372 0.743357
R1163 avss.n531 avss.n372 0.743357
R1164 avss.n659 avss.n13 0.743357
R1165 avss.n268 avss.n13 0.743357
R1166 avss.n660 avss.n659 0.743357
R1167 avss.n661 avss.n660 0.743357
R1168 avss.n568 avss.n562 0.743357
R1169 avss.n562 avss.n561 0.743357
R1170 avss.n568 avss.n50 0.743357
R1171 avss.n50 avss.n38 0.743357
R1172 avss.n626 avss.n55 0.743357
R1173 avss.n542 avss.n55 0.743357
R1174 avss.n626 avss.n625 0.743357
R1175 avss.n625 avss.n624 0.743357
R1176 avss.n446 avss.n422 0.743357
R1177 avss.n440 avss.n422 0.743357
R1178 avss.n447 avss.n446 0.743357
R1179 avss.n448 avss.n447 0.743357
R1180 avss.n518 avss.n384 0.743357
R1181 avss.n400 avss.n384 0.743357
R1182 avss.n518 avss.n378 0.743357
R1183 avss.n480 avss.n378 0.743357
R1184 avss.n530 avss.n529 0.743357
R1185 avss.n531 avss.n530 0.743357
R1186 avss.n280 avss.n245 0.743357
R1187 avss.n245 avss.n244 0.743357
R1188 avss.n119 avss.n72 0.743357
R1189 avss.n72 avss.n69 0.743357
R1190 avss.n210 avss.n109 0.743357
R1191 avss.n244 avss.n109 0.743357
R1192 avss.n243 avss.n242 0.743357
R1193 avss.n244 avss.n243 0.743357
R1194 avss.n528 avss.n376 0.622674
R1195 avss.n621 avss.n620 0.454413
R1196 avss.n490 avss.n489 0.454413
R1197 avss.n489 avss.n376 0.454413
R1198 avss.n529 avss.n528 0.454413
R1199 avss.n666 avss.n2 0.454413
R1200 avss.n242 avss.n0 0.454413
R1201 avss.n646 avss.n645 0.1445
R1202 avss.n645 avss.n644 0.1445
R1203 avss.n644 avss.n31 0.1445
R1204 avss.n637 avss.n31 0.1445
R1205 avss.n637 avss.n636 0.1445
R1206 avss.n636 avss.n635 0.1445
R1207 avss.n635 avss.n44 0.1445
R1208 avss.n599 avss.n44 0.1445
R1209 avss.n599 avss.n545 0.1445
R1210 avss.n604 avss.n545 0.1445
R1211 avss.n604 avss.n64 0.1445
R1212 avss.n617 avss.n64 0.1445
R1213 avss.n618 avss.n617 0.1445
R1214 avss.n647 avss.n28 0.1445
R1215 avss.n30 avss.n28 0.1445
R1216 avss.n40 avss.n30 0.1445
R1217 avss.n41 avss.n40 0.1445
R1218 avss.n42 avss.n41 0.1445
R1219 avss.n43 avss.n42 0.1445
R1220 avss.n546 avss.n43 0.1445
R1221 avss.n600 avss.n546 0.1445
R1222 avss.n601 avss.n600 0.1445
R1223 avss.n603 avss.n601 0.1445
R1224 avss.n603 avss.n602 0.1445
R1225 avss.n602 avss.n63 0.1445
R1226 avss.n619 avss.n63 0.1445
R1227 avss.n579 avss.n27 0.1445
R1228 avss.n584 avss.n579 0.1445
R1229 avss.n585 avss.n584 0.1445
R1230 avss.n586 avss.n585 0.1445
R1231 avss.n586 avss.n577 0.1445
R1232 avss.n591 avss.n577 0.1445
R1233 avss.n592 avss.n591 0.1445
R1234 avss.n593 avss.n592 0.1445
R1235 avss.n593 avss.n539 0.1445
R1236 avss.n609 avss.n539 0.1445
R1237 avss.n610 avss.n609 0.1445
R1238 avss.n611 avss.n610 0.1445
R1239 avss.n611 avss.n62 0.1445
R1240 avss.n582 avss.n580 0.1445
R1241 avss.n583 avss.n582 0.1445
R1242 avss.n583 avss.n578 0.1445
R1243 avss.n587 avss.n578 0.1445
R1244 avss.n589 avss.n587 0.1445
R1245 avss.n590 avss.n589 0.1445
R1246 avss.n590 avss.n576 0.1445
R1247 avss.n594 avss.n576 0.1445
R1248 avss.n594 avss.n540 0.1445
R1249 avss.n608 avss.n540 0.1445
R1250 avss.n608 avss.n538 0.1445
R1251 avss.n613 avss.n538 0.1445
R1252 avss.n613 avss.n612 0.1445
R1253 avss.n145 avss.n144 0.1445
R1254 avss.n144 avss.n121 0.1445
R1255 avss.n140 avss.n121 0.1445
R1256 avss.n140 avss.n137 0.1445
R1257 avss.n137 avss.n134 0.1445
R1258 avss.n134 avss.n133 0.1445
R1259 avss.n133 avss.n130 0.1445
R1260 avss.n130 avss.n129 0.1445
R1261 avss.n129 avss.n101 0.1445
R1262 avss.n337 avss.n101 0.1445
R1263 avss.n337 avss.n99 0.1445
R1264 avss.n341 avss.n99 0.1445
R1265 avss.n342 avss.n341 0.1445
R1266 avss.n553 avss.n551 0.1445
R1267 avss.n553 avss.n549 0.1445
R1268 avss.n557 avss.n549 0.1445
R1269 avss.n558 avss.n557 0.1445
R1270 avss.n656 avss.n655 0.1445
R1271 avss.n655 avss.n654 0.1445
R1272 avss.n654 avss.n18 0.1445
R1273 avss.n565 avss.n18 0.1445
R1274 avss.n657 avss.n15 0.1445
R1275 avss.n17 avss.n15 0.1445
R1276 avss.n563 avss.n17 0.1445
R1277 avss.n566 avss.n563 0.1445
R1278 avss.n630 avss.n629 0.1445
R1279 avss.n427 avss.n424 0.1445
R1280 avss.n443 avss.n423 0.1445
R1281 avss.n444 avss.n53 0.1445
R1282 avss.n515 avss.n386 0.1445
R1283 avss.n521 avss.n382 0.1445
R1284 avss.n526 avss.n525 0.1445
R1285 avss.n527 avss.n377 0.1445
R1286 avss.n451 avss.n413 0.1445
R1287 avss.n451 avss.n411 0.1445
R1288 avss.n456 avss.n411 0.1445
R1289 avss.n456 avss.n394 0.1445
R1290 avss.n510 avss.n394 0.1445
R1291 avss.n510 avss.n509 0.1445
R1292 avss.n509 avss.n508 0.1445
R1293 avss.n508 avss.n398 0.1445
R1294 avss.n483 avss.n398 0.1445
R1295 avss.n497 avss.n483 0.1445
R1296 avss.n497 avss.n496 0.1445
R1297 avss.n496 avss.n495 0.1445
R1298 avss.n495 avss.n492 0.1445
R1299 avss.n435 avss.n434 0.1445
R1300 avss.n434 avss.n433 0.1445
R1301 avss.n433 avss.n405 0.1445
R1302 avss.n461 avss.n405 0.1445
R1303 avss.n462 avss.n461 0.1445
R1304 avss.n464 avss.n462 0.1445
R1305 avss.n464 avss.n403 0.1445
R1306 avss.n503 avss.n403 0.1445
R1307 avss.n503 avss.n502 0.1445
R1308 avss.n502 avss.n501 0.1445
R1309 avss.n501 avss.n470 0.1445
R1310 avss.n476 avss.n470 0.1445
R1311 avss.n476 avss.n475 0.1445
R1312 avss.n436 avss.n430 0.1445
R1313 avss.n432 avss.n430 0.1445
R1314 avss.n432 avss.n431 0.1445
R1315 avss.n431 avss.n406 0.1445
R1316 avss.n406 avss.n404 0.1445
R1317 avss.n465 avss.n404 0.1445
R1318 avss.n466 avss.n465 0.1445
R1319 avss.n467 avss.n466 0.1445
R1320 avss.n468 avss.n467 0.1445
R1321 avss.n469 avss.n468 0.1445
R1322 avss.n472 avss.n469 0.1445
R1323 avss.n473 avss.n472 0.1445
R1324 avss.n474 avss.n473 0.1445
R1325 avss.n452 avss.n412 0.1445
R1326 avss.n453 avss.n452 0.1445
R1327 avss.n455 avss.n453 0.1445
R1328 avss.n455 avss.n454 0.1445
R1329 avss.n454 avss.n395 0.1445
R1330 avss.n396 avss.n395 0.1445
R1331 avss.n397 avss.n396 0.1445
R1332 avss.n484 avss.n397 0.1445
R1333 avss.n485 avss.n484 0.1445
R1334 avss.n486 avss.n485 0.1445
R1335 avss.n487 avss.n486 0.1445
R1336 avss.n488 avss.n487 0.1445
R1337 avss.n491 avss.n488 0.1445
R1338 avss.n520 avss.n375 0.1445
R1339 avss.n419 avss.n418 0.1445
R1340 avss.n420 avss.n383 0.1445
R1341 avss.n516 avss.n385 0.1445
R1342 avss.n426 avss.n425 0.1445
R1343 avss.n572 avss.n547 0.1445
R1344 avss.n571 avss.n570 0.1445
R1345 avss.n628 avss.n52 0.1445
R1346 avss.n554 avss.n550 0.1445
R1347 avss.n555 avss.n554 0.1445
R1348 avss.n556 avss.n555 0.1445
R1349 avss.n556 avss.n548 0.1445
R1350 avss.n143 avss.n120 0.1445
R1351 avss.n143 avss.n142 0.1445
R1352 avss.n142 avss.n141 0.1445
R1353 avss.n141 avss.n122 0.1445
R1354 avss.n123 avss.n122 0.1445
R1355 avss.n124 avss.n123 0.1445
R1356 avss.n125 avss.n124 0.1445
R1357 avss.n126 avss.n125 0.1445
R1358 avss.n126 avss.n100 0.1445
R1359 avss.n338 avss.n100 0.1445
R1360 avss.n339 avss.n338 0.1445
R1361 avss.n340 avss.n339 0.1445
R1362 avss.n340 avss.n14 0.1445
R1363 avss.n75 avss.n74 0.1445
R1364 avss.n76 avss.n75 0.1445
R1365 avss.n77 avss.n76 0.1445
R1366 avss.n78 avss.n77 0.1445
R1367 avss.n82 avss.n78 0.1445
R1368 avss.n83 avss.n82 0.1445
R1369 avss.n84 avss.n83 0.1445
R1370 avss.n85 avss.n84 0.1445
R1371 avss.n89 avss.n85 0.1445
R1372 avss.n90 avss.n89 0.1445
R1373 avss.n91 avss.n90 0.1445
R1374 avss.n92 avss.n91 0.1445
R1375 avss.n93 avss.n92 0.1445
R1376 avss.n367 avss.n366 0.1445
R1377 avss.n366 avss.n365 0.1445
R1378 avss.n365 avss.n362 0.1445
R1379 avss.n362 avss.n361 0.1445
R1380 avss.n361 avss.n79 0.1445
R1381 avss.n356 avss.n79 0.1445
R1382 avss.n356 avss.n355 0.1445
R1383 avss.n355 avss.n354 0.1445
R1384 avss.n354 avss.n86 0.1445
R1385 avss.n349 avss.n86 0.1445
R1386 avss.n349 avss.n348 0.1445
R1387 avss.n348 avss.n347 0.1445
R1388 avss.n347 avss.n94 0.1445
R1389 avss.n299 avss.n298 0.1445
R1390 avss.n298 avss.n282 0.1445
R1391 avss.n294 avss.n282 0.1445
R1392 avss.n294 avss.n291 0.1445
R1393 avss.n291 avss.n288 0.1445
R1394 avss.n288 avss.n287 0.1445
R1395 avss.n287 avss.n274 0.1445
R1396 avss.n304 avss.n274 0.1445
R1397 avss.n304 avss.n272 0.1445
R1398 avss.n310 avss.n272 0.1445
R1399 avss.n310 avss.n309 0.1445
R1400 avss.n309 avss.n4 0.1445
R1401 avss.n664 avss.n4 0.1445
R1402 avss.n297 avss.n281 0.1445
R1403 avss.n297 avss.n296 0.1445
R1404 avss.n296 avss.n295 0.1445
R1405 avss.n295 avss.n283 0.1445
R1406 avss.n284 avss.n283 0.1445
R1407 avss.n285 avss.n284 0.1445
R1408 avss.n285 avss.n273 0.1445
R1409 avss.n305 avss.n273 0.1445
R1410 avss.n306 avss.n305 0.1445
R1411 avss.n307 avss.n306 0.1445
R1412 avss.n308 avss.n307 0.1445
R1413 avss.n308 avss.n3 0.1445
R1414 avss.n665 avss.n3 0.1445
R1415 avss.n248 avss.n247 0.1445
R1416 avss.n249 avss.n248 0.1445
R1417 avss.n250 avss.n249 0.1445
R1418 avss.n251 avss.n250 0.1445
R1419 avss.n252 avss.n251 0.1445
R1420 avss.n253 avss.n252 0.1445
R1421 avss.n254 avss.n253 0.1445
R1422 avss.n255 avss.n254 0.1445
R1423 avss.n258 avss.n255 0.1445
R1424 avss.n259 avss.n258 0.1445
R1425 avss.n260 avss.n259 0.1445
R1426 avss.n261 avss.n260 0.1445
R1427 avss.n262 avss.n261 0.1445
R1428 avss.n330 avss.n329 0.1445
R1429 avss.n329 avss.n328 0.1445
R1430 avss.n328 avss.n325 0.1445
R1431 avss.n325 avss.n324 0.1445
R1432 avss.n324 avss.n321 0.1445
R1433 avss.n321 avss.n320 0.1445
R1434 avss.n320 avss.n317 0.1445
R1435 avss.n317 avss.n316 0.1445
R1436 avss.n316 avss.n256 0.1445
R1437 avss.n267 avss.n256 0.1445
R1438 avss.n267 avss.n266 0.1445
R1439 avss.n266 avss.n265 0.1445
R1440 avss.n265 avss.n263 0.1445
R1441 avss.n212 avss.n160 0.1445
R1442 avss.n216 avss.n160 0.1445
R1443 avss.n217 avss.n216 0.1445
R1444 avss.n220 avss.n217 0.1445
R1445 avss.n220 avss.n156 0.1445
R1446 avss.n224 avss.n156 0.1445
R1447 avss.n225 avss.n224 0.1445
R1448 avss.n228 avss.n225 0.1445
R1449 avss.n228 avss.n154 0.1445
R1450 avss.n233 avss.n154 0.1445
R1451 avss.n233 avss.n114 0.1445
R1452 avss.n239 avss.n114 0.1445
R1453 avss.n240 avss.n239 0.1445
R1454 avss.n208 avss.n207 0.1445
R1455 avss.n207 avss.n206 0.1445
R1456 avss.n206 avss.n168 0.1445
R1457 avss.n202 avss.n168 0.1445
R1458 avss.n202 avss.n201 0.1445
R1459 avss.n201 avss.n200 0.1445
R1460 avss.n200 avss.n176 0.1445
R1461 avss.n196 avss.n176 0.1445
R1462 avss.n196 avss.n195 0.1445
R1463 avss.n195 avss.n194 0.1445
R1464 avss.n194 avss.n184 0.1445
R1465 avss.n190 avss.n184 0.1445
R1466 avss.n190 avss.n189 0.1445
R1467 avss.n209 avss.n163 0.1445
R1468 avss.n205 avss.n163 0.1445
R1469 avss.n205 avss.n204 0.1445
R1470 avss.n204 avss.n203 0.1445
R1471 avss.n203 avss.n169 0.1445
R1472 avss.n199 avss.n169 0.1445
R1473 avss.n199 avss.n198 0.1445
R1474 avss.n198 avss.n197 0.1445
R1475 avss.n197 avss.n177 0.1445
R1476 avss.n193 avss.n177 0.1445
R1477 avss.n193 avss.n192 0.1445
R1478 avss.n192 avss.n191 0.1445
R1479 avss.n191 avss.n185 0.1445
R1480 avss.n214 avss.n213 0.1445
R1481 avss.n215 avss.n214 0.1445
R1482 avss.n215 avss.n159 0.1445
R1483 avss.n221 avss.n159 0.1445
R1484 avss.n222 avss.n221 0.1445
R1485 avss.n223 avss.n222 0.1445
R1486 avss.n223 avss.n155 0.1445
R1487 avss.n229 avss.n155 0.1445
R1488 avss.n230 avss.n229 0.1445
R1489 avss.n232 avss.n230 0.1445
R1490 avss.n232 avss.n231 0.1445
R1491 avss.n231 avss.n113 0.1445
R1492 avss.n241 avss.n113 0.1445
R1493 avss.n659 avss.n658 0.0556412
R1494 avss.n659 avss.n12 0.0556393
R1495 avss.n627 avss.n626 0.0543057
R1496 avss.n446 avss.n421 0.0543057
R1497 avss.n518 avss.n517 0.0543057
R1498 avss.n519 avss.n518 0.0543057
R1499 avss.n446 avss.n445 0.0543057
R1500 avss.n626 avss.n54 0.0543057
R1501 avss.n568 avss.n567 0.0543036
R1502 avss.n569 avss.n568 0.0542944
R1503 avdd.n357 avdd.n356 1078.83
R1504 avdd.n356 avdd.n355 1078.83
R1505 avdd.n207 avdd.n176 522.652
R1506 avdd.n181 avdd.n176 522.652
R1507 avdd.n199 avdd.n188 522.652
R1508 avdd.n191 avdd.n188 522.652
R1509 avdd.n246 avdd.n245 522.652
R1510 avdd.n246 avdd.n233 522.652
R1511 avdd.n256 avdd.n255 522.652
R1512 avdd.n255 avdd.n226 522.652
R1513 avdd.n358 avdd.n324 144.812
R1514 avdd.n354 avdd.n324 144.812
R1515 avdd.n333 avdd.n327 144.812
R1516 avdd.n335 avdd.n327 144.812
R1517 avdd.n103 avdd.n93 142.857
R1518 avdd.n103 avdd.n87 142.857
R1519 avdd.n111 avdd.n87 142.857
R1520 avdd.n111 avdd.n81 142.857
R1521 avdd.n119 avdd.n81 142.857
R1522 avdd.n119 avdd.n75 142.857
R1523 avdd.n127 avdd.n75 142.857
R1524 avdd.n127 avdd.n69 142.857
R1525 avdd.n135 avdd.n69 142.857
R1526 avdd.n135 avdd.n63 142.857
R1527 avdd.n143 avdd.n63 142.857
R1528 avdd.n143 avdd.n57 142.857
R1529 avdd.n151 avdd.n57 142.857
R1530 avdd.n151 avdd.n51 142.857
R1531 avdd.n159 avdd.n51 142.857
R1532 avdd.n159 avdd.n45 142.857
R1533 avdd.n167 avdd.n45 142.857
R1534 avdd.n167 avdd.n39 142.857
R1535 avdd.n216 avdd.n39 142.857
R1536 avdd.n288 avdd.n280 142.857
R1537 avdd.n297 avdd.n280 142.857
R1538 avdd.n297 avdd.n274 142.857
R1539 avdd.n305 avdd.n274 142.857
R1540 avdd.n305 avdd.n268 142.857
R1541 avdd.n313 avdd.n268 142.857
R1542 avdd.n208 avdd.n175 62.038
R1543 avdd.n182 avdd.n175 62.038
R1544 avdd.n205 avdd.n177 62.038
R1545 avdd.n206 avdd.n205 62.038
R1546 avdd.n197 avdd.n189 62.038
R1547 avdd.n198 avdd.n197 62.038
R1548 avdd.n192 avdd.n179 62.038
R1549 avdd.n200 avdd.n179 62.038
R1550 avdd.n247 avdd.n231 62.038
R1551 avdd.n247 avdd.n232 62.038
R1552 avdd.n238 avdd.n234 62.038
R1553 avdd.n244 avdd.n234 62.038
R1554 avdd.n257 avdd.n225 62.038
R1555 avdd.n227 avdd.n225 62.038
R1556 avdd.n254 avdd.n253 62.038
R1557 avdd.n254 avdd.n224 62.038
R1558 avdd.n215 avdd.n38 61.7755
R1559 avdd.n97 avdd.n94 61.7755
R1560 avdd.n312 avdd.n267 61.7755
R1561 avdd.n287 avdd.n284 61.7755
R1562 avdd.n217 avdd.n38 48.3669
R1563 avdd.n97 avdd.n96 48.3669
R1564 avdd.n314 avdd.n267 48.3669
R1565 avdd.n289 avdd.n284 48.3669
R1566 avdd.n104 avdd.n92 14.0005
R1567 avdd.n104 avdd.n88 14.0005
R1568 avdd.n110 avdd.n88 14.0005
R1569 avdd.n110 avdd.n80 14.0005
R1570 avdd.n120 avdd.n80 14.0005
R1571 avdd.n120 avdd.n76 14.0005
R1572 avdd.n126 avdd.n76 14.0005
R1573 avdd.n126 avdd.n68 14.0005
R1574 avdd.n136 avdd.n68 14.0005
R1575 avdd.n136 avdd.n64 14.0005
R1576 avdd.n142 avdd.n64 14.0005
R1577 avdd.n142 avdd.n56 14.0005
R1578 avdd.n152 avdd.n56 14.0005
R1579 avdd.n152 avdd.n52 14.0005
R1580 avdd.n158 avdd.n52 14.0005
R1581 avdd.n158 avdd.n44 14.0005
R1582 avdd.n168 avdd.n44 14.0005
R1583 avdd.n168 avdd.n40 14.0005
R1584 avdd.n215 avdd.n40 14.0005
R1585 avdd.n102 avdd.n94 14.0005
R1586 avdd.n102 avdd.n86 14.0005
R1587 avdd.n112 avdd.n86 14.0005
R1588 avdd.n112 avdd.n82 14.0005
R1589 avdd.n118 avdd.n82 14.0005
R1590 avdd.n118 avdd.n74 14.0005
R1591 avdd.n128 avdd.n74 14.0005
R1592 avdd.n128 avdd.n70 14.0005
R1593 avdd.n134 avdd.n70 14.0005
R1594 avdd.n134 avdd.n62 14.0005
R1595 avdd.n144 avdd.n62 14.0005
R1596 avdd.n144 avdd.n58 14.0005
R1597 avdd.n150 avdd.n58 14.0005
R1598 avdd.n150 avdd.n50 14.0005
R1599 avdd.n160 avdd.n50 14.0005
R1600 avdd.n160 avdd.n46 14.0005
R1601 avdd.n166 avdd.n46 14.0005
R1602 avdd.n166 avdd.n37 14.0005
R1603 avdd.n218 avdd.n37 14.0005
R1604 avdd.n290 avdd.n281 14.0005
R1605 avdd.n296 avdd.n281 14.0005
R1606 avdd.n296 avdd.n273 14.0005
R1607 avdd.n306 avdd.n273 14.0005
R1608 avdd.n306 avdd.n269 14.0005
R1609 avdd.n312 avdd.n269 14.0005
R1610 avdd.n287 avdd.n279 14.0005
R1611 avdd.n298 avdd.n279 14.0005
R1612 avdd.n298 avdd.n275 14.0005
R1613 avdd.n304 avdd.n275 14.0005
R1614 avdd.n304 avdd.n266 14.0005
R1615 avdd.n315 avdd.n266 14.0005
R1616 avdd.n348 avdd.n347 14.0005
R1617 avdd.n354 avdd.n330 14.0005
R1618 avdd.n337 avdd.n336 14.0005
R1619 avdd.n358 avdd.n323 14.0005
R1620 avdd.n262 avdd.n221 10.3984
R1621 avdd.n262 avdd.n261 7.63485
R1622 avdd.n319 avdd.n318 7.63485
R1623 avdd.n362 avdd.n361 6.33474
R1624 avdd.n215 avdd.n214 6.3005
R1625 avdd.n216 avdd.n215 6.3005
R1626 avdd.n41 avdd.n40 6.3005
R1627 avdd.n40 avdd.n39 6.3005
R1628 avdd.n169 avdd.n168 6.3005
R1629 avdd.n168 avdd.n167 6.3005
R1630 avdd.n44 avdd.n43 6.3005
R1631 avdd.n45 avdd.n44 6.3005
R1632 avdd.n158 avdd.n157 6.3005
R1633 avdd.n159 avdd.n158 6.3005
R1634 avdd.n53 avdd.n52 6.3005
R1635 avdd.n52 avdd.n51 6.3005
R1636 avdd.n153 avdd.n152 6.3005
R1637 avdd.n152 avdd.n151 6.3005
R1638 avdd.n56 avdd.n55 6.3005
R1639 avdd.n57 avdd.n56 6.3005
R1640 avdd.n142 avdd.n141 6.3005
R1641 avdd.n143 avdd.n142 6.3005
R1642 avdd.n65 avdd.n64 6.3005
R1643 avdd.n64 avdd.n63 6.3005
R1644 avdd.n137 avdd.n136 6.3005
R1645 avdd.n136 avdd.n135 6.3005
R1646 avdd.n68 avdd.n67 6.3005
R1647 avdd.n69 avdd.n68 6.3005
R1648 avdd.n126 avdd.n125 6.3005
R1649 avdd.n127 avdd.n126 6.3005
R1650 avdd.n77 avdd.n76 6.3005
R1651 avdd.n76 avdd.n75 6.3005
R1652 avdd.n121 avdd.n120 6.3005
R1653 avdd.n120 avdd.n119 6.3005
R1654 avdd.n80 avdd.n79 6.3005
R1655 avdd.n81 avdd.n80 6.3005
R1656 avdd.n110 avdd.n109 6.3005
R1657 avdd.n111 avdd.n110 6.3005
R1658 avdd.n89 avdd.n88 6.3005
R1659 avdd.n88 avdd.n87 6.3005
R1660 avdd.n105 avdd.n104 6.3005
R1661 avdd.n104 avdd.n103 6.3005
R1662 avdd.n92 avdd.n91 6.3005
R1663 avdd.n95 avdd.n94 6.3005
R1664 avdd.n94 avdd.n93 6.3005
R1665 avdd.n102 avdd.n101 6.3005
R1666 avdd.n103 avdd.n102 6.3005
R1667 avdd.n86 avdd.n85 6.3005
R1668 avdd.n87 avdd.n86 6.3005
R1669 avdd.n113 avdd.n112 6.3005
R1670 avdd.n112 avdd.n111 6.3005
R1671 avdd.n83 avdd.n82 6.3005
R1672 avdd.n82 avdd.n81 6.3005
R1673 avdd.n118 avdd.n117 6.3005
R1674 avdd.n119 avdd.n118 6.3005
R1675 avdd.n74 avdd.n73 6.3005
R1676 avdd.n75 avdd.n74 6.3005
R1677 avdd.n129 avdd.n128 6.3005
R1678 avdd.n128 avdd.n127 6.3005
R1679 avdd.n71 avdd.n70 6.3005
R1680 avdd.n70 avdd.n69 6.3005
R1681 avdd.n134 avdd.n133 6.3005
R1682 avdd.n135 avdd.n134 6.3005
R1683 avdd.n62 avdd.n61 6.3005
R1684 avdd.n63 avdd.n62 6.3005
R1685 avdd.n145 avdd.n144 6.3005
R1686 avdd.n144 avdd.n143 6.3005
R1687 avdd.n59 avdd.n58 6.3005
R1688 avdd.n58 avdd.n57 6.3005
R1689 avdd.n150 avdd.n149 6.3005
R1690 avdd.n151 avdd.n150 6.3005
R1691 avdd.n50 avdd.n49 6.3005
R1692 avdd.n51 avdd.n50 6.3005
R1693 avdd.n161 avdd.n160 6.3005
R1694 avdd.n160 avdd.n159 6.3005
R1695 avdd.n47 avdd.n46 6.3005
R1696 avdd.n46 avdd.n45 6.3005
R1697 avdd.n166 avdd.n165 6.3005
R1698 avdd.n167 avdd.n166 6.3005
R1699 avdd.n37 avdd.n36 6.3005
R1700 avdd.n39 avdd.n37 6.3005
R1701 avdd.n219 avdd.n218 6.3005
R1702 avdd.n183 avdd.n182 6.3005
R1703 avdd.n184 avdd.n177 6.3005
R1704 avdd.n209 avdd.n208 6.3005
R1705 avdd.n206 avdd.n174 6.3005
R1706 avdd.n193 avdd.n192 6.3005
R1707 avdd.n194 avdd.n189 6.3005
R1708 avdd.n201 avdd.n200 6.3005
R1709 avdd.n198 avdd.n187 6.3005
R1710 avdd.n239 avdd.n238 6.3005
R1711 avdd.n237 avdd.n231 6.3005
R1712 avdd.n244 avdd.n243 6.3005
R1713 avdd.n235 avdd.n232 6.3005
R1714 avdd.n228 avdd.n227 6.3005
R1715 avdd.n253 avdd.n252 6.3005
R1716 avdd.n258 avdd.n257 6.3005
R1717 avdd.n259 avdd.n224 6.3005
R1718 avdd.n312 avdd.n311 6.3005
R1719 avdd.n313 avdd.n312 6.3005
R1720 avdd.n270 avdd.n269 6.3005
R1721 avdd.n269 avdd.n268 6.3005
R1722 avdd.n307 avdd.n306 6.3005
R1723 avdd.n306 avdd.n305 6.3005
R1724 avdd.n273 avdd.n272 6.3005
R1725 avdd.n274 avdd.n273 6.3005
R1726 avdd.n296 avdd.n295 6.3005
R1727 avdd.n297 avdd.n296 6.3005
R1728 avdd.n282 avdd.n281 6.3005
R1729 avdd.n281 avdd.n280 6.3005
R1730 avdd.n291 avdd.n290 6.3005
R1731 avdd.n316 avdd.n315 6.3005
R1732 avdd.n266 avdd.n265 6.3005
R1733 avdd.n268 avdd.n266 6.3005
R1734 avdd.n304 avdd.n303 6.3005
R1735 avdd.n305 avdd.n304 6.3005
R1736 avdd.n276 avdd.n275 6.3005
R1737 avdd.n275 avdd.n274 6.3005
R1738 avdd.n299 avdd.n298 6.3005
R1739 avdd.n298 avdd.n297 6.3005
R1740 avdd.n279 avdd.n278 6.3005
R1741 avdd.n280 avdd.n279 6.3005
R1742 avdd.n287 avdd.n286 6.3005
R1743 avdd.n288 avdd.n287 6.3005
R1744 avdd.n354 avdd.n353 6.3005
R1745 avdd.n355 avdd.n354 6.3005
R1746 avdd.n331 avdd.n330 6.3005
R1747 avdd.n349 avdd.n348 6.3005
R1748 avdd.n347 avdd.n346 6.3005
R1749 avdd.n345 avdd.n333 6.3005
R1750 avdd.n359 avdd.n358 6.3005
R1751 avdd.n358 avdd.n357 6.3005
R1752 avdd.n323 avdd.n322 6.3005
R1753 avdd.n339 avdd.n337 6.3005
R1754 avdd.n340 avdd.n336 6.3005
R1755 avdd.n341 avdd.n335 6.3005
R1756 avdd.n344 avdd.n343 6.12735
R1757 avdd.n352 avdd.n320 6.12735
R1758 avdd.n343 avdd.n342 6.11952
R1759 avdd.n196 avdd.n186 5.20011
R1760 avdd.n196 avdd.n195 5.20011
R1761 avdd.n180 avdd.n172 5.20011
R1762 avdd.n242 avdd.n241 5.20011
R1763 avdd.n241 avdd.n240 5.20011
R1764 avdd.n251 avdd.n222 5.20011
R1765 avdd.n98 avdd.n90 5.19741
R1766 avdd.n292 avdd.n283 5.19741
R1767 avdd.n310 avdd.n263 5.19741
R1768 avdd.n99 avdd.n98 5.18959
R1769 avdd.n285 avdd.n283 5.18959
R1770 avdd.n96 avdd.n93 4.9335
R1771 avdd.n217 avdd.n216 4.9335
R1772 avdd.n289 avdd.n288 4.9335
R1773 avdd.n314 avdd.n313 4.9335
R1774 avdd.n203 avdd.n202 4.75136
R1775 avdd.n190 avdd.n178 4.75136
R1776 avdd.n249 avdd.n229 4.75136
R1777 avdd.n230 avdd.n223 4.75136
R1778 avdd.n178 avdd.n173 4.75135
R1779 avdd.n203 avdd.n185 4.75135
R1780 avdd.n236 avdd.n230 4.75135
R1781 avdd.n250 avdd.n249 4.75135
R1782 avdd.n211 avdd.n210 4.7462
R1783 avdd.n261 avdd.n260 4.7462
R1784 avdd.n221 avdd.n220 4.7435
R1785 avdd.n213 avdd.n212 4.7435
R1786 avdd.n318 avdd.n317 4.7435
R1787 avdd.n361 avdd.n360 4.7255
R1788 avdd.n25 avdd.n10 4.5005
R1789 avdd.n25 avdd.n24 4.5005
R1790 avdd.n24 avdd.n13 4.5005
R1791 avdd.n16 avdd.n10 4.5005
R1792 avdd.n22 avdd.n16 4.5005
R1793 avdd.n24 avdd.n16 4.5005
R1794 avdd.n12 avdd.n10 4.5005
R1795 avdd.n22 avdd.n12 4.5005
R1796 avdd.n24 avdd.n12 4.5005
R1797 avdd.n23 avdd.n22 4.5005
R1798 avdd.n24 avdd.n23 4.5005
R1799 avdd.n33 avdd.n1 4.5005
R1800 avdd.n33 avdd.n32 4.5005
R1801 avdd.n32 avdd.n4 4.5005
R1802 avdd.n7 avdd.n1 4.5005
R1803 avdd.n30 avdd.n7 4.5005
R1804 avdd.n32 avdd.n7 4.5005
R1805 avdd.n3 avdd.n1 4.5005
R1806 avdd.n30 avdd.n3 4.5005
R1807 avdd.n32 avdd.n3 4.5005
R1808 avdd.n31 avdd.n30 4.5005
R1809 avdd.n32 avdd.n31 4.5005
R1810 avdd.n99 avdd.n95 4.5005
R1811 avdd.n101 avdd.n100 4.5005
R1812 avdd.n85 avdd.n84 4.5005
R1813 avdd.n114 avdd.n113 4.5005
R1814 avdd.n115 avdd.n83 4.5005
R1815 avdd.n117 avdd.n116 4.5005
R1816 avdd.n73 avdd.n72 4.5005
R1817 avdd.n130 avdd.n129 4.5005
R1818 avdd.n131 avdd.n71 4.5005
R1819 avdd.n133 avdd.n132 4.5005
R1820 avdd.n61 avdd.n60 4.5005
R1821 avdd.n146 avdd.n145 4.5005
R1822 avdd.n147 avdd.n59 4.5005
R1823 avdd.n149 avdd.n148 4.5005
R1824 avdd.n49 avdd.n48 4.5005
R1825 avdd.n162 avdd.n161 4.5005
R1826 avdd.n163 avdd.n47 4.5005
R1827 avdd.n165 avdd.n164 4.5005
R1828 avdd.n36 avdd.n35 4.5005
R1829 avdd.n220 avdd.n219 4.5005
R1830 avdd.n106 avdd.n105 4.5005
R1831 avdd.n107 avdd.n89 4.5005
R1832 avdd.n109 avdd.n108 4.5005
R1833 avdd.n79 avdd.n78 4.5005
R1834 avdd.n122 avdd.n121 4.5005
R1835 avdd.n123 avdd.n77 4.5005
R1836 avdd.n125 avdd.n124 4.5005
R1837 avdd.n67 avdd.n66 4.5005
R1838 avdd.n138 avdd.n137 4.5005
R1839 avdd.n139 avdd.n65 4.5005
R1840 avdd.n141 avdd.n140 4.5005
R1841 avdd.n55 avdd.n54 4.5005
R1842 avdd.n154 avdd.n153 4.5005
R1843 avdd.n155 avdd.n53 4.5005
R1844 avdd.n157 avdd.n156 4.5005
R1845 avdd.n43 avdd.n42 4.5005
R1846 avdd.n170 avdd.n169 4.5005
R1847 avdd.n171 avdd.n41 4.5005
R1848 avdd.n214 avdd.n213 4.5005
R1849 avdd.n91 avdd.n90 4.5005
R1850 avdd.n210 avdd.n209 4.5005
R1851 avdd.n174 avdd.n173 4.5005
R1852 avdd.n202 avdd.n201 4.5005
R1853 avdd.n187 avdd.n186 4.5005
R1854 avdd.n193 avdd.n190 4.5005
R1855 avdd.n195 avdd.n194 4.5005
R1856 avdd.n183 avdd.n180 4.5005
R1857 avdd.n185 avdd.n184 4.5005
R1858 avdd.n243 avdd.n242 4.5005
R1859 avdd.n235 avdd.n229 4.5005
R1860 avdd.n240 avdd.n239 4.5005
R1861 avdd.n237 avdd.n236 4.5005
R1862 avdd.n258 avdd.n223 4.5005
R1863 avdd.n260 avdd.n259 4.5005
R1864 avdd.n250 avdd.n228 4.5005
R1865 avdd.n252 avdd.n251 4.5005
R1866 avdd.n278 avdd.n277 4.5005
R1867 avdd.n300 avdd.n299 4.5005
R1868 avdd.n301 avdd.n276 4.5005
R1869 avdd.n303 avdd.n302 4.5005
R1870 avdd.n265 avdd.n264 4.5005
R1871 avdd.n317 avdd.n316 4.5005
R1872 avdd.n286 avdd.n285 4.5005
R1873 avdd.n293 avdd.n282 4.5005
R1874 avdd.n295 avdd.n294 4.5005
R1875 avdd.n272 avdd.n271 4.5005
R1876 avdd.n308 avdd.n307 4.5005
R1877 avdd.n309 avdd.n270 4.5005
R1878 avdd.n311 avdd.n310 4.5005
R1879 avdd.n292 avdd.n291 4.5005
R1880 avdd.n340 avdd.n334 4.5005
R1881 avdd.n339 avdd.n338 4.5005
R1882 avdd.n322 avdd.n321 4.5005
R1883 avdd.n360 avdd.n359 4.5005
R1884 avdd.n342 avdd.n341 4.5005
R1885 avdd.n346 avdd.n332 4.5005
R1886 avdd.n350 avdd.n349 4.5005
R1887 avdd.n351 avdd.n331 4.5005
R1888 avdd.n353 avdd.n352 4.5005
R1889 avdd.n345 avdd.n344 4.5005
R1890 avdd.n363 avdd.n362 3.56023
R1891 avdd.n181 avdd.n177 3.31679
R1892 avdd.n182 avdd.n181 3.31679
R1893 avdd.n207 avdd.n206 3.31679
R1894 avdd.n208 avdd.n207 3.31679
R1895 avdd.n191 avdd.n189 3.31679
R1896 avdd.n192 avdd.n191 3.31679
R1897 avdd.n199 avdd.n198 3.31679
R1898 avdd.n200 avdd.n199 3.31679
R1899 avdd.n233 avdd.n231 3.31679
R1900 avdd.n238 avdd.n233 3.31679
R1901 avdd.n245 avdd.n232 3.31679
R1902 avdd.n245 avdd.n244 3.31679
R1903 avdd.n253 avdd.n226 3.31679
R1904 avdd.n227 avdd.n226 3.31679
R1905 avdd.n256 avdd.n224 3.31679
R1906 avdd.n257 avdd.n256 3.31679
R1907 avdd.n333 avdd.n328 3.31679
R1908 avdd.n348 avdd.n329 3.31679
R1909 avdd.n330 avdd.n329 3.31679
R1910 avdd.n347 avdd.n328 3.31679
R1911 avdd.n336 avdd.n325 3.31679
R1912 avdd.n326 avdd.n323 3.31679
R1913 avdd.n337 avdd.n326 3.31679
R1914 avdd.n335 avdd.n325 3.31679
R1915 avdd.n19 avdd.n11 2.24986
R1916 avdd.n15 avdd.n14 2.24986
R1917 avdd.n19 avdd.n18 2.24986
R1918 avdd.n17 avdd.n14 2.24986
R1919 avdd.n27 avdd.n2 2.24986
R1920 avdd.n6 avdd.n5 2.24986
R1921 avdd.n27 avdd.n26 2.24986
R1922 avdd.n8 avdd.n5 2.24986
R1923 avdd.n25 avdd.n9 2.24741
R1924 avdd.n21 avdd.n13 2.24741
R1925 avdd.n23 avdd.n20 2.24741
R1926 avdd.n33 avdd.n0 2.24741
R1927 avdd.n29 avdd.n4 2.24741
R1928 avdd.n31 avdd.n28 2.24741
R1929 avdd.n362 avdd.n319 1.9373
R1930 avdd.n355 avdd.n329 1.49311
R1931 avdd.n355 avdd.n328 1.49311
R1932 avdd.n357 avdd.n326 1.49311
R1933 avdd.n357 avdd.n325 1.49311
R1934 avdd.n361 avdd.n320 1.40235
R1935 avdd.n218 avdd.n217 1.24194
R1936 avdd.n96 avdd.n92 1.24194
R1937 avdd.n315 avdd.n314 1.24194
R1938 avdd.n290 avdd.n289 1.24194
R1939 avdd.n98 avdd.n97 0.9005
R1940 avdd.n197 avdd.n196 0.9005
R1941 avdd.n197 avdd.n188 0.9005
R1942 avdd.n204 avdd.n179 0.9005
R1943 avdd.n188 avdd.n179 0.9005
R1944 avdd.n205 avdd.n204 0.9005
R1945 avdd.n205 avdd.n176 0.9005
R1946 avdd.n175 avdd.n172 0.9005
R1947 avdd.n176 avdd.n175 0.9005
R1948 avdd.n38 avdd.n34 0.9005
R1949 avdd.n241 avdd.n234 0.9005
R1950 avdd.n246 avdd.n234 0.9005
R1951 avdd.n248 avdd.n225 0.9005
R1952 avdd.n255 avdd.n225 0.9005
R1953 avdd.n248 avdd.n247 0.9005
R1954 avdd.n247 avdd.n246 0.9005
R1955 avdd.n254 avdd.n222 0.9005
R1956 avdd.n255 avdd.n254 0.9005
R1957 avdd.n284 avdd.n283 0.9005
R1958 avdd.n267 avdd.n263 0.9005
R1959 avdd.n212 avdd.n211 0.622674
R1960 avdd.n319 avdd.n262 0.5801
R1961 avdd.n211 avdd.n172 0.454413
R1962 avdd.n212 avdd.n34 0.454413
R1963 avdd.n221 avdd.n34 0.454413
R1964 avdd.n261 avdd.n222 0.454413
R1965 avdd.n318 avdd.n263 0.454413
R1966 avdd.n343 avdd.n327 0.2255
R1967 avdd.n356 avdd.n327 0.2255
R1968 avdd.n324 avdd.n320 0.2255
R1969 avdd.n356 avdd.n324 0.2255
R1970 avdd avdd.n363 0.207455
R1971 avdd.n105 avdd.n91 0.1445
R1972 avdd.n105 avdd.n89 0.1445
R1973 avdd.n109 avdd.n89 0.1445
R1974 avdd.n109 avdd.n79 0.1445
R1975 avdd.n121 avdd.n79 0.1445
R1976 avdd.n121 avdd.n77 0.1445
R1977 avdd.n125 avdd.n77 0.1445
R1978 avdd.n125 avdd.n67 0.1445
R1979 avdd.n137 avdd.n67 0.1445
R1980 avdd.n137 avdd.n65 0.1445
R1981 avdd.n141 avdd.n65 0.1445
R1982 avdd.n141 avdd.n55 0.1445
R1983 avdd.n153 avdd.n55 0.1445
R1984 avdd.n153 avdd.n53 0.1445
R1985 avdd.n157 avdd.n53 0.1445
R1986 avdd.n157 avdd.n43 0.1445
R1987 avdd.n169 avdd.n43 0.1445
R1988 avdd.n169 avdd.n41 0.1445
R1989 avdd.n214 avdd.n41 0.1445
R1990 avdd.n101 avdd.n95 0.1445
R1991 avdd.n101 avdd.n85 0.1445
R1992 avdd.n113 avdd.n85 0.1445
R1993 avdd.n113 avdd.n83 0.1445
R1994 avdd.n117 avdd.n83 0.1445
R1995 avdd.n117 avdd.n73 0.1445
R1996 avdd.n129 avdd.n73 0.1445
R1997 avdd.n129 avdd.n71 0.1445
R1998 avdd.n133 avdd.n71 0.1445
R1999 avdd.n133 avdd.n61 0.1445
R2000 avdd.n145 avdd.n61 0.1445
R2001 avdd.n145 avdd.n59 0.1445
R2002 avdd.n149 avdd.n59 0.1445
R2003 avdd.n149 avdd.n49 0.1445
R2004 avdd.n161 avdd.n49 0.1445
R2005 avdd.n161 avdd.n47 0.1445
R2006 avdd.n165 avdd.n47 0.1445
R2007 avdd.n165 avdd.n36 0.1445
R2008 avdd.n219 avdd.n36 0.1445
R2009 avdd.n100 avdd.n99 0.1445
R2010 avdd.n100 avdd.n84 0.1445
R2011 avdd.n114 avdd.n84 0.1445
R2012 avdd.n115 avdd.n114 0.1445
R2013 avdd.n116 avdd.n115 0.1445
R2014 avdd.n116 avdd.n72 0.1445
R2015 avdd.n130 avdd.n72 0.1445
R2016 avdd.n131 avdd.n130 0.1445
R2017 avdd.n132 avdd.n131 0.1445
R2018 avdd.n132 avdd.n60 0.1445
R2019 avdd.n146 avdd.n60 0.1445
R2020 avdd.n147 avdd.n146 0.1445
R2021 avdd.n148 avdd.n147 0.1445
R2022 avdd.n148 avdd.n48 0.1445
R2023 avdd.n162 avdd.n48 0.1445
R2024 avdd.n163 avdd.n162 0.1445
R2025 avdd.n164 avdd.n163 0.1445
R2026 avdd.n164 avdd.n35 0.1445
R2027 avdd.n220 avdd.n35 0.1445
R2028 avdd.n106 avdd.n90 0.1445
R2029 avdd.n107 avdd.n106 0.1445
R2030 avdd.n108 avdd.n107 0.1445
R2031 avdd.n108 avdd.n78 0.1445
R2032 avdd.n122 avdd.n78 0.1445
R2033 avdd.n123 avdd.n122 0.1445
R2034 avdd.n124 avdd.n123 0.1445
R2035 avdd.n124 avdd.n66 0.1445
R2036 avdd.n138 avdd.n66 0.1445
R2037 avdd.n139 avdd.n138 0.1445
R2038 avdd.n140 avdd.n139 0.1445
R2039 avdd.n140 avdd.n54 0.1445
R2040 avdd.n154 avdd.n54 0.1445
R2041 avdd.n155 avdd.n154 0.1445
R2042 avdd.n156 avdd.n155 0.1445
R2043 avdd.n156 avdd.n42 0.1445
R2044 avdd.n170 avdd.n42 0.1445
R2045 avdd.n171 avdd.n170 0.1445
R2046 avdd.n213 avdd.n171 0.1445
R2047 avdd.n184 avdd.n183 0.1445
R2048 avdd.n209 avdd.n174 0.1445
R2049 avdd.n210 avdd.n173 0.1445
R2050 avdd.n194 avdd.n193 0.1445
R2051 avdd.n201 avdd.n187 0.1445
R2052 avdd.n202 avdd.n186 0.1445
R2053 avdd.n195 avdd.n190 0.1445
R2054 avdd.n185 avdd.n180 0.1445
R2055 avdd.n239 avdd.n237 0.1445
R2056 avdd.n243 avdd.n235 0.1445
R2057 avdd.n242 avdd.n229 0.1445
R2058 avdd.n240 avdd.n236 0.1445
R2059 avdd.n252 avdd.n228 0.1445
R2060 avdd.n259 avdd.n258 0.1445
R2061 avdd.n260 avdd.n223 0.1445
R2062 avdd.n251 avdd.n250 0.1445
R2063 avdd.n291 avdd.n282 0.1445
R2064 avdd.n295 avdd.n282 0.1445
R2065 avdd.n295 avdd.n272 0.1445
R2066 avdd.n307 avdd.n272 0.1445
R2067 avdd.n307 avdd.n270 0.1445
R2068 avdd.n311 avdd.n270 0.1445
R2069 avdd.n286 avdd.n278 0.1445
R2070 avdd.n299 avdd.n278 0.1445
R2071 avdd.n299 avdd.n276 0.1445
R2072 avdd.n303 avdd.n276 0.1445
R2073 avdd.n303 avdd.n265 0.1445
R2074 avdd.n316 avdd.n265 0.1445
R2075 avdd.n285 avdd.n277 0.1445
R2076 avdd.n300 avdd.n277 0.1445
R2077 avdd.n301 avdd.n300 0.1445
R2078 avdd.n302 avdd.n301 0.1445
R2079 avdd.n302 avdd.n264 0.1445
R2080 avdd.n317 avdd.n264 0.1445
R2081 avdd.n293 avdd.n292 0.1445
R2082 avdd.n294 avdd.n293 0.1445
R2083 avdd.n294 avdd.n271 0.1445
R2084 avdd.n308 avdd.n271 0.1445
R2085 avdd.n309 avdd.n308 0.1445
R2086 avdd.n310 avdd.n309 0.1445
R2087 avdd.n346 avdd.n345 0.1445
R2088 avdd.n349 avdd.n346 0.1445
R2089 avdd.n349 avdd.n331 0.1445
R2090 avdd.n353 avdd.n331 0.1445
R2091 avdd.n341 avdd.n340 0.1445
R2092 avdd.n340 avdd.n339 0.1445
R2093 avdd.n339 avdd.n322 0.1445
R2094 avdd.n359 avdd.n322 0.1445
R2095 avdd.n342 avdd.n334 0.1445
R2096 avdd.n338 avdd.n334 0.1445
R2097 avdd.n338 avdd.n321 0.1445
R2098 avdd.n360 avdd.n321 0.1445
R2099 avdd.n344 avdd.n332 0.1445
R2100 avdd.n350 avdd.n332 0.1445
R2101 avdd.n351 avdd.n350 0.1445
R2102 avdd.n352 avdd.n351 0.1445
R2103 avdd.n363 avdd.n33 0.0817893
R2104 avdd.n204 avdd.n203 0.0543057
R2105 avdd.n204 avdd.n178 0.0543057
R2106 avdd.n249 avdd.n248 0.0543057
R2107 avdd.n248 avdd.n230 0.0543057
R2108 avdd.n31 avdd.n25 0.0245
R2109 avdd.n32 avdd.n5 0.0149
R2110 avdd.n24 avdd.n14 0.0149
R2111 avdd.n5 avdd.n0 0.0081885
R2112 avdd.n29 avdd.n1 0.0081885
R2113 avdd.n28 avdd.n27 0.0081885
R2114 avdd.n14 avdd.n9 0.0081885
R2115 avdd.n21 avdd.n10 0.0081885
R2116 avdd.n20 avdd.n19 0.0081885
R2117 avdd.n22 avdd.n9 0.0081885
R2118 avdd.n22 avdd.n21 0.0081885
R2119 avdd.n20 avdd.n10 0.0081885
R2120 avdd.n30 avdd.n0 0.0081885
R2121 avdd.n30 avdd.n29 0.0081885
R2122 avdd.n28 avdd.n1 0.0081885
R2123 avdd.n4 avdd.n2 0.00328455
R2124 avdd.n7 avdd.n6 0.00328455
R2125 avdd.n26 avdd.n3 0.00328455
R2126 avdd.n31 avdd.n8 0.00328455
R2127 avdd.n13 avdd.n11 0.00328455
R2128 avdd.n16 avdd.n15 0.00328455
R2129 avdd.n18 avdd.n12 0.00328455
R2130 avdd.n23 avdd.n17 0.00328455
R2131 avdd.n25 avdd.n11 0.00328455
R2132 avdd.n15 avdd.n13 0.00328455
R2133 avdd.n18 avdd.n16 0.00328455
R2134 avdd.n17 avdd.n12 0.00328455
R2135 avdd.n33 avdd.n2 0.00328455
R2136 avdd.n6 avdd.n4 0.00328455
R2137 avdd.n26 avdd.n7 0.00328455
R2138 avdd.n8 avdd.n3 0.00328455
C0 nvpost xm4_0/a_n63_n339# 0.25212f
C1 xm7_0/a_63_n131# vb_pot 0.03305f
C2 xmcm_chain_3_0/a_1000_n131# xmcm_chain_4_0/a_1000_n131# 0.03432f
C3 vpost vb_pot 0.01467f
C4 xm1_0/a_n63_n339# xm9_0/a_63_n131# 0.06403f
C5 xm4_0/a_63_n131# vw 0.03003f
C6 xm7_0/a_63_n131# xm1_0/a_63_n131# 0.02729f
C7 xm7_0/a_63_n131# xmcm_chain_3_0/a_1000_n131# 0
C8 xmcm_chain_3_0/a_1000_n131# vpost 0.09065f
C9 vb_itd xm9_0/a_63_n131# 0
C10 vb_itd xmcm_chain_1_0/a_1000_n131# 0.17995f
C11 vw xm4_0/a_n63_n339# 0.47245f
C12 nvpost xm1_0/a_63_n131# 0.0397f
C13 nvpost xmcm_chain_3_0/a_1000_n131# 0
C14 vw vb_idep 0.092f
C15 xm7_0/a_63_n131# xm1_0/a_n63_n339# 0.00852f
C16 vb_itd xmcm_chain_4_0/a_1000_n131# 0.23508f
C17 xm4_0/a_63_n131# xmcm_chain_2_0/a_1000_n131# 0
C18 nvpre xm1_0/a_n63_n339# 0.65103f
C19 xm8_0/a_63_n131# vb_itp 0
C20 xm7_0/a_63_n131# vb_itd 0
C21 vw xm1_0/a_63_n131# 0.49038f
C22 nvpost xm1_0/a_n63_n339# 0.00597f
C23 vb_itd vpost 0.13666f
C24 avdd vb_itp 0.59836f
C25 vw vpre 0
C26 xmcm_chain_2_0/a_1000_n131# xm4_0/a_n63_n339# 0
C27 xm8_0/a_63_n131# xm9_0/a_63_n131# 0.0012f
C28 vb_itd nvpost 0.12986f
C29 avdd xm9_0/a_63_n131# 0.68252f
C30 xm4_0/a_63_n131# xm4_0/a_n63_n339# 0.11772f
C31 Iout xm1_0/a_n63_n339# 0.11832f
C32 vw xm1_0/a_n63_n339# 1.35394f
C33 xmcm_chain_2_0/a_1000_n131# vb_pot 0
C34 xmcm_chain_2_0/a_1000_n131# xmcm_chain_3_0/a_1000_n131# 0.03534f
C35 xm7_0/a_63_n131# xm8_0/a_63_n131# 0.14657f
C36 vb_itd vw 0.01665f
C37 xmcm_chain_2_0/a_1000_n131# vpre 0
C38 vb_idep xm4_0/a_n63_n339# 0.01381f
C39 xm4_0/a_63_n131# xm1_0/a_63_n131# 0.014f
C40 xm7_0/a_63_n131# avdd 0.80277f
C41 nvpre xm8_0/a_63_n131# 0.14982f
C42 xm4_0/a_63_n131# vpre 0.00163f
C43 xm4_0/a_n63_n339# vb_pot 0.02532f
C44 nvpre avdd 0.57647f
C45 nvpost xm8_0/a_63_n131# 0.00709f
C46 xm1_0/a_63_n131# xm4_0/a_n63_n339# 0
C47 nvpost avdd 0.25313f
C48 xm4_0/a_n63_n339# xmcm_chain_3_0/a_1000_n131# 0
C49 vpre xm4_0/a_n63_n339# 0.01465f
C50 vb_itd xmcm_chain_2_0/a_1000_n131# 0.18317f
C51 xm9_0/a_63_n131# vb_itp 0.27424f
C52 Iout xm8_0/a_63_n131# 0
C53 vw xm8_0/a_63_n131# 0
C54 xmcm_chain_3_0/a_1000_n131# vb_pot 0.08957f
C55 xm4_0/a_63_n131# vb_itd 0
C56 Iout avdd 0.49419f
C57 vw avdd 3.96449f
C58 xm1_0/a_n63_n339# xm4_0/a_n63_n339# 0.00193f
C59 xmcm_chain_1_0/a_1000_n131# xm9_0/a_63_n131# 0.01579f
C60 vpre xm1_0/a_63_n131# 0
C61 vb_idep xm1_0/a_n63_n339# 0.33998f
C62 vb_itd xm4_0/a_n63_n339# 0.17726f
C63 xm7_0/a_63_n131# vb_itp 0
C64 xmcm_chain_1_0/a_1000_n131# xmcm_chain_4_0/a_1000_n131# 0.07064f
C65 vb_itd vb_idep 0.00431f
C66 xm1_0/a_n63_n339# xm1_0/a_63_n131# 0.2921f
C67 nvpre vb_itp 0.01306f
C68 xm7_0/a_63_n131# xm9_0/a_63_n131# 0.72125f
C69 xm7_0/a_63_n131# xmcm_chain_1_0/a_1000_n131# 0.02759f
C70 xm9_0/a_63_n131# vpost 0.04032f
C71 vb_itd vb_pot 0.14114f
C72 xmcm_chain_1_0/a_1000_n131# vpost 0.081f
C73 nvpre xm9_0/a_63_n131# 0
C74 vb_itd xmcm_chain_3_0/a_1000_n131# 0.17915f
C75 xm4_0/a_63_n131# avdd 0.00114f
C76 nvpost xm9_0/a_63_n131# 0.19846f
C77 vb_itd vpre 0.00164f
C78 xmcm_chain_1_0/a_1000_n131# nvpost 0.20089f
C79 xm8_0/a_63_n131# xm4_0/a_n63_n339# 0
C80 vw vb_itp 0.08888f
C81 avdd xm4_0/a_n63_n339# 0.54253f
C82 xm7_0/a_63_n131# vpost 0
C83 xm7_0/a_63_n131# nvpre 0.00208f
C84 vw xm9_0/a_63_n131# 0
C85 vb_idep avdd 0.86882f
C86 xm7_0/a_63_n131# nvpost 0.08208f
C87 avdd xm1_0/a_63_n131# 0.98267f
C88 vw xmcm_chain_4_0/a_1000_n131# 0.00291f
C89 xm7_0/a_63_n131# Iout 0
C90 xm7_0/a_63_n131# vw 0.02238f
C91 xmcm_chain_2_0/a_1000_n131# xm9_0/a_63_n131# 0.00323f
C92 xm1_0/a_n63_n339# xm8_0/a_63_n131# 0.01891f
C93 xmcm_chain_1_0/a_1000_n131# xmcm_chain_2_0/a_1000_n131# 0.09857f
C94 Iout nvpre 0.1815f
C95 nvpre vw 0.09079f
C96 xm1_0/a_n63_n339# avdd 2.53769f
C97 xm4_0/a_63_n131# xm9_0/a_63_n131# 0.00622f
C98 vw nvpost 0.03415f
C99 xm4_0/a_63_n131# xmcm_chain_1_0/a_1000_n131# 0.00332f
C100 xm4_0/a_n63_n339# vb_itp 0
C101 xmcm_chain_2_0/a_1000_n131# xmcm_chain_4_0/a_1000_n131# 0.0045f
C102 vb_itd avdd 0.00825f
C103 vb_idep vb_itp 0.01121f
C104 xm9_0/a_63_n131# xm4_0/a_n63_n339# 0.98954f
C105 xm7_0/a_63_n131# xmcm_chain_2_0/a_1000_n131# 0
C106 xmcm_chain_1_0/a_1000_n131# xm4_0/a_n63_n339# 0.06299f
C107 xmcm_chain_2_0/a_1000_n131# vpost 0.07084f
C108 Iout vw 0.15817f
C109 vb_idep xm9_0/a_63_n131# 0.34686f
C110 xmcm_chain_1_0/a_1000_n131# vb_idep 0
C111 xmcm_chain_2_0/a_1000_n131# nvpost 0.09745f
C112 xm9_0/a_63_n131# vb_pot 0
C113 xm4_0/a_n63_n339# xmcm_chain_4_0/a_1000_n131# 0
C114 xmcm_chain_1_0/a_1000_n131# vb_pot 0.1201f
C115 xm7_0/a_63_n131# xm4_0/a_n63_n339# 0.17308f
C116 xm4_0/a_63_n131# nvpost 0.03937f
C117 xmcm_chain_1_0/a_1000_n131# xmcm_chain_3_0/a_1000_n131# 0.07349f
C118 xm4_0/a_n63_n339# vpost 0.0014f
C119 xm8_0/a_63_n131# avdd 0.83807f
C120 xmcm_chain_1_0/a_1000_n131# vpre 0
C121 xmcm_chain_4_0/a_1000_n131# vb_pot 0.08013f
C122 nvpre xm4_0/a_n63_n339# 0
C123 xm1_0/a_n63_n339# vb_itp 0.28993f
C124 vpre avss -0.05882f
C125 avdd.n1 avss 0.01239f
C126 avdd.n3 avss 0.01735f
C127 avdd.n4 avss 0.01735f
C128 avdd.n5 avss 0.01239f
C129 avdd.n7 avss 0.01735f
C130 avdd.n10 avss 0.01239f
C131 avdd.n12 avss 0.01735f
C132 avdd.n13 avss 0.01735f
C133 avdd.n14 avss 0.01239f
C134 avdd.n16 avss 0.01735f
C135 avdd.n19 avss 0.02013f
C136 avdd.n22 avss 0.01239f
C137 avdd.n23 avss 0.04987f
C138 avdd.n24 avss 0.02013f
C139 avdd.n25 avss 0.0542f
C140 avdd.n27 avss 0.02013f
C141 avdd.n30 avss 0.01239f
C142 avdd.n31 avss 0.0542f
C143 avdd.n32 avss 0.02013f
C144 avdd.n33 avss 0.02874f
C145 avdd.n34 avss 0.00331f
C146 avdd.n35 avss 0.00124f
C147 avdd.n36 avss 0.00124f
C148 avdd.n37 avss 0
C149 avdd.n38 avss 0.02388f
C150 avdd.n39 avss 0.01388f
C151 avdd.n40 avss 0
C152 avdd.n41 avss 0.00124f
C153 avdd.n42 avss 0.00124f
C154 avdd.n43 avss 0.00124f
C155 avdd.n44 avss 0
C156 avdd.n45 avss 0.01388f
C157 avdd.n46 avss 0
C158 avdd.n47 avss 0.00124f
C159 avdd.n48 avss 0.00124f
C160 avdd.n49 avss 0.00124f
C161 avdd.n50 avss 0
C162 avdd.n51 avss 0.01388f
C163 avdd.n52 avss 0
C164 avdd.n53 avss 0.00124f
C165 avdd.n54 avss 0.00124f
C166 avdd.n55 avss 0.00124f
C167 avdd.n56 avss 0
C168 avdd.n57 avss 0.01388f
C169 avdd.n58 avss 0
C170 avdd.n59 avss 0.00124f
C171 avdd.n60 avss 0.00124f
C172 avdd.n61 avss 0.00124f
C173 avdd.n62 avss 0
C174 avdd.n63 avss 0.01388f
C175 avdd.n64 avss 0
C176 avdd.n65 avss 0.00124f
C177 avdd.n66 avss 0.00124f
C178 avdd.n67 avss 0.00124f
C179 avdd.n68 avss 0
C180 avdd.n69 avss 0.01388f
C181 avdd.n70 avss 0
C182 avdd.n71 avss 0.00124f
C183 avdd.n72 avss 0.00124f
C184 avdd.n73 avss 0.00124f
C185 avdd.n74 avss 0
C186 avdd.n75 avss 0.01388f
C187 avdd.n76 avss 0
C188 avdd.n77 avss 0.00124f
C189 avdd.n78 avss 0.00124f
C190 avdd.n79 avss 0.00124f
C191 avdd.n80 avss 0
C192 avdd.n81 avss 0.01388f
C193 avdd.n82 avss 0
C194 avdd.n83 avss 0.00124f
C195 avdd.n84 avss 0.00124f
C196 avdd.n85 avss 0.00124f
C197 avdd.n86 avss 0
C198 avdd.n87 avss 0.01388f
C199 avdd.n88 avss 0
C200 avdd.n89 avss 0.00124f
C201 avdd.n90 avss 0.00321f
C202 avdd.n91 avss 0.00101f
C203 avdd.n92 avss 0.00254f
C204 avdd.n93 avss 0.01889f
C205 avdd.n94 avss 0.00254f
C206 avdd.n95 avss 0.00101f
C207 avdd.n97 avss 0.02388f
C208 avdd.n98 avss 0.03401f
C209 avdd.n99 avss 0.00385f
C210 avdd.n100 avss 0.00124f
C211 avdd.n101 avss 0.00124f
C212 avdd.n102 avss 0
C213 avdd.n103 avss 0.01388f
C214 avdd.n104 avss 0
C215 avdd.n105 avss 0.00124f
C216 avdd.n106 avss 0.00124f
C217 avdd.n107 avss 0.00124f
C218 avdd.n108 avss 0.00124f
C219 avdd.n109 avss 0.00124f
C220 avdd.n110 avss 0
C221 avdd.n111 avss 0.01388f
C222 avdd.n112 avss 0
C223 avdd.n113 avss 0.00124f
C224 avdd.n114 avss 0.00124f
C225 avdd.n115 avss 0.00124f
C226 avdd.n116 avss 0.00124f
C227 avdd.n117 avss 0.00124f
C228 avdd.n118 avss 0
C229 avdd.n119 avss 0.01388f
C230 avdd.n120 avss 0
C231 avdd.n121 avss 0.00124f
C232 avdd.n122 avss 0.00124f
C233 avdd.n123 avss 0.00124f
C234 avdd.n124 avss 0.00124f
C235 avdd.n125 avss 0.00124f
C236 avdd.n126 avss 0
C237 avdd.n127 avss 0.01388f
C238 avdd.n128 avss 0
C239 avdd.n129 avss 0.00124f
C240 avdd.n130 avss 0.00124f
C241 avdd.n131 avss 0.00124f
C242 avdd.n132 avss 0.00124f
C243 avdd.n133 avss 0.00124f
C244 avdd.n134 avss 0
C245 avdd.n135 avss 0.01388f
C246 avdd.n136 avss 0
C247 avdd.n137 avss 0.00124f
C248 avdd.n138 avss 0.00124f
C249 avdd.n139 avss 0.00124f
C250 avdd.n140 avss 0.00124f
C251 avdd.n141 avss 0.00124f
C252 avdd.n142 avss 0
C253 avdd.n143 avss 0.01388f
C254 avdd.n144 avss 0
C255 avdd.n145 avss 0.00124f
C256 avdd.n146 avss 0.00124f
C257 avdd.n147 avss 0.00124f
C258 avdd.n148 avss 0.00124f
C259 avdd.n149 avss 0.00124f
C260 avdd.n150 avss 0
C261 avdd.n151 avss 0.01388f
C262 avdd.n152 avss 0
C263 avdd.n153 avss 0.00124f
C264 avdd.n154 avss 0.00124f
C265 avdd.n155 avss 0.00124f
C266 avdd.n156 avss 0.00124f
C267 avdd.n157 avss 0.00124f
C268 avdd.n158 avss 0
C269 avdd.n159 avss 0.01388f
C270 avdd.n160 avss 0
C271 avdd.n161 avss 0.00124f
C272 avdd.n162 avss 0.00124f
C273 avdd.n163 avss 0.00124f
C274 avdd.n164 avss 0.00124f
C275 avdd.n165 avss 0.00124f
C276 avdd.n166 avss 0
C277 avdd.n167 avss 0.01388f
C278 avdd.n168 avss 0
C279 avdd.n169 avss 0.00124f
C280 avdd.n170 avss 0.00124f
C281 avdd.n171 avss 0.00124f
C282 avdd.n172 avss 0.00529f
C283 avdd.n173 avss 0.00305f
C284 avdd.n174 avss 0.00101f
C285 avdd.n175 avss 0.00411f
C286 avdd.n176 avss 0.03267f
C287 avdd.n177 avss 0.00254f
C288 avdd.n178 avss 0.01505f
C289 avdd.n179 avss 0.00411f
C290 avdd.n180 avss 0.00324f
C291 avdd.n181 avss 0.0226f
C292 avdd.n182 avss 0.00254f
C293 avdd.n183 avss 0.00101f
C294 avdd.n184 avss 0.00101f
C295 avdd.n185 avss 0.00305f
C296 avdd.n186 avss 0.00324f
C297 avdd.n187 avss 0.00101f
C298 avdd.n188 avss 0.03267f
C299 avdd.n189 avss 0.00254f
C300 avdd.n190 avss 0.00305f
C301 avdd.n191 avss 0.0226f
C302 avdd.n192 avss 0.00254f
C303 avdd.n193 avss 0.00101f
C304 avdd.n194 avss 0.00101f
C305 avdd.n195 avss 0.00324f
C306 avdd.n196 avss 0.00727f
C307 avdd.n197 avss 0.00411f
C308 avdd.n198 avss 0.00254f
C309 avdd.n199 avss 0.0226f
C310 avdd.n200 avss 0.00254f
C311 avdd.n201 avss 0.00101f
C312 avdd.n202 avss 0.00305f
C313 avdd.n203 avss 0.01359f
C314 avdd.n204 avss 0.0286f
C315 avdd.n205 avss 0.00411f
C316 avdd.n206 avss 0.00254f
C317 avdd.n207 avss 0.0226f
C318 avdd.n208 avss 0.00254f
C319 avdd.n209 avss 0.00101f
C320 avdd.n210 avss 0.00305f
C321 avdd.n211 avss 0.00411f
C322 avdd.n212 avss 0.00411f
C323 avdd.n213 avss 0.00302f
C324 avdd.n214 avss 0.00101f
C325 avdd.n215 avss 0.00254f
C326 avdd.n216 avss 0.01889f
C327 avdd.n218 avss 0.00254f
C328 avdd.n219 avss 0.00101f
C329 avdd.n220 avss 0.00302f
C330 avdd.n221 avss 0.02075f
C331 avdd.n222 avss 0.00529f
C332 avdd.n223 avss 0.00305f
C333 avdd.n224 avss 0.00254f
C334 avdd.n225 avss 0.00411f
C335 avdd.n226 avss 0.0226f
C336 avdd.n227 avss 0.00254f
C337 avdd.n228 avss 0.00101f
C338 avdd.n229 avss 0.00305f
C339 avdd.n230 avss 0.01505f
C340 avdd.n231 avss 0.00254f
C341 avdd.n232 avss 0.00254f
C342 avdd.n233 avss 0.0226f
C343 avdd.n234 avss 0.00411f
C344 avdd.n235 avss 0.00101f
C345 avdd.n236 avss 0.00305f
C346 avdd.n237 avss 0.00101f
C347 avdd.n238 avss 0.00254f
C348 avdd.n239 avss 0.00101f
C349 avdd.n240 avss 0.00324f
C350 avdd.n241 avss 0.00727f
C351 avdd.n242 avss 0.00324f
C352 avdd.n243 avss 0.00101f
C353 avdd.n244 avss 0.00254f
C354 avdd.n245 avss 0.0226f
C355 avdd.n246 avss 0.03267f
C356 avdd.n247 avss 0.00411f
C357 avdd.n248 avss 0.0286f
C358 avdd.n249 avss 0.01359f
C359 avdd.n250 avss 0.00305f
C360 avdd.n251 avss 0.00324f
C361 avdd.n252 avss 0.00101f
C362 avdd.n253 avss 0.00254f
C363 avdd.n254 avss 0.00411f
C364 avdd.n255 avss 0.03267f
C365 avdd.n256 avss 0.0226f
C366 avdd.n257 avss 0.00254f
C367 avdd.n258 avss 0.00101f
C368 avdd.n259 avss 0.00101f
C369 avdd.n260 avss 0.00305f
C370 avdd.n261 avss 0.02025f
C371 avdd.n262 avss 0.03793f
C372 avdd.n263 avss 0.00529f
C373 avdd.n264 avss 0.00124f
C374 avdd.n265 avss 0.00124f
C375 avdd.n266 avss 0
C376 avdd.n267 avss 0.02388f
C377 avdd.n268 avss 0.01388f
C378 avdd.n269 avss 0
C379 avdd.n270 avss 0.00124f
C380 avdd.n271 avss 0.00124f
C381 avdd.n272 avss 0.00124f
C382 avdd.n273 avss 0
C383 avdd.n274 avss 0.01388f
C384 avdd.n275 avss 0
C385 avdd.n276 avss 0.00124f
C386 avdd.n277 avss 0.00124f
C387 avdd.n278 avss 0.00124f
C388 avdd.n279 avss 0
C389 avdd.n280 avss 0.01388f
C390 avdd.n281 avss 0
C391 avdd.n282 avss 0.00124f
C392 avdd.n283 avss 0.01828f
C393 avdd.n284 avss 0.02388f
C394 avdd.n285 avss 0.00347f
C395 avdd.n286 avss 0.00101f
C396 avdd.n287 avss 0.00254f
C397 avdd.n288 avss 0.01889f
C398 avdd.n290 avss 0.00254f
C399 avdd.n291 avss 0.00101f
C400 avdd.n292 avss 0.00321f
C401 avdd.n293 avss 0.00124f
C402 avdd.n294 avss 0.00124f
C403 avdd.n295 avss 0.00124f
C404 avdd.n296 avss 0
C405 avdd.n297 avss 0.01388f
C406 avdd.n298 avss 0
C407 avdd.n299 avss 0.00124f
C408 avdd.n300 avss 0.00124f
C409 avdd.n301 avss 0.00124f
C410 avdd.n302 avss 0.00124f
C411 avdd.n303 avss 0.00124f
C412 avdd.n304 avss 0
C413 avdd.n305 avss 0.01388f
C414 avdd.n306 avss 0
C415 avdd.n307 avss 0.00124f
C416 avdd.n308 avss 0.00124f
C417 avdd.n309 avss 0.00124f
C418 avdd.n310 avss 0.00321f
C419 avdd.n311 avss 0.00101f
C420 avdd.n312 avss 0.00254f
C421 avdd.n313 avss 0.01889f
C422 avdd.n315 avss 0.00254f
C423 avdd.n316 avss 0.00101f
C424 avdd.n317 avss 0.00302f
C425 avdd.n318 avss 0.02025f
C426 avdd.n319 avss 0.01569f
C427 avdd.n320 avss 0.01454f
C428 avdd.n321 avss 0.00124f
C429 avdd.n322 avss 0.00124f
C430 avdd.n323 avss 0
C431 avdd.n324 avss 0.00929f
C432 avdd.n327 avss 0.00929f
C433 avdd.n330 avss 0
C434 avdd.n331 avss 0.00124f
C435 avdd.n332 avss 0.00124f
C436 avdd.n333 avss 0.00523f
C437 avdd.n334 avss 0.00124f
C438 avdd.n335 avss 0.00523f
C439 avdd.n336 avss 0
C440 avdd.n337 avss 0
C441 avdd.n338 avss 0.00124f
C442 avdd.n339 avss 0.00124f
C443 avdd.n340 avss 0.00124f
C444 avdd.n341 avss 0.00101f
C445 avdd.n342 avss 0.00778f
C446 avdd.n343 avss 0.03591f
C447 avdd.n344 avss 0.00416f
C448 avdd.n345 avss 0.00101f
C449 avdd.n346 avss 0.00124f
C450 avdd.n347 avss 0
C451 avdd.n348 avss 0
C452 avdd.n349 avss 0.00124f
C453 avdd.n350 avss 0.00124f
C454 avdd.n351 avss 0.00124f
C455 avdd.n352 avss 0.00416f
C456 avdd.n353 avss 0.00101f
C457 avdd.n354 avss 0.00523f
C458 avdd.n355 avss 0.0836f
C459 avdd.n356 avss 0.14822f
C460 avdd.n357 avss 0.0836f
C461 avdd.n358 avss 0.00523f
C462 avdd.n359 avss 0.00101f
C463 avdd.n360 avss 0.00288f
C464 avdd.n361 avss 0.01703f
C465 avdd.n362 avss 0.02854f
C466 avdd.n363 avss 0.00533f
C467 avss.n0 avss 0.05217f
C468 avss.n1 avss 0.00733f
C469 avss.n2 avss 0.00114f
C470 avss.n3 avss 0
C471 avss.n4 avss 0
C472 avss.n5 avss 0
C473 avss.n6 avss 0
C474 avss.n7 avss 0.01345f
C475 avss.n8 avss 0
C476 avss.n9 avss 0.01068f
C477 avss.n10 avss 0
C478 avss.n11 avss 0
C479 avss.n12 avss 0.00352f
C480 avss.n13 avss 0
C481 avss.n14 avss 0
C482 avss.n15 avss 0
C483 avss.n16 avss 0
C484 avss.n17 avss 0
C485 avss.n18 avss 0
C486 avss.n19 avss 0
C487 avss.n20 avss 0.01253f
C488 avss.n21 avss 0.01345f
C489 avss.n22 avss 0
C490 avss.n23 avss 0
C491 avss.n24 avss 0.01068f
C492 avss.n25 avss 0
C493 avss.n26 avss 0
C494 avss.n27 avss 0
C495 avss.n28 avss 0
C496 avss.n29 avss 0
C497 avss.n30 avss 0
C498 avss.n31 avss 0
C499 avss.n32 avss 0
C500 avss.n33 avss 0.00782f
C501 avss.n34 avss 0
C502 avss.n35 avss 0.01136f
C503 avss.n36 avss 0
C504 avss.n37 avss 0
C505 avss.n38 avss 0.00673f
C506 avss.n39 avss 0
C507 avss.n40 avss 0
C508 avss.n41 avss 0
C509 avss.n42 avss 0
C510 avss.n43 avss 0
C511 avss.n44 avss 0
C512 avss.n45 avss 0
C513 avss.n46 avss 0.00765f
C514 avss.n47 avss 0
C515 avss.n48 avss 0
C516 avss.n49 avss 0.00673f
C517 avss.n50 avss 0
C518 avss.n51 avss 0
C519 avss.n52 avss 0
C520 avss.n53 avss 0
C521 avss.n54 avss 0.00325f
C522 avss.n55 avss 0
C523 avss.n56 avss 0
C524 avss.n57 avss 0
C525 avss.n58 avss 0.00908f
C526 avss.n59 avss 0.01005f
C527 avss.n60 avss 0
C528 avss.n61 avss 0
C529 avss.n62 avss 0
C530 avss.n63 avss 0
C531 avss.n64 avss 0
C532 avss.n65 avss 0
C533 avss.n66 avss 0.01499f
C534 avss.n67 avss 0.01103f
C535 avss.n68 avss 0.01744f
C536 avss.n69 avss 0.06086f
C537 avss.n72 avss 0
C538 avss.n73 avss 0
C539 avss.n74 avss 0
C540 avss.n75 avss 0
C541 avss.n76 avss 0
C542 avss.n77 avss 0
C543 avss.n78 avss 0
C544 avss.n79 avss 0
C545 avss.n80 avss 0.0232f
C546 avss.n81 avss 0
C547 avss.n82 avss 0
C548 avss.n83 avss 0
C549 avss.n84 avss 0
C550 avss.n85 avss 0
C551 avss.n86 avss 0
C552 avss.n88 avss 0
C553 avss.n89 avss 0
C554 avss.n90 avss 0
C555 avss.n91 avss 0
C556 avss.n92 avss 0
C557 avss.n93 avss 0
C558 avss.n94 avss 0
C559 avss.n96 avss 0.04144f
C560 avss.n97 avss 0.00908f
C561 avss.n98 avss 0
C562 avss.n99 avss 0
C563 avss.n100 avss 0
C564 avss.n101 avss 0
C565 avss.n109 avss 0
C566 avss.n110 avss 0.20364f
C567 avss.n111 avss 0
C568 avss.n112 avss 0
C569 avss.n113 avss 0
C570 avss.n114 avss 0
C571 avss.n115 avss 0
C572 avss.n118 avss 0
C573 avss.n119 avss 0.00157f
C574 avss.n120 avss 0
C575 avss.n121 avss 0
C576 avss.n122 avss 0
C577 avss.n123 avss 0
C578 avss.n124 avss 0
C579 avss.n125 avss 0
C580 avss.n126 avss 0
C581 avss.n127 avss 0
C582 avss.n128 avss 0
C583 avss.n129 avss 0
C584 avss.n130 avss 0
C585 avss.n131 avss 0
C586 avss.n132 avss 0
C587 avss.n133 avss 0
C588 avss.n134 avss 0
C589 avss.n135 avss 0
C590 avss.n136 avss 0
C591 avss.n137 avss 0
C592 avss.n138 avss 0
C593 avss.n139 avss 0
C594 avss.n140 avss 0
C595 avss.n141 avss 0
C596 avss.n142 avss 0
C597 avss.n143 avss 0
C598 avss.n144 avss 0
C599 avss.n145 avss 0
C600 avss.n146 avss 0
C601 avss.n147 avss 0.0723f
C602 avss.n153 avss 0
C603 avss.n154 avss 0
C604 avss.n155 avss 0
C605 avss.n156 avss 0
C606 avss.n157 avss 0
C607 avss.n158 avss 0
C608 avss.n159 avss 0
C609 avss.n160 avss 0
C610 avss.n161 avss 0
C611 avss.n162 avss 0
C612 avss.n163 avss 0
C613 avss.n164 avss 0
C614 avss.n165 avss 0
C615 avss.n167 avss 0
C616 avss.n168 avss 0
C617 avss.n169 avss 0
C618 avss.n170 avss 0
C619 avss.n172 avss 0
C620 avss.n173 avss 0
C621 avss.n175 avss 0
C622 avss.n176 avss 0
C623 avss.n177 avss 0
C624 avss.n178 avss 0
C625 avss.n180 avss 0
C626 avss.n181 avss 0
C627 avss.n183 avss 0
C628 avss.n184 avss 0
C629 avss.n185 avss 0
C630 avss.n186 avss 0
C631 avss.n188 avss 0
C632 avss.n189 avss 0
C633 avss.n190 avss 0
C634 avss.n191 avss 0
C635 avss.n192 avss 0
C636 avss.n193 avss 0
C637 avss.n194 avss 0
C638 avss.n195 avss 0
C639 avss.n196 avss 0
C640 avss.n197 avss 0
C641 avss.n198 avss 0
C642 avss.n199 avss 0
C643 avss.n200 avss 0
C644 avss.n201 avss 0
C645 avss.n202 avss 0
C646 avss.n203 avss 0
C647 avss.n204 avss 0
C648 avss.n205 avss 0
C649 avss.n206 avss 0
C650 avss.n207 avss 0
C651 avss.n208 avss 0
C652 avss.n209 avss 0
C653 avss.n210 avss 0.0057f
C654 avss.n211 avss 0
C655 avss.n212 avss 0
C656 avss.n213 avss 0
C657 avss.n214 avss 0
C658 avss.n215 avss 0
C659 avss.n216 avss 0
C660 avss.n217 avss 0
C661 avss.n218 avss 0
C662 avss.n219 avss 0
C663 avss.n220 avss 0
C664 avss.n221 avss 0
C665 avss.n222 avss 0
C666 avss.n223 avss 0
C667 avss.n224 avss 0
C668 avss.n225 avss 0
C669 avss.n226 avss 0
C670 avss.n227 avss 0
C671 avss.n228 avss 0
C672 avss.n229 avss 0
C673 avss.n230 avss 0
C674 avss.n231 avss 0
C675 avss.n232 avss 0
C676 avss.n233 avss 0
C677 avss.n234 avss 0
C678 avss.n236 avss 0.04558f
C679 avss.n238 avss 0
C680 avss.n239 avss 0
C681 avss.n240 avss 0
C682 avss.n241 avss 0
C683 avss.n242 avss 0.00114f
C684 avss.n243 avss 0
C685 avss.n244 avss 0.05715f
C686 avss.n245 avss 0
C687 avss.n246 avss 0
C688 avss.n247 avss 0
C689 avss.n248 avss 0
C690 avss.n249 avss 0
C691 avss.n250 avss 0
C692 avss.n251 avss 0
C693 avss.n252 avss 0
C694 avss.n253 avss 0
C695 avss.n254 avss 0
C696 avss.n255 avss 0
C697 avss.n256 avss 0
C698 avss.n257 avss 0
C699 avss.n258 avss 0
C700 avss.n259 avss 0
C701 avss.n260 avss 0
C702 avss.n261 avss 0
C703 avss.n262 avss 0
C704 avss.n263 avss 0
C705 avss.n264 avss 0
C706 avss.n265 avss 0
C707 avss.n266 avss 0
C708 avss.n267 avss 0
C709 avss.n268 avss 0.00269f
C710 avss.n269 avss 0.01345f
C711 avss.n270 avss 0
C712 avss.n271 avss 0
C713 avss.n272 avss 0
C714 avss.n273 avss 0
C715 avss.n274 avss 0
C716 avss.n275 avss 0
C717 avss.n279 avss 0
C718 avss.n280 avss 0.00157f
C719 avss.n281 avss 0
C720 avss.n282 avss 0
C721 avss.n283 avss 0
C722 avss.n284 avss 0
C723 avss.n285 avss 0
C724 avss.n286 avss 0
C725 avss.n287 avss 0
C726 avss.n288 avss 0
C727 avss.n289 avss 0
C728 avss.n290 avss 0
C729 avss.n291 avss 0
C730 avss.n292 avss 0
C731 avss.n293 avss 0
C732 avss.n294 avss 0
C733 avss.n295 avss 0
C734 avss.n296 avss 0
C735 avss.n297 avss 0
C736 avss.n298 avss 0
C737 avss.n299 avss 0
C738 avss.n300 avss 0
C739 avss.n301 avss 0.03944f
C740 avss.n303 avss 0
C741 avss.n304 avss 0
C742 avss.n305 avss 0
C743 avss.n306 avss 0
C744 avss.n307 avss 0
C745 avss.n308 avss 0
C746 avss.n309 avss 0
C747 avss.n310 avss 0
C748 avss.n311 avss 0
C749 avss.n312 avss 0.00782f
C750 avss.n313 avss 0
C751 avss.n314 avss 0
C752 avss.n315 avss 0
C753 avss.n316 avss 0
C754 avss.n317 avss 0
C755 avss.n318 avss 0
C756 avss.n319 avss 0
C757 avss.n320 avss 0
C758 avss.n321 avss 0
C759 avss.n322 avss 0
C760 avss.n323 avss 0
C761 avss.n324 avss 0
C762 avss.n325 avss 0
C763 avss.n326 avss 0
C764 avss.n327 avss 0
C765 avss.n328 avss 0
C766 avss.n329 avss 0
C767 avss.n330 avss 0
C768 avss.n331 avss 0
C769 avss.n332 avss 0.0078f
C770 avss.n333 avss 0.01759f
C771 avss.n335 avss 0
C772 avss.n336 avss 0
C773 avss.n337 avss 0
C774 avss.n338 avss 0
C775 avss.n339 avss 0
C776 avss.n340 avss 0
C777 avss.n341 avss 0
C778 avss.n342 avss 0
C779 avss.n343 avss 0
C780 avss.n344 avss 0.00563f
C781 avss.n345 avss 0
C782 avss.n346 avss 0
C783 avss.n347 avss 0
C784 avss.n348 avss 0
C785 avss.n349 avss 0
C786 avss.n350 avss 0
C787 avss.n352 avss 0
C788 avss.n353 avss 0
C789 avss.n354 avss 0
C790 avss.n355 avss 0
C791 avss.n356 avss 0
C792 avss.n357 avss 0
C793 avss.n359 avss 0
C794 avss.n360 avss 0
C795 avss.n361 avss 0
C796 avss.n362 avss 0
C797 avss.n363 avss 0
C798 avss.n364 avss 0
C799 avss.n365 avss 0
C800 avss.n366 avss 0
C801 avss.n367 avss 0
C802 avss.n368 avss 0
C803 avss.n369 avss 0.69727f
C804 avss.n370 avss 0.51821f
C805 avss.n371 avss 0.01165f
C806 avss.n372 avss 0
C807 avss.n373 avss 0
C808 avss.n374 avss 0
C809 avss.n375 avss 0
C810 avss.n376 avss 0
C811 avss.n377 avss 0
C812 avss.n378 avss 0
C813 avss.n379 avss 0.01165f
C814 avss.n380 avss 0.00673f
C815 avss.n381 avss 0.00673f
C816 avss.n382 avss 0
C817 avss.n383 avss 0
C818 avss.n384 avss 0
C819 avss.n385 avss 0
C820 avss.n386 avss 0
C821 avss.n387 avss 0
C822 avss.n388 avss 0.00673f
C823 avss.n389 avss 0
C824 avss.n390 avss 0
C825 avss.n391 avss 0.0074f
C826 avss.n392 avss 0
C827 avss.n393 avss 0
C828 avss.n394 avss 0
C829 avss.n395 avss 0
C830 avss.n396 avss 0
C831 avss.n397 avss 0
C832 avss.n398 avss 0
C833 avss.n399 avss 0
C834 avss.n400 avss 0.00673f
C835 avss.n401 avss 0
C836 avss.n402 avss 0
C837 avss.n403 avss 0
C838 avss.n404 avss 0
C839 avss.n405 avss 0
C840 avss.n406 avss 0
C841 avss.n407 avss 0
C842 avss.n408 avss 0.00917f
C843 avss.n409 avss 0.00673f
C844 avss.n410 avss 0
C845 avss.n411 avss 0
C846 avss.n412 avss 0
C847 avss.n413 avss 0
C848 avss.n414 avss 0
C849 avss.n415 avss 0.00925f
C850 avss.n416 avss 0
C851 avss.n417 avss 0
C852 avss.n418 avss 0
C853 avss.n419 avss 0
C854 avss.n420 avss 0
C855 avss.n421 avss 0.00325f
C856 avss.n422 avss 0
C857 avss.n423 avss 0
C858 avss.n424 avss 0
C859 avss.n425 avss 0
C860 avss.n426 avss 0
C861 avss.n427 avss 0
C862 avss.n428 avss 0
C863 avss.n429 avss 0
C864 avss.n430 avss 0
C865 avss.n431 avss 0
C866 avss.n432 avss 0
C867 avss.n433 avss 0
C868 avss.n434 avss 0
C869 avss.n435 avss 0
C870 avss.n436 avss 0
C871 avss.n437 avss 0.00157f
C872 avss.n438 avss 0
C873 avss.n439 avss 0.01354f
C874 avss.n440 avss 0.01703f
C875 avss.n441 avss 0.01837f
C876 avss.n442 avss 0
C877 avss.n443 avss 0
C878 avss.n444 avss 0
C879 avss.n445 avss 0.00293f
C880 avss.n446 avss 0.00617f
C881 avss.n447 avss 0
C882 avss.n448 avss 0.00673f
C883 avss.n449 avss 0.01102f
C884 avss.n450 avss 0
C885 avss.n451 avss 0
C886 avss.n452 avss 0
C887 avss.n453 avss 0
C888 avss.n454 avss 0
C889 avss.n455 avss 0
C890 avss.n456 avss 0
C891 avss.n457 avss 0
C892 avss.n458 avss 0.00921f
C893 avss.n459 avss 0
C894 avss.n460 avss 0
C895 avss.n461 avss 0
C896 avss.n462 avss 0
C897 avss.n463 avss 0
C898 avss.n464 avss 0
C899 avss.n465 avss 0
C900 avss.n466 avss 0
C901 avss.n467 avss 0
C902 avss.n468 avss 0
C903 avss.n469 avss 0
C904 avss.n470 avss 0
C905 avss.n471 avss 0
C906 avss.n472 avss 0
C907 avss.n473 avss 0
C908 avss.n474 avss 0
C909 avss.n475 avss 0
C910 avss.n476 avss 0
C911 avss.n477 avss 0
C912 avss.n478 avss 0
C913 avss.n479 avss 0.0127f
C914 avss.n480 avss 0.00673f
C915 avss.n481 avss 0
C916 avss.n482 avss 0
C917 avss.n483 avss 0
C918 avss.n484 avss 0
C919 avss.n485 avss 0
C920 avss.n486 avss 0
C921 avss.n487 avss 0
C922 avss.n488 avss 0
C923 avss.n489 avss 0
C924 avss.n490 avss 0.00255f
C925 avss.n491 avss 0
C926 avss.n492 avss 0
C927 avss.n493 avss 0
C928 avss.n494 avss 0
C929 avss.n495 avss 0
C930 avss.n496 avss 0
C931 avss.n497 avss 0
C932 avss.n498 avss 0
C933 avss.n499 avss 0.00757f
C934 avss.n500 avss 0
C935 avss.n501 avss 0
C936 avss.n502 avss 0
C937 avss.n503 avss 0
C938 avss.n504 avss 0
C939 avss.n505 avss 0.00748f
C940 avss.n506 avss 0.01278f
C941 avss.n507 avss 0
C942 avss.n508 avss 0
C943 avss.n509 avss 0
C944 avss.n510 avss 0
C945 avss.n511 avss 0
C946 avss.n512 avss 0.01097f
C947 avss.n513 avss 0.00673f
C948 avss.n514 avss 0
C949 avss.n515 avss 0
C950 avss.n516 avss 0
C951 avss.n517 avss 0.00293f
C952 avss.n518 avss 0.00541f
C953 avss.n519 avss 0.00293f
C954 avss.n520 avss 0
C955 avss.n521 avss 0
C956 avss.n522 avss 0
C957 avss.n523 avss 0.00673f
C958 avss.n524 avss 0
C959 avss.n525 avss 0
C960 avss.n526 avss 0
C961 avss.n527 avss 0
C962 avss.n528 avss 0
C963 avss.n529 avss 0.00114f
C964 avss.n530 avss 0
C965 avss.n531 avss 0.05691f
C966 avss.n532 avss 0.07027f
C967 avss.n533 avss 0.01467f
C968 avss.n534 avss 0.01475f
C969 avss.n535 avss 0.01475f
C970 avss.n536 avss 0.01103f
C971 avss.n537 avss 0
C972 avss.n538 avss 0
C973 avss.n539 avss 0
C974 avss.n540 avss 0
C975 avss.n541 avss 0
C976 avss.n542 avss 0.00673f
C977 avss.n543 avss 0.009f
C978 avss.n544 avss 0
C979 avss.n545 avss 0
C980 avss.n546 avss 0
C981 avss.n547 avss 0
C982 avss.n548 avss 0
C983 avss.n549 avss 0
C984 avss.n550 avss 0
C985 avss.n551 avss 0
C986 avss.n552 avss 0
C987 avss.n553 avss 0
C988 avss.n554 avss 0
C989 avss.n555 avss 0
C990 avss.n556 avss 0
C991 avss.n557 avss 0
C992 avss.n558 avss 0
C993 avss.n559 avss 0
C994 avss.n560 avss 0.01068f
C995 avss.n561 avss 0.00673f
C996 avss.n562 avss 0
C997 avss.n563 avss 0
C998 avss.n564 avss 0
C999 avss.n565 avss 0
C1000 avss.n566 avss 0
C1001 avss.n567 avss 0.00295f
C1002 avss.n568 avss 0.00541f
C1003 avss.n569 avss 0.00295f
C1004 avss.n570 avss 0
C1005 avss.n571 avss 0
C1006 avss.n572 avss 0
C1007 avss.n573 avss 0
C1008 avss.n574 avss 0.00673f
C1009 avss.n575 avss 0
C1010 avss.n576 avss 0
C1011 avss.n577 avss 0
C1012 avss.n578 avss 0
C1013 avss.n579 avss 0
C1014 avss.n580 avss 0
C1015 avss.n581 avss 0
C1016 avss.n582 avss 0
C1017 avss.n583 avss 0
C1018 avss.n584 avss 0
C1019 avss.n585 avss 0
C1020 avss.n586 avss 0
C1021 avss.n587 avss 0
C1022 avss.n588 avss 0
C1023 avss.n589 avss 0
C1024 avss.n590 avss 0
C1025 avss.n591 avss 0
C1026 avss.n592 avss 0
C1027 avss.n593 avss 0
C1028 avss.n594 avss 0
C1029 avss.n595 avss 0
C1030 avss.n596 avss 0.00891f
C1031 avss.n597 avss 0.00946f
C1032 avss.n598 avss 0
C1033 avss.n599 avss 0
C1034 avss.n600 avss 0
C1035 avss.n601 avss 0
C1036 avss.n602 avss 0
C1037 avss.n603 avss 0
C1038 avss.n604 avss 0
C1039 avss.n605 avss 0
C1040 avss.n606 avss 0.01127f
C1041 avss.n607 avss 0
C1042 avss.n608 avss 0
C1043 avss.n609 avss 0
C1044 avss.n610 avss 0
C1045 avss.n611 avss 0
C1046 avss.n612 avss 0
C1047 avss.n613 avss 0
C1048 avss.n614 avss 0
C1049 avss.n615 avss 0.01118f
C1050 avss.n616 avss 0
C1051 avss.n617 avss 0
C1052 avss.n618 avss 0
C1053 avss.n619 avss 0
C1054 avss.n620 avss 0.00152f
C1055 avss.n621 avss 0.00114f
C1056 avss.n622 avss 0
C1057 avss.n623 avss 0.01165f
C1058 avss.n624 avss 0.01068f
C1059 avss.n625 avss 0
C1060 avss.n626 avss 0.00617f
C1061 avss.n627 avss 0.00293f
C1062 avss.n628 avss 0
C1063 avss.n629 avss 0
C1064 avss.n630 avss 0
C1065 avss.n631 avss 0
C1066 avss.n632 avss 0.00673f
C1067 avss.n633 avss 0.01072f
C1068 avss.n634 avss 0
C1069 avss.n635 avss 0
C1070 avss.n636 avss 0
C1071 avss.n637 avss 0
C1072 avss.n638 avss 0
C1073 avss.n639 avss 0.01253f
C1074 avss.n640 avss 0.00774f
C1075 avss.n641 avss 0.01103f
C1076 avss.n642 avss 0.01245f
C1077 avss.n643 avss 0
C1078 avss.n644 avss 0
C1079 avss.n645 avss 0
C1080 avss.n646 avss 0
C1081 avss.n647 avss 0
C1082 avss.n648 avss 0.00157f
C1083 avss.n649 avss 0
C1084 avss.n650 avss 0.00673f
C1085 avss.n651 avss 0.00782f
C1086 avss.n652 avss 0.01345f
C1087 avss.n653 avss 0
C1088 avss.n654 avss 0
C1089 avss.n655 avss 0
C1090 avss.n656 avss 0
C1091 avss.n657 avss 0
C1092 avss.n658 avss 0.00298f
C1093 avss.n659 avss 0.00673f
C1094 avss.n660 avss 0
C1095 avss.n661 avss 0.01068f
C1096 avss.n662 avss 0.01253f
C1097 avss.n663 avss 0
C1098 avss.n664 avss 0
C1099 avss.n665 avss 0
C1100 avss.n666 avss 0.00152f
C1101 avss.n667 avss 0.00412f
C1102 avss.n668 avss 0.18205f
C1103 nvpost.n0 avss 0.09991f
C1104 nvpre.n0 avss 0.10267f
C1105 vpost.n0 avss 0.22714f
C1106 vpre.n0 avss 0.02042f
C1107 vb_idep.n0 avss 0.43249f
C1108 vb_itd.n0 avss 0.05095f
C1109 vb_itd.n1 avss 0.01139f
C1110 vb_itd.n2 avss 0.05875f
C1111 vb_itd.n3 avss 0.01139f
C1112 vb_itd.n4 avss 0.0417f
C1113 vb_itd.n5 avss 0.01139f
C1114 vb_itd.n6 avss 0.0417f
C1115 vb_itd.n7 avss 0.01139f
C1116 vb_itd.n8 avss 0.0372f
C1117 vb_itp.n0 avss 0.22277f
C1118 vb_pot.n0 avss 0.32366f
C1119 vw.n1 avss 0.00841f
C1120 vw.n2 avss 0.01367f
C1121 vw.n3 avss 0.00841f
C1122 vw.n5 avss 0.00841f
C1123 vw.n6 avss 0.00841f
C1124 vw.n7 avss 0.01367f
C1125 vw.n10 avss 0.02422f
C1126 vw.n12 avss 0.02422f
C1127 vw.n13 avss 0.00841f
C1128 vw.n16 avss 0.01367f
C1129 vw.n19 avss 0.00841f
C1130 vw.n20 avss 0.01367f
C1131 vw.n21 avss 0.00841f
C1132 vw.n23 avss 0.00841f
C1133 vw.n24 avss 0.00841f
C1134 vw.n25 avss 0.01367f
C1135 vw.n28 avss 0.02422f
C1136 vw.n30 avss 0.02422f
C1137 vw.n31 avss 0.00841f
C1138 vw.n34 avss 0.01367f
C1139 vw.n37 avss 0.00841f
C1140 vw.n38 avss 0.01367f
C1141 vw.n39 avss 0.00841f
C1142 vw.n41 avss 0.00841f
C1143 vw.n42 avss 0.00841f
C1144 vw.n43 avss 0.01367f
C1145 vw.n46 avss 0.02422f
C1146 vw.n48 avss 0.02422f
C1147 vw.n49 avss 0.00841f
C1148 vw.n52 avss 0.01367f
C1149 vw.n55 avss 0.00841f
C1150 vw.n56 avss 0.01367f
C1151 vw.n57 avss 0.00841f
C1152 vw.n59 avss 0.00841f
C1153 vw.n60 avss 0.00841f
C1154 vw.n61 avss 0.01367f
C1155 vw.n64 avss 0.02422f
C1156 vw.n66 avss 0.02422f
C1157 vw.n67 avss 0.00841f
C1158 vw.n70 avss 0.01367f
C1159 vw.n73 avss 0.00841f
C1160 vw.n74 avss 0.01367f
C1161 vw.n75 avss 0.00841f
C1162 vw.n77 avss 0.00841f
C1163 vw.n78 avss 0.00841f
C1164 vw.n79 avss 0.01367f
C1165 vw.n82 avss 0.02422f
C1166 vw.n84 avss 0.02422f
C1167 vw.n85 avss 0.00841f
C1168 vw.n88 avss 0.01367f
C1169 vw.n93 avss 0.02422f
C1170 vw.n95 avss 0.00841f
C1171 vw.n96 avss 0.06965f
C1172 vw.n97 avss 0.01367f
C1173 vw.n98 avss 0.0757f
C1174 vw.n102 avss 0.02422f
C1175 vw.n104 avss 0.00841f
C1176 vw.n105 avss 0.0757f
C1177 vw.n106 avss 0.01367f
C1178 vw.n107 avss 0.0757f
C1179 vw.n111 avss 0.02422f
C1180 vw.n113 avss 0.00841f
C1181 vw.n114 avss 0.0757f
C1182 vw.n115 avss 0.01367f
C1183 vw.n116 avss 0.0757f
C1184 vw.n120 avss 0.02422f
C1185 vw.n122 avss 0.00841f
C1186 vw.n123 avss 0.0757f
C1187 vw.n124 avss 0.01367f
C1188 vw.n125 avss 0.0757f
C1189 vw.n129 avss 0.02422f
C1190 vw.n131 avss 0.00841f
C1191 vw.n132 avss 0.0757f
C1192 vw.n133 avss 0.01367f
C1193 vw.n134 avss 0.13098f
C1194 vw.n135 avss 0.06054f
C1195 vw.n136 avss 0.1035f
C1196 vb_idep avss -0.02155f
C1197 xmcm_chain_1_0/a_1000_n131# avss 1.65926f
C1198 xmcm_chain_2_0/a_1000_n131# avss -0.24915f
C1199 nvpost avss 0.22958f
C1200 vb_pot avss 0.5933f
C1201 xm1_0/a_n63_n339# avss -5.28997f
C1202 vpost avss 0.50438f
C1203 xm9_0/a_63_n131# avss -5.33575f
C1204 Iout avss 0.31674f
C1205 xm7_0/a_63_n131# avss -1.16243f
C1206 xm8_0/a_63_n131# avss -0.90811f
C1207 avdd avss -13.09877f
C1208 xm1_0/a_63_n131# avss -1.21883f
C1209 xmcm_chain_4_0/a_1000_n131# avss -0.22796f
C1210 nvpre avss 0.11862f
C1211 xm4_0/a_n63_n339# avss -3.57092f
C1212 xm4_0/a_63_n131# avss 0.08061f
C1213 vb_itd avss -1.19968f
C1214 vb_itp avss -0.10164f
C1215 vw avss -2.26899f
C1216 xmcm_chain_3_0/a_1000_n131# avss -0.27416f
.ends
