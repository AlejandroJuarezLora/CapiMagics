* NGSPICE file created from stdp.ext - technology: gf180mcuD

.subckt xm5 a_n1500_n339# a_n1620_n131# w_n1886_n560# a_1500_n131# VSUBS
X0 a_1500_n131# a_n1500_n339# a_n1620_n131# w_n1886_n560# pfet_03v3 ad=0.3p pd=2.2u as=0.3p ps=2.2u w=0.5u l=15u
C0 a_1500_n131# a_n1500_n339# 0.06934f
C1 a_n1500_n339# a_n1620_n131# 0.6108f
C2 a_1500_n131# w_n1886_n560# 1.82938f
C3 w_n1886_n560# a_n1620_n131# 0.45972f
C4 w_n1886_n560# a_n1500_n339# 6.38155f
C5 a_1500_n131# a_n1620_n131# 1.44038f
C6 a_1500_n131# VSUBS 0.06141f
C7 a_n1620_n131# VSUBS 0.05599f
C8 a_n1500_n339# VSUBS 0.30906f
C9 w_n1886_n560# VSUBS 15.2029f
.ends

.subckt xm3 a_63_n131# a_n393_n504# a_n63_n339# a_n183_n131#
X0 a_63_n131# a_n63_n339# a_n183_n131# a_n393_n504# nfet_03v3 ad=0.3p pd=2.2u as=0.3p ps=2.2u w=0.5u l=0.63u
C0 a_n183_n131# a_63_n131# 0.33209f
C1 a_n63_n339# a_63_n131# 0.01741f
C2 a_n63_n339# a_n183_n131# 0.04027f
C3 a_63_n131# a_n393_n504# 0.53054f
C4 a_n183_n131# a_n393_n504# 0.26905f
C5 a_n63_n339# a_n393_n504# 0.50927f
.ends

.subckt xm1 a_63_n131# a_n63_n339# w_n449_n560# a_n183_n131# VSUBS
X0 a_63_n131# a_n63_n339# a_n183_n131# w_n449_n560# pfet_03v3 ad=0.3p pd=2.2u as=0.3p ps=2.2u w=0.5u l=0.63u
C0 a_63_n131# a_n63_n339# 0.01741f
C1 a_n63_n339# a_n183_n131# 0.04027f
C2 a_63_n131# w_n449_n560# 0.48511f
C3 w_n449_n560# a_n183_n131# 0.2249f
C4 w_n449_n560# a_n63_n339# 0.45684f
C5 a_63_n131# a_n183_n131# 0.33209f
C6 a_63_n131# VSUBS 0.04546f
C7 a_n183_n131# VSUBS 0.04416f
C8 a_n63_n339# VSUBS 0.05243f
C9 w_n449_n560# VSUBS 3.76898f
.ends

.subckt xmcm_chain_4 a_n1120_n131# a_n1330_n504# a_1000_n131# a_n1000_n339#
X0 a_1000_n131# a_n1000_n339# a_n1120_n131# a_n1330_n504# nfet_03v3 ad=0.3p pd=2.2u as=0.3p ps=2.2u w=0.5u l=10u
C0 a_n1120_n131# a_1000_n131# 1.01551f
C1 a_n1000_n339# a_1000_n131# 0.06176f
C2 a_n1000_n339# a_n1120_n131# 0.42273f
C3 a_1000_n131# a_n1330_n504# 1.43795f
C4 a_n1120_n131# a_n1330_n504# 0.4423f
C5 a_n1000_n339# a_n1330_n504# 4.53847f
.ends

.subckt xm8 a_63_n131# a_n63_n339# w_n449_n560# a_n183_n131# VSUBS
X0 a_63_n131# a_n63_n339# a_n183_n131# w_n449_n560# pfet_03v3 ad=0.3p pd=2.2u as=0.3p ps=2.2u w=0.5u l=0.63u
C0 a_63_n131# a_n63_n339# 0.01741f
C1 a_n63_n339# a_n183_n131# 0.04027f
C2 a_63_n131# w_n449_n560# 0.48511f
C3 w_n449_n560# a_n183_n131# 0.2249f
C4 w_n449_n560# a_n63_n339# 0.45684f
C5 a_63_n131# a_n183_n131# 0.33209f
C6 a_63_n131# VSUBS 0.04546f
C7 a_n183_n131# VSUBS 0.04416f
C8 a_n63_n339# VSUBS 0.05243f
C9 w_n449_n560# VSUBS 3.76898f
.ends

.subckt xmcm_chain_2 a_n1120_n131# a_n1330_n504# a_1000_n131# a_n1000_n339#
X0 a_1000_n131# a_n1000_n339# a_n1120_n131# a_n1330_n504# nfet_03v3 ad=0.3p pd=2.2u as=0.3p ps=2.2u w=0.5u l=10u
C0 a_n1120_n131# a_1000_n131# 1.01551f
C1 a_n1000_n339# a_1000_n131# 0.06176f
C2 a_n1000_n339# a_n1120_n131# 0.42273f
C3 a_1000_n131# a_n1330_n504# 1.43795f
C4 a_n1120_n131# a_n1330_n504# 0.4423f
C5 a_n1000_n339# a_n1330_n504# 4.53847f
.ends

.subckt xm16 a_n400_n1101# a_n280_n1309# w_n666_n1529# a_280_n1101# VSUBS
X0 a_280_n1101# a_n280_n1309# a_n400_n1101# w_n666_n1529# pfet_03v3 ad=6.12p pd=21.6u as=6.12p ps=21.6u w=10.2u l=2.8u
C0 a_280_n1101# a_n280_n1309# 0.57005f
C1 a_n280_n1309# a_n400_n1101# 0.64393f
C2 a_280_n1101# w_n666_n1529# 1.53123f
C3 w_n666_n1529# a_n400_n1101# 1.08957f
C4 w_n666_n1529# a_n280_n1309# 1.30956f
C5 a_280_n1101# a_n400_n1101# 0.72266f
C6 a_280_n1101# VSUBS 0.28176f
C7 a_n400_n1101# VSUBS 0.30514f
C8 a_n280_n1309# VSUBS 0.12268f
C9 w_n666_n1529# VSUBS 13.9301f
.ends

.subckt xmcm_chain_0 a_n1120_n131# a_n1330_n504# a_1000_n131# a_n1000_n339#
X0 a_1000_n131# a_n1000_n339# a_n1120_n131# a_n1330_n504# nfet_03v3 ad=0.3p pd=2.2u as=0.3p ps=2.2u w=0.5u l=10u
C0 a_n1120_n131# a_1000_n131# 1.01551f
C1 a_n1000_n339# a_1000_n131# 0.06176f
C2 a_n1000_n339# a_n1120_n131# 0.42273f
C3 a_1000_n131# a_n1330_n504# 1.43795f
C4 a_n1120_n131# a_n1330_n504# 0.4423f
C5 a_n1000_n339# a_n1330_n504# 4.53847f
.ends

.subckt xm4 a_63_n131# a_n393_n504# a_n63_n339# a_n183_n131#
X0 a_63_n131# a_n63_n339# a_n183_n131# a_n393_n504# nfet_03v3 ad=0.3p pd=2.2u as=0.3p ps=2.2u w=0.5u l=0.63u
C0 a_n183_n131# a_63_n131# 0.33209f
C1 a_n63_n339# a_63_n131# 0.01741f
C2 a_n63_n339# a_n183_n131# 0.04027f
C3 a_63_n131# a_n393_n504# 0.53054f
C4 a_n183_n131# a_n393_n504# 0.26905f
C5 a_n63_n339# a_n393_n504# 0.50927f
.ends

.subckt xm12 a_63_n131# a_n393_n504# a_n63_n339# a_n183_n131#
X0 a_63_n131# a_n63_n339# a_n183_n131# a_n393_n504# nfet_03v3 ad=0.3p pd=2.2u as=0.3p ps=2.2u w=0.5u l=0.63u
C0 a_n183_n131# a_63_n131# 0.33209f
C1 a_n63_n339# a_63_n131# 0.01741f
C2 a_n63_n339# a_n183_n131# 0.04027f
C3 a_63_n131# a_n393_n504# 0.53054f
C4 a_n183_n131# a_n393_n504# 0.26905f
C5 a_n63_n339# a_n393_n504# 0.50927f
.ends

.subckt xm2 a_63_n131# a_n63_n339# w_n449_n560# a_n183_n131# VSUBS
X0 a_63_n131# a_n63_n339# a_n183_n131# w_n449_n560# pfet_03v3 ad=0.3p pd=2.2u as=0.3p ps=2.2u w=0.5u l=0.63u
C0 a_63_n131# a_n63_n339# 0.01741f
C1 a_n63_n339# a_n183_n131# 0.04027f
C2 a_63_n131# w_n449_n560# 0.48511f
C3 w_n449_n560# a_n183_n131# 0.2249f
C4 w_n449_n560# a_n63_n339# 0.45684f
C5 a_63_n131# a_n183_n131# 0.33209f
C6 a_63_n131# VSUBS 0.04546f
C7 a_n183_n131# VSUBS 0.04416f
C8 a_n63_n339# VSUBS 0.05243f
C9 w_n449_n560# VSUBS 3.76898f
.ends

.subckt xmcm_1 a_n280_n350# a_n400_n141# a_280_n141# a_n610_n515#
X0 a_280_n141# a_n280_n350# a_n400_n141# a_n610_n515# nfet_03v3 ad=0.366p pd=2.42u as=0.366p ps=2.42u w=0.61u l=2.8u
C0 a_n400_n141# a_280_n141# 0.4351f
C1 a_n280_n350# a_280_n141# 0.04694f
C2 a_n280_n350# a_n400_n141# 0.1455f
C3 a_280_n141# a_n610_n515# 0.76826f
C4 a_n400_n141# a_n610_n515# 0.3279f
C5 a_n280_n350# a_n610_n515# 1.4155f
.ends

.subckt xm9 a_63_n131# a_n393_n504# a_n63_n339# a_n183_n131#
X0 a_63_n131# a_n63_n339# a_n183_n131# a_n393_n504# nfet_03v3 ad=0.3p pd=2.2u as=0.3p ps=2.2u w=0.5u l=0.63u
C0 a_n183_n131# a_63_n131# 0.33209f
C1 a_n63_n339# a_63_n131# 0.01741f
C2 a_n63_n339# a_n183_n131# 0.04027f
C3 a_63_n131# a_n393_n504# 0.53054f
C4 a_n183_n131# a_n393_n504# 0.26905f
C5 a_n63_n339# a_n393_n504# 0.50927f
.ends

.subckt xmcm_chain_3 a_n1120_n131# a_n1330_n504# a_1000_n131# a_n1000_n339#
X0 a_1000_n131# a_n1000_n339# a_n1120_n131# a_n1330_n504# nfet_03v3 ad=0.3p pd=2.2u as=0.3p ps=2.2u w=0.5u l=10u
C0 a_n1120_n131# a_1000_n131# 1.01551f
C1 a_n1000_n339# a_1000_n131# 0.06176f
C2 a_n1000_n339# a_n1120_n131# 0.42273f
C3 a_1000_n131# a_n1330_n504# 1.43795f
C4 a_n1120_n131# a_n1330_n504# 0.4423f
C5 a_n1000_n339# a_n1330_n504# 4.53847f
.ends

.subckt xm17 a_n460_n339# w_n846_n560# a_n580_n131# a_460_n131# VSUBS
X0 a_460_n131# a_n460_n339# a_n580_n131# w_n846_n560# pfet_03v3 ad=0.3p pd=2.2u as=0.3p ps=2.2u w=0.5u l=4.6u
C0 a_460_n131# a_n460_n339# 0.04912f
C1 a_n460_n339# a_n580_n131# 0.21491f
C2 a_460_n131# w_n846_n560# 0.87034f
C3 w_n846_n560# a_n580_n131# 0.30191f
C4 w_n846_n560# a_n460_n339# 2.05763f
C5 a_460_n131# a_n580_n131# 0.57434f
C6 a_460_n131# VSUBS 0.04483f
C7 a_n580_n131# VSUBS 0.04363f
C8 a_n460_n339# VSUBS 0.12333f
C9 w_n846_n560# VSUBS 6.90762f
.ends

.subckt xm7 a_63_n131# a_n63_n339# w_n449_n560# a_n183_n131# VSUBS
X0 a_63_n131# a_n63_n339# a_n183_n131# w_n449_n560# pfet_03v3 ad=0.3p pd=2.2u as=0.3p ps=2.2u w=0.5u l=0.63u
C0 a_63_n131# a_n63_n339# 0.01741f
C1 a_n63_n339# a_n183_n131# 0.04027f
C2 a_63_n131# w_n449_n560# 0.48511f
C3 w_n449_n560# a_n183_n131# 0.2249f
C4 w_n449_n560# a_n63_n339# 0.45684f
C5 a_63_n131# a_n183_n131# 0.33209f
C6 a_63_n131# VSUBS 0.04546f
C7 a_n183_n131# VSUBS 0.04416f
C8 a_n63_n339# VSUBS 0.05243f
C9 w_n449_n560# VSUBS 3.76898f
.ends

.subckt xmcm_chain_1 a_n1120_n131# a_n1330_n504# a_1000_n131# a_n1000_n339#
X0 a_1000_n131# a_n1000_n339# a_n1120_n131# a_n1330_n504# nfet_03v3 ad=0.3p pd=2.2u as=0.3p ps=2.2u w=0.5u l=10u
C0 a_n1120_n131# a_1000_n131# 1.01551f
C1 a_n1000_n339# a_1000_n131# 0.06176f
C2 a_n1000_n339# a_n1120_n131# 0.42273f
C3 a_1000_n131# a_n1330_n504# 1.43795f
C4 a_n1120_n131# a_n1330_n504# 0.4423f
C5 a_n1000_n339# a_n1330_n504# 4.53847f
.ends

.subckt stdp avdd avss nvpost nvpre vpost vpre vb_idep vb_itd vb_itp vb_pot vw Iout
Xxm5_0 vw avdd avdd Iout avss xm5
Xxm3_0 vw avss vpre xm4_0/a_63_n131# xm3
Xxm1_0 xm1_0/a_63_n131# Iout avdd avdd avss xm1
Xxmcm_chain_4_0 avss avss xmcm_chain_4_0/a_1000_n131# xmcm_chain_4_0/a_n1000_n339#
+ xmcm_chain_4
Xxm8_0 xm8_0/a_63_n131# nvpre avdd Iout avss xm8
Xxmcm_chain_2_0 xmcm_chain_3_0/a_1000_n131# avss xmcm_chain_2_0/a_1000_n131# xmcm_chain_4_0/a_n1000_n339#
+ xmcm_chain_2
Xxm16_0 avdd vb_idep avdd xm9_0/a_63_n131# avss xm16
Xxmcm_chain_0_0 xmcm_chain_1_0/a_1000_n131# avss vw vb_itd xmcm_chain_0
Xxm4_0 xm4_0/a_63_n131# avss vw avss xm4
Xxm12_0 xm9_0/a_63_n131# avss vpost vw xm12
Xxm2_0 vw nvpost avdd xm1_0/a_63_n131# avss xm2
Xxmcm_1_0 vb_pot avss xm7_0/a_63_n131# avss xmcm_1
Xxm9_0 xm9_0/a_63_n131# avss xm9_0/a_63_n131# avss xm9
Xxmcm_chain_3_0 xmcm_chain_4_0/a_1000_n131# avss xmcm_chain_3_0/a_1000_n131# xmcm_chain_4_0/a_n1000_n339#
+ xmcm_chain_3
Xxm17_0 vb_itp avdd avdd Iout avss xm17
Xxm7_0 xm7_0/a_63_n131# xm8_0/a_63_n131# avdd avdd avss xm7
Xxmcm_chain_1_0 xmcm_chain_2_0/a_1000_n131# avss xmcm_chain_1_0/a_1000_n131# xmcm_chain_4_0/a_n1000_n339#
+ xmcm_chain_1
R0 Iout Iout.n0 30.9914
R1 vw.n7 vw.n6 44.0168
R2 vw.n5 vw.n4 29.2979
R3 vw.n9 vw.n8 0.563
R4 vw.n10 vw.n3 0.563
R5 vw.n12 vw.n11 0.563
R6 vw.n13 vw.n2 0.563
R7 vw.n15 vw.n14 0.563
R8 vw.n16 vw.n1 0.563
R9 vw.n18 vw.n17 0.563
R10 vw.n19 vw.n0 0.563
R11 vw vw.n19 0.276202
R12 vw.n7 vw.n5 0.0732989
R13 vw.n9 vw.n5 0.046062
R14 vw.n12 vw.n3 0.03175
R15 vw.n18 vw.n1 0.03175
R16 vw.n11 vw.n10 0.03175
R17 vw.n17 vw.n16 0.03175
R18 vw.n8 vw.n3 0.0055
R19 vw.n13 vw.n12 0.0055
R20 vw.n14 vw.n13 0.0055
R21 vw.n14 vw.n1 0.0055
R22 vw.n19 vw.n18 0.0055
R23 vw.n10 vw.n9 0.0055
R24 vw.n11 vw.n2 0.0055
R25 vw.n15 vw.n2 0.0055
R26 vw.n16 vw.n15 0.0055
R27 vw.n17 vw.n0 0.0055
R28 vw.n8 vw.n7 0.00396875
R29 vw vw.n0 0.003
R30 vb_pot vb_pot.n0 10.7367
R31 vb_itp vb_itp.n0 9.49353
R32 vb_itd vb_itd.n0 9.84231
R33 vb_idep vb_idep.n0 23.2425
R34 vpre vpre.n0 29.108
R35 vpost vpost.n0 29.108
R36 nvpre nvpre.n0 29.108
R37 nvpost nvpost.n0 29.108
R38 avss.n573 avss.n124 27273.1
R39 avss.n513 avss.n124 17334.8
R40 avss.n516 avss.n514 14475
R41 avss.n516 avss.n515 14475
R42 avss.n512 avss.n56 14000
R43 avss.n517 avss.n516 14000
R44 avss.n514 avss.n212 14000
R45 avss.n515 avss.n138 14000
R46 avss.n511 avss.n7 14000
R47 avss.n515 avss.n124 12850
R48 avss.n514 avss.n513 5350
R49 avss.n511 avss.n510 4163.87
R50 avss.n472 avss.n471 2283.78
R51 avss.n400 avss.n273 2283.78
R52 avss.n512 avss.n511 2067.12
R53 avss.n471 avss.n470 1051.61
R54 avss.n513 avss.n512 773.053
R55 avss.n656 avss.n9 203.708
R56 avss.n510 avss.n213 203.343
R57 avss.n272 avss.n213 203.343
R58 avss.n289 avss.n228 203.343
R59 avss.n391 avss.n289 203.343
R60 avss.n615 avss.n614 198.688
R61 avss.n470 avss.n272 187.267
R62 avss.n518 avss.n84 182.19
R63 avss.n574 avss.n573 182.19
R64 avss.n212 avss.n82 157.803
R65 avss.n663 avss.n9 114.766
R66 avss.n656 avss.n655 114.766
R67 avss.n45 avss.n18 114.766
R68 avss.n45 avss.n27 114.766
R69 avss.n647 avss.n27 114.766
R70 avss.n647 avss.n30 114.766
R71 avss.n54 avss.n30 114.766
R72 avss.n632 avss.n67 114.766
R73 avss.n171 avss.n69 114.766
R74 avss.n211 avss.n152 114.766
R75 avss.n614 avss.n613 114.766
R76 avss.n600 avss.n93 114.766
R77 avss.n545 avss.n105 114.766
R78 avss.n554 avss.n112 114.766
R79 avss.n638 avss.n56 111.897
R80 avss.n160 avss.n74 104.007
R81 avss.n624 avss.n75 104.007
R82 avss.n528 avss.n150 101.855
R83 avss.n601 avss.n91 101.855
R84 avss.n581 avss.n580 100.419
R85 avss.n580 avss.n114 98.268
R86 avss.n561 avss.n122 98.268
R87 avss.n151 avss.n75 94.6816
R88 avss.n543 avss.n138 84.6397
R89 avss.n469 avss.n7 83.2051
R90 avss.n544 avss.n543 74.5977
R91 avss.n631 avss.n69 73.1632
R92 avss.n102 avss.n93 71.0113
R93 avss.n594 avss.n593 71.0113
R94 avss.n582 avss.n110 68.9311
R95 avss.n572 avss.n125 68.9311
R96 avss.n572 avss.n126 68.9311
R97 avss.n582 avss.n111 68.9311
R98 avss.n106 avss.n104 68.9311
R99 avss.n592 avss.n106 68.9311
R100 avss.n602 avss.n90 68.9311
R101 avss.n602 avss.n89 68.9311
R102 avss.n85 avss.n83 68.9311
R103 avss.n612 avss.n85 68.9311
R104 avss.n616 avss.n81 68.9311
R105 avss.n616 avss.n80 68.9311
R106 avss.n625 avss.n73 68.9311
R107 avss.n623 avss.n73 68.9311
R108 avss.n630 avss.n71 68.9311
R109 avss.n630 avss.n70 68.9311
R110 avss.n640 avss.n53 67.7644
R111 avss.n640 avss.n32 67.7644
R112 avss.n657 avss.n17 67.7644
R113 avss.n657 avss.n16 67.7644
R114 avss.n664 avss.n663 67.4249
R115 avss.n655 avss.n18 67.4249
R116 avss.n639 avss.n54 67.4249
R117 avss.n123 avss.n121 66.6949
R118 avss.n575 avss.n121 66.6949
R119 avss.n521 avss.n519 66.6949
R120 avss.n521 avss.n148 66.6949
R121 avss.n155 avss.n153 66.6949
R122 avss.n210 avss.n155 66.6949
R123 avss.n654 avss.n20 66.6949
R124 avss.n654 avss.n19 66.6949
R125 avss.n662 avss.n10 66.6949
R126 avss.n662 avss.n11 66.6949
R127 avss.n271 avss.n216 66.6949
R128 avss.n509 avss.n216 66.6949
R129 avss.n8 avss.n6 66.6949
R130 avss.n665 avss.n6 66.6949
R131 avss.n430 avss.n286 66.6949
R132 avss.n436 avss.n286 66.6949
R133 avss.n301 avss.n297 66.6949
R134 avss.n390 avss.n297 66.6949
R135 avss.n329 avss.n327 66.6949
R136 avss.n327 avss.n290 66.6949
R137 avss.n528 avss.n517 57.383
R138 avss.n517 avss.n91 57.383
R139 avss.n639 avss.n638 47.341
R140 avss.n594 avss.n102 43.7546
R141 avss.n593 avss.n105 43.7546
R142 avss.n632 avss.n631 41.6028
R143 avss.n545 avss.n544 40.1682
R144 avss.n470 avss.n273 31.7197
R145 avss.n664 avss.n7 31.5609
R146 avss.n554 avss.n138 30.1263
R147 avss.n212 avss.n211 24.3881
R148 avss.n152 avss.n151 20.0844
R149 avss.n561 avss.n114 16.498
R150 avss.n574 avss.n122 16.498
R151 avss.n125 avss.n110 15.5561
R152 avss.n126 avss.n111 15.5561
R153 avss.n592 avss.n90 15.5561
R154 avss.n104 avss.n89 15.5561
R155 avss.n612 avss.n81 15.5561
R156 avss.n83 avss.n80 15.5561
R157 avss.n623 avss.n71 15.5561
R158 avss.n625 avss.n70 15.5561
R159 avss.n44 avss.n17 15.5561
R160 avss.n44 avss.n31 15.5561
R161 avss.n646 avss.n31 15.5561
R162 avss.n646 avss.n32 15.5561
R163 avss.n46 avss.n16 15.5561
R164 avss.n46 avss.n39 15.5561
R165 avss.n39 avss.n28 15.5561
R166 avss.n53 avss.n28 15.5561
R167 avss.n527 avss.n519 15.5561
R168 avss.n527 avss.n94 15.5561
R169 avss.n599 avss.n94 15.5561
R170 avss.n599 avss.n95 15.5561
R171 avss.n595 avss.n95 15.5561
R172 avss.n595 avss.n101 15.5561
R173 avss.n546 avss.n101 15.5561
R174 avss.n546 avss.n139 15.5561
R175 avss.n553 avss.n139 15.5561
R176 avss.n553 avss.n115 15.5561
R177 avss.n579 avss.n115 15.5561
R178 avss.n579 avss.n116 15.5561
R179 avss.n575 avss.n116 15.5561
R180 avss.n529 avss.n148 15.5561
R181 avss.n529 avss.n149 15.5561
R182 avss.n149 avss.n92 15.5561
R183 avss.n535 avss.n92 15.5561
R184 avss.n535 avss.n103 15.5561
R185 avss.n142 avss.n103 15.5561
R186 avss.n542 avss.n142 15.5561
R187 avss.n542 avss.n136 15.5561
R188 avss.n555 avss.n136 15.5561
R189 avss.n555 avss.n137 15.5561
R190 avss.n137 avss.n113 15.5561
R191 avss.n562 avss.n113 15.5561
R192 avss.n562 avss.n123 15.5561
R193 avss.n23 avss.n20 15.5561
R194 avss.n648 avss.n23 15.5561
R195 avss.n648 avss.n26 15.5561
R196 avss.n57 avss.n26 15.5561
R197 avss.n637 avss.n57 15.5561
R198 avss.n637 avss.n58 15.5561
R199 avss.n633 avss.n58 15.5561
R200 avss.n633 avss.n66 15.5561
R201 avss.n170 avss.n66 15.5561
R202 avss.n170 avss.n161 15.5561
R203 avss.n166 avss.n161 15.5561
R204 avss.n166 avss.n154 15.5561
R205 avss.n210 avss.n154 15.5561
R206 avss.n178 avss.n19 15.5561
R207 avss.n178 avss.n29 15.5561
R208 avss.n184 avss.n29 15.5561
R209 avss.n185 avss.n184 15.5561
R210 avss.n185 avss.n55 15.5561
R211 avss.n190 avss.n55 15.5561
R212 avss.n190 avss.n68 15.5561
R213 avss.n193 avss.n68 15.5561
R214 avss.n193 avss.n172 15.5561
R215 avss.n200 avss.n172 15.5561
R216 avss.n201 avss.n200 15.5561
R217 avss.n202 avss.n201 15.5561
R218 avss.n202 avss.n153 15.5561
R219 avss.n271 avss.n231 15.5561
R220 avss.n264 avss.n263 15.5561
R221 avss.n261 avss.n260 15.5561
R222 avss.n257 avss.n256 15.5561
R223 avss.n253 avss.n252 15.5561
R224 avss.n249 avss.n248 15.5561
R225 avss.n245 avss.n11 15.5561
R226 avss.n509 avss.n217 15.5561
R227 avss.n505 avss.n504 15.5561
R228 avss.n501 avss.n500 15.5561
R229 avss.n498 avss.n473 15.5561
R230 avss.n494 avss.n493 15.5561
R231 avss.n491 avss.n480 15.5561
R232 avss.n487 avss.n10 15.5561
R233 avss.n428 avss.n427 15.5561
R234 avss.n425 avss.n393 15.5561
R235 avss.n421 avss.n420 15.5561
R236 avss.n418 avss.n401 15.5561
R237 avss.n414 avss.n413 15.5561
R238 avss.n411 avss.n5 15.5561
R239 avss.n665 avss.n5 15.5561
R240 avss.n440 avss.n438 15.5561
R241 avss.n446 avss.n282 15.5561
R242 avss.n450 avss.n448 15.5561
R243 avss.n456 avss.n278 15.5561
R244 avss.n460 avss.n458 15.5561
R245 avss.n468 avss.n274 15.5561
R246 avss.n468 avss.n8 15.5561
R247 avss.n304 avss.n303 15.5561
R248 avss.n309 avss.n308 15.5561
R249 avss.n312 avss.n311 15.5561
R250 avss.n317 avss.n316 15.5561
R251 avss.n320 avss.n319 15.5561
R252 avss.n325 avss.n324 15.5561
R253 avss.n390 avss.n298 15.5561
R254 avss.n354 avss.n353 15.5561
R255 avss.n356 avss.n355 15.5561
R256 avss.n360 avss.n359 15.5561
R257 avss.n362 avss.n361 15.5561
R258 avss.n366 avss.n365 15.5561
R259 avss.n367 avss.n290 15.5561
R260 avss.n581 avss.n112 14.3461
R261 avss.n518 avss.n150 12.9116
R262 avss.n601 avss.n600 12.9116
R263 avss.n171 avss.n160 10.7597
R264 avss.n624 avss.n74 10.7597
R265 avss.n470 avss.n469 10.0424
R266 avss.n130 avss.n1 6.57316
R267 avss.n670 avss.n0 5.96746
R268 avss.n470 avss.n228 5.6489
R269 avss.n207 avss.n1 5.20876
R270 avss.n669 avss.n668 5.20876
R271 avss.n275 avss.n274 5.2005
R272 avss.n461 avss.n460 5.2005
R273 avss.n458 avss.n277 5.2005
R274 avss.n456 avss.n455 5.2005
R275 avss.n279 avss.n278 5.2005
R276 avss.n451 avss.n450 5.2005
R277 avss.n448 avss.n281 5.2005
R278 avss.n446 avss.n445 5.2005
R279 avss.n411 avss.n410 5.2005
R280 avss.n413 avss.n406 5.2005
R281 avss.n415 avss.n414 5.2005
R282 avss.n416 avss.n401 5.2005
R283 avss.n418 avss.n417 5.2005
R284 avss.n420 avss.n398 5.2005
R285 avss.n422 avss.n421 5.2005
R286 avss.n423 avss.n393 5.2005
R287 avss.n488 avss.n487 5.2005
R288 avss.n489 avss.n480 5.2005
R289 avss.n491 avss.n490 5.2005
R290 avss.n493 avss.n478 5.2005
R291 avss.n495 avss.n494 5.2005
R292 avss.n496 avss.n473 5.2005
R293 avss.n498 avss.n497 5.2005
R294 avss.n500 avss.n223 5.2005
R295 avss.n246 avss.n245 5.2005
R296 avss.n248 avss.n247 5.2005
R297 avss.n250 avss.n249 5.2005
R298 avss.n252 avss.n251 5.2005
R299 avss.n254 avss.n253 5.2005
R300 avss.n256 avss.n255 5.2005
R301 avss.n258 avss.n257 5.2005
R302 avss.n260 avss.n259 5.2005
R303 avss.n466 avss.n8 5.2005
R304 avss.n664 avss.n8 5.2005
R305 avss.n468 avss.n467 5.2005
R306 avss.n469 avss.n468 5.2005
R307 avss.n666 avss.n665 5.2005
R308 avss.n665 avss.n664 5.2005
R309 avss.n5 avss.n4 5.2005
R310 avss.n469 avss.n5 5.2005
R311 avss.n204 avss.n153 5.2005
R312 avss.n211 avss.n153 5.2005
R313 avss.n203 avss.n202 5.2005
R314 avss.n202 avss.n152 5.2005
R315 avss.n201 avss.n159 5.2005
R316 avss.n201 avss.n75 5.2005
R317 avss.n200 avss.n199 5.2005
R318 avss.n200 avss.n74 5.2005
R319 avss.n173 avss.n172 5.2005
R320 avss.n172 avss.n171 5.2005
R321 avss.n194 avss.n193 5.2005
R322 avss.n193 avss.n69 5.2005
R323 avss.n192 avss.n68 5.2005
R324 avss.n632 avss.n68 5.2005
R325 avss.n191 avss.n190 5.2005
R326 avss.n190 avss.n67 5.2005
R327 avss.n175 avss.n55 5.2005
R328 avss.n638 avss.n55 5.2005
R329 avss.n186 avss.n185 5.2005
R330 avss.n185 avss.n54 5.2005
R331 avss.n184 avss.n183 5.2005
R332 avss.n184 avss.n30 5.2005
R333 avss.n182 avss.n29 5.2005
R334 avss.n647 avss.n29 5.2005
R335 avss.n179 avss.n178 5.2005
R336 avss.n178 avss.n27 5.2005
R337 avss.n177 avss.n19 5.2005
R338 avss.n45 avss.n19 5.2005
R339 avss.n210 avss.n209 5.2005
R340 avss.n211 avss.n210 5.2005
R341 avss.n156 avss.n154 5.2005
R342 avss.n154 avss.n152 5.2005
R343 avss.n167 avss.n166 5.2005
R344 avss.n166 avss.n75 5.2005
R345 avss.n168 avss.n161 5.2005
R346 avss.n161 avss.n74 5.2005
R347 avss.n170 avss.n169 5.2005
R348 avss.n171 avss.n170 5.2005
R349 avss.n66 avss.n65 5.2005
R350 avss.n69 avss.n66 5.2005
R351 avss.n634 avss.n633 5.2005
R352 avss.n633 avss.n632 5.2005
R353 avss.n635 avss.n58 5.2005
R354 avss.n67 avss.n58 5.2005
R355 avss.n637 avss.n636 5.2005
R356 avss.n638 avss.n637 5.2005
R357 avss.n59 avss.n57 5.2005
R358 avss.n57 avss.n54 5.2005
R359 avss.n26 avss.n25 5.2005
R360 avss.n30 avss.n26 5.2005
R361 avss.n649 avss.n648 5.2005
R362 avss.n648 avss.n647 5.2005
R363 avss.n650 avss.n23 5.2005
R364 avss.n27 avss.n23 5.2005
R365 avss.n651 avss.n20 5.2005
R366 avss.n45 avss.n20 5.2005
R367 avss.n564 avss.n123 5.2005
R368 avss.n574 avss.n123 5.2005
R369 avss.n563 avss.n562 5.2005
R370 avss.n562 avss.n561 5.2005
R371 avss.n560 avss.n113 5.2005
R372 avss.n580 avss.n113 5.2005
R373 avss.n137 avss.n133 5.2005
R374 avss.n137 avss.n112 5.2005
R375 avss.n556 avss.n555 5.2005
R376 avss.n555 avss.n554 5.2005
R377 avss.n136 avss.n135 5.2005
R378 avss.n543 avss.n136 5.2005
R379 avss.n542 avss.n541 5.2005
R380 avss.n545 avss.n542 5.2005
R381 avss.n143 avss.n142 5.2005
R382 avss.n142 avss.n105 5.2005
R383 avss.n537 avss.n103 5.2005
R384 avss.n594 avss.n103 5.2005
R385 avss.n536 avss.n535 5.2005
R386 avss.n535 avss.n93 5.2005
R387 avss.n534 avss.n92 5.2005
R388 avss.n600 avss.n92 5.2005
R389 avss.n149 avss.n145 5.2005
R390 avss.n149 avss.n91 5.2005
R391 avss.n530 avss.n529 5.2005
R392 avss.n529 avss.n528 5.2005
R393 avss.n148 avss.n147 5.2005
R394 avss.n518 avss.n148 5.2005
R395 avss.n576 avss.n575 5.2005
R396 avss.n575 avss.n574 5.2005
R397 avss.n577 avss.n116 5.2005
R398 avss.n561 avss.n116 5.2005
R399 avss.n579 avss.n578 5.2005
R400 avss.n580 avss.n579 5.2005
R401 avss.n117 avss.n115 5.2005
R402 avss.n115 avss.n112 5.2005
R403 avss.n553 avss.n552 5.2005
R404 avss.n554 avss.n553 5.2005
R405 avss.n140 avss.n139 5.2005
R406 avss.n543 avss.n139 5.2005
R407 avss.n547 avss.n546 5.2005
R408 avss.n546 avss.n545 5.2005
R409 avss.n101 avss.n100 5.2005
R410 avss.n105 avss.n101 5.2005
R411 avss.n596 avss.n595 5.2005
R412 avss.n595 avss.n594 5.2005
R413 avss.n597 avss.n95 5.2005
R414 avss.n95 avss.n93 5.2005
R415 avss.n599 avss.n598 5.2005
R416 avss.n600 avss.n599 5.2005
R417 avss.n96 avss.n94 5.2005
R418 avss.n94 avss.n91 5.2005
R419 avss.n527 avss.n526 5.2005
R420 avss.n528 avss.n527 5.2005
R421 avss.n520 avss.n519 5.2005
R422 avss.n519 avss.n518 5.2005
R423 avss.n485 avss.n10 5.2005
R424 avss.n469 avss.n10 5.2005
R425 avss.n244 avss.n11 5.2005
R426 avss.n469 avss.n11 5.2005
R427 avss.n53 avss.n52 5.2005
R428 avss.n53 avss.n30 5.2005
R429 avss.n51 avss.n28 5.2005
R430 avss.n647 avss.n28 5.2005
R431 avss.n39 avss.n37 5.2005
R432 avss.n39 avss.n27 5.2005
R433 avss.n47 avss.n46 5.2005
R434 avss.n46 avss.n45 5.2005
R435 avss.n38 avss.n16 5.2005
R436 avss.n18 avss.n16 5.2005
R437 avss.n644 avss.n32 5.2005
R438 avss.n32 avss.n30 5.2005
R439 avss.n646 avss.n645 5.2005
R440 avss.n647 avss.n646 5.2005
R441 avss.n33 avss.n31 5.2005
R442 avss.n31 avss.n27 5.2005
R443 avss.n44 avss.n43 5.2005
R444 avss.n45 avss.n44 5.2005
R445 avss.n40 avss.n17 5.2005
R446 avss.n18 avss.n17 5.2005
R447 avss.n626 avss.n625 5.2005
R448 avss.n625 avss.n624 5.2005
R449 avss.n627 avss.n70 5.2005
R450 avss.n160 avss.n70 5.2005
R451 avss.n623 avss.n622 5.2005
R452 avss.n624 avss.n623 5.2005
R453 avss.n76 avss.n71 5.2005
R454 avss.n160 avss.n71 5.2005
R455 avss.n606 avss.n83 5.2005
R456 avss.n613 avss.n83 5.2005
R457 avss.n605 avss.n80 5.2005
R458 avss.n614 avss.n80 5.2005
R459 avss.n612 avss.n611 5.2005
R460 avss.n613 avss.n612 5.2005
R461 avss.n86 avss.n81 5.2005
R462 avss.n614 avss.n81 5.2005
R463 avss.n586 avss.n104 5.2005
R464 avss.n593 avss.n104 5.2005
R465 avss.n585 avss.n89 5.2005
R466 avss.n102 avss.n89 5.2005
R467 avss.n592 avss.n591 5.2005
R468 avss.n593 avss.n592 5.2005
R469 avss.n107 avss.n90 5.2005
R470 avss.n102 avss.n90 5.2005
R471 avss.n568 avss.n126 5.2005
R472 avss.n126 avss.n122 5.2005
R473 avss.n567 avss.n111 5.2005
R474 avss.n114 avss.n111 5.2005
R475 avss.n127 avss.n110 5.2005
R476 avss.n114 avss.n110 5.2005
R477 avss.n128 avss.n125 5.2005
R478 avss.n125 avss.n122 5.2005
R479 avss.n283 avss.n282 5.2005
R480 avss.n441 avss.n440 5.2005
R481 avss.n438 avss.n285 5.2005
R482 avss.n436 avss.n435 5.2005
R483 avss.n425 avss.n424 5.2005
R484 avss.n427 avss.n392 5.2005
R485 avss.n428 avss.n288 5.2005
R486 avss.n431 avss.n430 5.2005
R487 avss.n502 avss.n501 5.2005
R488 avss.n504 avss.n503 5.2005
R489 avss.n506 avss.n505 5.2005
R490 avss.n507 avss.n217 5.2005
R491 avss.n509 avss.n508 5.2005
R492 avss.n510 avss.n509 5.2005
R493 avss.n262 avss.n261 5.2005
R494 avss.n265 avss.n264 5.2005
R495 avss.n263 avss.n234 5.2005
R496 avss.n269 avss.n231 5.2005
R497 avss.n271 avss.n270 5.2005
R498 avss.n272 avss.n271 5.2005
R499 avss.n330 avss.n329 5.2005
R500 avss.n331 avss.n325 5.2005
R501 avss.n324 avss.n321 5.2005
R502 avss.n335 avss.n320 5.2005
R503 avss.n336 avss.n319 5.2005
R504 avss.n337 avss.n317 5.2005
R505 avss.n316 avss.n313 5.2005
R506 avss.n341 avss.n312 5.2005
R507 avss.n342 avss.n311 5.2005
R508 avss.n343 avss.n309 5.2005
R509 avss.n308 avss.n305 5.2005
R510 avss.n347 avss.n304 5.2005
R511 avss.n348 avss.n303 5.2005
R512 avss.n349 avss.n301 5.2005
R513 avss.n368 avss.n290 5.2005
R514 avss.n391 avss.n290 5.2005
R515 avss.n371 avss.n367 5.2005
R516 avss.n372 avss.n366 5.2005
R517 avss.n373 avss.n365 5.2005
R518 avss.n363 avss.n362 5.2005
R519 avss.n377 avss.n361 5.2005
R520 avss.n378 avss.n360 5.2005
R521 avss.n379 avss.n359 5.2005
R522 avss.n357 avss.n356 5.2005
R523 avss.n383 avss.n355 5.2005
R524 avss.n384 avss.n354 5.2005
R525 avss.n385 avss.n353 5.2005
R526 avss.n299 avss.n298 5.2005
R527 avss.n390 avss.n389 5.2005
R528 avss.n391 avss.n390 5.2005
R529 avss.n571 avss.n129 5.20011
R530 avss.n583 avss.n109 5.20011
R531 avss.n588 avss.n587 5.20011
R532 avss.n608 avss.n607 5.20011
R533 avss.n619 avss.n72 5.20011
R534 avss.n629 avss.n628 5.20011
R535 avss.n603 avss.n88 5.19229
R536 avss.n617 avss.n79 5.19229
R537 avss.n641 avss.n36 5.19017
R538 avss.n658 avss.n15 5.18235
R539 avss.n206 avss.n205 5.17941
R540 avss.n653 avss.n652 5.17941
R541 avss.n653 avss.n21 5.17941
R542 avss.n661 avss.n12 5.17941
R543 avss.n522 avss.n146 5.17941
R544 avss.n523 avss.n522 5.17941
R545 avss.n233 avss.n232 5.17941
R546 avss.n232 avss.n218 5.17941
R547 avss.n465 avss.n2 5.17941
R548 avss.n433 avss.n432 5.17941
R549 avss.n434 avss.n433 5.17941
R550 avss.n388 avss.n351 5.17941
R551 avss.n326 avss.n322 5.17941
R552 avss.n351 avss.n350 5.17159
R553 avss.n642 avss.n641 4.96517
R554 avss.n659 avss.n658 4.96517
R555 avss.n661 avss.n660 4.95441
R556 avss.n584 avss.n583 4.95441
R557 avss.n589 avss.n588 4.95441
R558 avss.n604 avss.n603 4.95441
R559 avss.n609 avss.n608 4.95441
R560 avss.n618 avss.n617 4.95441
R561 avss.n620 avss.n619 4.95441
R562 avss.n629 avss.n35 4.95441
R563 avss.n570 avss.n569 4.7462
R564 avss.n208 avss.n207 4.7255
R565 avss.n566 avss.n565 4.7255
R566 avss.n130 avss.n120 4.7255
R567 avss.n668 avss.n667 4.7255
R568 avss.n369 avss.n0 4.7255
R569 avss.n650 avss.n22 4.5005
R570 avss.n649 avss.n24 4.5005
R571 avss.n60 avss.n25 4.5005
R572 avss.n61 avss.n59 4.5005
R573 avss.n636 avss.n62 4.5005
R574 avss.n635 avss.n63 4.5005
R575 avss.n634 avss.n64 4.5005
R576 avss.n162 avss.n65 4.5005
R577 avss.n169 avss.n163 4.5005
R578 avss.n168 avss.n164 4.5005
R579 avss.n167 avss.n165 4.5005
R580 avss.n157 avss.n156 4.5005
R581 avss.n209 avss.n208 4.5005
R582 avss.n652 avss.n651 4.5005
R583 avss.n180 avss.n179 4.5005
R584 avss.n182 avss.n181 4.5005
R585 avss.n183 avss.n176 4.5005
R586 avss.n187 avss.n186 4.5005
R587 avss.n188 avss.n175 4.5005
R588 avss.n191 avss.n189 4.5005
R589 avss.n192 avss.n174 4.5005
R590 avss.n195 avss.n194 4.5005
R591 avss.n196 avss.n173 4.5005
R592 avss.n199 avss.n198 4.5005
R593 avss.n197 avss.n159 4.5005
R594 avss.n203 avss.n158 4.5005
R595 avss.n205 avss.n204 4.5005
R596 avss.n177 avss.n21 4.5005
R597 avss.n48 avss.n47 4.5005
R598 avss.n49 avss.n37 4.5005
R599 avss.n51 avss.n50 4.5005
R600 avss.n52 avss.n36 4.5005
R601 avss.n38 avss.n15 4.5005
R602 avss.n531 avss.n530 4.5005
R603 avss.n532 avss.n145 4.5005
R604 avss.n534 avss.n533 4.5005
R605 avss.n536 avss.n144 4.5005
R606 avss.n538 avss.n537 4.5005
R607 avss.n539 avss.n143 4.5005
R608 avss.n541 avss.n540 4.5005
R609 avss.n135 avss.n134 4.5005
R610 avss.n557 avss.n556 4.5005
R611 avss.n558 avss.n133 4.5005
R612 avss.n560 avss.n559 4.5005
R613 avss.n563 avss.n132 4.5005
R614 avss.n565 avss.n564 4.5005
R615 avss.n147 avss.n146 4.5005
R616 avss.n526 avss.n525 4.5005
R617 avss.n524 avss.n96 4.5005
R618 avss.n598 avss.n97 4.5005
R619 avss.n597 avss.n98 4.5005
R620 avss.n596 avss.n99 4.5005
R621 avss.n141 avss.n100 4.5005
R622 avss.n548 avss.n547 4.5005
R623 avss.n549 avss.n140 4.5005
R624 avss.n552 avss.n551 4.5005
R625 avss.n550 avss.n117 4.5005
R626 avss.n578 avss.n118 4.5005
R627 avss.n577 avss.n119 4.5005
R628 avss.n576 avss.n120 4.5005
R629 avss.n523 avss.n520 4.5005
R630 avss.n127 avss.n109 4.5005
R631 avss.n129 avss.n128 4.5005
R632 avss.n587 avss.n586 4.5005
R633 avss.n585 avss.n88 4.5005
R634 avss.n607 avss.n606 4.5005
R635 avss.n605 avss.n79 4.5005
R636 avss.n626 avss.n72 4.5005
R637 avss.n628 avss.n627 4.5005
R638 avss.n622 avss.n621 4.5005
R639 avss.n77 avss.n76 4.5005
R640 avss.n611 avss.n610 4.5005
R641 avss.n86 avss.n78 4.5005
R642 avss.n591 avss.n590 4.5005
R643 avss.n107 avss.n87 4.5005
R644 avss.n569 avss.n568 4.5005
R645 avss.n567 avss.n108 4.5005
R646 avss.n43 avss.n42 4.5005
R647 avss.n41 avss.n33 4.5005
R648 avss.n645 avss.n34 4.5005
R649 avss.n644 avss.n643 4.5005
R650 avss.n40 avss.n14 4.5005
R651 avss.n269 avss.n268 4.5005
R652 avss.n267 avss.n234 4.5005
R653 avss.n266 avss.n265 4.5005
R654 avss.n262 avss.n235 4.5005
R655 avss.n259 avss.n236 4.5005
R656 avss.n258 avss.n237 4.5005
R657 avss.n255 avss.n238 4.5005
R658 avss.n254 avss.n239 4.5005
R659 avss.n251 avss.n240 4.5005
R660 avss.n250 avss.n241 4.5005
R661 avss.n247 avss.n242 4.5005
R662 avss.n246 avss.n243 4.5005
R663 avss.n244 avss.n13 4.5005
R664 avss.n270 avss.n233 4.5005
R665 avss.n507 avss.n219 4.5005
R666 avss.n506 avss.n220 4.5005
R667 avss.n503 avss.n221 4.5005
R668 avss.n502 avss.n222 4.5005
R669 avss.n474 avss.n223 4.5005
R670 avss.n497 avss.n475 4.5005
R671 avss.n496 avss.n476 4.5005
R672 avss.n495 avss.n477 4.5005
R673 avss.n481 avss.n478 4.5005
R674 avss.n490 avss.n482 4.5005
R675 avss.n489 avss.n483 4.5005
R676 avss.n488 avss.n484 4.5005
R677 avss.n485 avss.n12 4.5005
R678 avss.n508 avss.n218 4.5005
R679 avss.n288 avss.n287 4.5005
R680 avss.n394 avss.n392 4.5005
R681 avss.n424 avss.n395 4.5005
R682 avss.n423 avss.n396 4.5005
R683 avss.n422 avss.n397 4.5005
R684 avss.n402 avss.n398 4.5005
R685 avss.n417 avss.n403 4.5005
R686 avss.n416 avss.n404 4.5005
R687 avss.n415 avss.n405 4.5005
R688 avss.n408 avss.n406 4.5005
R689 avss.n410 avss.n409 4.5005
R690 avss.n4 avss.n3 4.5005
R691 avss.n667 avss.n666 4.5005
R692 avss.n432 avss.n431 4.5005
R693 avss.n285 avss.n284 4.5005
R694 avss.n442 avss.n441 4.5005
R695 avss.n443 avss.n283 4.5005
R696 avss.n445 avss.n444 4.5005
R697 avss.n281 avss.n280 4.5005
R698 avss.n452 avss.n451 4.5005
R699 avss.n453 avss.n279 4.5005
R700 avss.n455 avss.n454 4.5005
R701 avss.n277 avss.n276 4.5005
R702 avss.n462 avss.n461 4.5005
R703 avss.n463 avss.n275 4.5005
R704 avss.n467 avss.n464 4.5005
R705 avss.n466 avss.n465 4.5005
R706 avss.n435 avss.n434 4.5005
R707 avss.n387 avss.n299 4.5005
R708 avss.n386 avss.n385 4.5005
R709 avss.n384 avss.n352 4.5005
R710 avss.n383 avss.n382 4.5005
R711 avss.n381 avss.n357 4.5005
R712 avss.n380 avss.n379 4.5005
R713 avss.n378 avss.n358 4.5005
R714 avss.n377 avss.n376 4.5005
R715 avss.n375 avss.n363 4.5005
R716 avss.n374 avss.n373 4.5005
R717 avss.n372 avss.n364 4.5005
R718 avss.n371 avss.n370 4.5005
R719 avss.n369 avss.n368 4.5005
R720 avss.n389 avss.n388 4.5005
R721 avss.n348 avss.n300 4.5005
R722 avss.n347 avss.n346 4.5005
R723 avss.n345 avss.n305 4.5005
R724 avss.n344 avss.n343 4.5005
R725 avss.n342 avss.n306 4.5005
R726 avss.n341 avss.n340 4.5005
R727 avss.n339 avss.n313 4.5005
R728 avss.n338 avss.n337 4.5005
R729 avss.n336 avss.n314 4.5005
R730 avss.n335 avss.n334 4.5005
R731 avss.n333 avss.n321 4.5005
R732 avss.n332 avss.n331 4.5005
R733 avss.n330 avss.n322 4.5005
R734 avss.n350 avss.n349 4.5005
R735 avss avss.n670 4.5005
R736 avss.n613 avss.n84 3.5869
R737 avss.n263 avss.n230 3.11744
R738 avss.n261 avss.n229 3.11744
R739 avss.n257 avss.n224 3.11744
R740 avss.n253 avss.n225 3.11744
R741 avss.n249 avss.n226 3.11744
R742 avss.n245 avss.n227 3.11744
R743 avss.n505 avss.n215 3.11744
R744 avss.n501 avss.n214 3.11744
R745 avss.n499 avss.n498 3.11744
R746 avss.n494 avss.n479 3.11744
R747 avss.n492 avss.n491 3.11744
R748 avss.n487 avss.n486 3.11744
R749 avss.n429 avss.n428 3.11744
R750 avss.n426 avss.n425 3.11744
R751 avss.n421 avss.n399 3.11744
R752 avss.n419 avss.n418 3.11744
R753 avss.n414 avss.n407 3.11744
R754 avss.n412 avss.n411 3.11744
R755 avss.n438 avss.n437 3.11744
R756 avss.n439 avss.n282 3.11744
R757 avss.n448 avss.n447 3.11744
R758 avss.n449 avss.n278 3.11744
R759 avss.n458 avss.n457 3.11744
R760 avss.n459 avss.n274 3.11744
R761 avss.n460 avss.n459 3.11744
R762 avss.n457 avss.n456 3.11744
R763 avss.n450 avss.n449 3.11744
R764 avss.n447 avss.n446 3.11744
R765 avss.n413 avss.n412 3.11744
R766 avss.n407 avss.n401 3.11744
R767 avss.n420 avss.n419 3.11744
R768 avss.n399 avss.n393 3.11744
R769 avss.n486 avss.n480 3.11744
R770 avss.n493 avss.n492 3.11744
R771 avss.n479 avss.n473 3.11744
R772 avss.n500 avss.n499 3.11744
R773 avss.n248 avss.n227 3.11744
R774 avss.n252 avss.n226 3.11744
R775 avss.n256 avss.n225 3.11744
R776 avss.n260 avss.n224 3.11744
R777 avss.n440 avss.n439 3.11744
R778 avss.n437 avss.n436 3.11744
R779 avss.n427 avss.n426 3.11744
R780 avss.n430 avss.n429 3.11744
R781 avss.n504 avss.n214 3.11744
R782 avss.n217 avss.n215 3.11744
R783 avss.n264 avss.n229 3.11744
R784 avss.n231 avss.n230 3.11744
R785 avss.n302 avss.n301 3.11744
R786 avss.n307 avss.n304 3.11744
R787 avss.n310 avss.n309 3.11744
R788 avss.n315 avss.n312 3.11744
R789 avss.n318 avss.n317 3.11744
R790 avss.n323 avss.n320 3.11744
R791 avss.n328 avss.n325 3.11744
R792 avss.n329 avss.n328 3.11744
R793 avss.n324 avss.n323 3.11744
R794 avss.n319 avss.n318 3.11744
R795 avss.n316 avss.n315 3.11744
R796 avss.n311 avss.n310 3.11744
R797 avss.n308 avss.n307 3.11744
R798 avss.n303 avss.n302 3.11744
R799 avss.n353 avss.n296 3.11744
R800 avss.n355 avss.n295 3.11744
R801 avss.n359 avss.n294 3.11744
R802 avss.n361 avss.n293 3.11744
R803 avss.n365 avss.n292 3.11744
R804 avss.n367 avss.n291 3.11744
R805 avss.n366 avss.n291 3.11744
R806 avss.n362 avss.n292 3.11744
R807 avss.n360 avss.n293 3.11744
R808 avss.n356 avss.n294 3.11744
R809 avss.n354 avss.n295 3.11744
R810 avss.n298 avss.n296 3.11744
R811 avss.n67 avss.n56 2.86962
R812 avss.n615 avss.n82 1.43506
R813 avss.n669 avss.n1 1.3649
R814 avss.n459 avss.n273 1.04278
R815 avss.n457 avss.n273 1.04278
R816 avss.n449 avss.n273 1.04278
R817 avss.n447 avss.n273 1.04278
R818 avss.n412 avss.n400 1.04278
R819 avss.n407 avss.n400 1.04278
R820 avss.n419 avss.n400 1.04278
R821 avss.n400 avss.n399 1.04278
R822 avss.n486 avss.n472 1.04278
R823 avss.n492 avss.n472 1.04278
R824 avss.n479 avss.n472 1.04278
R825 avss.n499 avss.n472 1.04278
R826 avss.n471 avss.n227 1.04278
R827 avss.n471 avss.n226 1.04278
R828 avss.n471 avss.n225 1.04278
R829 avss.n471 avss.n224 1.04278
R830 avss.n439 avss.n228 1.04278
R831 avss.n437 avss.n228 1.04278
R832 avss.n426 avss.n391 1.04278
R833 avss.n429 avss.n391 1.04278
R834 avss.n510 avss.n214 1.04278
R835 avss.n510 avss.n215 1.04278
R836 avss.n272 avss.n229 1.04278
R837 avss.n272 avss.n230 1.04278
R838 avss.n328 avss.n228 1.04278
R839 avss.n323 avss.n228 1.04278
R840 avss.n318 avss.n228 1.04278
R841 avss.n315 avss.n228 1.04278
R842 avss.n310 avss.n228 1.04278
R843 avss.n307 avss.n228 1.04278
R844 avss.n302 avss.n228 1.04278
R845 avss.n391 avss.n291 1.04278
R846 avss.n391 avss.n292 1.04278
R847 avss.n391 avss.n293 1.04278
R848 avss.n391 avss.n294 1.04278
R849 avss.n391 avss.n295 1.04278
R850 avss.n391 avss.n296 1.04278
R851 avss.n6 avss.n2 0.743357
R852 avss.n9 avss.n6 0.743357
R853 avss.n654 avss.n653 0.743357
R854 avss.n655 avss.n654 0.743357
R855 avss.n206 avss.n155 0.743357
R856 avss.n155 avss.n82 0.743357
R857 avss.n522 avss.n521 0.743357
R858 avss.n521 avss.n84 0.743357
R859 avss.n131 avss.n121 0.743357
R860 avss.n573 avss.n121 0.743357
R861 avss.n662 avss.n661 0.743357
R862 avss.n663 avss.n662 0.743357
R863 avss.n658 avss.n657 0.743357
R864 avss.n657 avss.n656 0.743357
R865 avss.n641 avss.n640 0.743357
R866 avss.n640 avss.n639 0.743357
R867 avss.n630 avss.n629 0.743357
R868 avss.n631 avss.n630 0.743357
R869 avss.n619 avss.n73 0.743357
R870 avss.n151 avss.n73 0.743357
R871 avss.n617 avss.n616 0.743357
R872 avss.n616 avss.n615 0.743357
R873 avss.n608 avss.n85 0.743357
R874 avss.n150 avss.n85 0.743357
R875 avss.n603 avss.n602 0.743357
R876 avss.n602 avss.n601 0.743357
R877 avss.n588 avss.n106 0.743357
R878 avss.n544 avss.n106 0.743357
R879 avss.n583 avss.n582 0.743357
R880 avss.n582 avss.n581 0.743357
R881 avss.n572 avss.n571 0.743357
R882 avss.n573 avss.n572 0.743357
R883 avss.n433 avss.n286 0.743357
R884 avss.n289 avss.n286 0.743357
R885 avss.n232 avss.n216 0.743357
R886 avss.n216 avss.n213 0.743357
R887 avss.n351 avss.n297 0.743357
R888 avss.n297 avss.n289 0.743357
R889 avss.n327 avss.n326 0.743357
R890 avss.n327 avss.n289 0.743357
R891 avss.n670 avss.n669 0.6026
R892 avss.n207 avss.n206 0.454413
R893 avss.n131 avss.n130 0.454413
R894 avss.n566 avss.n131 0.454413
R895 avss.n571 avss.n570 0.454413
R896 avss.n668 avss.n2 0.454413
R897 avss.n326 avss.n0 0.454413
R898 avss.n570 avss.n566 0.427022
R899 avss.n620 avss.n618 0.4073
R900 avss.n609 avss.n604 0.4073
R901 avss.n589 avss.n584 0.4073
R902 avss.n642 avss.n35 0.402841
R903 avss.n660 avss.n659 0.402841
R904 avss.n77 avss.n35 0.2462
R905 avss.n621 avss.n620 0.2462
R906 avss.n618 avss.n78 0.2462
R907 avss.n610 avss.n609 0.2462
R908 avss.n604 avss.n87 0.2462
R909 avss.n590 avss.n589 0.2462
R910 avss.n584 avss.n108 0.2462
R911 avss.n660 avss.n13 0.2255
R912 avss.n659 avss.n14 0.203203
R913 avss.n643 avss.n642 0.203203
R914 avss.n651 avss.n650 0.1445
R915 avss.n650 avss.n649 0.1445
R916 avss.n649 avss.n25 0.1445
R917 avss.n59 avss.n25 0.1445
R918 avss.n636 avss.n59 0.1445
R919 avss.n636 avss.n635 0.1445
R920 avss.n635 avss.n634 0.1445
R921 avss.n634 avss.n65 0.1445
R922 avss.n169 avss.n65 0.1445
R923 avss.n169 avss.n168 0.1445
R924 avss.n168 avss.n167 0.1445
R925 avss.n167 avss.n156 0.1445
R926 avss.n209 avss.n156 0.1445
R927 avss.n652 avss.n22 0.1445
R928 avss.n24 avss.n22 0.1445
R929 avss.n60 avss.n24 0.1445
R930 avss.n61 avss.n60 0.1445
R931 avss.n62 avss.n61 0.1445
R932 avss.n63 avss.n62 0.1445
R933 avss.n64 avss.n63 0.1445
R934 avss.n162 avss.n64 0.1445
R935 avss.n163 avss.n162 0.1445
R936 avss.n164 avss.n163 0.1445
R937 avss.n165 avss.n164 0.1445
R938 avss.n165 avss.n157 0.1445
R939 avss.n208 avss.n157 0.1445
R940 avss.n180 avss.n21 0.1445
R941 avss.n181 avss.n180 0.1445
R942 avss.n181 avss.n176 0.1445
R943 avss.n187 avss.n176 0.1445
R944 avss.n188 avss.n187 0.1445
R945 avss.n189 avss.n188 0.1445
R946 avss.n189 avss.n174 0.1445
R947 avss.n195 avss.n174 0.1445
R948 avss.n196 avss.n195 0.1445
R949 avss.n198 avss.n196 0.1445
R950 avss.n198 avss.n197 0.1445
R951 avss.n197 avss.n158 0.1445
R952 avss.n205 avss.n158 0.1445
R953 avss.n179 avss.n177 0.1445
R954 avss.n182 avss.n179 0.1445
R955 avss.n183 avss.n182 0.1445
R956 avss.n186 avss.n183 0.1445
R957 avss.n186 avss.n175 0.1445
R958 avss.n191 avss.n175 0.1445
R959 avss.n192 avss.n191 0.1445
R960 avss.n194 avss.n192 0.1445
R961 avss.n194 avss.n173 0.1445
R962 avss.n199 avss.n173 0.1445
R963 avss.n199 avss.n159 0.1445
R964 avss.n203 avss.n159 0.1445
R965 avss.n204 avss.n203 0.1445
R966 avss.n270 avss.n269 0.1445
R967 avss.n269 avss.n234 0.1445
R968 avss.n265 avss.n234 0.1445
R969 avss.n265 avss.n262 0.1445
R970 avss.n262 avss.n259 0.1445
R971 avss.n259 avss.n258 0.1445
R972 avss.n258 avss.n255 0.1445
R973 avss.n255 avss.n254 0.1445
R974 avss.n254 avss.n251 0.1445
R975 avss.n251 avss.n250 0.1445
R976 avss.n250 avss.n247 0.1445
R977 avss.n247 avss.n246 0.1445
R978 avss.n246 avss.n244 0.1445
R979 avss.n43 avss.n40 0.1445
R980 avss.n43 avss.n33 0.1445
R981 avss.n645 avss.n33 0.1445
R982 avss.n645 avss.n644 0.1445
R983 avss.n47 avss.n38 0.1445
R984 avss.n47 avss.n37 0.1445
R985 avss.n51 avss.n37 0.1445
R986 avss.n52 avss.n51 0.1445
R987 avss.n48 avss.n15 0.1445
R988 avss.n49 avss.n48 0.1445
R989 avss.n50 avss.n49 0.1445
R990 avss.n50 avss.n36 0.1445
R991 avss.n568 avss.n567 0.1445
R992 avss.n591 avss.n107 0.1445
R993 avss.n611 avss.n86 0.1445
R994 avss.n622 avss.n76 0.1445
R995 avss.n128 avss.n127 0.1445
R996 avss.n526 avss.n520 0.1445
R997 avss.n526 avss.n96 0.1445
R998 avss.n598 avss.n96 0.1445
R999 avss.n598 avss.n597 0.1445
R1000 avss.n597 avss.n596 0.1445
R1001 avss.n596 avss.n100 0.1445
R1002 avss.n547 avss.n100 0.1445
R1003 avss.n547 avss.n140 0.1445
R1004 avss.n552 avss.n140 0.1445
R1005 avss.n552 avss.n117 0.1445
R1006 avss.n578 avss.n117 0.1445
R1007 avss.n578 avss.n577 0.1445
R1008 avss.n577 avss.n576 0.1445
R1009 avss.n530 avss.n147 0.1445
R1010 avss.n530 avss.n145 0.1445
R1011 avss.n534 avss.n145 0.1445
R1012 avss.n536 avss.n534 0.1445
R1013 avss.n537 avss.n536 0.1445
R1014 avss.n537 avss.n143 0.1445
R1015 avss.n541 avss.n143 0.1445
R1016 avss.n541 avss.n135 0.1445
R1017 avss.n556 avss.n135 0.1445
R1018 avss.n556 avss.n133 0.1445
R1019 avss.n560 avss.n133 0.1445
R1020 avss.n563 avss.n560 0.1445
R1021 avss.n564 avss.n563 0.1445
R1022 avss.n531 avss.n146 0.1445
R1023 avss.n532 avss.n531 0.1445
R1024 avss.n533 avss.n532 0.1445
R1025 avss.n533 avss.n144 0.1445
R1026 avss.n538 avss.n144 0.1445
R1027 avss.n539 avss.n538 0.1445
R1028 avss.n540 avss.n539 0.1445
R1029 avss.n540 avss.n134 0.1445
R1030 avss.n557 avss.n134 0.1445
R1031 avss.n558 avss.n557 0.1445
R1032 avss.n559 avss.n558 0.1445
R1033 avss.n559 avss.n132 0.1445
R1034 avss.n565 avss.n132 0.1445
R1035 avss.n525 avss.n523 0.1445
R1036 avss.n525 avss.n524 0.1445
R1037 avss.n524 avss.n97 0.1445
R1038 avss.n98 avss.n97 0.1445
R1039 avss.n99 avss.n98 0.1445
R1040 avss.n141 avss.n99 0.1445
R1041 avss.n548 avss.n141 0.1445
R1042 avss.n549 avss.n548 0.1445
R1043 avss.n551 avss.n549 0.1445
R1044 avss.n551 avss.n550 0.1445
R1045 avss.n550 avss.n118 0.1445
R1046 avss.n119 avss.n118 0.1445
R1047 avss.n120 avss.n119 0.1445
R1048 avss.n129 avss.n109 0.1445
R1049 avss.n586 avss.n585 0.1445
R1050 avss.n587 avss.n88 0.1445
R1051 avss.n606 avss.n605 0.1445
R1052 avss.n607 avss.n79 0.1445
R1053 avss.n627 avss.n626 0.1445
R1054 avss.n628 avss.n72 0.1445
R1055 avss.n621 avss.n77 0.1445
R1056 avss.n610 avss.n78 0.1445
R1057 avss.n590 avss.n87 0.1445
R1058 avss.n569 avss.n108 0.1445
R1059 avss.n268 avss.n233 0.1445
R1060 avss.n268 avss.n267 0.1445
R1061 avss.n267 avss.n266 0.1445
R1062 avss.n266 avss.n235 0.1445
R1063 avss.n236 avss.n235 0.1445
R1064 avss.n237 avss.n236 0.1445
R1065 avss.n238 avss.n237 0.1445
R1066 avss.n239 avss.n238 0.1445
R1067 avss.n240 avss.n239 0.1445
R1068 avss.n241 avss.n240 0.1445
R1069 avss.n242 avss.n241 0.1445
R1070 avss.n243 avss.n242 0.1445
R1071 avss.n243 avss.n13 0.1445
R1072 avss.n219 avss.n218 0.1445
R1073 avss.n220 avss.n219 0.1445
R1074 avss.n221 avss.n220 0.1445
R1075 avss.n222 avss.n221 0.1445
R1076 avss.n474 avss.n222 0.1445
R1077 avss.n475 avss.n474 0.1445
R1078 avss.n476 avss.n475 0.1445
R1079 avss.n477 avss.n476 0.1445
R1080 avss.n481 avss.n477 0.1445
R1081 avss.n482 avss.n481 0.1445
R1082 avss.n483 avss.n482 0.1445
R1083 avss.n484 avss.n483 0.1445
R1084 avss.n484 avss.n12 0.1445
R1085 avss.n508 avss.n507 0.1445
R1086 avss.n507 avss.n506 0.1445
R1087 avss.n506 avss.n503 0.1445
R1088 avss.n503 avss.n502 0.1445
R1089 avss.n502 avss.n223 0.1445
R1090 avss.n497 avss.n223 0.1445
R1091 avss.n497 avss.n496 0.1445
R1092 avss.n496 avss.n495 0.1445
R1093 avss.n495 avss.n478 0.1445
R1094 avss.n490 avss.n478 0.1445
R1095 avss.n490 avss.n489 0.1445
R1096 avss.n489 avss.n488 0.1445
R1097 avss.n488 avss.n485 0.1445
R1098 avss.n431 avss.n288 0.1445
R1099 avss.n392 avss.n288 0.1445
R1100 avss.n424 avss.n392 0.1445
R1101 avss.n424 avss.n423 0.1445
R1102 avss.n423 avss.n422 0.1445
R1103 avss.n422 avss.n398 0.1445
R1104 avss.n417 avss.n398 0.1445
R1105 avss.n417 avss.n416 0.1445
R1106 avss.n416 avss.n415 0.1445
R1107 avss.n415 avss.n406 0.1445
R1108 avss.n410 avss.n406 0.1445
R1109 avss.n410 avss.n4 0.1445
R1110 avss.n666 avss.n4 0.1445
R1111 avss.n432 avss.n287 0.1445
R1112 avss.n394 avss.n287 0.1445
R1113 avss.n395 avss.n394 0.1445
R1114 avss.n396 avss.n395 0.1445
R1115 avss.n397 avss.n396 0.1445
R1116 avss.n402 avss.n397 0.1445
R1117 avss.n403 avss.n402 0.1445
R1118 avss.n404 avss.n403 0.1445
R1119 avss.n405 avss.n404 0.1445
R1120 avss.n408 avss.n405 0.1445
R1121 avss.n409 avss.n408 0.1445
R1122 avss.n409 avss.n3 0.1445
R1123 avss.n667 avss.n3 0.1445
R1124 avss.n434 avss.n284 0.1445
R1125 avss.n442 avss.n284 0.1445
R1126 avss.n443 avss.n442 0.1445
R1127 avss.n444 avss.n443 0.1445
R1128 avss.n444 avss.n280 0.1445
R1129 avss.n452 avss.n280 0.1445
R1130 avss.n453 avss.n452 0.1445
R1131 avss.n454 avss.n453 0.1445
R1132 avss.n454 avss.n276 0.1445
R1133 avss.n462 avss.n276 0.1445
R1134 avss.n463 avss.n462 0.1445
R1135 avss.n464 avss.n463 0.1445
R1136 avss.n465 avss.n464 0.1445
R1137 avss.n435 avss.n285 0.1445
R1138 avss.n441 avss.n285 0.1445
R1139 avss.n441 avss.n283 0.1445
R1140 avss.n445 avss.n283 0.1445
R1141 avss.n445 avss.n281 0.1445
R1142 avss.n451 avss.n281 0.1445
R1143 avss.n451 avss.n279 0.1445
R1144 avss.n455 avss.n279 0.1445
R1145 avss.n455 avss.n277 0.1445
R1146 avss.n461 avss.n277 0.1445
R1147 avss.n461 avss.n275 0.1445
R1148 avss.n467 avss.n275 0.1445
R1149 avss.n467 avss.n466 0.1445
R1150 avss.n349 avss.n348 0.1445
R1151 avss.n348 avss.n347 0.1445
R1152 avss.n347 avss.n305 0.1445
R1153 avss.n343 avss.n305 0.1445
R1154 avss.n343 avss.n342 0.1445
R1155 avss.n342 avss.n341 0.1445
R1156 avss.n341 avss.n313 0.1445
R1157 avss.n337 avss.n313 0.1445
R1158 avss.n337 avss.n336 0.1445
R1159 avss.n336 avss.n335 0.1445
R1160 avss.n335 avss.n321 0.1445
R1161 avss.n331 avss.n321 0.1445
R1162 avss.n331 avss.n330 0.1445
R1163 avss.n389 avss.n299 0.1445
R1164 avss.n385 avss.n299 0.1445
R1165 avss.n385 avss.n384 0.1445
R1166 avss.n384 avss.n383 0.1445
R1167 avss.n383 avss.n357 0.1445
R1168 avss.n379 avss.n357 0.1445
R1169 avss.n379 avss.n378 0.1445
R1170 avss.n378 avss.n377 0.1445
R1171 avss.n377 avss.n363 0.1445
R1172 avss.n373 avss.n363 0.1445
R1173 avss.n373 avss.n372 0.1445
R1174 avss.n372 avss.n371 0.1445
R1175 avss.n371 avss.n368 0.1445
R1176 avss.n388 avss.n387 0.1445
R1177 avss.n387 avss.n386 0.1445
R1178 avss.n386 avss.n352 0.1445
R1179 avss.n382 avss.n352 0.1445
R1180 avss.n382 avss.n381 0.1445
R1181 avss.n381 avss.n380 0.1445
R1182 avss.n380 avss.n358 0.1445
R1183 avss.n376 avss.n358 0.1445
R1184 avss.n376 avss.n375 0.1445
R1185 avss.n375 avss.n374 0.1445
R1186 avss.n374 avss.n364 0.1445
R1187 avss.n370 avss.n364 0.1445
R1188 avss.n370 avss.n369 0.1445
R1189 avss.n350 avss.n300 0.1445
R1190 avss.n346 avss.n300 0.1445
R1191 avss.n346 avss.n345 0.1445
R1192 avss.n345 avss.n344 0.1445
R1193 avss.n344 avss.n306 0.1445
R1194 avss.n340 avss.n306 0.1445
R1195 avss.n340 avss.n339 0.1445
R1196 avss.n339 avss.n338 0.1445
R1197 avss.n338 avss.n314 0.1445
R1198 avss.n334 avss.n314 0.1445
R1199 avss.n334 avss.n333 0.1445
R1200 avss.n333 avss.n332 0.1445
R1201 avss.n332 avss.n322 0.1445
R1202 avss.n42 avss.n14 0.13023
R1203 avss.n42 avss.n41 0.13023
R1204 avss.n41 avss.n34 0.13023
R1205 avss.n643 avss.n34 0.13023
R1206 avdd.n323 avdd.n322 1078.83
R1207 avdd.n322 avdd.n321 1078.83
R1208 avdd.n173 avdd.n142 522.652
R1209 avdd.n147 avdd.n142 522.652
R1210 avdd.n165 avdd.n154 522.652
R1211 avdd.n157 avdd.n154 522.652
R1212 avdd.n212 avdd.n211 522.652
R1213 avdd.n212 avdd.n199 522.652
R1214 avdd.n222 avdd.n221 522.652
R1215 avdd.n221 avdd.n192 522.652
R1216 avdd.n324 avdd.n290 144.812
R1217 avdd.n320 avdd.n290 144.812
R1218 avdd.n299 avdd.n293 144.812
R1219 avdd.n301 avdd.n293 144.812
R1220 avdd.n69 avdd.n59 142.857
R1221 avdd.n69 avdd.n53 142.857
R1222 avdd.n77 avdd.n53 142.857
R1223 avdd.n77 avdd.n47 142.857
R1224 avdd.n85 avdd.n47 142.857
R1225 avdd.n85 avdd.n41 142.857
R1226 avdd.n93 avdd.n41 142.857
R1227 avdd.n93 avdd.n35 142.857
R1228 avdd.n101 avdd.n35 142.857
R1229 avdd.n101 avdd.n29 142.857
R1230 avdd.n109 avdd.n29 142.857
R1231 avdd.n109 avdd.n23 142.857
R1232 avdd.n117 avdd.n23 142.857
R1233 avdd.n117 avdd.n17 142.857
R1234 avdd.n125 avdd.n17 142.857
R1235 avdd.n125 avdd.n11 142.857
R1236 avdd.n133 avdd.n11 142.857
R1237 avdd.n133 avdd.n5 142.857
R1238 avdd.n182 avdd.n5 142.857
R1239 avdd.n254 avdd.n246 142.857
R1240 avdd.n263 avdd.n246 142.857
R1241 avdd.n263 avdd.n240 142.857
R1242 avdd.n271 avdd.n240 142.857
R1243 avdd.n271 avdd.n234 142.857
R1244 avdd.n279 avdd.n234 142.857
R1245 avdd.n174 avdd.n141 62.038
R1246 avdd.n148 avdd.n141 62.038
R1247 avdd.n171 avdd.n143 62.038
R1248 avdd.n172 avdd.n171 62.038
R1249 avdd.n163 avdd.n155 62.038
R1250 avdd.n164 avdd.n163 62.038
R1251 avdd.n158 avdd.n145 62.038
R1252 avdd.n166 avdd.n145 62.038
R1253 avdd.n213 avdd.n197 62.038
R1254 avdd.n213 avdd.n198 62.038
R1255 avdd.n204 avdd.n200 62.038
R1256 avdd.n210 avdd.n200 62.038
R1257 avdd.n223 avdd.n191 62.038
R1258 avdd.n193 avdd.n191 62.038
R1259 avdd.n220 avdd.n219 62.038
R1260 avdd.n220 avdd.n190 62.038
R1261 avdd.n181 avdd.n4 61.7755
R1262 avdd.n63 avdd.n60 61.7755
R1263 avdd.n278 avdd.n233 61.7755
R1264 avdd.n253 avdd.n250 61.7755
R1265 avdd.n183 avdd.n4 48.3669
R1266 avdd.n63 avdd.n62 48.3669
R1267 avdd.n280 avdd.n233 48.3669
R1268 avdd.n255 avdd.n250 48.3669
R1269 avdd.n70 avdd.n58 14.0005
R1270 avdd.n70 avdd.n54 14.0005
R1271 avdd.n76 avdd.n54 14.0005
R1272 avdd.n76 avdd.n46 14.0005
R1273 avdd.n86 avdd.n46 14.0005
R1274 avdd.n86 avdd.n42 14.0005
R1275 avdd.n92 avdd.n42 14.0005
R1276 avdd.n92 avdd.n34 14.0005
R1277 avdd.n102 avdd.n34 14.0005
R1278 avdd.n102 avdd.n30 14.0005
R1279 avdd.n108 avdd.n30 14.0005
R1280 avdd.n108 avdd.n22 14.0005
R1281 avdd.n118 avdd.n22 14.0005
R1282 avdd.n118 avdd.n18 14.0005
R1283 avdd.n124 avdd.n18 14.0005
R1284 avdd.n124 avdd.n10 14.0005
R1285 avdd.n134 avdd.n10 14.0005
R1286 avdd.n134 avdd.n6 14.0005
R1287 avdd.n181 avdd.n6 14.0005
R1288 avdd.n68 avdd.n60 14.0005
R1289 avdd.n68 avdd.n52 14.0005
R1290 avdd.n78 avdd.n52 14.0005
R1291 avdd.n78 avdd.n48 14.0005
R1292 avdd.n84 avdd.n48 14.0005
R1293 avdd.n84 avdd.n40 14.0005
R1294 avdd.n94 avdd.n40 14.0005
R1295 avdd.n94 avdd.n36 14.0005
R1296 avdd.n100 avdd.n36 14.0005
R1297 avdd.n100 avdd.n28 14.0005
R1298 avdd.n110 avdd.n28 14.0005
R1299 avdd.n110 avdd.n24 14.0005
R1300 avdd.n116 avdd.n24 14.0005
R1301 avdd.n116 avdd.n16 14.0005
R1302 avdd.n126 avdd.n16 14.0005
R1303 avdd.n126 avdd.n12 14.0005
R1304 avdd.n132 avdd.n12 14.0005
R1305 avdd.n132 avdd.n3 14.0005
R1306 avdd.n184 avdd.n3 14.0005
R1307 avdd.n256 avdd.n247 14.0005
R1308 avdd.n262 avdd.n247 14.0005
R1309 avdd.n262 avdd.n239 14.0005
R1310 avdd.n272 avdd.n239 14.0005
R1311 avdd.n272 avdd.n235 14.0005
R1312 avdd.n278 avdd.n235 14.0005
R1313 avdd.n253 avdd.n245 14.0005
R1314 avdd.n264 avdd.n245 14.0005
R1315 avdd.n264 avdd.n241 14.0005
R1316 avdd.n270 avdd.n241 14.0005
R1317 avdd.n270 avdd.n232 14.0005
R1318 avdd.n281 avdd.n232 14.0005
R1319 avdd.n314 avdd.n313 14.0005
R1320 avdd.n320 avdd.n296 14.0005
R1321 avdd.n303 avdd.n302 14.0005
R1322 avdd.n324 avdd.n289 14.0005
R1323 avdd.n228 avdd.n187 8.02173
R1324 avdd.n228 avdd.n227 7.48713
R1325 avdd.n285 avdd.n284 7.48713
R1326 avdd.n328 avdd.n327 6.5392
R1327 avdd.n181 avdd.n180 6.3005
R1328 avdd.n182 avdd.n181 6.3005
R1329 avdd.n7 avdd.n6 6.3005
R1330 avdd.n6 avdd.n5 6.3005
R1331 avdd.n135 avdd.n134 6.3005
R1332 avdd.n134 avdd.n133 6.3005
R1333 avdd.n10 avdd.n9 6.3005
R1334 avdd.n11 avdd.n10 6.3005
R1335 avdd.n124 avdd.n123 6.3005
R1336 avdd.n125 avdd.n124 6.3005
R1337 avdd.n19 avdd.n18 6.3005
R1338 avdd.n18 avdd.n17 6.3005
R1339 avdd.n119 avdd.n118 6.3005
R1340 avdd.n118 avdd.n117 6.3005
R1341 avdd.n22 avdd.n21 6.3005
R1342 avdd.n23 avdd.n22 6.3005
R1343 avdd.n108 avdd.n107 6.3005
R1344 avdd.n109 avdd.n108 6.3005
R1345 avdd.n31 avdd.n30 6.3005
R1346 avdd.n30 avdd.n29 6.3005
R1347 avdd.n103 avdd.n102 6.3005
R1348 avdd.n102 avdd.n101 6.3005
R1349 avdd.n34 avdd.n33 6.3005
R1350 avdd.n35 avdd.n34 6.3005
R1351 avdd.n92 avdd.n91 6.3005
R1352 avdd.n93 avdd.n92 6.3005
R1353 avdd.n43 avdd.n42 6.3005
R1354 avdd.n42 avdd.n41 6.3005
R1355 avdd.n87 avdd.n86 6.3005
R1356 avdd.n86 avdd.n85 6.3005
R1357 avdd.n46 avdd.n45 6.3005
R1358 avdd.n47 avdd.n46 6.3005
R1359 avdd.n76 avdd.n75 6.3005
R1360 avdd.n77 avdd.n76 6.3005
R1361 avdd.n55 avdd.n54 6.3005
R1362 avdd.n54 avdd.n53 6.3005
R1363 avdd.n71 avdd.n70 6.3005
R1364 avdd.n70 avdd.n69 6.3005
R1365 avdd.n58 avdd.n57 6.3005
R1366 avdd.n61 avdd.n60 6.3005
R1367 avdd.n60 avdd.n59 6.3005
R1368 avdd.n68 avdd.n67 6.3005
R1369 avdd.n69 avdd.n68 6.3005
R1370 avdd.n52 avdd.n51 6.3005
R1371 avdd.n53 avdd.n52 6.3005
R1372 avdd.n79 avdd.n78 6.3005
R1373 avdd.n78 avdd.n77 6.3005
R1374 avdd.n49 avdd.n48 6.3005
R1375 avdd.n48 avdd.n47 6.3005
R1376 avdd.n84 avdd.n83 6.3005
R1377 avdd.n85 avdd.n84 6.3005
R1378 avdd.n40 avdd.n39 6.3005
R1379 avdd.n41 avdd.n40 6.3005
R1380 avdd.n95 avdd.n94 6.3005
R1381 avdd.n94 avdd.n93 6.3005
R1382 avdd.n37 avdd.n36 6.3005
R1383 avdd.n36 avdd.n35 6.3005
R1384 avdd.n100 avdd.n99 6.3005
R1385 avdd.n101 avdd.n100 6.3005
R1386 avdd.n28 avdd.n27 6.3005
R1387 avdd.n29 avdd.n28 6.3005
R1388 avdd.n111 avdd.n110 6.3005
R1389 avdd.n110 avdd.n109 6.3005
R1390 avdd.n25 avdd.n24 6.3005
R1391 avdd.n24 avdd.n23 6.3005
R1392 avdd.n116 avdd.n115 6.3005
R1393 avdd.n117 avdd.n116 6.3005
R1394 avdd.n16 avdd.n15 6.3005
R1395 avdd.n17 avdd.n16 6.3005
R1396 avdd.n127 avdd.n126 6.3005
R1397 avdd.n126 avdd.n125 6.3005
R1398 avdd.n13 avdd.n12 6.3005
R1399 avdd.n12 avdd.n11 6.3005
R1400 avdd.n132 avdd.n131 6.3005
R1401 avdd.n133 avdd.n132 6.3005
R1402 avdd.n3 avdd.n2 6.3005
R1403 avdd.n5 avdd.n3 6.3005
R1404 avdd.n185 avdd.n184 6.3005
R1405 avdd.n149 avdd.n148 6.3005
R1406 avdd.n150 avdd.n143 6.3005
R1407 avdd.n175 avdd.n174 6.3005
R1408 avdd.n172 avdd.n140 6.3005
R1409 avdd.n159 avdd.n158 6.3005
R1410 avdd.n160 avdd.n155 6.3005
R1411 avdd.n167 avdd.n166 6.3005
R1412 avdd.n164 avdd.n153 6.3005
R1413 avdd.n205 avdd.n204 6.3005
R1414 avdd.n203 avdd.n197 6.3005
R1415 avdd.n210 avdd.n209 6.3005
R1416 avdd.n201 avdd.n198 6.3005
R1417 avdd.n194 avdd.n193 6.3005
R1418 avdd.n219 avdd.n218 6.3005
R1419 avdd.n224 avdd.n223 6.3005
R1420 avdd.n225 avdd.n190 6.3005
R1421 avdd.n278 avdd.n277 6.3005
R1422 avdd.n279 avdd.n278 6.3005
R1423 avdd.n236 avdd.n235 6.3005
R1424 avdd.n235 avdd.n234 6.3005
R1425 avdd.n273 avdd.n272 6.3005
R1426 avdd.n272 avdd.n271 6.3005
R1427 avdd.n239 avdd.n238 6.3005
R1428 avdd.n240 avdd.n239 6.3005
R1429 avdd.n262 avdd.n261 6.3005
R1430 avdd.n263 avdd.n262 6.3005
R1431 avdd.n248 avdd.n247 6.3005
R1432 avdd.n247 avdd.n246 6.3005
R1433 avdd.n257 avdd.n256 6.3005
R1434 avdd.n282 avdd.n281 6.3005
R1435 avdd.n232 avdd.n231 6.3005
R1436 avdd.n234 avdd.n232 6.3005
R1437 avdd.n270 avdd.n269 6.3005
R1438 avdd.n271 avdd.n270 6.3005
R1439 avdd.n242 avdd.n241 6.3005
R1440 avdd.n241 avdd.n240 6.3005
R1441 avdd.n265 avdd.n264 6.3005
R1442 avdd.n264 avdd.n263 6.3005
R1443 avdd.n245 avdd.n244 6.3005
R1444 avdd.n246 avdd.n245 6.3005
R1445 avdd.n253 avdd.n252 6.3005
R1446 avdd.n254 avdd.n253 6.3005
R1447 avdd.n320 avdd.n319 6.3005
R1448 avdd.n321 avdd.n320 6.3005
R1449 avdd.n297 avdd.n296 6.3005
R1450 avdd.n315 avdd.n314 6.3005
R1451 avdd.n313 avdd.n312 6.3005
R1452 avdd.n311 avdd.n299 6.3005
R1453 avdd.n325 avdd.n324 6.3005
R1454 avdd.n324 avdd.n323 6.3005
R1455 avdd.n289 avdd.n288 6.3005
R1456 avdd.n305 avdd.n303 6.3005
R1457 avdd.n306 avdd.n302 6.3005
R1458 avdd.n307 avdd.n301 6.3005
R1459 avdd.n310 avdd.n309 6.12735
R1460 avdd.n318 avdd.n286 6.12735
R1461 avdd.n309 avdd.n308 6.11952
R1462 avdd.n162 avdd.n152 5.20011
R1463 avdd.n162 avdd.n161 5.20011
R1464 avdd.n146 avdd.n138 5.20011
R1465 avdd.n208 avdd.n207 5.20011
R1466 avdd.n207 avdd.n206 5.20011
R1467 avdd.n217 avdd.n188 5.20011
R1468 avdd.n64 avdd.n56 5.19741
R1469 avdd.n258 avdd.n249 5.19741
R1470 avdd.n276 avdd.n229 5.19741
R1471 avdd.n65 avdd.n64 5.18959
R1472 avdd.n251 avdd.n249 5.18959
R1473 avdd.n62 avdd.n59 4.9335
R1474 avdd.n183 avdd.n182 4.9335
R1475 avdd.n255 avdd.n254 4.9335
R1476 avdd.n280 avdd.n279 4.9335
R1477 avdd avdd.n328 4.8686
R1478 avdd.n169 avdd.n168 4.75136
R1479 avdd.n156 avdd.n144 4.75136
R1480 avdd.n215 avdd.n195 4.75136
R1481 avdd.n196 avdd.n189 4.75136
R1482 avdd.n144 avdd.n139 4.75135
R1483 avdd.n169 avdd.n151 4.75135
R1484 avdd.n202 avdd.n196 4.75135
R1485 avdd.n216 avdd.n215 4.75135
R1486 avdd.n177 avdd.n176 4.7462
R1487 avdd.n227 avdd.n226 4.7462
R1488 avdd.n187 avdd.n186 4.7435
R1489 avdd.n179 avdd.n178 4.7435
R1490 avdd.n284 avdd.n283 4.7435
R1491 avdd.n327 avdd.n326 4.7255
R1492 avdd.n65 avdd.n61 4.5005
R1493 avdd.n67 avdd.n66 4.5005
R1494 avdd.n51 avdd.n50 4.5005
R1495 avdd.n80 avdd.n79 4.5005
R1496 avdd.n81 avdd.n49 4.5005
R1497 avdd.n83 avdd.n82 4.5005
R1498 avdd.n39 avdd.n38 4.5005
R1499 avdd.n96 avdd.n95 4.5005
R1500 avdd.n97 avdd.n37 4.5005
R1501 avdd.n99 avdd.n98 4.5005
R1502 avdd.n27 avdd.n26 4.5005
R1503 avdd.n112 avdd.n111 4.5005
R1504 avdd.n113 avdd.n25 4.5005
R1505 avdd.n115 avdd.n114 4.5005
R1506 avdd.n15 avdd.n14 4.5005
R1507 avdd.n128 avdd.n127 4.5005
R1508 avdd.n129 avdd.n13 4.5005
R1509 avdd.n131 avdd.n130 4.5005
R1510 avdd.n2 avdd.n1 4.5005
R1511 avdd.n186 avdd.n185 4.5005
R1512 avdd.n72 avdd.n71 4.5005
R1513 avdd.n73 avdd.n55 4.5005
R1514 avdd.n75 avdd.n74 4.5005
R1515 avdd.n45 avdd.n44 4.5005
R1516 avdd.n88 avdd.n87 4.5005
R1517 avdd.n89 avdd.n43 4.5005
R1518 avdd.n91 avdd.n90 4.5005
R1519 avdd.n33 avdd.n32 4.5005
R1520 avdd.n104 avdd.n103 4.5005
R1521 avdd.n105 avdd.n31 4.5005
R1522 avdd.n107 avdd.n106 4.5005
R1523 avdd.n21 avdd.n20 4.5005
R1524 avdd.n120 avdd.n119 4.5005
R1525 avdd.n121 avdd.n19 4.5005
R1526 avdd.n123 avdd.n122 4.5005
R1527 avdd.n9 avdd.n8 4.5005
R1528 avdd.n136 avdd.n135 4.5005
R1529 avdd.n137 avdd.n7 4.5005
R1530 avdd.n180 avdd.n179 4.5005
R1531 avdd.n57 avdd.n56 4.5005
R1532 avdd.n176 avdd.n175 4.5005
R1533 avdd.n140 avdd.n139 4.5005
R1534 avdd.n168 avdd.n167 4.5005
R1535 avdd.n153 avdd.n152 4.5005
R1536 avdd.n159 avdd.n156 4.5005
R1537 avdd.n161 avdd.n160 4.5005
R1538 avdd.n149 avdd.n146 4.5005
R1539 avdd.n151 avdd.n150 4.5005
R1540 avdd.n209 avdd.n208 4.5005
R1541 avdd.n201 avdd.n195 4.5005
R1542 avdd.n206 avdd.n205 4.5005
R1543 avdd.n203 avdd.n202 4.5005
R1544 avdd.n224 avdd.n189 4.5005
R1545 avdd.n226 avdd.n225 4.5005
R1546 avdd.n216 avdd.n194 4.5005
R1547 avdd.n218 avdd.n217 4.5005
R1548 avdd.n244 avdd.n243 4.5005
R1549 avdd.n266 avdd.n265 4.5005
R1550 avdd.n267 avdd.n242 4.5005
R1551 avdd.n269 avdd.n268 4.5005
R1552 avdd.n231 avdd.n230 4.5005
R1553 avdd.n283 avdd.n282 4.5005
R1554 avdd.n252 avdd.n251 4.5005
R1555 avdd.n259 avdd.n248 4.5005
R1556 avdd.n261 avdd.n260 4.5005
R1557 avdd.n238 avdd.n237 4.5005
R1558 avdd.n274 avdd.n273 4.5005
R1559 avdd.n275 avdd.n236 4.5005
R1560 avdd.n277 avdd.n276 4.5005
R1561 avdd.n258 avdd.n257 4.5005
R1562 avdd.n306 avdd.n300 4.5005
R1563 avdd.n305 avdd.n304 4.5005
R1564 avdd.n288 avdd.n287 4.5005
R1565 avdd.n326 avdd.n325 4.5005
R1566 avdd.n308 avdd.n307 4.5005
R1567 avdd.n312 avdd.n298 4.5005
R1568 avdd.n316 avdd.n315 4.5005
R1569 avdd.n317 avdd.n297 4.5005
R1570 avdd.n319 avdd.n318 4.5005
R1571 avdd.n311 avdd.n310 4.5005
R1572 avdd.n147 avdd.n143 3.31679
R1573 avdd.n148 avdd.n147 3.31679
R1574 avdd.n173 avdd.n172 3.31679
R1575 avdd.n174 avdd.n173 3.31679
R1576 avdd.n157 avdd.n155 3.31679
R1577 avdd.n158 avdd.n157 3.31679
R1578 avdd.n165 avdd.n164 3.31679
R1579 avdd.n166 avdd.n165 3.31679
R1580 avdd.n199 avdd.n197 3.31679
R1581 avdd.n204 avdd.n199 3.31679
R1582 avdd.n211 avdd.n198 3.31679
R1583 avdd.n211 avdd.n210 3.31679
R1584 avdd.n219 avdd.n192 3.31679
R1585 avdd.n193 avdd.n192 3.31679
R1586 avdd.n222 avdd.n190 3.31679
R1587 avdd.n223 avdd.n222 3.31679
R1588 avdd.n299 avdd.n294 3.31679
R1589 avdd.n314 avdd.n295 3.31679
R1590 avdd.n296 avdd.n295 3.31679
R1591 avdd.n313 avdd.n294 3.31679
R1592 avdd.n302 avdd.n291 3.31679
R1593 avdd.n292 avdd.n289 3.31679
R1594 avdd.n303 avdd.n292 3.31679
R1595 avdd.n301 avdd.n291 3.31679
R1596 avdd.n321 avdd.n295 1.49311
R1597 avdd.n321 avdd.n294 1.49311
R1598 avdd.n323 avdd.n292 1.49311
R1599 avdd.n323 avdd.n291 1.49311
R1600 avdd.n327 avdd.n286 1.40235
R1601 avdd.n184 avdd.n183 1.24194
R1602 avdd.n62 avdd.n58 1.24194
R1603 avdd.n281 avdd.n280 1.24194
R1604 avdd.n256 avdd.n255 1.24194
R1605 avdd.n64 avdd.n63 0.9005
R1606 avdd.n163 avdd.n162 0.9005
R1607 avdd.n163 avdd.n154 0.9005
R1608 avdd.n170 avdd.n145 0.9005
R1609 avdd.n154 avdd.n145 0.9005
R1610 avdd.n171 avdd.n170 0.9005
R1611 avdd.n171 avdd.n142 0.9005
R1612 avdd.n141 avdd.n138 0.9005
R1613 avdd.n142 avdd.n141 0.9005
R1614 avdd.n4 avdd.n0 0.9005
R1615 avdd.n207 avdd.n200 0.9005
R1616 avdd.n212 avdd.n200 0.9005
R1617 avdd.n214 avdd.n191 0.9005
R1618 avdd.n221 avdd.n191 0.9005
R1619 avdd.n214 avdd.n213 0.9005
R1620 avdd.n213 avdd.n212 0.9005
R1621 avdd.n220 avdd.n188 0.9005
R1622 avdd.n221 avdd.n220 0.9005
R1623 avdd.n250 avdd.n249 0.9005
R1624 avdd.n233 avdd.n229 0.9005
R1625 avdd.n328 avdd.n285 0.8789
R1626 avdd.n177 avdd.n138 0.454413
R1627 avdd.n178 avdd.n0 0.454413
R1628 avdd.n187 avdd.n0 0.454413
R1629 avdd.n227 avdd.n188 0.454413
R1630 avdd.n284 avdd.n229 0.454413
R1631 avdd.n178 avdd.n177 0.427022
R1632 avdd.n309 avdd.n293 0.2255
R1633 avdd.n322 avdd.n293 0.2255
R1634 avdd.n290 avdd.n286 0.2255
R1635 avdd.n322 avdd.n290 0.2255
R1636 avdd.n285 avdd.n228 0.2003
R1637 avdd.n71 avdd.n57 0.1445
R1638 avdd.n71 avdd.n55 0.1445
R1639 avdd.n75 avdd.n55 0.1445
R1640 avdd.n75 avdd.n45 0.1445
R1641 avdd.n87 avdd.n45 0.1445
R1642 avdd.n87 avdd.n43 0.1445
R1643 avdd.n91 avdd.n43 0.1445
R1644 avdd.n91 avdd.n33 0.1445
R1645 avdd.n103 avdd.n33 0.1445
R1646 avdd.n103 avdd.n31 0.1445
R1647 avdd.n107 avdd.n31 0.1445
R1648 avdd.n107 avdd.n21 0.1445
R1649 avdd.n119 avdd.n21 0.1445
R1650 avdd.n119 avdd.n19 0.1445
R1651 avdd.n123 avdd.n19 0.1445
R1652 avdd.n123 avdd.n9 0.1445
R1653 avdd.n135 avdd.n9 0.1445
R1654 avdd.n135 avdd.n7 0.1445
R1655 avdd.n180 avdd.n7 0.1445
R1656 avdd.n67 avdd.n61 0.1445
R1657 avdd.n67 avdd.n51 0.1445
R1658 avdd.n79 avdd.n51 0.1445
R1659 avdd.n79 avdd.n49 0.1445
R1660 avdd.n83 avdd.n49 0.1445
R1661 avdd.n83 avdd.n39 0.1445
R1662 avdd.n95 avdd.n39 0.1445
R1663 avdd.n95 avdd.n37 0.1445
R1664 avdd.n99 avdd.n37 0.1445
R1665 avdd.n99 avdd.n27 0.1445
R1666 avdd.n111 avdd.n27 0.1445
R1667 avdd.n111 avdd.n25 0.1445
R1668 avdd.n115 avdd.n25 0.1445
R1669 avdd.n115 avdd.n15 0.1445
R1670 avdd.n127 avdd.n15 0.1445
R1671 avdd.n127 avdd.n13 0.1445
R1672 avdd.n131 avdd.n13 0.1445
R1673 avdd.n131 avdd.n2 0.1445
R1674 avdd.n185 avdd.n2 0.1445
R1675 avdd.n66 avdd.n65 0.1445
R1676 avdd.n66 avdd.n50 0.1445
R1677 avdd.n80 avdd.n50 0.1445
R1678 avdd.n81 avdd.n80 0.1445
R1679 avdd.n82 avdd.n81 0.1445
R1680 avdd.n82 avdd.n38 0.1445
R1681 avdd.n96 avdd.n38 0.1445
R1682 avdd.n97 avdd.n96 0.1445
R1683 avdd.n98 avdd.n97 0.1445
R1684 avdd.n98 avdd.n26 0.1445
R1685 avdd.n112 avdd.n26 0.1445
R1686 avdd.n113 avdd.n112 0.1445
R1687 avdd.n114 avdd.n113 0.1445
R1688 avdd.n114 avdd.n14 0.1445
R1689 avdd.n128 avdd.n14 0.1445
R1690 avdd.n129 avdd.n128 0.1445
R1691 avdd.n130 avdd.n129 0.1445
R1692 avdd.n130 avdd.n1 0.1445
R1693 avdd.n186 avdd.n1 0.1445
R1694 avdd.n72 avdd.n56 0.1445
R1695 avdd.n73 avdd.n72 0.1445
R1696 avdd.n74 avdd.n73 0.1445
R1697 avdd.n74 avdd.n44 0.1445
R1698 avdd.n88 avdd.n44 0.1445
R1699 avdd.n89 avdd.n88 0.1445
R1700 avdd.n90 avdd.n89 0.1445
R1701 avdd.n90 avdd.n32 0.1445
R1702 avdd.n104 avdd.n32 0.1445
R1703 avdd.n105 avdd.n104 0.1445
R1704 avdd.n106 avdd.n105 0.1445
R1705 avdd.n106 avdd.n20 0.1445
R1706 avdd.n120 avdd.n20 0.1445
R1707 avdd.n121 avdd.n120 0.1445
R1708 avdd.n122 avdd.n121 0.1445
R1709 avdd.n122 avdd.n8 0.1445
R1710 avdd.n136 avdd.n8 0.1445
R1711 avdd.n137 avdd.n136 0.1445
R1712 avdd.n179 avdd.n137 0.1445
R1713 avdd.n150 avdd.n149 0.1445
R1714 avdd.n175 avdd.n140 0.1445
R1715 avdd.n176 avdd.n139 0.1445
R1716 avdd.n160 avdd.n159 0.1445
R1717 avdd.n167 avdd.n153 0.1445
R1718 avdd.n168 avdd.n152 0.1445
R1719 avdd.n161 avdd.n156 0.1445
R1720 avdd.n151 avdd.n146 0.1445
R1721 avdd.n205 avdd.n203 0.1445
R1722 avdd.n209 avdd.n201 0.1445
R1723 avdd.n208 avdd.n195 0.1445
R1724 avdd.n206 avdd.n202 0.1445
R1725 avdd.n218 avdd.n194 0.1445
R1726 avdd.n225 avdd.n224 0.1445
R1727 avdd.n226 avdd.n189 0.1445
R1728 avdd.n217 avdd.n216 0.1445
R1729 avdd.n257 avdd.n248 0.1445
R1730 avdd.n261 avdd.n248 0.1445
R1731 avdd.n261 avdd.n238 0.1445
R1732 avdd.n273 avdd.n238 0.1445
R1733 avdd.n273 avdd.n236 0.1445
R1734 avdd.n277 avdd.n236 0.1445
R1735 avdd.n252 avdd.n244 0.1445
R1736 avdd.n265 avdd.n244 0.1445
R1737 avdd.n265 avdd.n242 0.1445
R1738 avdd.n269 avdd.n242 0.1445
R1739 avdd.n269 avdd.n231 0.1445
R1740 avdd.n282 avdd.n231 0.1445
R1741 avdd.n251 avdd.n243 0.1445
R1742 avdd.n266 avdd.n243 0.1445
R1743 avdd.n267 avdd.n266 0.1445
R1744 avdd.n268 avdd.n267 0.1445
R1745 avdd.n268 avdd.n230 0.1445
R1746 avdd.n283 avdd.n230 0.1445
R1747 avdd.n259 avdd.n258 0.1445
R1748 avdd.n260 avdd.n259 0.1445
R1749 avdd.n260 avdd.n237 0.1445
R1750 avdd.n274 avdd.n237 0.1445
R1751 avdd.n275 avdd.n274 0.1445
R1752 avdd.n276 avdd.n275 0.1445
R1753 avdd.n312 avdd.n311 0.1445
R1754 avdd.n315 avdd.n312 0.1445
R1755 avdd.n315 avdd.n297 0.1445
R1756 avdd.n319 avdd.n297 0.1445
R1757 avdd.n307 avdd.n306 0.1445
R1758 avdd.n306 avdd.n305 0.1445
R1759 avdd.n305 avdd.n288 0.1445
R1760 avdd.n325 avdd.n288 0.1445
R1761 avdd.n308 avdd.n300 0.1445
R1762 avdd.n304 avdd.n300 0.1445
R1763 avdd.n304 avdd.n287 0.1445
R1764 avdd.n326 avdd.n287 0.1445
R1765 avdd.n310 avdd.n298 0.1445
R1766 avdd.n316 avdd.n298 0.1445
R1767 avdd.n317 avdd.n316 0.1445
R1768 avdd.n318 avdd.n317 0.1445
R1769 avdd.n170 avdd.n169 0.0740097
R1770 avdd.n170 avdd.n144 0.0740097
R1771 avdd.n215 avdd.n214 0.0740097
R1772 avdd.n214 avdd.n196 0.0740097
C0 vb_idep xm9_0/a_63_n131# 0.11176f
C1 avdd xm7_0/a_63_n131# 0.82725f
C2 xmcm_chain_4_0/a_1000_n131# xmcm_chain_4_0/a_n1000_n339# 0.12631f
C3 vb_pot xmcm_chain_3_0/a_1000_n131# 0
C4 Iout xm7_0/a_63_n131# 0.00724f
C5 nvpost xm8_0/a_63_n131# 0.00736f
C6 xmcm_chain_4_0/a_n1000_n339# xmcm_chain_1_0/a_1000_n131# 0.04758f
C7 vb_itd avdd 0.01352f
C8 xm4_0/a_63_n131# xm9_0/a_63_n131# 0.0142f
C9 nvpre xm7_0/a_63_n131# 0.00209f
C10 vw xm7_0/a_63_n131# 0.18617f
C11 xmcm_chain_2_0/a_1000_n131# xm9_0/a_63_n131# 0.00189f
C12 vb_itd Iout 0.00797f
C13 xmcm_chain_3_0/a_1000_n131# xm7_0/a_63_n131# 0
C14 vpost xmcm_chain_2_0/a_1000_n131# 0
C15 vw vb_itd 0.00708f
C16 Iout avdd 3.2355f
C17 vb_itd xmcm_chain_3_0/a_1000_n131# 0.00421f
C18 xm8_0/a_63_n131# xm9_0/a_63_n131# 0
C19 nvpre avdd 0.05708f
C20 vw avdd 3.7779f
C21 nvpre Iout 0.00239f
C22 vw Iout 2.57869f
C23 vw nvpre 0
C24 xmcm_chain_4_0/a_n1000_n339# xm4_0/a_63_n131# 0
C25 xmcm_chain_4_0/a_n1000_n339# xmcm_chain_2_0/a_1000_n131# 0.12554f
C26 vb_pot xmcm_chain_1_0/a_1000_n131# 0.00411f
C27 vw xmcm_chain_3_0/a_1000_n131# 0
C28 xm7_0/a_63_n131# xmcm_chain_1_0/a_1000_n131# 0.00601f
C29 xmcm_chain_4_0/a_1000_n131# vb_itd 0.0028f
C30 vpre vw 0.03752f
C31 vpost xm9_0/a_63_n131# 0.02722f
C32 vb_itd xmcm_chain_1_0/a_1000_n131# 0.06312f
C33 vb_pot xmcm_chain_2_0/a_1000_n131# 0.00135f
C34 vw xmcm_chain_4_0/a_1000_n131# 0.02308f
C35 xm1_0/a_63_n131# xm7_0/a_63_n131# 0.06511f
C36 Iout xmcm_chain_1_0/a_1000_n131# 0.01135f
C37 xmcm_chain_4_0/a_1000_n131# xmcm_chain_3_0/a_1000_n131# 0.04151f
C38 vw xmcm_chain_1_0/a_1000_n131# 0.04047f
C39 xmcm_chain_4_0/a_n1000_n339# xm9_0/a_63_n131# 0.00198f
C40 vb_itd vb_idep 0.00434f
C41 xmcm_chain_3_0/a_1000_n131# xmcm_chain_1_0/a_1000_n131# 0.04858f
C42 vb_itp avdd 0.06144f
C43 vpost xmcm_chain_4_0/a_n1000_n339# 0.00209f
C44 xmcm_chain_2_0/a_1000_n131# xm7_0/a_63_n131# 0
C45 vb_idep avdd 0.03874f
C46 xm1_0/a_63_n131# avdd 0.87243f
C47 vb_itp Iout 0.0188f
C48 Iout vb_idep 0.08924f
C49 xm1_0/a_63_n131# Iout 0.29221f
C50 vb_itp nvpre 0.00838f
C51 vb_itp vw 0
C52 vw vb_idep 0.00728f
C53 xm8_0/a_63_n131# xm7_0/a_63_n131# 0.13673f
C54 avdd xm4_0/a_63_n131# 0
C55 xm1_0/a_63_n131# vw 0.52729f
C56 vpre xmcm_chain_1_0/a_1000_n131# 0
C57 vw xm4_0/a_63_n131# 0.16248f
C58 nvpost xm7_0/a_63_n131# 0.01914f
C59 vw xmcm_chain_2_0/a_1000_n131# 0
C60 xm8_0/a_63_n131# avdd 0.77197f
C61 vb_pot xm9_0/a_63_n131# 0
C62 xmcm_chain_3_0/a_1000_n131# xmcm_chain_2_0/a_1000_n131# 0.04151f
C63 xmcm_chain_4_0/a_1000_n131# xmcm_chain_1_0/a_1000_n131# 0.01434f
C64 Iout xm8_0/a_63_n131# 0.05968f
C65 vb_pot vpost 0.01175f
C66 nvpre xm8_0/a_63_n131# 0.04739f
C67 vw xm8_0/a_63_n131# 0.00481f
C68 nvpost avdd 0.06053f
C69 xm7_0/a_63_n131# xm9_0/a_63_n131# 0.47751f
C70 nvpost Iout 0.0071f
C71 vpre xm4_0/a_63_n131# 0.00239f
C72 vpost xm7_0/a_63_n131# 0
C73 vpre xmcm_chain_2_0/a_1000_n131# 0
C74 vw nvpost 0.02062f
C75 vb_itd xm9_0/a_63_n131# 0
C76 vb_pot xmcm_chain_4_0/a_n1000_n339# 0.00469f
C77 avdd xm9_0/a_63_n131# 0.65446f
C78 vb_idep xmcm_chain_1_0/a_1000_n131# 0
C79 Iout xm9_0/a_63_n131# 0.20699f
C80 xmcm_chain_4_0/a_1000_n131# xmcm_chain_2_0/a_1000_n131# 0.00555f
C81 nvpre xm9_0/a_63_n131# 0
C82 vw xm9_0/a_63_n131# 1.01175f
C83 xm4_0/a_63_n131# xmcm_chain_1_0/a_1000_n131# 0
C84 xmcm_chain_2_0/a_1000_n131# xmcm_chain_1_0/a_1000_n131# 0.07902f
C85 vpost vw 0.00293f
C86 xmcm_chain_3_0/a_1000_n131# xm9_0/a_63_n131# 0
C87 vb_itd xmcm_chain_4_0/a_n1000_n339# 0.02153f
C88 vpost xmcm_chain_3_0/a_1000_n131# 0
C89 xm1_0/a_63_n131# xm4_0/a_63_n131# 0.01204f
C90 vw xmcm_chain_4_0/a_n1000_n339# 0.03206f
C91 vb_itp xm8_0/a_63_n131# 0
C92 xmcm_chain_2_0/a_1000_n131# xm4_0/a_63_n131# 0
C93 xmcm_chain_4_0/a_n1000_n339# xmcm_chain_3_0/a_1000_n131# 0.15956f
C94 vb_pot xm7_0/a_63_n131# 0.01895f
C95 vb_pot vb_itd 0.01322f
C96 xmcm_chain_1_0/a_1000_n131# xm9_0/a_63_n131# 0.00444f
C97 xm1_0/a_63_n131# nvpost 0.01738f
C98 vpre xmcm_chain_4_0/a_n1000_n339# 0.00209f
C99 vpost xmcm_chain_1_0/a_1000_n131# 0.00231f
C100 vb_itd xm7_0/a_63_n131# 0
C101 vb_pot vw 0.00142f
C102 vb_itp xm9_0/a_63_n131# 0.02983f
C103 vb_pot avss -0.02967f
C104 vb_itp avss -0.1018f
C105 vb_itd avss -0.05497f
C106 vpre avss -0.02444f
C107 vpost avss -0.03028f
C108 nvpre avss -0.06878f
C109 nvpost avss -0.07062f
C110 avdd.n0 avss 0.0014f
C111 avdd.n1 avss 0
C112 avdd.n2 avss 0
C113 avdd.n3 avss 0
C114 avdd.n4 avss 0.01013f
C115 avdd.n5 avss 0.00588f
C116 avdd.n6 avss 0
C117 avdd.n7 avss 0
C118 avdd.n8 avss 0
C119 avdd.n9 avss 0
C120 avdd.n10 avss 0
C121 avdd.n11 avss 0.00588f
C122 avdd.n12 avss 0
C123 avdd.n13 avss 0
C124 avdd.n14 avss 0
C125 avdd.n15 avss 0
C126 avdd.n16 avss 0
C127 avdd.n17 avss 0.00588f
C128 avdd.n18 avss 0
C129 avdd.n19 avss 0
C130 avdd.n20 avss 0
C131 avdd.n21 avss 0
C132 avdd.n22 avss 0
C133 avdd.n23 avss 0.00588f
C134 avdd.n24 avss 0
C135 avdd.n25 avss 0
C136 avdd.n26 avss 0
C137 avdd.n27 avss 0
C138 avdd.n28 avss 0
C139 avdd.n29 avss 0.00588f
C140 avdd.n30 avss 0
C141 avdd.n31 avss 0
C142 avdd.n32 avss 0
C143 avdd.n33 avss 0
C144 avdd.n34 avss 0
C145 avdd.n35 avss 0.00588f
C146 avdd.n36 avss 0
C147 avdd.n37 avss 0
C148 avdd.n38 avss 0
C149 avdd.n39 avss 0
C150 avdd.n40 avss 0
C151 avdd.n41 avss 0.00588f
C152 avdd.n42 avss 0
C153 avdd.n43 avss 0
C154 avdd.n44 avss 0
C155 avdd.n45 avss 0
C156 avdd.n46 avss 0
C157 avdd.n47 avss 0.00588f
C158 avdd.n48 avss 0
C159 avdd.n49 avss 0
C160 avdd.n50 avss 0
C161 avdd.n51 avss 0
C162 avdd.n52 avss 0
C163 avdd.n53 avss 0.00588f
C164 avdd.n54 avss 0
C165 avdd.n55 avss 0
C166 avdd.n56 avss 0.00136f
C167 avdd.n57 avss 0
C168 avdd.n58 avss 0.00108f
C169 avdd.n59 avss 0.00801f
C170 avdd.n60 avss 0.00108f
C171 avdd.n61 avss 0
C172 avdd.n63 avss 0.01013f
C173 avdd.n64 avss 0.01442f
C174 avdd.n65 avss 0.00163f
C175 avdd.n66 avss 0
C176 avdd.n67 avss 0
C177 avdd.n68 avss 0
C178 avdd.n69 avss 0.00588f
C179 avdd.n70 avss 0
C180 avdd.n71 avss 0
C181 avdd.n72 avss 0
C182 avdd.n73 avss 0
C183 avdd.n74 avss 0
C184 avdd.n75 avss 0
C185 avdd.n76 avss 0
C186 avdd.n77 avss 0.00588f
C187 avdd.n78 avss 0
C188 avdd.n79 avss 0
C189 avdd.n80 avss 0
C190 avdd.n81 avss 0
C191 avdd.n82 avss 0
C192 avdd.n83 avss 0
C193 avdd.n84 avss 0
C194 avdd.n85 avss 0.00588f
C195 avdd.n86 avss 0
C196 avdd.n87 avss 0
C197 avdd.n88 avss 0
C198 avdd.n89 avss 0
C199 avdd.n90 avss 0
C200 avdd.n91 avss 0
C201 avdd.n92 avss 0
C202 avdd.n93 avss 0.00588f
C203 avdd.n94 avss 0
C204 avdd.n95 avss 0
C205 avdd.n96 avss 0
C206 avdd.n97 avss 0
C207 avdd.n98 avss 0
C208 avdd.n99 avss 0
C209 avdd.n100 avss 0
C210 avdd.n101 avss 0.00588f
C211 avdd.n102 avss 0
C212 avdd.n103 avss 0
C213 avdd.n104 avss 0
C214 avdd.n105 avss 0
C215 avdd.n106 avss 0
C216 avdd.n107 avss 0
C217 avdd.n108 avss 0
C218 avdd.n109 avss 0.00588f
C219 avdd.n110 avss 0
C220 avdd.n111 avss 0
C221 avdd.n112 avss 0
C222 avdd.n113 avss 0
C223 avdd.n114 avss 0
C224 avdd.n115 avss 0
C225 avdd.n116 avss 0
C226 avdd.n117 avss 0.00588f
C227 avdd.n118 avss 0
C228 avdd.n119 avss 0
C229 avdd.n120 avss 0
C230 avdd.n121 avss 0
C231 avdd.n122 avss 0
C232 avdd.n123 avss 0
C233 avdd.n124 avss 0
C234 avdd.n125 avss 0.00588f
C235 avdd.n126 avss 0
C236 avdd.n127 avss 0
C237 avdd.n128 avss 0
C238 avdd.n129 avss 0
C239 avdd.n130 avss 0
C240 avdd.n131 avss 0
C241 avdd.n132 avss 0
C242 avdd.n133 avss 0.00588f
C243 avdd.n134 avss 0
C244 avdd.n135 avss 0
C245 avdd.n136 avss 0
C246 avdd.n137 avss 0
C247 avdd.n138 avss 0.00224f
C248 avdd.n139 avss 0.00129f
C249 avdd.n140 avss 0
C250 avdd.n141 avss 0.00174f
C251 avdd.n142 avss 0.01385f
C252 avdd.n143 avss 0.00108f
C253 avdd.n144 avss 0.00501f
C254 avdd.n145 avss 0.00174f
C255 avdd.n146 avss 0.00137f
C256 avdd.n147 avss 0.00959f
C257 avdd.n148 avss 0.00108f
C258 avdd.n149 avss 0
C259 avdd.n150 avss 0
C260 avdd.n151 avss 0.00129f
C261 avdd.n152 avss 0.00137f
C262 avdd.n153 avss 0
C263 avdd.n154 avss 0.01385f
C264 avdd.n155 avss 0.00108f
C265 avdd.n156 avss 0.00129f
C266 avdd.n157 avss 0.00959f
C267 avdd.n158 avss 0.00108f
C268 avdd.n159 avss 0
C269 avdd.n160 avss 0
C270 avdd.n161 avss 0.00137f
C271 avdd.n162 avss 0.00308f
C272 avdd.n163 avss 0.00174f
C273 avdd.n164 avss 0.00108f
C274 avdd.n165 avss 0.00959f
C275 avdd.n166 avss 0.00108f
C276 avdd.n167 avss 0
C277 avdd.n168 avss 0.00129f
C278 avdd.n169 avss 0.00439f
C279 avdd.n170 avss 0.0092f
C280 avdd.n171 avss 0.00174f
C281 avdd.n172 avss 0.00108f
C282 avdd.n173 avss 0.00959f
C283 avdd.n174 avss 0.00108f
C284 avdd.n175 avss 0
C285 avdd.n176 avss 0.00129f
C286 avdd.n177 avss 0.00144f
C287 avdd.n178 avss 0.00144f
C288 avdd.n179 avss 0.00128f
C289 avdd.n180 avss 0
C290 avdd.n181 avss 0.00108f
C291 avdd.n182 avss 0.00801f
C292 avdd.n184 avss 0.00108f
C293 avdd.n185 avss 0
C294 avdd.n186 avss 0.00128f
C295 avdd.n187 avss 0.00947f
C296 avdd.n188 avss 0.00224f
C297 avdd.n189 avss 0.00129f
C298 avdd.n190 avss 0.00108f
C299 avdd.n191 avss 0.00174f
C300 avdd.n192 avss 0.00959f
C301 avdd.n193 avss 0.00108f
C302 avdd.n194 avss 0
C303 avdd.n195 avss 0.00129f
C304 avdd.n196 avss 0.00501f
C305 avdd.n197 avss 0.00108f
C306 avdd.n198 avss 0.00108f
C307 avdd.n199 avss 0.00959f
C308 avdd.n200 avss 0.00174f
C309 avdd.n201 avss 0
C310 avdd.n202 avss 0.00129f
C311 avdd.n203 avss 0
C312 avdd.n204 avss 0.00108f
C313 avdd.n205 avss 0
C314 avdd.n206 avss 0.00137f
C315 avdd.n207 avss 0.00308f
C316 avdd.n208 avss 0.00137f
C317 avdd.n209 avss 0
C318 avdd.n210 avss 0.00108f
C319 avdd.n211 avss 0.00959f
C320 avdd.n212 avss 0.01385f
C321 avdd.n213 avss 0.00174f
C322 avdd.n214 avss 0.0092f
C323 avdd.n215 avss 0.00439f
C324 avdd.n216 avss 0.00129f
C325 avdd.n217 avss 0.00137f
C326 avdd.n218 avss 0
C327 avdd.n219 avss 0.00108f
C328 avdd.n220 avss 0.00174f
C329 avdd.n221 avss 0.01385f
C330 avdd.n222 avss 0.00959f
C331 avdd.n223 avss 0.00108f
C332 avdd.n224 avss 0
C333 avdd.n225 avss 0
C334 avdd.n226 avss 0.00129f
C335 avdd.n227 avss 0.00828f
C336 avdd.n228 avss 0.03069f
C337 avdd.n229 avss 0.00224f
C338 avdd.n230 avss 0
C339 avdd.n231 avss 0
C340 avdd.n232 avss 0
C341 avdd.n233 avss 0.01013f
C342 avdd.n234 avss 0.00588f
C343 avdd.n235 avss 0
C344 avdd.n236 avss 0
C345 avdd.n237 avss 0
C346 avdd.n238 avss 0
C347 avdd.n239 avss 0
C348 avdd.n240 avss 0.00588f
C349 avdd.n241 avss 0
C350 avdd.n242 avss 0
C351 avdd.n243 avss 0
C352 avdd.n244 avss 0
C353 avdd.n245 avss 0
C354 avdd.n246 avss 0.00588f
C355 avdd.n247 avss 0
C356 avdd.n248 avss 0
C357 avdd.n249 avss 0.00775f
C358 avdd.n250 avss 0.01013f
C359 avdd.n251 avss 0.00147f
C360 avdd.n252 avss 0
C361 avdd.n253 avss 0.00108f
C362 avdd.n254 avss 0.00801f
C363 avdd.n256 avss 0.00108f
C364 avdd.n257 avss 0
C365 avdd.n258 avss 0.00136f
C366 avdd.n259 avss 0
C367 avdd.n260 avss 0
C368 avdd.n261 avss 0
C369 avdd.n262 avss 0
C370 avdd.n263 avss 0.00588f
C371 avdd.n264 avss 0
C372 avdd.n265 avss 0
C373 avdd.n266 avss 0
C374 avdd.n267 avss 0
C375 avdd.n268 avss 0
C376 avdd.n269 avss 0
C377 avdd.n270 avss 0
C378 avdd.n271 avss 0.00588f
C379 avdd.n272 avss 0
C380 avdd.n273 avss 0
C381 avdd.n274 avss 0
C382 avdd.n275 avss 0
C383 avdd.n276 avss 0.00136f
C384 avdd.n277 avss 0
C385 avdd.n278 avss 0.00108f
C386 avdd.n279 avss 0.00801f
C387 avdd.n281 avss 0.00108f
C388 avdd.n282 avss 0
C389 avdd.n283 avss 0.00128f
C390 avdd.n284 avss 0.00828f
C391 avdd.n285 avss 0.00978f
C392 avdd.n286 avss 0.00617f
C393 avdd.n287 avss 0
C394 avdd.n288 avss 0
C395 avdd.n289 avss 0
C396 avdd.n290 avss 0.00394f
C397 avdd.n293 avss 0.00394f
C398 avdd.n296 avss 0
C399 avdd.n297 avss 0
C400 avdd.n298 avss 0
C401 avdd.n299 avss 0.00222f
C402 avdd.n300 avss 0
C403 avdd.n301 avss 0.00222f
C404 avdd.n302 avss 0
C405 avdd.n303 avss 0
C406 avdd.n304 avss 0
C407 avdd.n305 avss 0
C408 avdd.n306 avss 0
C409 avdd.n307 avss 0
C410 avdd.n308 avss 0.0033f
C411 avdd.n309 avss 0.01523f
C412 avdd.n310 avss 0.00177f
C413 avdd.n311 avss 0
C414 avdd.n312 avss 0
C415 avdd.n313 avss 0
C416 avdd.n314 avss 0
C417 avdd.n315 avss 0
C418 avdd.n316 avss 0
C419 avdd.n317 avss 0
C420 avdd.n318 avss 0.00177f
C421 avdd.n319 avss 0
C422 avdd.n320 avss 0.00222f
C423 avdd.n321 avss 0.03545f
C424 avdd.n322 avss 0.06285f
C425 avdd.n323 avss 0.03545f
C426 avdd.n324 avss 0.00222f
C427 avdd.n325 avss 0
C428 avdd.n326 avss 0.00122f
C429 avdd.n327 avss 0.00769f
C430 avdd.n328 avss 0.06056f
C431 avss.n0 avss 0.00689f
C432 avss.n1 avss 0.02377f
C433 avss.n2 avss 0.00174f
C434 avss.n3 avss 0
C435 avss.n4 avss 0
C436 avss.n5 avss 0
C437 avss.n6 avss 0.0013f
C438 avss.n7 avss 0.01292f
C439 avss.n8 avss 0
C440 avss.n9 avss 0.02558f
C441 avss.n10 avss 0
C442 avss.n11 avss 0
C443 avss.n12 avss 0.00101f
C444 avss.n13 avss 0
C445 avss.n14 avss 0
C446 avss.n15 avss 0.00108f
C447 avss.n16 avss 0
C448 avss.n17 avss 0
C449 avss.n18 avss 0.01463f
C450 avss.n19 avss 0
C451 avss.n20 avss 0
C452 avss.n21 avss 0.00101f
C453 avss.n22 avss 0
C454 avss.n23 avss 0
C455 avss.n24 avss 0
C456 avss.n25 avss 0
C457 avss.n26 avss 0
C458 avss.n27 avss 0.01844f
C459 avss.n28 avss 0
C460 avss.n29 avss 0
C461 avss.n30 avss 0.01844f
C462 avss.n31 avss 0
C463 avss.n32 avss 0
C464 avss.n33 avss 0
C465 avss.n34 avss 0
C466 avss.n35 avss 0
C467 avss.n36 avss 0.00101f
C468 avss.n37 avss 0
C469 avss.n38 avss 0
C470 avss.n39 avss 0
C471 avss.n40 avss 0
C472 avss.n41 avss 0
C473 avss.n42 avss 0
C474 avss.n43 avss 0
C475 avss.n44 avss 0
C476 avss.n45 avss 0.01844f
C477 avss.n46 avss 0
C478 avss.n47 avss 0
C479 avss.n48 avss 0
C480 avss.n49 avss 0
C481 avss.n50 avss 0
C482 avss.n51 avss 0
C483 avss.n52 avss 0
C484 avss.n53 avss 0
C485 avss.n54 avss 0.01463f
C486 avss.n55 avss 0
C487 avss.n56 avss 0.01292f
C488 avss.n57 avss 0
C489 avss.n58 avss 0
C490 avss.n59 avss 0
C491 avss.n60 avss 0
C492 avss.n61 avss 0
C493 avss.n62 avss 0
C494 avss.n63 avss 0
C495 avss.n64 avss 0
C496 avss.n65 avss 0
C497 avss.n66 avss 0
C498 avss.n67 avss 0.00945f
C499 avss.n68 avss 0
C500 avss.n69 avss 0.0151f
C501 avss.n70 avss 0
C502 avss.n71 avss 0
C503 avss.n72 avss 0.00106f
C504 avss.n73 avss 0.00135f
C505 avss.n74 avss 0.00922f
C506 avss.n75 avss 0.01596f
C507 avss.n76 avss 0
C508 avss.n77 avss 0
C509 avss.n78 avss 0
C510 avss.n79 avss 0.0011f
C511 avss.n80 avss 0
C512 avss.n81 avss 0
C513 avss.n82 avss 0.01279f
C514 avss.n83 avss 0
C515 avss.n84 avss 0.01492f
C516 avss.n85 avss 0.00135f
C517 avss.n86 avss 0
C518 avss.n87 avss 0
C519 avss.n88 avss 0.0011f
C520 avss.n89 avss 0
C521 avss.n90 avss 0
C522 avss.n91 avss 0.01279f
C523 avss.n92 avss 0
C524 avss.n93 avss 0.01492f
C525 avss.n94 avss 0
C526 avss.n95 avss 0
C527 avss.n96 avss 0
C528 avss.n97 avss 0
C529 avss.n98 avss 0
C530 avss.n99 avss 0
C531 avss.n100 avss 0
C532 avss.n101 avss 0
C533 avss.n102 avss 0.00922f
C534 avss.n103 avss 0
C535 avss.n104 avss 0
C536 avss.n105 avss 0.01273f
C537 avss.n106 avss 0.00135f
C538 avss.n107 avss 0
C539 avss.n108 avss 0
C540 avss.n109 avss 0.00106f
C541 avss.n110 avss 0
C542 avss.n111 avss 0
C543 avss.n112 avss 0.01037f
C544 avss.n113 avss 0
C545 avss.n114 avss 0.00922f
C546 avss.n115 avss 0
C547 avss.n116 avss 0
C548 avss.n117 avss 0
C549 avss.n118 avss 0
C550 avss.n119 avss 0
C551 avss.n120 avss 0
C552 avss.n121 avss 0.0013f
C553 avss.n122 avss 0.00922f
C554 avss.n123 avss 0
C555 avss.n124 avss 0.07371f
C556 avss.n125 avss 0
C557 avss.n126 avss 0
C558 avss.n127 avss 0
C559 avss.n128 avss 0
C560 avss.n129 avss 0.00106f
C561 avss.n130 avss 0.00446f
C562 avss.n131 avss 0.00109f
C563 avss.n132 avss 0
C564 avss.n133 avss 0
C565 avss.n134 avss 0
C566 avss.n135 avss 0
C567 avss.n136 avss 0
C568 avss.n137 avss 0
C569 avss.n138 avss 0.01292f
C570 avss.n139 avss 0
C571 avss.n140 avss 0
C572 avss.n141 avss 0
C573 avss.n142 avss 0
C574 avss.n143 avss 0
C575 avss.n144 avss 0
C576 avss.n145 avss 0
C577 avss.n146 avss 0.00101f
C578 avss.n147 avss 0
C579 avss.n148 avss 0
C580 avss.n149 avss 0
C581 avss.n150 avss 0.00922f
C582 avss.n151 avss 0.00922f
C583 avss.n152 avss 0.01083f
C584 avss.n153 avss 0
C585 avss.n154 avss 0
C586 avss.n155 avss 0.0013f
C587 avss.n156 avss 0
C588 avss.n157 avss 0
C589 avss.n158 avss 0
C590 avss.n159 avss 0
C591 avss.n160 avss 0.00922f
C592 avss.n161 avss 0
C593 avss.n162 avss 0
C594 avss.n163 avss 0
C595 avss.n164 avss 0
C596 avss.n165 avss 0
C597 avss.n166 avss 0
C598 avss.n167 avss 0
C599 avss.n168 avss 0
C600 avss.n169 avss 0
C601 avss.n170 avss 0
C602 avss.n171 avss 0.01008f
C603 avss.n172 avss 0
C604 avss.n173 avss 0
C605 avss.n174 avss 0
C606 avss.n175 avss 0
C607 avss.n176 avss 0
C608 avss.n177 avss 0
C609 avss.n178 avss 0
C610 avss.n179 avss 0
C611 avss.n180 avss 0
C612 avss.n181 avss 0
C613 avss.n182 avss 0
C614 avss.n183 avss 0
C615 avss.n184 avss 0
C616 avss.n185 avss 0
C617 avss.n186 avss 0
C618 avss.n187 avss 0
C619 avss.n188 avss 0
C620 avss.n189 avss 0
C621 avss.n190 avss 0
C622 avss.n191 avss 0
C623 avss.n192 avss 0
C624 avss.n193 avss 0
C625 avss.n194 avss 0
C626 avss.n195 avss 0
C627 avss.n196 avss 0
C628 avss.n197 avss 0
C629 avss.n198 avss 0
C630 avss.n199 avss 0
C631 avss.n200 avss 0
C632 avss.n201 avss 0
C633 avss.n202 avss 0
C634 avss.n203 avss 0
C635 avss.n204 avss 0
C636 avss.n205 avss 0.00101f
C637 avss.n206 avss 0.00174f
C638 avss.n207 avss 0.00231f
C639 avss.n208 avss 0
C640 avss.n209 avss 0
C641 avss.n210 avss 0
C642 avss.n211 avss 0.01118f
C643 avss.n212 avss 0.01834f
C644 avss.n213 avss 0.08903f
C645 avss.n216 avss 0.0013f
C646 avss.n217 avss 0
C647 avss.n218 avss 0.00101f
C648 avss.n219 avss 0
C649 avss.n220 avss 0
C650 avss.n221 avss 0
C651 avss.n222 avss 0
C652 avss.n223 avss 0
C653 avss.n228 avss 0.04575f
C654 avss.n231 avss 0
C655 avss.n232 avss 0.00238f
C656 avss.n233 avss 0.00101f
C657 avss.n234 avss 0
C658 avss.n235 avss 0
C659 avss.n236 avss 0
C660 avss.n237 avss 0
C661 avss.n238 avss 0
C662 avss.n239 avss 0
C663 avss.n240 avss 0
C664 avss.n241 avss 0
C665 avss.n242 avss 0
C666 avss.n243 avss 0
C667 avss.n244 avss 0
C668 avss.n245 avss 0
C669 avss.n246 avss 0
C670 avss.n247 avss 0
C671 avss.n248 avss 0
C672 avss.n249 avss 0
C673 avss.n250 avss 0
C674 avss.n251 avss 0
C675 avss.n252 avss 0
C676 avss.n253 avss 0
C677 avss.n254 avss 0
C678 avss.n255 avss 0
C679 avss.n256 avss 0
C680 avss.n257 avss 0
C681 avss.n258 avss 0
C682 avss.n259 avss 0
C683 avss.n260 avss 0
C684 avss.n261 avss 0
C685 avss.n262 avss 0
C686 avss.n263 avss 0
C687 avss.n264 avss 0
C688 avss.n265 avss 0
C689 avss.n266 avss 0
C690 avss.n267 avss 0
C691 avss.n268 avss 0
C692 avss.n269 avss 0
C693 avss.n270 avss 0
C694 avss.n271 avss 0
C695 avss.n272 avss 0.08551f
C696 avss.n273 avss 0.01607f
C697 avss.n274 avss 0
C698 avss.n275 avss 0
C699 avss.n276 avss 0
C700 avss.n277 avss 0
C701 avss.n278 avss 0
C702 avss.n279 avss 0
C703 avss.n280 avss 0
C704 avss.n281 avss 0
C705 avss.n282 avss 0
C706 avss.n283 avss 0
C707 avss.n284 avss 0
C708 avss.n285 avss 0
C709 avss.n286 avss 0.0013f
C710 avss.n287 avss 0
C711 avss.n288 avss 0
C712 avss.n289 avss 0.08903f
C713 avss.n290 avss 0
C714 avss.n297 avss 0.0013f
C715 avss.n298 avss 0
C716 avss.n299 avss 0
C717 avss.n300 avss 0
C718 avss.n301 avss 0
C719 avss.n303 avss 0
C720 avss.n304 avss 0
C721 avss.n305 avss 0
C722 avss.n306 avss 0
C723 avss.n308 avss 0
C724 avss.n309 avss 0
C725 avss.n311 avss 0
C726 avss.n312 avss 0
C727 avss.n313 avss 0
C728 avss.n314 avss 0
C729 avss.n316 avss 0
C730 avss.n317 avss 0
C731 avss.n319 avss 0
C732 avss.n320 avss 0
C733 avss.n321 avss 0
C734 avss.n322 avss 0.00101f
C735 avss.n324 avss 0
C736 avss.n325 avss 0
C737 avss.n326 avss 0.00174f
C738 avss.n327 avss 0.0013f
C739 avss.n329 avss 0
C740 avss.n330 avss 0
C741 avss.n331 avss 0
C742 avss.n332 avss 0
C743 avss.n333 avss 0
C744 avss.n334 avss 0
C745 avss.n335 avss 0
C746 avss.n336 avss 0
C747 avss.n337 avss 0
C748 avss.n338 avss 0
C749 avss.n339 avss 0
C750 avss.n340 avss 0
C751 avss.n341 avss 0
C752 avss.n342 avss 0
C753 avss.n343 avss 0
C754 avss.n344 avss 0
C755 avss.n345 avss 0
C756 avss.n346 avss 0
C757 avss.n347 avss 0
C758 avss.n348 avss 0
C759 avss.n349 avss 0
C760 avss.n350 avss 0.00116f
C761 avss.n351 avss 0.00868f
C762 avss.n352 avss 0
C763 avss.n353 avss 0
C764 avss.n354 avss 0
C765 avss.n355 avss 0
C766 avss.n356 avss 0
C767 avss.n357 avss 0
C768 avss.n358 avss 0
C769 avss.n359 avss 0
C770 avss.n360 avss 0
C771 avss.n361 avss 0
C772 avss.n362 avss 0
C773 avss.n363 avss 0
C774 avss.n364 avss 0
C775 avss.n365 avss 0
C776 avss.n366 avss 0
C777 avss.n367 avss 0
C778 avss.n368 avss 0
C779 avss.n369 avss 0
C780 avss.n370 avss 0
C781 avss.n371 avss 0
C782 avss.n372 avss 0
C783 avss.n373 avss 0
C784 avss.n374 avss 0
C785 avss.n375 avss 0
C786 avss.n376 avss 0
C787 avss.n377 avss 0
C788 avss.n378 avss 0
C789 avss.n379 avss 0
C790 avss.n380 avss 0
C791 avss.n381 avss 0
C792 avss.n382 avss 0
C793 avss.n383 avss 0
C794 avss.n384 avss 0
C795 avss.n385 avss 0
C796 avss.n386 avss 0
C797 avss.n387 avss 0
C798 avss.n388 avss 0.00101f
C799 avss.n389 avss 0
C800 avss.n390 avss 0
C801 avss.n391 avss 0.20279f
C802 avss.n392 avss 0
C803 avss.n393 avss 0
C804 avss.n394 avss 0
C805 avss.n395 avss 0
C806 avss.n396 avss 0
C807 avss.n397 avss 0
C808 avss.n398 avss 0
C809 avss.n400 avss 0.04404f
C810 avss.n401 avss 0
C811 avss.n402 avss 0
C812 avss.n403 avss 0
C813 avss.n404 avss 0
C814 avss.n405 avss 0
C815 avss.n406 avss 0
C816 avss.n408 avss 0
C817 avss.n409 avss 0
C818 avss.n410 avss 0
C819 avss.n411 avss 0
C820 avss.n413 avss 0
C821 avss.n414 avss 0
C822 avss.n415 avss 0
C823 avss.n416 avss 0
C824 avss.n417 avss 0
C825 avss.n418 avss 0
C826 avss.n420 avss 0
C827 avss.n421 avss 0
C828 avss.n422 avss 0
C829 avss.n423 avss 0
C830 avss.n424 avss 0
C831 avss.n425 avss 0
C832 avss.n427 avss 0
C833 avss.n428 avss 0
C834 avss.n430 avss 0
C835 avss.n431 avss 0
C836 avss.n432 avss 0.00101f
C837 avss.n433 avss 0.00238f
C838 avss.n434 avss 0.00101f
C839 avss.n435 avss 0
C840 avss.n436 avss 0
C841 avss.n438 avss 0
C842 avss.n440 avss 0
C843 avss.n441 avss 0
C844 avss.n442 avss 0
C845 avss.n443 avss 0
C846 avss.n444 avss 0
C847 avss.n445 avss 0
C848 avss.n446 avss 0
C849 avss.n448 avss 0
C850 avss.n450 avss 0
C851 avss.n451 avss 0
C852 avss.n452 avss 0
C853 avss.n453 avss 0
C854 avss.n454 avss 0
C855 avss.n455 avss 0
C856 avss.n456 avss 0
C857 avss.n458 avss 0
C858 avss.n460 avss 0
C859 avss.n461 avss 0
C860 avss.n462 avss 0
C861 avss.n463 avss 0
C862 avss.n464 avss 0
C863 avss.n465 avss 0.00101f
C864 avss.n466 avss 0
C865 avss.n467 avss 0
C866 avss.n468 avss 0
C867 avss.n469 avss 0.00749f
C868 avss.n470 avss 0.05056f
C869 avss.n471 avss 0.02315f
C870 avss.n472 avss 0.02988f
C871 avss.n473 avss 0
C872 avss.n474 avss 0
C873 avss.n475 avss 0
C874 avss.n476 avss 0
C875 avss.n477 avss 0
C876 avss.n478 avss 0
C877 avss.n480 avss 0
C878 avss.n481 avss 0
C879 avss.n482 avss 0
C880 avss.n483 avss 0
C881 avss.n484 avss 0
C882 avss.n485 avss 0
C883 avss.n487 avss 0
C884 avss.n488 avss 0
C885 avss.n489 avss 0
C886 avss.n490 avss 0
C887 avss.n491 avss 0
C888 avss.n493 avss 0
C889 avss.n494 avss 0
C890 avss.n495 avss 0
C891 avss.n496 avss 0
C892 avss.n497 avss 0
C893 avss.n498 avss 0
C894 avss.n500 avss 0
C895 avss.n501 avss 0
C896 avss.n502 avss 0
C897 avss.n503 avss 0
C898 avss.n504 avss 0
C899 avss.n505 avss 0
C900 avss.n506 avss 0
C901 avss.n507 avss 0
C902 avss.n508 avss 0
C903 avss.n509 avss 0
C904 avss.n510 avss 0.82741f
C905 avss.n511 avss 0.43825f
C906 avss.n512 avss 0.10837f
C907 avss.n513 avss 0.17191f
C908 avss.n514 avss 0.00895f
C909 avss.n515 avss 0.01093f
C910 avss.n516 avss 0.01136f
C911 avss.n517 avss 0.01292f
C912 avss.n518 avss 0.01567f
C913 avss.n519 avss 0
C914 avss.n520 avss 0
C915 avss.n521 avss 0.0013f
C916 avss.n522 avss 0.00238f
C917 avss.n523 avss 0.00101f
C918 avss.n524 avss 0
C919 avss.n525 avss 0
C920 avss.n526 avss 0
C921 avss.n527 avss 0
C922 avss.n528 avss 0.01279f
C923 avss.n529 avss 0
C924 avss.n530 avss 0
C925 avss.n531 avss 0
C926 avss.n532 avss 0
C927 avss.n533 avss 0
C928 avss.n534 avss 0
C929 avss.n535 avss 0
C930 avss.n536 avss 0
C931 avss.n537 avss 0
C932 avss.n538 avss 0
C933 avss.n539 avss 0
C934 avss.n540 avss 0
C935 avss.n541 avss 0
C936 avss.n542 avss 0
C937 avss.n543 avss 0.01279f
C938 avss.n544 avss 0.00922f
C939 avss.n545 avss 0.01245f
C940 avss.n546 avss 0
C941 avss.n547 avss 0
C942 avss.n548 avss 0
C943 avss.n549 avss 0
C944 avss.n550 avss 0
C945 avss.n551 avss 0
C946 avss.n552 avss 0
C947 avss.n553 avss 0
C948 avss.n554 avss 0.01164f
C949 avss.n555 avss 0
C950 avss.n556 avss 0
C951 avss.n557 avss 0
C952 avss.n558 avss 0
C953 avss.n559 avss 0
C954 avss.n560 avss 0
C955 avss.n561 avss 0.00922f
C956 avss.n562 avss 0
C957 avss.n563 avss 0
C958 avss.n564 avss 0
C959 avss.n565 avss 0
C960 avss.n566 avss 0.00111f
C961 avss.n567 avss 0
C962 avss.n568 avss 0
C963 avss.n569 avss 0.001f
C964 avss.n570 avss 0.00112f
C965 avss.n571 avss 0.00174f
C966 avss.n572 avss 0.00135f
C967 avss.n573 avss 0.06809f
C968 avss.n574 avss 0.01596f
C969 avss.n575 avss 0
C970 avss.n576 avss 0
C971 avss.n577 avss 0
C972 avss.n578 avss 0
C973 avss.n579 avss 0
C974 avss.n580 avss 0.01596f
C975 avss.n581 avss 0.00922f
C976 avss.n582 avss 0.00135f
C977 avss.n583 avss 0.00236f
C978 avss.n584 avss 0
C979 avss.n585 avss 0
C980 avss.n586 avss 0
C981 avss.n587 avss 0.00106f
C982 avss.n588 avss 0.00236f
C983 avss.n589 avss 0
C984 avss.n590 avss 0
C985 avss.n591 avss 0
C986 avss.n592 avss 0
C987 avss.n593 avss 0.00922f
C988 avss.n594 avss 0.00922f
C989 avss.n595 avss 0
C990 avss.n596 avss 0
C991 avss.n597 avss 0
C992 avss.n598 avss 0
C993 avss.n599 avss 0
C994 avss.n600 avss 0.01026f
C995 avss.n601 avss 0.00922f
C996 avss.n602 avss 0.00135f
C997 avss.n603 avss 0.00401f
C998 avss.n604 avss 0
C999 avss.n605 avss 0
C1000 avss.n606 avss 0
C1001 avss.n607 avss 0.00106f
C1002 avss.n608 avss 0.00236f
C1003 avss.n609 avss 0
C1004 avss.n610 avss 0
C1005 avss.n611 avss 0
C1006 avss.n612 avss 0
C1007 avss.n613 avss 0.00951f
C1008 avss.n614 avss 0.02518f
C1009 avss.n615 avss 0.01608f
C1010 avss.n616 avss 0.00135f
C1011 avss.n617 avss 0.00401f
C1012 avss.n618 avss 0
C1013 avss.n619 avss 0.00236f
C1014 avss.n620 avss 0
C1015 avss.n621 avss 0
C1016 avss.n622 avss 0
C1017 avss.n623 avss 0
C1018 avss.n624 avss 0.00922f
C1019 avss.n625 avss 0
C1020 avss.n626 avss 0
C1021 avss.n627 avss 0
C1022 avss.n628 avss 0.00106f
C1023 avss.n629 avss 0.00236f
C1024 avss.n630 avss 0.00135f
C1025 avss.n631 avss 0.00922f
C1026 avss.n632 avss 0.01256f
C1027 avss.n633 avss 0
C1028 avss.n634 avss 0
C1029 avss.n635 avss 0
C1030 avss.n636 avss 0
C1031 avss.n637 avss 0
C1032 avss.n638 avss 0.01279f
C1033 avss.n639 avss 0.00922f
C1034 avss.n640 avss 0.00132f
C1035 avss.n641 avss 0.00241f
C1036 avss.n642 avss 0.00101f
C1037 avss.n643 avss 0
C1038 avss.n644 avss 0
C1039 avss.n645 avss 0
C1040 avss.n646 avss 0
C1041 avss.n647 avss 0.01844f
C1042 avss.n648 avss 0
C1043 avss.n649 avss 0
C1044 avss.n650 avss 0
C1045 avss.n651 avss 0
C1046 avss.n652 avss 0.00101f
C1047 avss.n653 avss 0.00238f
C1048 avss.n654 avss 0.0013f
C1049 avss.n655 avss 0.01463f
C1050 avss.n656 avss 0.02558f
C1051 avss.n657 avss 0.00132f
C1052 avss.n658 avss 0.005f
C1053 avss.n659 avss 0.00101f
C1054 avss.n660 avss 0
C1055 avss.n661 avss 0.00236f
C1056 avss.n662 avss 0.0013f
C1057 avss.n663 avss 0.01463f
C1058 avss.n664 avss 0.00795f
C1059 avss.n665 avss 0
C1060 avss.n666 avss 0
C1061 avss.n667 avss 0
C1062 avss.n668 avss 0.00231f
C1063 avss.n669 avss 0.01125f
C1064 avss.n670 avss 0.03913f
C1065 nvpost.n0 avss 0.05745f
C1066 nvpre.n0 avss 0.05138f
C1067 vpost.n0 avss 0.03605f
C1068 vpre.n0 avss 0.03364f
C1069 vb_idep.n0 avss 0.16695f
C1070 vb_itd.n0 avss 0.11184f
C1071 vb_itp.n0 avss 0.0817f
C1072 vb_pot.n0 avss 0.0822f
C1073 vw.n0 avss 0.0057f
C1074 vw.n1 avss 0.02755f
C1075 vw.n2 avss 0.0076f
C1076 vw.n3 avss 0.02755f
C1077 vw.n4 avss 0.03325f
C1078 vw.n5 avss 0.22711f
C1079 vw.n6 avss 0.00479f
C1080 vw.n7 avss 0.28371f
C1081 vw.n8 avss 0.00644f
C1082 vw.n9 avss 0.05841f
C1083 vw.n10 avss 0.02755f
C1084 vw.n11 avss 0.02755f
C1085 vw.n12 avss 0.02755f
C1086 vw.n13 avss 0.0076f
C1087 vw.n14 avss 0.0076f
C1088 vw.n15 avss 0.0076f
C1089 vw.n16 avss 0.02755f
C1090 vw.n17 avss 0.02755f
C1091 vw.n18 avss 0.02755f
C1092 vw.n19 avss 0.0403f
C1093 Iout.n0 avss 0.01014f
C1094 xmcm_chain_2_0/a_1000_n131# avss -0.2045f
C1095 avdd avss -15.95675f
C1096 xm4_0/a_63_n131# avss -0.10177f
C1097 vb_idep avss -0.07597f
C1098 xm7_0/a_63_n131# avss -1.22273f
C1099 xmcm_chain_3_0/a_1000_n131# avss -0.20499f
C1100 Iout avss -5.46482f
C1101 xmcm_chain_4_0/a_n1000_n339# avss -1.26534f
C1102 vw avss -8.36406f
C1103 xmcm_chain_1_0/a_1000_n131# avss 2.75724f
C1104 xmcm_chain_4_0/a_1000_n131# avss -0.16541f
C1105 xm9_0/a_63_n131# avss -4.66169f
C1106 xm8_0/a_63_n131# avss -0.88199f
C1107 xm1_0/a_63_n131# avss -1.1972f
.ends
