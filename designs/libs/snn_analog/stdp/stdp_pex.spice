* NGSPICE file created from stdp.ext - technology: gf180mcuD

.subckt xm5 a_n1500_n339# a_n1620_n131# w_n1886_n560# a_1500_n131# VSUBS
X0 a_1500_n131# a_n1500_n339# a_n1620_n131# w_n1886_n560# pfet_03v3 ad=0.3p pd=2.2u as=0.3p ps=2.2u w=0.5u l=15u
C0 a_n1500_n339# w_n1886_n560# 6.38155f
C1 a_n1620_n131# a_1500_n131# 1.44038f
C2 a_1500_n131# w_n1886_n560# 1.82938f
C3 a_n1620_n131# w_n1886_n560# 0.45972f
C4 a_n1500_n339# a_1500_n131# 0.06934f
C5 a_n1500_n339# a_n1620_n131# 0.6108f
C6 a_1500_n131# VSUBS 0.06141f
C7 a_n1620_n131# VSUBS 0.05599f
C8 a_n1500_n339# VSUBS 0.30906f
C9 w_n1886_n560# VSUBS 15.2029f
.ends

.subckt xm3 a_63_n131# a_n393_n504# a_n63_n339# a_n183_n131#
X0 a_63_n131# a_n63_n339# a_n183_n131# a_n393_n504# nfet_03v3 ad=0.3p pd=2.2u as=0.3p ps=2.2u w=0.5u l=0.63u
C0 a_n183_n131# a_n63_n339# 0.04027f
C1 a_63_n131# a_n63_n339# 0.01741f
C2 a_n183_n131# a_63_n131# 0.33209f
C3 a_63_n131# a_n393_n504# 0.53054f
C4 a_n183_n131# a_n393_n504# 0.26905f
C5 a_n63_n339# a_n393_n504# 0.50927f
.ends

.subckt xm1 a_63_n131# a_n63_n339# w_n449_n560# a_n183_n131# VSUBS
X0 a_63_n131# a_n63_n339# a_n183_n131# w_n449_n560# pfet_03v3 ad=0.3p pd=2.2u as=0.3p ps=2.2u w=0.5u l=0.63u
C0 a_n63_n339# w_n449_n560# 0.45684f
C1 a_n183_n131# a_63_n131# 0.33209f
C2 a_63_n131# w_n449_n560# 0.48511f
C3 a_n183_n131# w_n449_n560# 0.2249f
C4 a_n63_n339# a_63_n131# 0.01741f
C5 a_n63_n339# a_n183_n131# 0.04027f
C6 a_63_n131# VSUBS 0.04546f
C7 a_n183_n131# VSUBS 0.04416f
C8 a_n63_n339# VSUBS 0.05243f
C9 w_n449_n560# VSUBS 3.76898f
.ends

.subckt xmcm_chain_4 a_n1120_n131# a_n1330_n504# a_1000_n131# a_n1000_n339#
X0 a_1000_n131# a_n1000_n339# a_n1120_n131# a_n1330_n504# nfet_03v3 ad=0.3p pd=2.2u as=0.3p ps=2.2u w=0.5u l=10u
C0 a_n1120_n131# a_n1000_n339# 0.42273f
C1 a_1000_n131# a_n1000_n339# 0.06176f
C2 a_n1120_n131# a_1000_n131# 1.01551f
C3 a_1000_n131# a_n1330_n504# 1.43795f
C4 a_n1120_n131# a_n1330_n504# 0.4423f
C5 a_n1000_n339# a_n1330_n504# 4.53847f
.ends

.subckt cpot m4_n700_n700# m4_n500_n500# VSUBS
X0 m4_n500_n500# m4_n700_n700# cap_mim_2f0_m4m5_noshield c_width=5u c_length=5u
X1 m4_n500_n500# m4_n700_n700# cap_mim_2f0_m4m5_noshield c_width=5u c_length=5u
C0 m4_n500_n500# m4_n700_n700# 1.99903f
C1 m4_n500_n500# VSUBS 1.68062f
C2 m4_n700_n700# VSUBS 1.59113f
.ends

.subckt xm8 a_63_n131# a_n63_n339# w_n449_n560# a_n183_n131# VSUBS
X0 a_63_n131# a_n63_n339# a_n183_n131# w_n449_n560# pfet_03v3 ad=0.3p pd=2.2u as=0.3p ps=2.2u w=0.5u l=0.63u
C0 a_n63_n339# w_n449_n560# 0.45684f
C1 a_n183_n131# a_63_n131# 0.33209f
C2 a_63_n131# w_n449_n560# 0.48511f
C3 a_n183_n131# w_n449_n560# 0.2249f
C4 a_n63_n339# a_63_n131# 0.01741f
C5 a_n63_n339# a_n183_n131# 0.04027f
C6 a_63_n131# VSUBS 0.04546f
C7 a_n183_n131# VSUBS 0.04416f
C8 a_n63_n339# VSUBS 0.05243f
C9 w_n449_n560# VSUBS 3.76898f
.ends

.subckt xmcm_chain_2 a_n1120_n131# a_n1330_n504# a_1000_n131# a_n1000_n339#
X0 a_1000_n131# a_n1000_n339# a_n1120_n131# a_n1330_n504# nfet_03v3 ad=0.3p pd=2.2u as=0.3p ps=2.2u w=0.5u l=10u
C0 a_n1120_n131# a_n1000_n339# 0.42273f
C1 a_1000_n131# a_n1000_n339# 0.06176f
C2 a_n1120_n131# a_1000_n131# 1.01551f
C3 a_1000_n131# a_n1330_n504# 1.43795f
C4 a_n1120_n131# a_n1330_n504# 0.4423f
C5 a_n1000_n339# a_n1330_n504# 4.53847f
.ends

.subckt xm16 a_n400_n1101# a_n280_n1309# w_n666_n1529# a_280_n1101# VSUBS
X0 a_280_n1101# a_n280_n1309# a_n400_n1101# w_n666_n1529# pfet_03v3 ad=6.12p pd=21.6u as=6.12p ps=21.6u w=10.2u l=2.8u
C0 a_n280_n1309# w_n666_n1529# 1.30956f
C1 a_n400_n1101# a_280_n1101# 0.72266f
C2 a_280_n1101# w_n666_n1529# 1.53123f
C3 a_n400_n1101# w_n666_n1529# 1.08957f
C4 a_n280_n1309# a_280_n1101# 0.57005f
C5 a_n280_n1309# a_n400_n1101# 0.64393f
C6 a_280_n1101# VSUBS 0.28176f
C7 a_n400_n1101# VSUBS 0.30514f
C8 a_n280_n1309# VSUBS 0.12268f
C9 w_n666_n1529# VSUBS 13.9301f
.ends

.subckt xmcm_chain_0 a_n1120_n131# a_n1330_n504# a_1000_n131# a_n1000_n339#
X0 a_1000_n131# a_n1000_n339# a_n1120_n131# a_n1330_n504# nfet_03v3 ad=0.3p pd=2.2u as=0.3p ps=2.2u w=0.5u l=10u
C0 a_n1120_n131# a_n1000_n339# 0.42273f
C1 a_1000_n131# a_n1000_n339# 0.06176f
C2 a_n1120_n131# a_1000_n131# 1.01551f
C3 a_1000_n131# a_n1330_n504# 1.43795f
C4 a_n1120_n131# a_n1330_n504# 0.4423f
C5 a_n1000_n339# a_n1330_n504# 4.53847f
.ends

.subckt cw m4_n700_n700# m4_n500_n500# VSUBS
X0 m4_n500_n500# m4_n700_n700# cap_mim_2f0_m4m5_noshield c_width=5u c_length=5u
X1 m4_n500_n500# m4_n700_n700# cap_mim_2f0_m4m5_noshield c_width=5u c_length=5u
X2 m4_n500_n500# m4_n700_n700# cap_mim_2f0_m4m5_noshield c_width=5u c_length=5u
X3 m4_n500_n500# m4_n700_n700# cap_mim_2f0_m4m5_noshield c_width=5u c_length=5u
X4 m4_n500_n500# m4_n700_n700# cap_mim_2f0_m4m5_noshield c_width=5u c_length=5u
X5 m4_n500_n500# m4_n700_n700# cap_mim_2f0_m4m5_noshield c_width=5u c_length=5u
X6 m4_n500_n500# m4_n700_n700# cap_mim_2f0_m4m5_noshield c_width=5u c_length=5u
X7 m4_n500_n500# m4_n700_n700# cap_mim_2f0_m4m5_noshield c_width=5u c_length=5u
X8 m4_n500_n500# m4_n700_n700# cap_mim_2f0_m4m5_noshield c_width=5u c_length=5u
X9 m4_n500_n500# m4_n700_n700# cap_mim_2f0_m4m5_noshield c_width=5u c_length=5u
C0 m4_n500_n500# m4_n700_n700# 10.9018f
C1 m4_n500_n500# VSUBS 4.99987f
C2 m4_n700_n700# VSUBS 4.97766f
.ends

.subckt xm4 a_63_n131# a_n393_n504# a_n63_n339# a_n183_n131#
X0 a_63_n131# a_n63_n339# a_n183_n131# a_n393_n504# nfet_03v3 ad=0.3p pd=2.2u as=0.3p ps=2.2u w=0.5u l=0.63u
C0 a_n183_n131# a_n63_n339# 0.04027f
C1 a_63_n131# a_n63_n339# 0.01741f
C2 a_n183_n131# a_63_n131# 0.33209f
C3 a_63_n131# a_n393_n504# 0.53054f
C4 a_n183_n131# a_n393_n504# 0.26905f
C5 a_n63_n339# a_n393_n504# 0.50927f
.ends

.subckt xm12 a_63_n131# a_n393_n504# a_n63_n339# a_n183_n131#
X0 a_63_n131# a_n63_n339# a_n183_n131# a_n393_n504# nfet_03v3 ad=0.3p pd=2.2u as=0.3p ps=2.2u w=0.5u l=0.63u
C0 a_n183_n131# a_n63_n339# 0.04027f
C1 a_63_n131# a_n63_n339# 0.01741f
C2 a_n183_n131# a_63_n131# 0.33209f
C3 a_63_n131# a_n393_n504# 0.53054f
C4 a_n183_n131# a_n393_n504# 0.26905f
C5 a_n63_n339# a_n393_n504# 0.50927f
.ends

.subckt xm2 a_63_n131# a_n63_n339# w_n449_n560# a_n183_n131# VSUBS
X0 a_63_n131# a_n63_n339# a_n183_n131# w_n449_n560# pfet_03v3 ad=0.3p pd=2.2u as=0.3p ps=2.2u w=0.5u l=0.63u
C0 a_n63_n339# w_n449_n560# 0.45684f
C1 a_n183_n131# a_63_n131# 0.33209f
C2 a_63_n131# w_n449_n560# 0.48511f
C3 a_n183_n131# w_n449_n560# 0.2249f
C4 a_n63_n339# a_63_n131# 0.01741f
C5 a_n63_n339# a_n183_n131# 0.04027f
C6 a_63_n131# VSUBS 0.04546f
C7 a_n183_n131# VSUBS 0.04416f
C8 a_n63_n339# VSUBS 0.05243f
C9 w_n449_n560# VSUBS 3.76898f
.ends

.subckt cdep m4_n700_n700# m4_n500_n500# VSUBS
X0 m4_n500_n500# m4_n700_n700# cap_mim_2f0_m4m5_noshield c_width=5u c_length=5u
X1 m4_n500_n500# m4_n700_n700# cap_mim_2f0_m4m5_noshield c_width=5u c_length=5u
C0 m4_n500_n500# m4_n700_n700# 1.99903f
C1 m4_n500_n500# VSUBS 1.68062f
C2 m4_n700_n700# VSUBS 1.59113f
.ends

.subckt xmcm_1 a_n280_n350# a_n400_n141# a_280_n141# a_n610_n515#
X0 a_280_n141# a_n280_n350# a_n400_n141# a_n610_n515# nfet_03v3 ad=0.366p pd=2.42u as=0.366p ps=2.42u w=0.61u l=2.8u
C0 a_n400_n141# a_n280_n350# 0.1455f
C1 a_280_n141# a_n280_n350# 0.04694f
C2 a_n400_n141# a_280_n141# 0.4351f
C3 a_280_n141# a_n610_n515# 0.76826f
C4 a_n400_n141# a_n610_n515# 0.3279f
C5 a_n280_n350# a_n610_n515# 1.4155f
.ends

.subckt xm9 a_63_n131# a_n393_n504# a_n63_n339# a_n183_n131#
X0 a_63_n131# a_n63_n339# a_n183_n131# a_n393_n504# nfet_03v3 ad=0.3p pd=2.2u as=0.3p ps=2.2u w=0.5u l=0.63u
C0 a_n183_n131# a_n63_n339# 0.04027f
C1 a_63_n131# a_n63_n339# 0.01741f
C2 a_n183_n131# a_63_n131# 0.33209f
C3 a_63_n131# a_n393_n504# 0.53054f
C4 a_n183_n131# a_n393_n504# 0.26905f
C5 a_n63_n339# a_n393_n504# 0.50927f
.ends

.subckt xmcm_chain_3 a_n1120_n131# a_n1330_n504# a_1000_n131# a_n1000_n339#
X0 a_1000_n131# a_n1000_n339# a_n1120_n131# a_n1330_n504# nfet_03v3 ad=0.3p pd=2.2u as=0.3p ps=2.2u w=0.5u l=10u
C0 a_n1120_n131# a_n1000_n339# 0.42273f
C1 a_1000_n131# a_n1000_n339# 0.06176f
C2 a_n1120_n131# a_1000_n131# 1.01551f
C3 a_1000_n131# a_n1330_n504# 1.43795f
C4 a_n1120_n131# a_n1330_n504# 0.4423f
C5 a_n1000_n339# a_n1330_n504# 4.53847f
.ends

.subckt xm17 a_n460_n339# w_n846_n560# a_n580_n131# a_460_n131# VSUBS
X0 a_460_n131# a_n460_n339# a_n580_n131# w_n846_n560# pfet_03v3 ad=0.3p pd=2.2u as=0.3p ps=2.2u w=0.5u l=4.6u
C0 a_n460_n339# w_n846_n560# 2.05763f
C1 a_n580_n131# a_460_n131# 0.57434f
C2 a_460_n131# w_n846_n560# 0.87034f
C3 a_n580_n131# w_n846_n560# 0.30191f
C4 a_n460_n339# a_460_n131# 0.04912f
C5 a_n460_n339# a_n580_n131# 0.21491f
C6 a_460_n131# VSUBS 0.04483f
C7 a_n580_n131# VSUBS 0.04363f
C8 a_n460_n339# VSUBS 0.12333f
C9 w_n846_n560# VSUBS 6.90762f
.ends

.subckt xm7 a_63_n131# a_n63_n339# w_n449_n560# a_n183_n131# VSUBS
X0 a_63_n131# a_n63_n339# a_n183_n131# w_n449_n560# pfet_03v3 ad=0.3p pd=2.2u as=0.3p ps=2.2u w=0.5u l=0.63u
C0 a_n63_n339# w_n449_n560# 0.45684f
C1 a_n183_n131# a_63_n131# 0.33209f
C2 a_63_n131# w_n449_n560# 0.48511f
C3 a_n183_n131# w_n449_n560# 0.2249f
C4 a_n63_n339# a_63_n131# 0.01741f
C5 a_n63_n339# a_n183_n131# 0.04027f
C6 a_63_n131# VSUBS 0.04546f
C7 a_n183_n131# VSUBS 0.04416f
C8 a_n63_n339# VSUBS 0.05243f
C9 w_n449_n560# VSUBS 3.76898f
.ends

.subckt xmcm_chain_1 a_n1120_n131# a_n1330_n504# a_1000_n131# a_n1000_n339#
X0 a_1000_n131# a_n1000_n339# a_n1120_n131# a_n1330_n504# nfet_03v3 ad=0.3p pd=2.2u as=0.3p ps=2.2u w=0.5u l=10u
C0 a_n1120_n131# a_n1000_n339# 0.42273f
C1 a_1000_n131# a_n1000_n339# 0.06176f
C2 a_n1120_n131# a_1000_n131# 1.01551f
C3 a_1000_n131# a_n1330_n504# 1.43795f
C4 a_n1120_n131# a_n1330_n504# 0.4423f
C5 a_n1000_n339# a_n1330_n504# 4.53847f
.ends

.subckt stdp avdd avss nvpost nvpre vpost vpre vb_idep vb_itd vb_itp vb_pot vw Iout
Xxm5_0 vw avdd avdd Iout avss xm5
Xxm3_0 vw avss vpre xm4_0/a_63_n131# xm3
Xxm1_0 xm1_0/a_63_n131# xm1_0/a_n63_n339# avdd avdd avss xm1
Xxmcm_chain_4_0 avss avss xmcm_chain_4_0/a_1000_n131# vb_itd xmcm_chain_4
Xcpot_0 xm1_0/a_n63_n339# avdd avss cpot
Xxm8_0 xm8_0/a_63_n131# nvpre avdd xm1_0/a_n63_n339# avss xm8
Xxmcm_chain_2_0 xmcm_chain_3_0/a_1000_n131# avss xmcm_chain_2_0/a_1000_n131# vb_itd
+ xmcm_chain_2
Xxm16_0 avdd vb_idep avdd xm9_0/a_63_n131# avss xm16
Xxmcm_chain_0_0 xmcm_chain_1_0/a_1000_n131# avss avdd vb_itd xmcm_chain_0
Xcw_0 avss vw avss cw
Xxm4_0 xm4_0/a_63_n131# avss avdd avss xm4
Xxm12_0 xm9_0/a_63_n131# avss vpost avdd xm12
Xxm2_0 vw nvpost avdd xm1_0/a_63_n131# avss xm2
Xcdep_0 avss avdd avss cdep
Xxmcm_1_0 vb_pot avss xm7_0/a_63_n131# avss xmcm_1
Xxm9_0 xm9_0/a_63_n131# avss xm9_0/a_63_n131# avss xm9
Xxmcm_chain_3_0 xmcm_chain_4_0/a_1000_n131# avss xmcm_chain_3_0/a_1000_n131# vb_itd
+ xmcm_chain_3
Xxm17_0 vb_itp avdd avdd xm1_0/a_n63_n339# avss xm17
Xxm7_0 xm7_0/a_63_n131# xm8_0/a_63_n131# avdd avdd avss xm7
Xxmcm_chain_1_0 xmcm_chain_2_0/a_1000_n131# avss xmcm_chain_1_0/a_1000_n131# vb_itd
+ xmcm_chain_1
R0 vw.n136 vw.n135 18.0159
R1 vw vw.n136 16.8197
R2 vw.n136 vw.n134 13.9146
R3 vw.n98 vw.n77 4.5005
R4 vw.n98 vw.n75 4.5005
R5 vw.n98 vw.n78 4.5005
R6 vw.n98 vw.n74 4.5005
R7 vw.n93 vw.n74 4.5005
R8 vw.n84 vw.n75 4.5005
R9 vw.n84 vw.n78 4.5005
R10 vw.n84 vw.n74 4.5005
R11 vw.n96 vw.n75 4.5005
R12 vw.n96 vw.n78 4.5005
R13 vw.n96 vw.n74 4.5005
R14 vw.n98 vw.n79 4.5005
R15 vw.n98 vw.n73 4.5005
R16 vw.n98 vw.n97 4.5005
R17 vw.n93 vw.n79 4.5005
R18 vw.n84 vw.n79 4.5005
R19 vw.n84 vw.n73 4.5005
R20 vw.n95 vw.n84 4.5005
R21 vw.n85 vw.n84 4.5005
R22 vw.n97 vw.n84 4.5005
R23 vw.n82 vw.n79 4.5005
R24 vw.n82 vw.n73 4.5005
R25 vw.n95 vw.n82 4.5005
R26 vw.n97 vw.n82 4.5005
R27 vw.n96 vw.n95 4.5005
R28 vw.n97 vw.n96 4.5005
R29 vw.n107 vw.n59 4.5005
R30 vw.n107 vw.n57 4.5005
R31 vw.n107 vw.n60 4.5005
R32 vw.n107 vw.n56 4.5005
R33 vw.n102 vw.n56 4.5005
R34 vw.n66 vw.n57 4.5005
R35 vw.n66 vw.n60 4.5005
R36 vw.n66 vw.n56 4.5005
R37 vw.n105 vw.n57 4.5005
R38 vw.n105 vw.n60 4.5005
R39 vw.n105 vw.n56 4.5005
R40 vw.n107 vw.n61 4.5005
R41 vw.n107 vw.n55 4.5005
R42 vw.n107 vw.n106 4.5005
R43 vw.n102 vw.n61 4.5005
R44 vw.n66 vw.n61 4.5005
R45 vw.n66 vw.n55 4.5005
R46 vw.n104 vw.n66 4.5005
R47 vw.n67 vw.n66 4.5005
R48 vw.n106 vw.n66 4.5005
R49 vw.n64 vw.n61 4.5005
R50 vw.n64 vw.n55 4.5005
R51 vw.n104 vw.n64 4.5005
R52 vw.n106 vw.n64 4.5005
R53 vw.n105 vw.n104 4.5005
R54 vw.n106 vw.n105 4.5005
R55 vw.n116 vw.n41 4.5005
R56 vw.n116 vw.n39 4.5005
R57 vw.n116 vw.n42 4.5005
R58 vw.n116 vw.n38 4.5005
R59 vw.n111 vw.n38 4.5005
R60 vw.n48 vw.n39 4.5005
R61 vw.n48 vw.n42 4.5005
R62 vw.n48 vw.n38 4.5005
R63 vw.n114 vw.n39 4.5005
R64 vw.n114 vw.n42 4.5005
R65 vw.n114 vw.n38 4.5005
R66 vw.n116 vw.n43 4.5005
R67 vw.n116 vw.n37 4.5005
R68 vw.n116 vw.n115 4.5005
R69 vw.n111 vw.n43 4.5005
R70 vw.n48 vw.n43 4.5005
R71 vw.n48 vw.n37 4.5005
R72 vw.n113 vw.n48 4.5005
R73 vw.n49 vw.n48 4.5005
R74 vw.n115 vw.n48 4.5005
R75 vw.n46 vw.n43 4.5005
R76 vw.n46 vw.n37 4.5005
R77 vw.n113 vw.n46 4.5005
R78 vw.n115 vw.n46 4.5005
R79 vw.n114 vw.n113 4.5005
R80 vw.n115 vw.n114 4.5005
R81 vw.n125 vw.n23 4.5005
R82 vw.n125 vw.n21 4.5005
R83 vw.n125 vw.n24 4.5005
R84 vw.n125 vw.n20 4.5005
R85 vw.n120 vw.n20 4.5005
R86 vw.n30 vw.n21 4.5005
R87 vw.n30 vw.n24 4.5005
R88 vw.n30 vw.n20 4.5005
R89 vw.n123 vw.n21 4.5005
R90 vw.n123 vw.n24 4.5005
R91 vw.n123 vw.n20 4.5005
R92 vw.n125 vw.n25 4.5005
R93 vw.n125 vw.n19 4.5005
R94 vw.n125 vw.n124 4.5005
R95 vw.n120 vw.n25 4.5005
R96 vw.n30 vw.n25 4.5005
R97 vw.n30 vw.n19 4.5005
R98 vw.n122 vw.n30 4.5005
R99 vw.n31 vw.n30 4.5005
R100 vw.n124 vw.n30 4.5005
R101 vw.n28 vw.n25 4.5005
R102 vw.n28 vw.n19 4.5005
R103 vw.n122 vw.n28 4.5005
R104 vw.n124 vw.n28 4.5005
R105 vw.n123 vw.n122 4.5005
R106 vw.n124 vw.n123 4.5005
R107 vw.n134 vw.n5 4.5005
R108 vw.n134 vw.n3 4.5005
R109 vw.n134 vw.n6 4.5005
R110 vw.n134 vw.n2 4.5005
R111 vw.n129 vw.n2 4.5005
R112 vw.n12 vw.n3 4.5005
R113 vw.n12 vw.n6 4.5005
R114 vw.n12 vw.n2 4.5005
R115 vw.n132 vw.n3 4.5005
R116 vw.n132 vw.n6 4.5005
R117 vw.n132 vw.n2 4.5005
R118 vw.n134 vw.n7 4.5005
R119 vw.n134 vw.n1 4.5005
R120 vw.n134 vw.n133 4.5005
R121 vw.n129 vw.n7 4.5005
R122 vw.n12 vw.n7 4.5005
R123 vw.n12 vw.n1 4.5005
R124 vw.n131 vw.n12 4.5005
R125 vw.n13 vw.n12 4.5005
R126 vw.n133 vw.n12 4.5005
R127 vw.n10 vw.n7 4.5005
R128 vw.n10 vw.n1 4.5005
R129 vw.n131 vw.n10 4.5005
R130 vw.n133 vw.n10 4.5005
R131 vw.n132 vw.n131 4.5005
R132 vw.n133 vw.n132 4.5005
R133 vw.n88 vw.n76 2.25044
R134 vw.n92 vw.n77 2.25044
R135 vw.n88 vw.n87 2.25044
R136 vw.n86 vw.n85 2.25044
R137 vw.n70 vw.n58 2.25044
R138 vw.n101 vw.n59 2.25044
R139 vw.n70 vw.n69 2.25044
R140 vw.n68 vw.n67 2.25044
R141 vw.n52 vw.n40 2.25044
R142 vw.n110 vw.n41 2.25044
R143 vw.n52 vw.n51 2.25044
R144 vw.n50 vw.n49 2.25044
R145 vw.n34 vw.n22 2.25044
R146 vw.n119 vw.n23 2.25044
R147 vw.n34 vw.n33 2.25044
R148 vw.n32 vw.n31 2.25044
R149 vw.n16 vw.n4 2.25044
R150 vw.n128 vw.n5 2.25044
R151 vw.n16 vw.n15 2.25044
R152 vw.n14 vw.n13 2.25044
R153 vw.n93 vw.n91 2.24741
R154 vw.n82 vw.n80 2.24741
R155 vw.n82 vw.n81 2.24741
R156 vw.n96 vw.n89 2.24741
R157 vw.n98 vw.n72 2.24741
R158 vw.n94 vw.n93 2.24741
R159 vw.n93 vw.n83 2.24741
R160 vw.n96 vw.n90 2.24741
R161 vw.n102 vw.n100 2.24741
R162 vw.n64 vw.n62 2.24741
R163 vw.n64 vw.n63 2.24741
R164 vw.n105 vw.n71 2.24741
R165 vw.n107 vw.n54 2.24741
R166 vw.n103 vw.n102 2.24741
R167 vw.n102 vw.n65 2.24741
R168 vw.n105 vw.n99 2.24741
R169 vw.n111 vw.n109 2.24741
R170 vw.n46 vw.n44 2.24741
R171 vw.n46 vw.n45 2.24741
R172 vw.n114 vw.n53 2.24741
R173 vw.n116 vw.n36 2.24741
R174 vw.n112 vw.n111 2.24741
R175 vw.n111 vw.n47 2.24741
R176 vw.n114 vw.n108 2.24741
R177 vw.n120 vw.n118 2.24741
R178 vw.n28 vw.n26 2.24741
R179 vw.n28 vw.n27 2.24741
R180 vw.n123 vw.n35 2.24741
R181 vw.n125 vw.n18 2.24741
R182 vw.n121 vw.n120 2.24741
R183 vw.n120 vw.n29 2.24741
R184 vw.n123 vw.n117 2.24741
R185 vw.n129 vw.n127 2.24741
R186 vw.n10 vw.n8 2.24741
R187 vw.n10 vw.n9 2.24741
R188 vw.n132 vw.n17 2.24741
R189 vw.n134 vw.n0 2.24741
R190 vw.n130 vw.n129 2.24741
R191 vw.n129 vw.n11 2.24741
R192 vw.n132 vw.n126 2.24741
R193 vw.n132 vw.n125 0.0121667
R194 vw.n123 vw.n116 0.0121667
R195 vw.n114 vw.n107 0.0121667
R196 vw.n105 vw.n98 0.0121667
R197 vw.n13 vw.n11 0.0081885
R198 vw.n13 vw.n0 0.0081885
R199 vw.n130 vw.n1 0.0081885
R200 vw.n126 vw.n7 0.0081885
R201 vw.n9 vw.n6 0.0081885
R202 vw.n127 vw.n3 0.0081885
R203 vw.n8 vw.n5 0.0081885
R204 vw.n17 vw.n16 0.0081885
R205 vw.n31 vw.n29 0.0081885
R206 vw.n31 vw.n18 0.0081885
R207 vw.n121 vw.n19 0.0081885
R208 vw.n117 vw.n25 0.0081885
R209 vw.n27 vw.n24 0.0081885
R210 vw.n118 vw.n21 0.0081885
R211 vw.n26 vw.n23 0.0081885
R212 vw.n35 vw.n34 0.0081885
R213 vw.n49 vw.n47 0.0081885
R214 vw.n49 vw.n36 0.0081885
R215 vw.n112 vw.n37 0.0081885
R216 vw.n108 vw.n43 0.0081885
R217 vw.n45 vw.n42 0.0081885
R218 vw.n109 vw.n39 0.0081885
R219 vw.n44 vw.n41 0.0081885
R220 vw.n53 vw.n52 0.0081885
R221 vw.n67 vw.n65 0.0081885
R222 vw.n67 vw.n54 0.0081885
R223 vw.n103 vw.n55 0.0081885
R224 vw.n99 vw.n61 0.0081885
R225 vw.n63 vw.n60 0.0081885
R226 vw.n100 vw.n57 0.0081885
R227 vw.n62 vw.n59 0.0081885
R228 vw.n71 vw.n70 0.0081885
R229 vw.n85 vw.n83 0.0081885
R230 vw.n85 vw.n72 0.0081885
R231 vw.n94 vw.n73 0.0081885
R232 vw.n90 vw.n79 0.0081885
R233 vw.n81 vw.n78 0.0081885
R234 vw.n91 vw.n75 0.0081885
R235 vw.n80 vw.n77 0.0081885
R236 vw.n89 vw.n88 0.0081885
R237 vw.n91 vw.n78 0.0081885
R238 vw.n80 vw.n75 0.0081885
R239 vw.n81 vw.n74 0.0081885
R240 vw.n89 vw.n77 0.0081885
R241 vw.n95 vw.n72 0.0081885
R242 vw.n95 vw.n94 0.0081885
R243 vw.n97 vw.n83 0.0081885
R244 vw.n90 vw.n73 0.0081885
R245 vw.n100 vw.n60 0.0081885
R246 vw.n62 vw.n57 0.0081885
R247 vw.n63 vw.n56 0.0081885
R248 vw.n71 vw.n59 0.0081885
R249 vw.n104 vw.n54 0.0081885
R250 vw.n104 vw.n103 0.0081885
R251 vw.n106 vw.n65 0.0081885
R252 vw.n99 vw.n55 0.0081885
R253 vw.n109 vw.n42 0.0081885
R254 vw.n44 vw.n39 0.0081885
R255 vw.n45 vw.n38 0.0081885
R256 vw.n53 vw.n41 0.0081885
R257 vw.n113 vw.n36 0.0081885
R258 vw.n113 vw.n112 0.0081885
R259 vw.n115 vw.n47 0.0081885
R260 vw.n108 vw.n37 0.0081885
R261 vw.n118 vw.n24 0.0081885
R262 vw.n26 vw.n21 0.0081885
R263 vw.n27 vw.n20 0.0081885
R264 vw.n35 vw.n23 0.0081885
R265 vw.n122 vw.n18 0.0081885
R266 vw.n122 vw.n121 0.0081885
R267 vw.n124 vw.n29 0.0081885
R268 vw.n117 vw.n19 0.0081885
R269 vw.n127 vw.n6 0.0081885
R270 vw.n8 vw.n3 0.0081885
R271 vw.n9 vw.n2 0.0081885
R272 vw.n17 vw.n5 0.0081885
R273 vw.n131 vw.n0 0.0081885
R274 vw.n131 vw.n130 0.0081885
R275 vw.n133 vw.n11 0.0081885
R276 vw.n126 vw.n1 0.0081885
R277 vw.n129 vw.n4 0.00211084
R278 vw.n129 vw.n128 0.00211084
R279 vw.n15 vw.n10 0.00211084
R280 vw.n132 vw.n14 0.00211084
R281 vw.n120 vw.n22 0.00211084
R282 vw.n120 vw.n119 0.00211084
R283 vw.n33 vw.n28 0.00211084
R284 vw.n123 vw.n32 0.00211084
R285 vw.n111 vw.n40 0.00211084
R286 vw.n111 vw.n110 0.00211084
R287 vw.n51 vw.n46 0.00211084
R288 vw.n114 vw.n50 0.00211084
R289 vw.n102 vw.n58 0.00211084
R290 vw.n102 vw.n101 0.00211084
R291 vw.n69 vw.n64 0.00211084
R292 vw.n105 vw.n68 0.00211084
R293 vw.n93 vw.n76 0.00211084
R294 vw.n93 vw.n92 0.00211084
R295 vw.n87 vw.n82 0.00211084
R296 vw.n96 vw.n86 0.00211084
R297 vw.n98 vw.n76 0.00211084
R298 vw.n87 vw.n84 0.00211084
R299 vw.n92 vw.n84 0.00211084
R300 vw.n86 vw.n82 0.00211084
R301 vw.n107 vw.n58 0.00211084
R302 vw.n69 vw.n66 0.00211084
R303 vw.n101 vw.n66 0.00211084
R304 vw.n68 vw.n64 0.00211084
R305 vw.n116 vw.n40 0.00211084
R306 vw.n51 vw.n48 0.00211084
R307 vw.n110 vw.n48 0.00211084
R308 vw.n50 vw.n46 0.00211084
R309 vw.n125 vw.n22 0.00211084
R310 vw.n33 vw.n30 0.00211084
R311 vw.n119 vw.n30 0.00211084
R312 vw.n32 vw.n28 0.00211084
R313 vw.n134 vw.n4 0.00211084
R314 vw.n15 vw.n12 0.00211084
R315 vw.n128 vw.n12 0.00211084
R316 vw.n14 vw.n10 0.00211084
R317 vb_pot vb_pot.n0 10.6917
R318 vb_itp vb_itp.n0 9.44853
R319 vb_itd.n8 vb_itd.n6 13.8517
R320 vb_itd.n4 vb_itd.n3 7.3405
R321 vb_itd.n8 vb_itd.n7 5.29737
R322 vb_itd vb_itd.n8 4.5005
R323 vb_itd.n4 vb_itd.n2 4.45298
R324 vb_itd.n5 vb_itd.n1 4.45298
R325 vb_itd.n6 vb_itd.n0 4.45298
R326 vb_itd.n6 vb_itd.n5 2.88807
R327 vb_itd.n5 vb_itd.n4 2.88807
R328 vb_idep vb_idep.n0 23.1975
R329 vpre vpre.n0 29.063
R330 vpost vpost.n0 29.063
R331 nvpre nvpre.n0 29.063
R332 nvpost nvpost.n0 29.063
R333 avss.n569 avss.n70 19754.3
R334 avss.n571 avss.n570 9594.57
R335 avss.n572 avss.n571 9594.57
R336 avss.n572 avss.n39 9594.57
R337 avss.n39 avss.n9 7969.56
R338 avss.n570 avss.n69 7913.04
R339 avss.n571 avss.n68 7913.04
R340 avss.n573 avss.n572 7913.04
R341 avss.n638 avss.n39 7913.04
R342 avss.n568 avss.n9 6127.73
R343 avss.n665 avss.n9 6122.88
R344 avss.n568 avss.n567 3893.55
R345 avss.n570 avss.n569 3363.04
R346 avss.n310 avss.n82 2283.78
R347 avss.n507 avss.n298 2283.78
R348 avss.n507 avss.n98 1651.84
R349 avss.n310 avss.n298 1571.32
R350 avss.n569 avss.n568 433.959
R351 avss.n349 avss.n98 222.697
R352 avss.n347 avss.n346 211.843
R353 avss.n567 avss.n71 153.947
R354 avss.n346 avss.n71 153.947
R355 avss.n452 avss.n347 153.947
R356 avss.n452 avss.n349 153.947
R357 avss.n585 avss.n584 115.669
R358 avss.n666 avss.n665 106.064
R359 avss.n239 avss.n238 82.6807
R360 avss.n583 avss.n573 81.0104
R361 avss.n656 avss.n15 68.9311
R362 avss.n664 avss.n10 68.9311
R363 avss.n664 avss.n11 68.9311
R364 avss.n658 avss.n15 68.9311
R365 avss.n25 avss.n20 68.9311
R366 avss.n648 avss.n20 68.9311
R367 avss.n591 avss.n23 68.9311
R368 avss.n591 avss.n57 68.9311
R369 avss.n67 avss.n62 68.9311
R370 avss.n586 avss.n62 68.9311
R371 avss.n240 avss.n65 68.9311
R372 avss.n240 avss.n160 68.9311
R373 avss.n200 avss.n155 68.9311
R374 avss.n155 avss.n152 68.9311
R375 avss.n246 avss.n151 68.9311
R376 avss.n151 avss.n149 68.9311
R377 avss.n193 avss.n190 67.7644
R378 avss.n193 avss.n116 67.7644
R379 avss.n536 avss.n107 67.7644
R380 avss.n536 avss.n106 67.7644
R381 avss.n517 avss.n286 66.8128
R382 avss.n526 avss.n286 66.8128
R383 avss.n526 avss.n108 66.8128
R384 avss.n278 avss.n277 66.8128
R385 avss.n277 avss.n110 66.8128
R386 avss.n269 avss.n110 66.8128
R387 avss.n260 avss.n127 66.8128
R388 avss.n254 avss.n138 66.8128
R389 avss.n248 avss.n147 66.8128
R390 avss.n212 avss.n211 66.8128
R391 avss.n221 avss.n174 66.8128
R392 avss.n230 avss.n161 66.8128
R393 avss.n585 avss.n66 66.8128
R394 avss.n593 avss.n55 66.8128
R395 avss.n602 avss.n48 66.8128
R396 avss.n646 avss.n27 66.8128
R397 avss.n640 avss.n639 66.8128
R398 avss.n637 avss.n626 66.8128
R399 avss.n8 avss.n6 66.6949
R400 avss.n667 avss.n6 66.6949
R401 avss.n582 avss.n54 66.6949
R402 avss.n582 avss.n574 66.6949
R403 avss.n237 avss.n162 66.6949
R404 avss.n237 avss.n163 66.6949
R405 avss.n267 avss.n120 66.6949
R406 avss.n267 avss.n119 66.6949
R407 avss.n543 avss.n97 66.6949
R408 avss.n541 avss.n97 66.6949
R409 avss.n345 avss.n74 66.6949
R410 avss.n566 avss.n74 66.6949
R411 avss.n533 avss.n279 66.6949
R412 avss.n533 avss.n280 66.6949
R413 avss.n506 avss.n453 66.6949
R414 avss.n483 avss.n453 66.6949
R415 avss.n367 avss.n348 66.6949
R416 avss.n415 avss.n348 66.6949
R417 avss.n451 avss.n350 66.6949
R418 avss.n451 avss.n351 66.6949
R419 avss.n640 avss.n36 60.1316
R420 avss.n638 avss.n637 59.2964
R421 avss.n625 avss.n16 58.4612
R422 avss.n535 avss.n108 57.6261
R423 avss.n534 avss.n278 57.6261
R424 avss.n254 avss.n139 57.6261
R425 avss.n657 avss.n16 57.2085
R426 avss.n17 avss.n7 57.2085
R427 avss.n260 avss.n69 56.7909
R428 avss.n268 avss.n118 55.9558
R429 avss.n192 avss.n191 55.9558
R430 avss.n584 avss.n583 53.4503
R431 avss.n542 avss.n99 50.1097
R432 avss.n191 avss.n118 50.1097
R433 avss.n535 avss.n534 48.4394
R434 avss.n221 avss.n173 45.0988
R435 avss.n230 avss.n68 44.2636
R436 avss.n593 avss.n592 42.5933
R437 avss.n49 avss.n24 42.1758
R438 avss.n647 avss.n646 42.1758
R439 avss.n99 avss.n70 40.0879
R440 avss.n248 avss.n247 39.6703
R441 avss.n201 avss.n150 39.6703
R442 avss.n238 avss.n66 32.9891
R443 avss.n247 avss.n150 27.143
R444 avss.n212 avss.n201 27.143
R445 avss.n573 avss.n55 25.0551
R446 avss.n602 avss.n49 24.6375
R447 avss.n647 avss.n24 24.6375
R448 avss.n592 avss.n48 24.22
R449 avss.n239 avss.n161 23.3848
R450 avss.n174 avss.n68 22.5496
R451 avss.n211 avss.n173 21.7145
R452 avss.n292 avss.n70 15.8684
R453 avss.n656 avss.n10 15.5561
R454 avss.n658 avss.n11 15.5561
R455 avss.n648 avss.n23 15.5561
R456 avss.n57 avss.n25 15.5561
R457 avss.n586 avss.n65 15.5561
R458 avss.n160 avss.n67 15.5561
R459 avss.n246 avss.n152 15.5561
R460 avss.n200 avss.n149 15.5561
R461 avss.n276 avss.n107 15.5561
R462 avss.n276 avss.n111 15.5561
R463 avss.n270 avss.n111 15.5561
R464 avss.n270 avss.n116 15.5561
R465 avss.n109 avss.n106 15.5561
R466 avss.n180 avss.n109 15.5561
R467 avss.n180 avss.n117 15.5561
R468 avss.n190 avss.n117 15.5561
R469 avss.n594 avss.n54 15.5561
R470 avss.n594 avss.n50 15.5561
R471 avss.n601 avss.n50 15.5561
R472 avss.n601 avss.n28 15.5561
R473 avss.n645 avss.n28 15.5561
R474 avss.n645 avss.n29 15.5561
R475 avss.n641 avss.n29 15.5561
R476 avss.n641 avss.n35 15.5561
R477 avss.n636 avss.n35 15.5561
R478 avss.n636 avss.n627 15.5561
R479 avss.n632 avss.n627 15.5561
R480 avss.n632 avss.n5 15.5561
R481 avss.n667 avss.n5 15.5561
R482 avss.n574 avss.n56 15.5561
R483 avss.n56 avss.n47 15.5561
R484 avss.n603 avss.n47 15.5561
R485 avss.n604 avss.n603 15.5561
R486 avss.n604 avss.n26 15.5561
R487 avss.n609 avss.n26 15.5561
R488 avss.n609 avss.n37 15.5561
R489 avss.n38 avss.n37 15.5561
R490 avss.n40 avss.n38 15.5561
R491 avss.n624 avss.n40 15.5561
R492 avss.n624 avss.n41 15.5561
R493 avss.n620 avss.n41 15.5561
R494 avss.n620 avss.n8 15.5561
R495 avss.n123 avss.n120 15.5561
R496 avss.n261 avss.n123 15.5561
R497 avss.n261 avss.n126 15.5561
R498 avss.n253 avss.n126 15.5561
R499 avss.n253 avss.n140 15.5561
R500 avss.n249 avss.n140 15.5561
R501 avss.n249 avss.n146 15.5561
R502 avss.n213 avss.n146 15.5561
R503 avss.n213 avss.n175 15.5561
R504 avss.n220 avss.n175 15.5561
R505 avss.n220 avss.n167 15.5561
R506 avss.n231 avss.n167 15.5561
R507 avss.n231 avss.n163 15.5561
R508 avss.n128 avss.n119 15.5561
R509 avss.n259 avss.n128 15.5561
R510 avss.n259 avss.n129 15.5561
R511 avss.n255 avss.n129 15.5561
R512 avss.n255 avss.n137 15.5561
R513 avss.n148 avss.n137 15.5561
R514 avss.n202 avss.n148 15.5561
R515 avss.n210 avss.n202 15.5561
R516 avss.n210 avss.n172 15.5561
R517 avss.n222 avss.n172 15.5561
R518 avss.n222 avss.n168 15.5561
R519 avss.n229 avss.n168 15.5561
R520 avss.n229 avss.n162 15.5561
R521 avss.n345 avss.n304 15.5561
R522 avss.n338 avss.n337 15.5561
R523 avss.n335 avss.n334 15.5561
R524 avss.n332 avss.n311 15.5561
R525 avss.n328 avss.n327 15.5561
R526 avss.n325 avss.n319 15.5561
R527 avss.n541 avss.n100 15.5561
R528 avss.n566 avss.n75 15.5561
R529 avss.n562 avss.n561 15.5561
R530 avss.n558 avss.n557 15.5561
R531 avss.n555 avss.n83 15.5561
R532 avss.n551 avss.n550 15.5561
R533 avss.n548 avss.n90 15.5561
R534 avss.n544 avss.n543 15.5561
R535 avss.n506 avss.n454 15.5561
R536 avss.n499 avss.n498 15.5561
R537 avss.n496 avss.n495 15.5561
R538 avss.n492 avss.n297 15.5561
R539 avss.n509 avss.n293 15.5561
R540 avss.n516 avss.n293 15.5561
R541 avss.n516 avss.n285 15.5561
R542 avss.n527 avss.n285 15.5561
R543 avss.n527 avss.n280 15.5561
R544 avss.n483 avss.n482 15.5561
R545 avss.n480 avss.n457 15.5561
R546 avss.n476 avss.n475 15.5561
R547 avss.n473 avss.n463 15.5561
R548 avss.n469 avss.n291 15.5561
R549 avss.n518 avss.n291 15.5561
R550 avss.n518 avss.n287 15.5561
R551 avss.n525 avss.n287 15.5561
R552 avss.n525 avss.n279 15.5561
R553 avss.n370 avss.n369 15.5561
R554 avss.n375 avss.n374 15.5561
R555 avss.n378 avss.n377 15.5561
R556 avss.n383 avss.n382 15.5561
R557 avss.n386 avss.n385 15.5561
R558 avss.n391 avss.n389 15.5561
R559 avss.n415 avss.n414 15.5561
R560 avss.n422 avss.n421 15.5561
R561 avss.n425 avss.n424 15.5561
R562 avss.n432 avss.n431 15.5561
R563 avss.n435 avss.n434 15.5561
R564 avss.n443 avss.n442 15.5561
R565 avss.n445 avss.n351 15.5561
R566 avss.n353 avss.n0 13.6859
R567 avss.n672 avss.n0 11.7466
R568 avss.n672 avss.n671 10.9337
R569 avss.n517 avss.n292 10.8575
R570 avss.n269 avss.n268 10.8575
R571 avss.n192 avss.n127 10.8575
R572 avss.n138 avss.n69 10.0223
R573 avss.n657 avss.n17 9.60477
R574 avss.n666 avss.n7 9.60477
R575 avss.n147 avss.n139 9.18719
R576 avss.n626 avss.n625 8.35203
R577 avss.n639 avss.n638 7.51688
R578 avss.n36 avss.n27 6.68173
R579 avss.n542 avss.n98 5.84657
R580 avss.n235 avss.n1 5.20876
R581 avss.n671 avss.n670 5.20876
R582 avss.n531 avss.n282 5.20876
R583 avss.n449 avss.n353 5.20876
R584 avss.n470 avss.n469 5.2005
R585 avss.n471 avss.n463 5.2005
R586 avss.n473 avss.n472 5.2005
R587 avss.n475 avss.n461 5.2005
R588 avss.n477 avss.n476 5.2005
R589 avss.n478 avss.n457 5.2005
R590 avss.n480 avss.n479 5.2005
R591 avss.n482 avss.n456 5.2005
R592 avss.n484 avss.n483 5.2005
R593 avss.n483 avss.n298 5.2005
R594 avss.n510 avss.n509 5.2005
R595 avss.n297 avss.n296 5.2005
R596 avss.n493 avss.n492 5.2005
R597 avss.n495 avss.n494 5.2005
R598 avss.n497 avss.n496 5.2005
R599 avss.n500 avss.n499 5.2005
R600 avss.n498 avss.n488 5.2005
R601 avss.n504 avss.n454 5.2005
R602 avss.n506 avss.n505 5.2005
R603 avss.n507 avss.n506 5.2005
R604 avss.n545 avss.n544 5.2005
R605 avss.n546 avss.n90 5.2005
R606 avss.n548 avss.n547 5.2005
R607 avss.n550 avss.n88 5.2005
R608 avss.n552 avss.n551 5.2005
R609 avss.n553 avss.n83 5.2005
R610 avss.n555 avss.n554 5.2005
R611 avss.n557 avss.n81 5.2005
R612 avss.n101 avss.n100 5.2005
R613 avss.n323 avss.n319 5.2005
R614 avss.n325 avss.n324 5.2005
R615 avss.n327 avss.n316 5.2005
R616 avss.n329 avss.n328 5.2005
R617 avss.n330 avss.n311 5.2005
R618 avss.n332 avss.n331 5.2005
R619 avss.n334 avss.n309 5.2005
R620 avss.n523 avss.n279 5.2005
R621 avss.n279 avss.n108 5.2005
R622 avss.n525 avss.n524 5.2005
R623 avss.n526 avss.n525 5.2005
R624 avss.n288 avss.n287 5.2005
R625 avss.n287 avss.n286 5.2005
R626 avss.n519 avss.n518 5.2005
R627 avss.n518 avss.n517 5.2005
R628 avss.n291 avss.n290 5.2005
R629 avss.n291 avss.n99 5.2005
R630 avss.n529 avss.n280 5.2005
R631 avss.n280 avss.n108 5.2005
R632 avss.n528 avss.n527 5.2005
R633 avss.n527 avss.n526 5.2005
R634 avss.n285 avss.n284 5.2005
R635 avss.n286 avss.n285 5.2005
R636 avss.n516 avss.n515 5.2005
R637 avss.n517 avss.n516 5.2005
R638 avss.n294 avss.n293 5.2005
R639 avss.n293 avss.n99 5.2005
R640 avss.n227 avss.n162 5.2005
R641 avss.n162 avss.n161 5.2005
R642 avss.n229 avss.n228 5.2005
R643 avss.n230 avss.n229 5.2005
R644 avss.n169 avss.n168 5.2005
R645 avss.n174 avss.n168 5.2005
R646 avss.n223 avss.n222 5.2005
R647 avss.n222 avss.n221 5.2005
R648 avss.n172 avss.n171 5.2005
R649 avss.n211 avss.n172 5.2005
R650 avss.n210 avss.n209 5.2005
R651 avss.n212 avss.n210 5.2005
R652 avss.n203 avss.n202 5.2005
R653 avss.n202 avss.n150 5.2005
R654 avss.n205 avss.n148 5.2005
R655 avss.n248 avss.n148 5.2005
R656 avss.n137 avss.n136 5.2005
R657 avss.n147 avss.n137 5.2005
R658 avss.n256 avss.n255 5.2005
R659 avss.n255 avss.n254 5.2005
R660 avss.n257 avss.n129 5.2005
R661 avss.n138 avss.n129 5.2005
R662 avss.n259 avss.n258 5.2005
R663 avss.n260 avss.n259 5.2005
R664 avss.n131 avss.n128 5.2005
R665 avss.n128 avss.n127 5.2005
R666 avss.n130 avss.n119 5.2005
R667 avss.n191 avss.n119 5.2005
R668 avss.n233 avss.n163 5.2005
R669 avss.n163 avss.n161 5.2005
R670 avss.n232 avss.n231 5.2005
R671 avss.n231 avss.n230 5.2005
R672 avss.n167 avss.n166 5.2005
R673 avss.n174 avss.n167 5.2005
R674 avss.n220 avss.n219 5.2005
R675 avss.n221 avss.n220 5.2005
R676 avss.n176 avss.n175 5.2005
R677 avss.n211 avss.n175 5.2005
R678 avss.n214 avss.n213 5.2005
R679 avss.n213 avss.n212 5.2005
R680 avss.n146 avss.n145 5.2005
R681 avss.n150 avss.n146 5.2005
R682 avss.n250 avss.n249 5.2005
R683 avss.n249 avss.n248 5.2005
R684 avss.n251 avss.n140 5.2005
R685 avss.n147 avss.n140 5.2005
R686 avss.n253 avss.n252 5.2005
R687 avss.n254 avss.n253 5.2005
R688 avss.n126 avss.n125 5.2005
R689 avss.n138 avss.n126 5.2005
R690 avss.n262 avss.n261 5.2005
R691 avss.n261 avss.n260 5.2005
R692 avss.n263 avss.n123 5.2005
R693 avss.n127 avss.n123 5.2005
R694 avss.n264 avss.n120 5.2005
R695 avss.n191 avss.n120 5.2005
R696 avss.n619 avss.n8 5.2005
R697 avss.n666 avss.n8 5.2005
R698 avss.n621 avss.n620 5.2005
R699 avss.n620 avss.n17 5.2005
R700 avss.n622 avss.n41 5.2005
R701 avss.n41 avss.n16 5.2005
R702 avss.n624 avss.n623 5.2005
R703 avss.n626 avss.n624 5.2005
R704 avss.n42 avss.n40 5.2005
R705 avss.n637 avss.n40 5.2005
R706 avss.n612 avss.n38 5.2005
R707 avss.n639 avss.n38 5.2005
R708 avss.n611 avss.n37 5.2005
R709 avss.n640 avss.n37 5.2005
R710 avss.n610 avss.n609 5.2005
R711 avss.n609 avss.n27 5.2005
R712 avss.n44 avss.n26 5.2005
R713 avss.n646 avss.n26 5.2005
R714 avss.n605 avss.n604 5.2005
R715 avss.n604 avss.n24 5.2005
R716 avss.n603 avss.n46 5.2005
R717 avss.n603 avss.n602 5.2005
R718 avss.n577 avss.n47 5.2005
R719 avss.n48 avss.n47 5.2005
R720 avss.n578 avss.n56 5.2005
R721 avss.n593 avss.n56 5.2005
R722 avss.n579 avss.n574 5.2005
R723 avss.n574 avss.n55 5.2005
R724 avss.n668 avss.n667 5.2005
R725 avss.n667 avss.n666 5.2005
R726 avss.n5 avss.n4 5.2005
R727 avss.n17 avss.n5 5.2005
R728 avss.n633 avss.n632 5.2005
R729 avss.n632 avss.n16 5.2005
R730 avss.n634 avss.n627 5.2005
R731 avss.n627 avss.n626 5.2005
R732 avss.n636 avss.n635 5.2005
R733 avss.n637 avss.n636 5.2005
R734 avss.n35 avss.n34 5.2005
R735 avss.n639 avss.n35 5.2005
R736 avss.n642 avss.n641 5.2005
R737 avss.n641 avss.n640 5.2005
R738 avss.n643 avss.n29 5.2005
R739 avss.n29 avss.n27 5.2005
R740 avss.n645 avss.n644 5.2005
R741 avss.n646 avss.n645 5.2005
R742 avss.n30 avss.n28 5.2005
R743 avss.n28 avss.n24 5.2005
R744 avss.n601 avss.n600 5.2005
R745 avss.n602 avss.n601 5.2005
R746 avss.n51 avss.n50 5.2005
R747 avss.n50 avss.n48 5.2005
R748 avss.n595 avss.n594 5.2005
R749 avss.n594 avss.n593 5.2005
R750 avss.n54 avss.n53 5.2005
R751 avss.n55 avss.n54 5.2005
R752 avss.n543 avss.n95 5.2005
R753 avss.n543 avss.n542 5.2005
R754 avss.n541 avss.n540 5.2005
R755 avss.n542 avss.n541 5.2005
R756 avss.n190 avss.n189 5.2005
R757 avss.n190 avss.n118 5.2005
R758 avss.n188 avss.n117 5.2005
R759 avss.n269 avss.n117 5.2005
R760 avss.n181 avss.n180 5.2005
R761 avss.n180 avss.n110 5.2005
R762 avss.n184 avss.n109 5.2005
R763 avss.n277 avss.n109 5.2005
R764 avss.n183 avss.n106 5.2005
R765 avss.n278 avss.n106 5.2005
R766 avss.n116 avss.n115 5.2005
R767 avss.n118 avss.n116 5.2005
R768 avss.n271 avss.n270 5.2005
R769 avss.n270 avss.n269 5.2005
R770 avss.n113 avss.n111 5.2005
R771 avss.n111 avss.n110 5.2005
R772 avss.n276 avss.n275 5.2005
R773 avss.n277 avss.n276 5.2005
R774 avss.n112 avss.n107 5.2005
R775 avss.n278 avss.n107 5.2005
R776 avss.n200 avss.n199 5.2005
R777 avss.n201 avss.n200 5.2005
R778 avss.n178 avss.n149 5.2005
R779 avss.n247 avss.n149 5.2005
R780 avss.n244 avss.n152 5.2005
R781 avss.n201 avss.n152 5.2005
R782 avss.n246 avss.n245 5.2005
R783 avss.n247 avss.n246 5.2005
R784 avss.n158 avss.n67 5.2005
R785 avss.n585 avss.n67 5.2005
R786 avss.n160 avss.n159 5.2005
R787 avss.n160 avss.n66 5.2005
R788 avss.n587 avss.n586 5.2005
R789 avss.n586 avss.n585 5.2005
R790 avss.n65 avss.n64 5.2005
R791 avss.n66 avss.n65 5.2005
R792 avss.n58 avss.n25 5.2005
R793 avss.n647 avss.n25 5.2005
R794 avss.n59 avss.n57 5.2005
R795 avss.n57 avss.n49 5.2005
R796 avss.n649 avss.n648 5.2005
R797 avss.n648 avss.n647 5.2005
R798 avss.n23 avss.n22 5.2005
R799 avss.n49 avss.n23 5.2005
R800 avss.n660 avss.n11 5.2005
R801 avss.n11 avss.n7 5.2005
R802 avss.n659 avss.n658 5.2005
R803 avss.n658 avss.n657 5.2005
R804 avss.n656 avss.n655 5.2005
R805 avss.n657 avss.n656 5.2005
R806 avss.n18 avss.n10 5.2005
R807 avss.n10 avss.n7 5.2005
R808 avss.n559 avss.n558 5.2005
R809 avss.n561 avss.n560 5.2005
R810 avss.n563 avss.n562 5.2005
R811 avss.n564 avss.n75 5.2005
R812 avss.n566 avss.n565 5.2005
R813 avss.n567 avss.n566 5.2005
R814 avss.n336 avss.n335 5.2005
R815 avss.n339 avss.n338 5.2005
R816 avss.n337 avss.n307 5.2005
R817 avss.n343 avss.n304 5.2005
R818 avss.n345 avss.n344 5.2005
R819 avss.n346 avss.n345 5.2005
R820 avss.n392 avss.n350 5.2005
R821 avss.n393 avss.n391 5.2005
R822 avss.n389 avss.n387 5.2005
R823 avss.n397 avss.n386 5.2005
R824 avss.n398 avss.n385 5.2005
R825 avss.n399 avss.n383 5.2005
R826 avss.n382 avss.n379 5.2005
R827 avss.n403 avss.n378 5.2005
R828 avss.n404 avss.n377 5.2005
R829 avss.n405 avss.n375 5.2005
R830 avss.n374 avss.n371 5.2005
R831 avss.n409 avss.n370 5.2005
R832 avss.n410 avss.n369 5.2005
R833 avss.n411 avss.n367 5.2005
R834 avss.n447 avss.n351 5.2005
R835 avss.n351 avss.n349 5.2005
R836 avss.n446 avss.n445 5.2005
R837 avss.n443 avss.n355 5.2005
R838 avss.n442 avss.n441 5.2005
R839 avss.n434 avss.n357 5.2005
R840 avss.n436 avss.n435 5.2005
R841 avss.n432 avss.n359 5.2005
R842 avss.n431 avss.n430 5.2005
R843 avss.n424 avss.n361 5.2005
R844 avss.n426 avss.n425 5.2005
R845 avss.n422 avss.n363 5.2005
R846 avss.n421 avss.n420 5.2005
R847 avss.n414 avss.n365 5.2005
R848 avss.n416 avss.n415 5.2005
R849 avss.n415 avss.n349 5.2005
R850 avss.n663 avss.n12 5.20011
R851 avss.n236 avss.n164 5.17941
R852 avss.n266 avss.n265 5.17941
R853 avss.n266 avss.n121 5.17941
R854 avss.n581 avss.n580 5.17941
R855 avss.n581 avss.n52 5.17941
R856 avss.n306 avss.n305 5.17941
R857 avss.n305 avss.n76 5.17941
R858 avss.n532 avss.n281 5.17941
R859 avss.n487 avss.n486 5.17941
R860 avss.n486 avss.n485 5.17941
R861 avss.n417 avss.n413 5.17941
R862 avss.n450 avss.n352 5.17941
R863 avss.n413 avss.n412 5.17159
R864 avss.n194 avss.n114 4.76902
R865 avss.n196 avss.n179 4.769
R866 avss.n242 avss.n63 4.75136
R867 avss.n651 avss.n14 4.75136
R868 avss.n61 avss.n60 4.75136
R869 avss.n653 avss.n19 4.75136
R870 avss.n589 avss.n21 4.75136
R871 avss.n198 avss.n154 4.75136
R872 avss.n197 avss.n196 4.75136
R873 avss.n194 avss.n153 4.75135
R874 avss.n589 avss.n588 4.75135
R875 avss.n654 avss.n653 4.75135
R876 avss.n651 avss.n650 4.75135
R877 avss.n157 avss.n61 4.75135
R878 avss.n156 avss.n154 4.75135
R879 avss.n243 avss.n242 4.75135
R880 avss.n662 avss.n661 4.7462
R881 avss.n539 avss.n538 4.73124
R882 avss.n105 avss.n104 4.73124
R883 avss.n182 avss.n105 4.73067
R884 avss.n538 avss.n103 4.73067
R885 avss.n235 avss.n234 4.7255
R886 avss.n618 avss.n13 4.7255
R887 avss.n670 avss.n669 4.7255
R888 avss.n531 avss.n530 4.7255
R889 avss.n449 avss.n448 4.7255
R890 avss.n263 avss.n122 4.5005
R891 avss.n262 avss.n124 4.5005
R892 avss.n141 avss.n125 4.5005
R893 avss.n252 avss.n142 4.5005
R894 avss.n251 avss.n143 4.5005
R895 avss.n250 avss.n144 4.5005
R896 avss.n177 avss.n145 4.5005
R897 avss.n215 avss.n214 4.5005
R898 avss.n216 avss.n176 4.5005
R899 avss.n219 avss.n218 4.5005
R900 avss.n217 avss.n166 4.5005
R901 avss.n232 avss.n165 4.5005
R902 avss.n234 avss.n233 4.5005
R903 avss.n265 avss.n264 4.5005
R904 avss.n132 avss.n131 4.5005
R905 avss.n258 avss.n133 4.5005
R906 avss.n257 avss.n134 4.5005
R907 avss.n256 avss.n135 4.5005
R908 avss.n204 avss.n136 4.5005
R909 avss.n206 avss.n205 4.5005
R910 avss.n207 avss.n203 4.5005
R911 avss.n209 avss.n208 4.5005
R912 avss.n171 avss.n170 4.5005
R913 avss.n224 avss.n223 4.5005
R914 avss.n225 avss.n169 4.5005
R915 avss.n228 avss.n226 4.5005
R916 avss.n227 avss.n164 4.5005
R917 avss.n130 avss.n121 4.5005
R918 avss.n275 avss.n274 4.5005
R919 avss.n273 avss.n113 4.5005
R920 avss.n272 avss.n271 4.5005
R921 avss.n115 avss.n114 4.5005
R922 avss.n112 avss.n103 4.5005
R923 avss.n588 avss.n587 4.5005
R924 avss.n64 avss.n63 4.5005
R925 avss.n661 avss.n660 4.5005
R926 avss.n659 avss.n14 4.5005
R927 avss.n578 avss.n575 4.5005
R928 avss.n577 avss.n576 4.5005
R929 avss.n46 avss.n45 4.5005
R930 avss.n606 avss.n605 4.5005
R931 avss.n607 avss.n44 4.5005
R932 avss.n610 avss.n608 4.5005
R933 avss.n611 avss.n43 4.5005
R934 avss.n613 avss.n612 4.5005
R935 avss.n614 avss.n42 4.5005
R936 avss.n623 avss.n615 4.5005
R937 avss.n622 avss.n616 4.5005
R938 avss.n621 avss.n617 4.5005
R939 avss.n619 avss.n618 4.5005
R940 avss.n580 avss.n579 4.5005
R941 avss.n596 avss.n595 4.5005
R942 avss.n597 avss.n51 4.5005
R943 avss.n600 avss.n599 4.5005
R944 avss.n598 avss.n30 4.5005
R945 avss.n644 avss.n31 4.5005
R946 avss.n643 avss.n32 4.5005
R947 avss.n642 avss.n33 4.5005
R948 avss.n628 avss.n34 4.5005
R949 avss.n635 avss.n629 4.5005
R950 avss.n634 avss.n630 4.5005
R951 avss.n633 avss.n631 4.5005
R952 avss.n4 avss.n3 4.5005
R953 avss.n669 avss.n668 4.5005
R954 avss.n53 avss.n52 4.5005
R955 avss.n655 avss.n654 4.5005
R956 avss.n18 avss.n12 4.5005
R957 avss.n58 avss.n19 4.5005
R958 avss.n60 avss.n59 4.5005
R959 avss.n650 avss.n649 4.5005
R960 avss.n22 avss.n21 4.5005
R961 avss.n158 avss.n157 4.5005
R962 avss.n159 avss.n156 4.5005
R963 avss.n199 avss.n198 4.5005
R964 avss.n197 avss.n178 4.5005
R965 avss.n244 avss.n243 4.5005
R966 avss.n245 avss.n153 4.5005
R967 avss.n185 avss.n184 4.5005
R968 avss.n186 avss.n181 4.5005
R969 avss.n188 avss.n187 4.5005
R970 avss.n189 avss.n179 4.5005
R971 avss.n183 avss.n182 4.5005
R972 avss.n343 avss.n342 4.5005
R973 avss.n341 avss.n307 4.5005
R974 avss.n340 avss.n339 4.5005
R975 avss.n336 avss.n308 4.5005
R976 avss.n312 avss.n309 4.5005
R977 avss.n331 avss.n313 4.5005
R978 avss.n330 avss.n314 4.5005
R979 avss.n329 avss.n315 4.5005
R980 avss.n320 avss.n316 4.5005
R981 avss.n324 avss.n321 4.5005
R982 avss.n323 avss.n322 4.5005
R983 avss.n102 avss.n101 4.5005
R984 avss.n540 avss.n539 4.5005
R985 avss.n344 avss.n306 4.5005
R986 avss.n564 avss.n77 4.5005
R987 avss.n563 avss.n78 4.5005
R988 avss.n560 avss.n79 4.5005
R989 avss.n559 avss.n80 4.5005
R990 avss.n84 avss.n81 4.5005
R991 avss.n554 avss.n85 4.5005
R992 avss.n553 avss.n86 4.5005
R993 avss.n552 avss.n87 4.5005
R994 avss.n91 avss.n88 4.5005
R995 avss.n547 avss.n92 4.5005
R996 avss.n546 avss.n93 4.5005
R997 avss.n545 avss.n94 4.5005
R998 avss.n104 avss.n95 4.5005
R999 avss.n565 avss.n76 4.5005
R1000 avss.n504 avss.n503 4.5005
R1001 avss.n502 avss.n488 4.5005
R1002 avss.n501 avss.n500 4.5005
R1003 avss.n497 avss.n489 4.5005
R1004 avss.n494 avss.n490 4.5005
R1005 avss.n493 avss.n491 4.5005
R1006 avss.n296 avss.n295 4.5005
R1007 avss.n511 avss.n510 4.5005
R1008 avss.n512 avss.n294 4.5005
R1009 avss.n515 avss.n514 4.5005
R1010 avss.n513 avss.n284 4.5005
R1011 avss.n528 avss.n283 4.5005
R1012 avss.n530 avss.n529 4.5005
R1013 avss.n505 avss.n487 4.5005
R1014 avss.n456 avss.n455 4.5005
R1015 avss.n479 avss.n458 4.5005
R1016 avss.n478 avss.n459 4.5005
R1017 avss.n477 avss.n460 4.5005
R1018 avss.n464 avss.n461 4.5005
R1019 avss.n472 avss.n465 4.5005
R1020 avss.n471 avss.n466 4.5005
R1021 avss.n470 avss.n467 4.5005
R1022 avss.n290 avss.n289 4.5005
R1023 avss.n520 avss.n519 4.5005
R1024 avss.n521 avss.n288 4.5005
R1025 avss.n524 avss.n522 4.5005
R1026 avss.n523 avss.n281 4.5005
R1027 avss.n485 avss.n484 4.5005
R1028 avss.n418 avss.n365 4.5005
R1029 avss.n420 avss.n419 4.5005
R1030 avss.n363 avss.n362 4.5005
R1031 avss.n427 avss.n426 4.5005
R1032 avss.n428 avss.n361 4.5005
R1033 avss.n430 avss.n429 4.5005
R1034 avss.n359 avss.n358 4.5005
R1035 avss.n437 avss.n436 4.5005
R1036 avss.n438 avss.n357 4.5005
R1037 avss.n441 avss.n440 4.5005
R1038 avss.n439 avss.n355 4.5005
R1039 avss.n446 avss.n354 4.5005
R1040 avss.n448 avss.n447 4.5005
R1041 avss.n417 avss.n416 4.5005
R1042 avss.n410 avss.n366 4.5005
R1043 avss.n409 avss.n408 4.5005
R1044 avss.n407 avss.n371 4.5005
R1045 avss.n406 avss.n405 4.5005
R1046 avss.n404 avss.n372 4.5005
R1047 avss.n403 avss.n402 4.5005
R1048 avss.n401 avss.n379 4.5005
R1049 avss.n400 avss.n399 4.5005
R1050 avss.n398 avss.n380 4.5005
R1051 avss.n397 avss.n396 4.5005
R1052 avss.n395 avss.n387 4.5005
R1053 avss.n394 avss.n393 4.5005
R1054 avss.n392 avss.n352 4.5005
R1055 avss.n412 avss.n411 4.5005
R1056 avss avss.n672 3.19152
R1057 avss.n337 avss.n303 3.11744
R1058 avss.n335 avss.n302 3.11744
R1059 avss.n333 avss.n332 3.11744
R1060 avss.n328 avss.n317 3.11744
R1061 avss.n326 avss.n325 3.11744
R1062 avss.n318 avss.n100 3.11744
R1063 avss.n562 avss.n73 3.11744
R1064 avss.n558 avss.n72 3.11744
R1065 avss.n556 avss.n555 3.11744
R1066 avss.n551 avss.n89 3.11744
R1067 avss.n549 avss.n548 3.11744
R1068 avss.n544 avss.n96 3.11744
R1069 avss.n498 avss.n301 3.11744
R1070 avss.n496 avss.n300 3.11744
R1071 avss.n492 avss.n299 3.11744
R1072 avss.n509 avss.n508 3.11744
R1073 avss.n481 avss.n480 3.11744
R1074 avss.n476 avss.n462 3.11744
R1075 avss.n474 avss.n473 3.11744
R1076 avss.n469 avss.n468 3.11744
R1077 avss.n468 avss.n463 3.11744
R1078 avss.n475 avss.n474 3.11744
R1079 avss.n462 avss.n457 3.11744
R1080 avss.n482 avss.n481 3.11744
R1081 avss.n508 avss.n297 3.11744
R1082 avss.n495 avss.n299 3.11744
R1083 avss.n499 avss.n300 3.11744
R1084 avss.n454 avss.n301 3.11744
R1085 avss.n96 avss.n90 3.11744
R1086 avss.n550 avss.n549 3.11744
R1087 avss.n89 avss.n83 3.11744
R1088 avss.n557 avss.n556 3.11744
R1089 avss.n319 avss.n318 3.11744
R1090 avss.n327 avss.n326 3.11744
R1091 avss.n317 avss.n311 3.11744
R1092 avss.n334 avss.n333 3.11744
R1093 avss.n561 avss.n72 3.11744
R1094 avss.n75 avss.n73 3.11744
R1095 avss.n338 avss.n302 3.11744
R1096 avss.n304 avss.n303 3.11744
R1097 avss.n368 avss.n367 3.11744
R1098 avss.n373 avss.n370 3.11744
R1099 avss.n376 avss.n375 3.11744
R1100 avss.n381 avss.n378 3.11744
R1101 avss.n384 avss.n383 3.11744
R1102 avss.n388 avss.n386 3.11744
R1103 avss.n391 avss.n390 3.11744
R1104 avss.n390 avss.n350 3.11744
R1105 avss.n389 avss.n388 3.11744
R1106 avss.n385 avss.n384 3.11744
R1107 avss.n382 avss.n381 3.11744
R1108 avss.n377 avss.n376 3.11744
R1109 avss.n374 avss.n373 3.11744
R1110 avss.n369 avss.n368 3.11744
R1111 avss.n421 avss.n364 3.11744
R1112 avss.n425 avss.n423 3.11744
R1113 avss.n431 avss.n360 3.11744
R1114 avss.n435 avss.n433 3.11744
R1115 avss.n442 avss.n356 3.11744
R1116 avss.n445 avss.n444 3.11744
R1117 avss.n444 avss.n443 3.11744
R1118 avss.n434 avss.n356 3.11744
R1119 avss.n433 avss.n432 3.11744
R1120 avss.n424 avss.n360 3.11744
R1121 avss.n423 avss.n422 3.11744
R1122 avss.n414 avss.n364 3.11744
R1123 avss avss.n0 2.51955
R1124 avss.n282 avss.n1 1.4549
R1125 avss.n671 avss.n1 1.4549
R1126 avss.n353 avss.n282 1.4513
R1127 avss.n468 avss.n298 1.04278
R1128 avss.n474 avss.n298 1.04278
R1129 avss.n462 avss.n298 1.04278
R1130 avss.n481 avss.n298 1.04278
R1131 avss.n508 avss.n507 1.04278
R1132 avss.n507 avss.n299 1.04278
R1133 avss.n507 avss.n300 1.04278
R1134 avss.n507 avss.n301 1.04278
R1135 avss.n96 avss.n82 1.04278
R1136 avss.n549 avss.n82 1.04278
R1137 avss.n89 avss.n82 1.04278
R1138 avss.n556 avss.n82 1.04278
R1139 avss.n318 avss.n310 1.04278
R1140 avss.n326 avss.n310 1.04278
R1141 avss.n317 avss.n310 1.04278
R1142 avss.n333 avss.n310 1.04278
R1143 avss.n567 avss.n72 1.04278
R1144 avss.n567 avss.n73 1.04278
R1145 avss.n346 avss.n302 1.04278
R1146 avss.n346 avss.n303 1.04278
R1147 avss.n390 avss.n347 1.04278
R1148 avss.n388 avss.n347 1.04278
R1149 avss.n384 avss.n347 1.04278
R1150 avss.n381 avss.n347 1.04278
R1151 avss.n376 avss.n347 1.04278
R1152 avss.n373 avss.n347 1.04278
R1153 avss.n368 avss.n347 1.04278
R1154 avss.n444 avss.n349 1.04278
R1155 avss.n356 avss.n349 1.04278
R1156 avss.n433 avss.n349 1.04278
R1157 avss.n360 avss.n349 1.04278
R1158 avss.n423 avss.n349 1.04278
R1159 avss.n364 avss.n349 1.04278
R1160 avss.n533 avss.n532 0.743357
R1161 avss.n534 avss.n533 0.743357
R1162 avss.n267 avss.n266 0.743357
R1163 avss.n268 avss.n267 0.743357
R1164 avss.n237 avss.n236 0.743357
R1165 avss.n238 avss.n237 0.743357
R1166 avss.n582 avss.n581 0.743357
R1167 avss.n583 avss.n582 0.743357
R1168 avss.n6 avss.n2 0.743357
R1169 avss.n665 avss.n6 0.743357
R1170 avss.n537 avss.n97 0.743357
R1171 avss.n292 avss.n97 0.743357
R1172 avss.n537 avss.n536 0.743357
R1173 avss.n536 avss.n535 0.743357
R1174 avss.n195 avss.n193 0.743357
R1175 avss.n193 avss.n192 0.743357
R1176 avss.n195 avss.n151 0.743357
R1177 avss.n151 avss.n139 0.743357
R1178 avss.n241 avss.n155 0.743357
R1179 avss.n173 avss.n155 0.743357
R1180 avss.n241 avss.n240 0.743357
R1181 avss.n240 avss.n239 0.743357
R1182 avss.n590 avss.n62 0.743357
R1183 avss.n584 avss.n62 0.743357
R1184 avss.n591 avss.n590 0.743357
R1185 avss.n592 avss.n591 0.743357
R1186 avss.n652 avss.n20 0.743357
R1187 avss.n36 avss.n20 0.743357
R1188 avss.n652 avss.n15 0.743357
R1189 avss.n625 avss.n15 0.743357
R1190 avss.n664 avss.n663 0.743357
R1191 avss.n665 avss.n664 0.743357
R1192 avss.n486 avss.n453 0.743357
R1193 avss.n453 avss.n452 0.743357
R1194 avss.n305 avss.n74 0.743357
R1195 avss.n74 avss.n71 0.743357
R1196 avss.n413 avss.n348 0.743357
R1197 avss.n452 avss.n348 0.743357
R1198 avss.n451 avss.n450 0.743357
R1199 avss.n452 avss.n451 0.743357
R1200 avss.n662 avss.n13 0.622674
R1201 avss.n236 avss.n235 0.454413
R1202 avss.n670 avss.n2 0.454413
R1203 avss.n13 avss.n2 0.454413
R1204 avss.n663 avss.n662 0.454413
R1205 avss.n532 avss.n531 0.454413
R1206 avss.n450 avss.n449 0.454413
R1207 avss.n264 avss.n263 0.1445
R1208 avss.n263 avss.n262 0.1445
R1209 avss.n262 avss.n125 0.1445
R1210 avss.n252 avss.n125 0.1445
R1211 avss.n252 avss.n251 0.1445
R1212 avss.n251 avss.n250 0.1445
R1213 avss.n250 avss.n145 0.1445
R1214 avss.n214 avss.n145 0.1445
R1215 avss.n214 avss.n176 0.1445
R1216 avss.n219 avss.n176 0.1445
R1217 avss.n219 avss.n166 0.1445
R1218 avss.n232 avss.n166 0.1445
R1219 avss.n233 avss.n232 0.1445
R1220 avss.n265 avss.n122 0.1445
R1221 avss.n124 avss.n122 0.1445
R1222 avss.n141 avss.n124 0.1445
R1223 avss.n142 avss.n141 0.1445
R1224 avss.n143 avss.n142 0.1445
R1225 avss.n144 avss.n143 0.1445
R1226 avss.n177 avss.n144 0.1445
R1227 avss.n215 avss.n177 0.1445
R1228 avss.n216 avss.n215 0.1445
R1229 avss.n218 avss.n216 0.1445
R1230 avss.n218 avss.n217 0.1445
R1231 avss.n217 avss.n165 0.1445
R1232 avss.n234 avss.n165 0.1445
R1233 avss.n132 avss.n121 0.1445
R1234 avss.n133 avss.n132 0.1445
R1235 avss.n134 avss.n133 0.1445
R1236 avss.n135 avss.n134 0.1445
R1237 avss.n204 avss.n135 0.1445
R1238 avss.n206 avss.n204 0.1445
R1239 avss.n207 avss.n206 0.1445
R1240 avss.n208 avss.n207 0.1445
R1241 avss.n208 avss.n170 0.1445
R1242 avss.n224 avss.n170 0.1445
R1243 avss.n225 avss.n224 0.1445
R1244 avss.n226 avss.n225 0.1445
R1245 avss.n226 avss.n164 0.1445
R1246 avss.n131 avss.n130 0.1445
R1247 avss.n258 avss.n131 0.1445
R1248 avss.n258 avss.n257 0.1445
R1249 avss.n257 avss.n256 0.1445
R1250 avss.n256 avss.n136 0.1445
R1251 avss.n205 avss.n136 0.1445
R1252 avss.n205 avss.n203 0.1445
R1253 avss.n209 avss.n203 0.1445
R1254 avss.n209 avss.n171 0.1445
R1255 avss.n223 avss.n171 0.1445
R1256 avss.n223 avss.n169 0.1445
R1257 avss.n228 avss.n169 0.1445
R1258 avss.n228 avss.n227 0.1445
R1259 avss.n344 avss.n343 0.1445
R1260 avss.n343 avss.n307 0.1445
R1261 avss.n339 avss.n307 0.1445
R1262 avss.n339 avss.n336 0.1445
R1263 avss.n336 avss.n309 0.1445
R1264 avss.n331 avss.n309 0.1445
R1265 avss.n331 avss.n330 0.1445
R1266 avss.n330 avss.n329 0.1445
R1267 avss.n329 avss.n316 0.1445
R1268 avss.n324 avss.n316 0.1445
R1269 avss.n324 avss.n323 0.1445
R1270 avss.n323 avss.n101 0.1445
R1271 avss.n540 avss.n101 0.1445
R1272 avss.n184 avss.n183 0.1445
R1273 avss.n184 avss.n181 0.1445
R1274 avss.n188 avss.n181 0.1445
R1275 avss.n189 avss.n188 0.1445
R1276 avss.n275 avss.n112 0.1445
R1277 avss.n275 avss.n113 0.1445
R1278 avss.n271 avss.n113 0.1445
R1279 avss.n271 avss.n115 0.1445
R1280 avss.n274 avss.n103 0.1445
R1281 avss.n274 avss.n273 0.1445
R1282 avss.n273 avss.n272 0.1445
R1283 avss.n272 avss.n114 0.1445
R1284 avss.n245 avss.n244 0.1445
R1285 avss.n159 avss.n158 0.1445
R1286 avss.n587 avss.n64 0.1445
R1287 avss.n588 avss.n63 0.1445
R1288 avss.n649 avss.n22 0.1445
R1289 avss.n655 avss.n18 0.1445
R1290 avss.n660 avss.n659 0.1445
R1291 avss.n661 avss.n14 0.1445
R1292 avss.n595 avss.n53 0.1445
R1293 avss.n595 avss.n51 0.1445
R1294 avss.n600 avss.n51 0.1445
R1295 avss.n600 avss.n30 0.1445
R1296 avss.n644 avss.n30 0.1445
R1297 avss.n644 avss.n643 0.1445
R1298 avss.n643 avss.n642 0.1445
R1299 avss.n642 avss.n34 0.1445
R1300 avss.n635 avss.n34 0.1445
R1301 avss.n635 avss.n634 0.1445
R1302 avss.n634 avss.n633 0.1445
R1303 avss.n633 avss.n4 0.1445
R1304 avss.n668 avss.n4 0.1445
R1305 avss.n579 avss.n578 0.1445
R1306 avss.n578 avss.n577 0.1445
R1307 avss.n577 avss.n46 0.1445
R1308 avss.n605 avss.n46 0.1445
R1309 avss.n605 avss.n44 0.1445
R1310 avss.n610 avss.n44 0.1445
R1311 avss.n611 avss.n610 0.1445
R1312 avss.n612 avss.n611 0.1445
R1313 avss.n612 avss.n42 0.1445
R1314 avss.n623 avss.n42 0.1445
R1315 avss.n623 avss.n622 0.1445
R1316 avss.n622 avss.n621 0.1445
R1317 avss.n621 avss.n619 0.1445
R1318 avss.n580 avss.n575 0.1445
R1319 avss.n576 avss.n575 0.1445
R1320 avss.n576 avss.n45 0.1445
R1321 avss.n606 avss.n45 0.1445
R1322 avss.n607 avss.n606 0.1445
R1323 avss.n608 avss.n607 0.1445
R1324 avss.n608 avss.n43 0.1445
R1325 avss.n613 avss.n43 0.1445
R1326 avss.n614 avss.n613 0.1445
R1327 avss.n615 avss.n614 0.1445
R1328 avss.n616 avss.n615 0.1445
R1329 avss.n617 avss.n616 0.1445
R1330 avss.n618 avss.n617 0.1445
R1331 avss.n596 avss.n52 0.1445
R1332 avss.n597 avss.n596 0.1445
R1333 avss.n599 avss.n597 0.1445
R1334 avss.n599 avss.n598 0.1445
R1335 avss.n598 avss.n31 0.1445
R1336 avss.n32 avss.n31 0.1445
R1337 avss.n33 avss.n32 0.1445
R1338 avss.n628 avss.n33 0.1445
R1339 avss.n629 avss.n628 0.1445
R1340 avss.n630 avss.n629 0.1445
R1341 avss.n631 avss.n630 0.1445
R1342 avss.n631 avss.n3 0.1445
R1343 avss.n669 avss.n3 0.1445
R1344 avss.n654 avss.n12 0.1445
R1345 avss.n59 avss.n58 0.1445
R1346 avss.n60 avss.n19 0.1445
R1347 avss.n650 avss.n21 0.1445
R1348 avss.n157 avss.n156 0.1445
R1349 avss.n199 avss.n178 0.1445
R1350 avss.n198 avss.n197 0.1445
R1351 avss.n243 avss.n153 0.1445
R1352 avss.n185 avss.n182 0.1445
R1353 avss.n186 avss.n185 0.1445
R1354 avss.n187 avss.n186 0.1445
R1355 avss.n187 avss.n179 0.1445
R1356 avss.n342 avss.n306 0.1445
R1357 avss.n342 avss.n341 0.1445
R1358 avss.n341 avss.n340 0.1445
R1359 avss.n340 avss.n308 0.1445
R1360 avss.n312 avss.n308 0.1445
R1361 avss.n313 avss.n312 0.1445
R1362 avss.n314 avss.n313 0.1445
R1363 avss.n315 avss.n314 0.1445
R1364 avss.n320 avss.n315 0.1445
R1365 avss.n321 avss.n320 0.1445
R1366 avss.n322 avss.n321 0.1445
R1367 avss.n322 avss.n102 0.1445
R1368 avss.n539 avss.n102 0.1445
R1369 avss.n77 avss.n76 0.1445
R1370 avss.n78 avss.n77 0.1445
R1371 avss.n79 avss.n78 0.1445
R1372 avss.n80 avss.n79 0.1445
R1373 avss.n84 avss.n80 0.1445
R1374 avss.n85 avss.n84 0.1445
R1375 avss.n86 avss.n85 0.1445
R1376 avss.n87 avss.n86 0.1445
R1377 avss.n91 avss.n87 0.1445
R1378 avss.n92 avss.n91 0.1445
R1379 avss.n93 avss.n92 0.1445
R1380 avss.n94 avss.n93 0.1445
R1381 avss.n104 avss.n94 0.1445
R1382 avss.n565 avss.n564 0.1445
R1383 avss.n564 avss.n563 0.1445
R1384 avss.n563 avss.n560 0.1445
R1385 avss.n560 avss.n559 0.1445
R1386 avss.n559 avss.n81 0.1445
R1387 avss.n554 avss.n81 0.1445
R1388 avss.n554 avss.n553 0.1445
R1389 avss.n553 avss.n552 0.1445
R1390 avss.n552 avss.n88 0.1445
R1391 avss.n547 avss.n88 0.1445
R1392 avss.n547 avss.n546 0.1445
R1393 avss.n546 avss.n545 0.1445
R1394 avss.n545 avss.n95 0.1445
R1395 avss.n505 avss.n504 0.1445
R1396 avss.n504 avss.n488 0.1445
R1397 avss.n500 avss.n488 0.1445
R1398 avss.n500 avss.n497 0.1445
R1399 avss.n497 avss.n494 0.1445
R1400 avss.n494 avss.n493 0.1445
R1401 avss.n493 avss.n296 0.1445
R1402 avss.n510 avss.n296 0.1445
R1403 avss.n510 avss.n294 0.1445
R1404 avss.n515 avss.n294 0.1445
R1405 avss.n515 avss.n284 0.1445
R1406 avss.n528 avss.n284 0.1445
R1407 avss.n529 avss.n528 0.1445
R1408 avss.n503 avss.n487 0.1445
R1409 avss.n503 avss.n502 0.1445
R1410 avss.n502 avss.n501 0.1445
R1411 avss.n501 avss.n489 0.1445
R1412 avss.n490 avss.n489 0.1445
R1413 avss.n491 avss.n490 0.1445
R1414 avss.n491 avss.n295 0.1445
R1415 avss.n511 avss.n295 0.1445
R1416 avss.n512 avss.n511 0.1445
R1417 avss.n514 avss.n512 0.1445
R1418 avss.n514 avss.n513 0.1445
R1419 avss.n513 avss.n283 0.1445
R1420 avss.n530 avss.n283 0.1445
R1421 avss.n485 avss.n455 0.1445
R1422 avss.n458 avss.n455 0.1445
R1423 avss.n459 avss.n458 0.1445
R1424 avss.n460 avss.n459 0.1445
R1425 avss.n464 avss.n460 0.1445
R1426 avss.n465 avss.n464 0.1445
R1427 avss.n466 avss.n465 0.1445
R1428 avss.n467 avss.n466 0.1445
R1429 avss.n467 avss.n289 0.1445
R1430 avss.n520 avss.n289 0.1445
R1431 avss.n521 avss.n520 0.1445
R1432 avss.n522 avss.n521 0.1445
R1433 avss.n522 avss.n281 0.1445
R1434 avss.n484 avss.n456 0.1445
R1435 avss.n479 avss.n456 0.1445
R1436 avss.n479 avss.n478 0.1445
R1437 avss.n478 avss.n477 0.1445
R1438 avss.n477 avss.n461 0.1445
R1439 avss.n472 avss.n461 0.1445
R1440 avss.n472 avss.n471 0.1445
R1441 avss.n471 avss.n470 0.1445
R1442 avss.n470 avss.n290 0.1445
R1443 avss.n519 avss.n290 0.1445
R1444 avss.n519 avss.n288 0.1445
R1445 avss.n524 avss.n288 0.1445
R1446 avss.n524 avss.n523 0.1445
R1447 avss.n411 avss.n410 0.1445
R1448 avss.n410 avss.n409 0.1445
R1449 avss.n409 avss.n371 0.1445
R1450 avss.n405 avss.n371 0.1445
R1451 avss.n405 avss.n404 0.1445
R1452 avss.n404 avss.n403 0.1445
R1453 avss.n403 avss.n379 0.1445
R1454 avss.n399 avss.n379 0.1445
R1455 avss.n399 avss.n398 0.1445
R1456 avss.n398 avss.n397 0.1445
R1457 avss.n397 avss.n387 0.1445
R1458 avss.n393 avss.n387 0.1445
R1459 avss.n393 avss.n392 0.1445
R1460 avss.n416 avss.n365 0.1445
R1461 avss.n420 avss.n365 0.1445
R1462 avss.n420 avss.n363 0.1445
R1463 avss.n426 avss.n363 0.1445
R1464 avss.n426 avss.n361 0.1445
R1465 avss.n430 avss.n361 0.1445
R1466 avss.n430 avss.n359 0.1445
R1467 avss.n436 avss.n359 0.1445
R1468 avss.n436 avss.n357 0.1445
R1469 avss.n441 avss.n357 0.1445
R1470 avss.n441 avss.n355 0.1445
R1471 avss.n446 avss.n355 0.1445
R1472 avss.n447 avss.n446 0.1445
R1473 avss.n418 avss.n417 0.1445
R1474 avss.n419 avss.n418 0.1445
R1475 avss.n419 avss.n362 0.1445
R1476 avss.n427 avss.n362 0.1445
R1477 avss.n428 avss.n427 0.1445
R1478 avss.n429 avss.n428 0.1445
R1479 avss.n429 avss.n358 0.1445
R1480 avss.n437 avss.n358 0.1445
R1481 avss.n438 avss.n437 0.1445
R1482 avss.n440 avss.n438 0.1445
R1483 avss.n440 avss.n439 0.1445
R1484 avss.n439 avss.n354 0.1445
R1485 avss.n448 avss.n354 0.1445
R1486 avss.n412 avss.n366 0.1445
R1487 avss.n408 avss.n366 0.1445
R1488 avss.n408 avss.n407 0.1445
R1489 avss.n407 avss.n406 0.1445
R1490 avss.n406 avss.n372 0.1445
R1491 avss.n402 avss.n372 0.1445
R1492 avss.n402 avss.n401 0.1445
R1493 avss.n401 avss.n400 0.1445
R1494 avss.n400 avss.n380 0.1445
R1495 avss.n396 avss.n380 0.1445
R1496 avss.n396 avss.n395 0.1445
R1497 avss.n395 avss.n394 0.1445
R1498 avss.n394 avss.n352 0.1445
R1499 avss.n538 avss.n537 0.0556412
R1500 avss.n537 avss.n105 0.0556393
R1501 avss.n242 avss.n241 0.0543057
R1502 avss.n590 avss.n61 0.0543057
R1503 avss.n652 avss.n651 0.0543057
R1504 avss.n653 avss.n652 0.0543057
R1505 avss.n590 avss.n589 0.0543057
R1506 avss.n241 avss.n154 0.0543057
R1507 avss.n195 avss.n194 0.0543036
R1508 avss.n196 avss.n195 0.0542944
R1509 avdd.n396 avdd.n395 1078.83
R1510 avdd.n395 avdd.n394 1078.83
R1511 avdd.n208 avdd.n177 522.652
R1512 avdd.n182 avdd.n177 522.652
R1513 avdd.n200 avdd.n189 522.652
R1514 avdd.n192 avdd.n189 522.652
R1515 avdd.n248 avdd.n247 522.652
R1516 avdd.n248 avdd.n235 522.652
R1517 avdd.n258 avdd.n257 522.652
R1518 avdd.n257 avdd.n228 522.652
R1519 avdd.n397 avdd.n326 144.812
R1520 avdd.n393 avdd.n326 144.812
R1521 avdd.n335 avdd.n329 144.812
R1522 avdd.n371 avdd.n329 144.812
R1523 avdd.n104 avdd.n94 142.857
R1524 avdd.n104 avdd.n88 142.857
R1525 avdd.n112 avdd.n88 142.857
R1526 avdd.n112 avdd.n82 142.857
R1527 avdd.n120 avdd.n82 142.857
R1528 avdd.n120 avdd.n76 142.857
R1529 avdd.n128 avdd.n76 142.857
R1530 avdd.n128 avdd.n70 142.857
R1531 avdd.n136 avdd.n70 142.857
R1532 avdd.n136 avdd.n64 142.857
R1533 avdd.n144 avdd.n64 142.857
R1534 avdd.n144 avdd.n58 142.857
R1535 avdd.n152 avdd.n58 142.857
R1536 avdd.n152 avdd.n52 142.857
R1537 avdd.n160 avdd.n52 142.857
R1538 avdd.n160 avdd.n46 142.857
R1539 avdd.n168 avdd.n46 142.857
R1540 avdd.n168 avdd.n40 142.857
R1541 avdd.n217 avdd.n40 142.857
R1542 avdd.n290 avdd.n282 142.857
R1543 avdd.n299 avdd.n282 142.857
R1544 avdd.n299 avdd.n276 142.857
R1545 avdd.n307 avdd.n276 142.857
R1546 avdd.n307 avdd.n270 142.857
R1547 avdd.n315 avdd.n270 142.857
R1548 avdd.n209 avdd.n176 62.038
R1549 avdd.n183 avdd.n176 62.038
R1550 avdd.n206 avdd.n178 62.038
R1551 avdd.n207 avdd.n206 62.038
R1552 avdd.n198 avdd.n190 62.038
R1553 avdd.n199 avdd.n198 62.038
R1554 avdd.n193 avdd.n180 62.038
R1555 avdd.n201 avdd.n180 62.038
R1556 avdd.n249 avdd.n233 62.038
R1557 avdd.n249 avdd.n234 62.038
R1558 avdd.n240 avdd.n236 62.038
R1559 avdd.n246 avdd.n236 62.038
R1560 avdd.n259 avdd.n227 62.038
R1561 avdd.n229 avdd.n227 62.038
R1562 avdd.n256 avdd.n255 62.038
R1563 avdd.n256 avdd.n226 62.038
R1564 avdd.n216 avdd.n39 61.7755
R1565 avdd.n98 avdd.n95 61.7755
R1566 avdd.n314 avdd.n269 61.7755
R1567 avdd.n289 avdd.n286 61.7755
R1568 avdd.n218 avdd.n39 48.3669
R1569 avdd.n98 avdd.n97 48.3669
R1570 avdd.n316 avdd.n269 48.3669
R1571 avdd.n291 avdd.n286 48.3669
R1572 avdd.n390 avdd.n389 40.0903
R1573 avdd.n105 avdd.n93 14.0005
R1574 avdd.n105 avdd.n89 14.0005
R1575 avdd.n111 avdd.n89 14.0005
R1576 avdd.n111 avdd.n81 14.0005
R1577 avdd.n121 avdd.n81 14.0005
R1578 avdd.n121 avdd.n77 14.0005
R1579 avdd.n127 avdd.n77 14.0005
R1580 avdd.n127 avdd.n69 14.0005
R1581 avdd.n137 avdd.n69 14.0005
R1582 avdd.n137 avdd.n65 14.0005
R1583 avdd.n143 avdd.n65 14.0005
R1584 avdd.n143 avdd.n57 14.0005
R1585 avdd.n153 avdd.n57 14.0005
R1586 avdd.n153 avdd.n53 14.0005
R1587 avdd.n159 avdd.n53 14.0005
R1588 avdd.n159 avdd.n45 14.0005
R1589 avdd.n169 avdd.n45 14.0005
R1590 avdd.n169 avdd.n41 14.0005
R1591 avdd.n216 avdd.n41 14.0005
R1592 avdd.n103 avdd.n95 14.0005
R1593 avdd.n103 avdd.n87 14.0005
R1594 avdd.n113 avdd.n87 14.0005
R1595 avdd.n113 avdd.n83 14.0005
R1596 avdd.n119 avdd.n83 14.0005
R1597 avdd.n119 avdd.n75 14.0005
R1598 avdd.n129 avdd.n75 14.0005
R1599 avdd.n129 avdd.n71 14.0005
R1600 avdd.n135 avdd.n71 14.0005
R1601 avdd.n135 avdd.n63 14.0005
R1602 avdd.n145 avdd.n63 14.0005
R1603 avdd.n145 avdd.n59 14.0005
R1604 avdd.n151 avdd.n59 14.0005
R1605 avdd.n151 avdd.n51 14.0005
R1606 avdd.n161 avdd.n51 14.0005
R1607 avdd.n161 avdd.n47 14.0005
R1608 avdd.n167 avdd.n47 14.0005
R1609 avdd.n167 avdd.n38 14.0005
R1610 avdd.n219 avdd.n38 14.0005
R1611 avdd.n292 avdd.n283 14.0005
R1612 avdd.n298 avdd.n283 14.0005
R1613 avdd.n298 avdd.n275 14.0005
R1614 avdd.n308 avdd.n275 14.0005
R1615 avdd.n308 avdd.n271 14.0005
R1616 avdd.n314 avdd.n271 14.0005
R1617 avdd.n289 avdd.n281 14.0005
R1618 avdd.n300 avdd.n281 14.0005
R1619 avdd.n300 avdd.n277 14.0005
R1620 avdd.n306 avdd.n277 14.0005
R1621 avdd.n306 avdd.n268 14.0005
R1622 avdd.n317 avdd.n268 14.0005
R1623 avdd.n385 avdd.n384 14.0005
R1624 avdd.n393 avdd.n332 14.0005
R1625 avdd.n373 avdd.n372 14.0005
R1626 avdd.n397 avdd.n325 14.0005
R1627 avdd.n403 avdd.n402 12.3666
R1628 avdd.n403 avdd.n0 11.3626
R1629 avdd.n223 avdd.n0 9.6737
R1630 avdd.n264 avdd.n263 7.63485
R1631 avdd.n321 avdd.n320 7.63485
R1632 avdd.n401 avdd.n400 6.68691
R1633 avdd.n216 avdd.n215 6.3005
R1634 avdd.n217 avdd.n216 6.3005
R1635 avdd.n42 avdd.n41 6.3005
R1636 avdd.n41 avdd.n40 6.3005
R1637 avdd.n170 avdd.n169 6.3005
R1638 avdd.n169 avdd.n168 6.3005
R1639 avdd.n45 avdd.n44 6.3005
R1640 avdd.n46 avdd.n45 6.3005
R1641 avdd.n159 avdd.n158 6.3005
R1642 avdd.n160 avdd.n159 6.3005
R1643 avdd.n54 avdd.n53 6.3005
R1644 avdd.n53 avdd.n52 6.3005
R1645 avdd.n154 avdd.n153 6.3005
R1646 avdd.n153 avdd.n152 6.3005
R1647 avdd.n57 avdd.n56 6.3005
R1648 avdd.n58 avdd.n57 6.3005
R1649 avdd.n143 avdd.n142 6.3005
R1650 avdd.n144 avdd.n143 6.3005
R1651 avdd.n66 avdd.n65 6.3005
R1652 avdd.n65 avdd.n64 6.3005
R1653 avdd.n138 avdd.n137 6.3005
R1654 avdd.n137 avdd.n136 6.3005
R1655 avdd.n69 avdd.n68 6.3005
R1656 avdd.n70 avdd.n69 6.3005
R1657 avdd.n127 avdd.n126 6.3005
R1658 avdd.n128 avdd.n127 6.3005
R1659 avdd.n78 avdd.n77 6.3005
R1660 avdd.n77 avdd.n76 6.3005
R1661 avdd.n122 avdd.n121 6.3005
R1662 avdd.n121 avdd.n120 6.3005
R1663 avdd.n81 avdd.n80 6.3005
R1664 avdd.n82 avdd.n81 6.3005
R1665 avdd.n111 avdd.n110 6.3005
R1666 avdd.n112 avdd.n111 6.3005
R1667 avdd.n90 avdd.n89 6.3005
R1668 avdd.n89 avdd.n88 6.3005
R1669 avdd.n106 avdd.n105 6.3005
R1670 avdd.n105 avdd.n104 6.3005
R1671 avdd.n93 avdd.n92 6.3005
R1672 avdd.n96 avdd.n95 6.3005
R1673 avdd.n95 avdd.n94 6.3005
R1674 avdd.n103 avdd.n102 6.3005
R1675 avdd.n104 avdd.n103 6.3005
R1676 avdd.n87 avdd.n86 6.3005
R1677 avdd.n88 avdd.n87 6.3005
R1678 avdd.n114 avdd.n113 6.3005
R1679 avdd.n113 avdd.n112 6.3005
R1680 avdd.n84 avdd.n83 6.3005
R1681 avdd.n83 avdd.n82 6.3005
R1682 avdd.n119 avdd.n118 6.3005
R1683 avdd.n120 avdd.n119 6.3005
R1684 avdd.n75 avdd.n74 6.3005
R1685 avdd.n76 avdd.n75 6.3005
R1686 avdd.n130 avdd.n129 6.3005
R1687 avdd.n129 avdd.n128 6.3005
R1688 avdd.n72 avdd.n71 6.3005
R1689 avdd.n71 avdd.n70 6.3005
R1690 avdd.n135 avdd.n134 6.3005
R1691 avdd.n136 avdd.n135 6.3005
R1692 avdd.n63 avdd.n62 6.3005
R1693 avdd.n64 avdd.n63 6.3005
R1694 avdd.n146 avdd.n145 6.3005
R1695 avdd.n145 avdd.n144 6.3005
R1696 avdd.n60 avdd.n59 6.3005
R1697 avdd.n59 avdd.n58 6.3005
R1698 avdd.n151 avdd.n150 6.3005
R1699 avdd.n152 avdd.n151 6.3005
R1700 avdd.n51 avdd.n50 6.3005
R1701 avdd.n52 avdd.n51 6.3005
R1702 avdd.n162 avdd.n161 6.3005
R1703 avdd.n161 avdd.n160 6.3005
R1704 avdd.n48 avdd.n47 6.3005
R1705 avdd.n47 avdd.n46 6.3005
R1706 avdd.n167 avdd.n166 6.3005
R1707 avdd.n168 avdd.n167 6.3005
R1708 avdd.n38 avdd.n37 6.3005
R1709 avdd.n40 avdd.n38 6.3005
R1710 avdd.n220 avdd.n219 6.3005
R1711 avdd.n184 avdd.n183 6.3005
R1712 avdd.n185 avdd.n178 6.3005
R1713 avdd.n210 avdd.n209 6.3005
R1714 avdd.n207 avdd.n175 6.3005
R1715 avdd.n194 avdd.n193 6.3005
R1716 avdd.n195 avdd.n190 6.3005
R1717 avdd.n202 avdd.n201 6.3005
R1718 avdd.n199 avdd.n188 6.3005
R1719 avdd.n241 avdd.n240 6.3005
R1720 avdd.n239 avdd.n233 6.3005
R1721 avdd.n246 avdd.n245 6.3005
R1722 avdd.n237 avdd.n234 6.3005
R1723 avdd.n230 avdd.n229 6.3005
R1724 avdd.n255 avdd.n254 6.3005
R1725 avdd.n260 avdd.n259 6.3005
R1726 avdd.n261 avdd.n226 6.3005
R1727 avdd.n314 avdd.n313 6.3005
R1728 avdd.n315 avdd.n314 6.3005
R1729 avdd.n272 avdd.n271 6.3005
R1730 avdd.n271 avdd.n270 6.3005
R1731 avdd.n309 avdd.n308 6.3005
R1732 avdd.n308 avdd.n307 6.3005
R1733 avdd.n275 avdd.n274 6.3005
R1734 avdd.n276 avdd.n275 6.3005
R1735 avdd.n298 avdd.n297 6.3005
R1736 avdd.n299 avdd.n298 6.3005
R1737 avdd.n284 avdd.n283 6.3005
R1738 avdd.n283 avdd.n282 6.3005
R1739 avdd.n293 avdd.n292 6.3005
R1740 avdd.n318 avdd.n317 6.3005
R1741 avdd.n268 avdd.n267 6.3005
R1742 avdd.n270 avdd.n268 6.3005
R1743 avdd.n306 avdd.n305 6.3005
R1744 avdd.n307 avdd.n306 6.3005
R1745 avdd.n278 avdd.n277 6.3005
R1746 avdd.n277 avdd.n276 6.3005
R1747 avdd.n301 avdd.n300 6.3005
R1748 avdd.n300 avdd.n299 6.3005
R1749 avdd.n281 avdd.n280 6.3005
R1750 avdd.n282 avdd.n281 6.3005
R1751 avdd.n289 avdd.n288 6.3005
R1752 avdd.n290 avdd.n289 6.3005
R1753 avdd.n393 avdd.n392 6.3005
R1754 avdd.n394 avdd.n393 6.3005
R1755 avdd.n333 avdd.n332 6.3005
R1756 avdd.n386 avdd.n385 6.3005
R1757 avdd.n384 avdd.n383 6.3005
R1758 avdd.n382 avdd.n335 6.3005
R1759 avdd.n398 avdd.n397 6.3005
R1760 avdd.n397 avdd.n396 6.3005
R1761 avdd.n325 avdd.n324 6.3005
R1762 avdd.n375 avdd.n373 6.3005
R1763 avdd.n376 avdd.n372 6.3005
R1764 avdd.n377 avdd.n371 6.3005
R1765 avdd.n379 avdd.n378 6.11952
R1766 avdd.n223 avdd.n222 6.0892
R1767 avdd.n380 avdd.n379 5.90235
R1768 avdd.n390 avdd.n322 5.90235
R1769 avdd.n197 avdd.n187 5.20011
R1770 avdd.n197 avdd.n196 5.20011
R1771 avdd.n181 avdd.n173 5.20011
R1772 avdd.n244 avdd.n243 5.20011
R1773 avdd.n243 avdd.n242 5.20011
R1774 avdd.n253 avdd.n224 5.20011
R1775 avdd.n99 avdd.n91 5.19741
R1776 avdd.n294 avdd.n285 5.19741
R1777 avdd.n312 avdd.n265 5.19741
R1778 avdd.n100 avdd.n99 5.18959
R1779 avdd.n287 avdd.n285 5.18959
R1780 avdd.n380 avdd.n369 5.09758
R1781 avdd.n97 avdd.n94 4.9335
R1782 avdd.n218 avdd.n217 4.9335
R1783 avdd.n291 avdd.n290 4.9335
R1784 avdd.n316 avdd.n315 4.9335
R1785 avdd.n204 avdd.n203 4.75136
R1786 avdd.n191 avdd.n179 4.75136
R1787 avdd.n251 avdd.n231 4.75136
R1788 avdd.n232 avdd.n225 4.75136
R1789 avdd.n179 avdd.n174 4.75135
R1790 avdd.n204 avdd.n186 4.75135
R1791 avdd.n238 avdd.n232 4.75135
R1792 avdd.n252 avdd.n251 4.75135
R1793 avdd.n212 avdd.n211 4.7462
R1794 avdd.n263 avdd.n262 4.7462
R1795 avdd.n222 avdd.n221 4.7435
R1796 avdd.n214 avdd.n213 4.7435
R1797 avdd.n320 avdd.n319 4.7435
R1798 avdd.n400 avdd.n399 4.7255
R1799 avdd.n100 avdd.n96 4.5005
R1800 avdd.n102 avdd.n101 4.5005
R1801 avdd.n86 avdd.n85 4.5005
R1802 avdd.n115 avdd.n114 4.5005
R1803 avdd.n116 avdd.n84 4.5005
R1804 avdd.n118 avdd.n117 4.5005
R1805 avdd.n74 avdd.n73 4.5005
R1806 avdd.n131 avdd.n130 4.5005
R1807 avdd.n132 avdd.n72 4.5005
R1808 avdd.n134 avdd.n133 4.5005
R1809 avdd.n62 avdd.n61 4.5005
R1810 avdd.n147 avdd.n146 4.5005
R1811 avdd.n148 avdd.n60 4.5005
R1812 avdd.n150 avdd.n149 4.5005
R1813 avdd.n50 avdd.n49 4.5005
R1814 avdd.n163 avdd.n162 4.5005
R1815 avdd.n164 avdd.n48 4.5005
R1816 avdd.n166 avdd.n165 4.5005
R1817 avdd.n37 avdd.n36 4.5005
R1818 avdd.n221 avdd.n220 4.5005
R1819 avdd.n107 avdd.n106 4.5005
R1820 avdd.n108 avdd.n90 4.5005
R1821 avdd.n110 avdd.n109 4.5005
R1822 avdd.n80 avdd.n79 4.5005
R1823 avdd.n123 avdd.n122 4.5005
R1824 avdd.n124 avdd.n78 4.5005
R1825 avdd.n126 avdd.n125 4.5005
R1826 avdd.n68 avdd.n67 4.5005
R1827 avdd.n139 avdd.n138 4.5005
R1828 avdd.n140 avdd.n66 4.5005
R1829 avdd.n142 avdd.n141 4.5005
R1830 avdd.n56 avdd.n55 4.5005
R1831 avdd.n155 avdd.n154 4.5005
R1832 avdd.n156 avdd.n54 4.5005
R1833 avdd.n158 avdd.n157 4.5005
R1834 avdd.n44 avdd.n43 4.5005
R1835 avdd.n171 avdd.n170 4.5005
R1836 avdd.n172 avdd.n42 4.5005
R1837 avdd.n215 avdd.n214 4.5005
R1838 avdd.n92 avdd.n91 4.5005
R1839 avdd.n211 avdd.n210 4.5005
R1840 avdd.n175 avdd.n174 4.5005
R1841 avdd.n203 avdd.n202 4.5005
R1842 avdd.n188 avdd.n187 4.5005
R1843 avdd.n194 avdd.n191 4.5005
R1844 avdd.n196 avdd.n195 4.5005
R1845 avdd.n184 avdd.n181 4.5005
R1846 avdd.n186 avdd.n185 4.5005
R1847 avdd.n245 avdd.n244 4.5005
R1848 avdd.n237 avdd.n231 4.5005
R1849 avdd.n242 avdd.n241 4.5005
R1850 avdd.n239 avdd.n238 4.5005
R1851 avdd.n260 avdd.n225 4.5005
R1852 avdd.n262 avdd.n261 4.5005
R1853 avdd.n252 avdd.n230 4.5005
R1854 avdd.n254 avdd.n253 4.5005
R1855 avdd.n280 avdd.n279 4.5005
R1856 avdd.n302 avdd.n301 4.5005
R1857 avdd.n303 avdd.n278 4.5005
R1858 avdd.n305 avdd.n304 4.5005
R1859 avdd.n267 avdd.n266 4.5005
R1860 avdd.n319 avdd.n318 4.5005
R1861 avdd.n288 avdd.n287 4.5005
R1862 avdd.n295 avdd.n284 4.5005
R1863 avdd.n297 avdd.n296 4.5005
R1864 avdd.n274 avdd.n273 4.5005
R1865 avdd.n310 avdd.n309 4.5005
R1866 avdd.n311 avdd.n272 4.5005
R1867 avdd.n313 avdd.n312 4.5005
R1868 avdd.n294 avdd.n293 4.5005
R1869 avdd.n376 avdd.n370 4.5005
R1870 avdd.n375 avdd.n374 4.5005
R1871 avdd.n324 avdd.n323 4.5005
R1872 avdd.n399 avdd.n398 4.5005
R1873 avdd.n378 avdd.n377 4.5005
R1874 avdd.n363 avdd.n360 4.5005
R1875 avdd.n368 avdd.n360 4.5005
R1876 avdd.n368 avdd.n340 4.5005
R1877 avdd.n367 avdd.n363 4.5005
R1878 avdd.n367 avdd.n338 4.5005
R1879 avdd.n368 avdd.n367 4.5005
R1880 avdd.n363 avdd.n339 4.5005
R1881 avdd.n339 avdd.n338 4.5005
R1882 avdd.n368 avdd.n339 4.5005
R1883 avdd.n369 avdd.n338 4.5005
R1884 avdd.n369 avdd.n368 4.5005
R1885 avdd.n352 avdd.n349 4.5005
R1886 avdd.n357 avdd.n349 4.5005
R1887 avdd.n357 avdd.n346 4.5005
R1888 avdd.n356 avdd.n352 4.5005
R1889 avdd.n356 avdd.n344 4.5005
R1890 avdd.n357 avdd.n356 4.5005
R1891 avdd.n352 avdd.n345 4.5005
R1892 avdd.n345 avdd.n344 4.5005
R1893 avdd.n357 avdd.n345 4.5005
R1894 avdd.n358 avdd.n344 4.5005
R1895 avdd.n358 avdd.n357 4.5005
R1896 avdd.n383 avdd.n334 4.5005
R1897 avdd.n387 avdd.n386 4.5005
R1898 avdd.n388 avdd.n333 4.5005
R1899 avdd.n392 avdd.n391 4.5005
R1900 avdd.n382 avdd.n381 4.5005
R1901 avdd.n26 avdd.n11 4.5005
R1902 avdd.n26 avdd.n25 4.5005
R1903 avdd.n25 avdd.n14 4.5005
R1904 avdd.n17 avdd.n11 4.5005
R1905 avdd.n23 avdd.n17 4.5005
R1906 avdd.n25 avdd.n17 4.5005
R1907 avdd.n13 avdd.n11 4.5005
R1908 avdd.n23 avdd.n13 4.5005
R1909 avdd.n25 avdd.n13 4.5005
R1910 avdd.n24 avdd.n23 4.5005
R1911 avdd.n25 avdd.n24 4.5005
R1912 avdd.n34 avdd.n2 4.5005
R1913 avdd.n34 avdd.n33 4.5005
R1914 avdd.n33 avdd.n5 4.5005
R1915 avdd.n8 avdd.n2 4.5005
R1916 avdd.n31 avdd.n8 4.5005
R1917 avdd.n33 avdd.n8 4.5005
R1918 avdd.n4 avdd.n2 4.5005
R1919 avdd.n31 avdd.n4 4.5005
R1920 avdd.n33 avdd.n4 4.5005
R1921 avdd.n32 avdd.n31 4.5005
R1922 avdd.n33 avdd.n32 4.5005
R1923 avdd.n182 avdd.n178 3.31679
R1924 avdd.n183 avdd.n182 3.31679
R1925 avdd.n208 avdd.n207 3.31679
R1926 avdd.n209 avdd.n208 3.31679
R1927 avdd.n192 avdd.n190 3.31679
R1928 avdd.n193 avdd.n192 3.31679
R1929 avdd.n200 avdd.n199 3.31679
R1930 avdd.n201 avdd.n200 3.31679
R1931 avdd.n235 avdd.n233 3.31679
R1932 avdd.n240 avdd.n235 3.31679
R1933 avdd.n247 avdd.n234 3.31679
R1934 avdd.n247 avdd.n246 3.31679
R1935 avdd.n255 avdd.n228 3.31679
R1936 avdd.n229 avdd.n228 3.31679
R1937 avdd.n258 avdd.n226 3.31679
R1938 avdd.n259 avdd.n258 3.31679
R1939 avdd.n335 avdd.n330 3.31679
R1940 avdd.n385 avdd.n331 3.31679
R1941 avdd.n332 avdd.n331 3.31679
R1942 avdd.n384 avdd.n330 3.31679
R1943 avdd.n372 avdd.n327 3.31679
R1944 avdd.n328 avdd.n325 3.31679
R1945 avdd.n373 avdd.n328 3.31679
R1946 avdd.n371 avdd.n327 3.31679
R1947 avdd avdd.n403 2.90949
R1948 avdd.n402 avdd.n34 2.68306
R1949 avdd avdd.n0 2.32887
R1950 avdd.n365 avdd.n364 2.24986
R1951 avdd.n361 avdd.n341 2.24986
R1952 avdd.n366 avdd.n365 2.24986
R1953 avdd.n341 avdd.n336 2.24986
R1954 avdd.n354 avdd.n353 2.24986
R1955 avdd.n350 avdd.n347 2.24986
R1956 avdd.n355 avdd.n354 2.24986
R1957 avdd.n347 avdd.n342 2.24986
R1958 avdd.n20 avdd.n12 2.24986
R1959 avdd.n16 avdd.n15 2.24986
R1960 avdd.n20 avdd.n19 2.24986
R1961 avdd.n18 avdd.n15 2.24986
R1962 avdd.n28 avdd.n3 2.24986
R1963 avdd.n7 avdd.n6 2.24986
R1964 avdd.n28 avdd.n27 2.24986
R1965 avdd.n9 avdd.n6 2.24986
R1966 avdd.n360 avdd.n359 2.24741
R1967 avdd.n362 avdd.n340 2.24741
R1968 avdd.n369 avdd.n337 2.24741
R1969 avdd.n349 avdd.n348 2.24741
R1970 avdd.n351 avdd.n346 2.24741
R1971 avdd.n358 avdd.n343 2.24741
R1972 avdd.n26 avdd.n10 2.24741
R1973 avdd.n22 avdd.n14 2.24741
R1974 avdd.n24 avdd.n21 2.24741
R1975 avdd.n34 avdd.n1 2.24741
R1976 avdd.n30 avdd.n5 2.24741
R1977 avdd.n32 avdd.n29 2.24741
R1978 avdd.n264 avdd.n223 2.1551
R1979 avdd.n394 avdd.n331 1.49311
R1980 avdd.n394 avdd.n330 1.49311
R1981 avdd.n396 avdd.n328 1.49311
R1982 avdd.n396 avdd.n327 1.49311
R1983 avdd.n400 avdd.n322 1.40235
R1984 avdd.n219 avdd.n218 1.24194
R1985 avdd.n97 avdd.n93 1.24194
R1986 avdd.n317 avdd.n316 1.24194
R1987 avdd.n292 avdd.n291 1.24194
R1988 avdd.n402 avdd.n401 1.00678
R1989 avdd.n401 avdd.n321 0.9689
R1990 avdd.n99 avdd.n98 0.9005
R1991 avdd.n198 avdd.n197 0.9005
R1992 avdd.n198 avdd.n189 0.9005
R1993 avdd.n205 avdd.n180 0.9005
R1994 avdd.n189 avdd.n180 0.9005
R1995 avdd.n206 avdd.n205 0.9005
R1996 avdd.n206 avdd.n177 0.9005
R1997 avdd.n176 avdd.n173 0.9005
R1998 avdd.n177 avdd.n176 0.9005
R1999 avdd.n39 avdd.n35 0.9005
R2000 avdd.n243 avdd.n236 0.9005
R2001 avdd.n248 avdd.n236 0.9005
R2002 avdd.n250 avdd.n227 0.9005
R2003 avdd.n257 avdd.n227 0.9005
R2004 avdd.n250 avdd.n249 0.9005
R2005 avdd.n249 avdd.n248 0.9005
R2006 avdd.n256 avdd.n224 0.9005
R2007 avdd.n257 avdd.n256 0.9005
R2008 avdd.n286 avdd.n285 0.9005
R2009 avdd.n269 avdd.n265 0.9005
R2010 avdd.n213 avdd.n212 0.622674
R2011 avdd.n212 avdd.n173 0.454413
R2012 avdd.n213 avdd.n35 0.454413
R2013 avdd.n222 avdd.n35 0.454413
R2014 avdd.n263 avdd.n224 0.454413
R2015 avdd.n320 avdd.n265 0.454413
R2016 avdd.n321 avdd.n264 0.2903
R2017 avdd.n379 avdd.n329 0.2255
R2018 avdd.n395 avdd.n329 0.2255
R2019 avdd.n326 avdd.n322 0.2255
R2020 avdd.n395 avdd.n326 0.2255
R2021 avdd.n106 avdd.n92 0.1445
R2022 avdd.n106 avdd.n90 0.1445
R2023 avdd.n110 avdd.n90 0.1445
R2024 avdd.n110 avdd.n80 0.1445
R2025 avdd.n122 avdd.n80 0.1445
R2026 avdd.n122 avdd.n78 0.1445
R2027 avdd.n126 avdd.n78 0.1445
R2028 avdd.n126 avdd.n68 0.1445
R2029 avdd.n138 avdd.n68 0.1445
R2030 avdd.n138 avdd.n66 0.1445
R2031 avdd.n142 avdd.n66 0.1445
R2032 avdd.n142 avdd.n56 0.1445
R2033 avdd.n154 avdd.n56 0.1445
R2034 avdd.n154 avdd.n54 0.1445
R2035 avdd.n158 avdd.n54 0.1445
R2036 avdd.n158 avdd.n44 0.1445
R2037 avdd.n170 avdd.n44 0.1445
R2038 avdd.n170 avdd.n42 0.1445
R2039 avdd.n215 avdd.n42 0.1445
R2040 avdd.n102 avdd.n96 0.1445
R2041 avdd.n102 avdd.n86 0.1445
R2042 avdd.n114 avdd.n86 0.1445
R2043 avdd.n114 avdd.n84 0.1445
R2044 avdd.n118 avdd.n84 0.1445
R2045 avdd.n118 avdd.n74 0.1445
R2046 avdd.n130 avdd.n74 0.1445
R2047 avdd.n130 avdd.n72 0.1445
R2048 avdd.n134 avdd.n72 0.1445
R2049 avdd.n134 avdd.n62 0.1445
R2050 avdd.n146 avdd.n62 0.1445
R2051 avdd.n146 avdd.n60 0.1445
R2052 avdd.n150 avdd.n60 0.1445
R2053 avdd.n150 avdd.n50 0.1445
R2054 avdd.n162 avdd.n50 0.1445
R2055 avdd.n162 avdd.n48 0.1445
R2056 avdd.n166 avdd.n48 0.1445
R2057 avdd.n166 avdd.n37 0.1445
R2058 avdd.n220 avdd.n37 0.1445
R2059 avdd.n101 avdd.n100 0.1445
R2060 avdd.n101 avdd.n85 0.1445
R2061 avdd.n115 avdd.n85 0.1445
R2062 avdd.n116 avdd.n115 0.1445
R2063 avdd.n117 avdd.n116 0.1445
R2064 avdd.n117 avdd.n73 0.1445
R2065 avdd.n131 avdd.n73 0.1445
R2066 avdd.n132 avdd.n131 0.1445
R2067 avdd.n133 avdd.n132 0.1445
R2068 avdd.n133 avdd.n61 0.1445
R2069 avdd.n147 avdd.n61 0.1445
R2070 avdd.n148 avdd.n147 0.1445
R2071 avdd.n149 avdd.n148 0.1445
R2072 avdd.n149 avdd.n49 0.1445
R2073 avdd.n163 avdd.n49 0.1445
R2074 avdd.n164 avdd.n163 0.1445
R2075 avdd.n165 avdd.n164 0.1445
R2076 avdd.n165 avdd.n36 0.1445
R2077 avdd.n221 avdd.n36 0.1445
R2078 avdd.n107 avdd.n91 0.1445
R2079 avdd.n108 avdd.n107 0.1445
R2080 avdd.n109 avdd.n108 0.1445
R2081 avdd.n109 avdd.n79 0.1445
R2082 avdd.n123 avdd.n79 0.1445
R2083 avdd.n124 avdd.n123 0.1445
R2084 avdd.n125 avdd.n124 0.1445
R2085 avdd.n125 avdd.n67 0.1445
R2086 avdd.n139 avdd.n67 0.1445
R2087 avdd.n140 avdd.n139 0.1445
R2088 avdd.n141 avdd.n140 0.1445
R2089 avdd.n141 avdd.n55 0.1445
R2090 avdd.n155 avdd.n55 0.1445
R2091 avdd.n156 avdd.n155 0.1445
R2092 avdd.n157 avdd.n156 0.1445
R2093 avdd.n157 avdd.n43 0.1445
R2094 avdd.n171 avdd.n43 0.1445
R2095 avdd.n172 avdd.n171 0.1445
R2096 avdd.n214 avdd.n172 0.1445
R2097 avdd.n185 avdd.n184 0.1445
R2098 avdd.n210 avdd.n175 0.1445
R2099 avdd.n211 avdd.n174 0.1445
R2100 avdd.n195 avdd.n194 0.1445
R2101 avdd.n202 avdd.n188 0.1445
R2102 avdd.n203 avdd.n187 0.1445
R2103 avdd.n196 avdd.n191 0.1445
R2104 avdd.n186 avdd.n181 0.1445
R2105 avdd.n241 avdd.n239 0.1445
R2106 avdd.n245 avdd.n237 0.1445
R2107 avdd.n244 avdd.n231 0.1445
R2108 avdd.n242 avdd.n238 0.1445
R2109 avdd.n254 avdd.n230 0.1445
R2110 avdd.n261 avdd.n260 0.1445
R2111 avdd.n262 avdd.n225 0.1445
R2112 avdd.n253 avdd.n252 0.1445
R2113 avdd.n293 avdd.n284 0.1445
R2114 avdd.n297 avdd.n284 0.1445
R2115 avdd.n297 avdd.n274 0.1445
R2116 avdd.n309 avdd.n274 0.1445
R2117 avdd.n309 avdd.n272 0.1445
R2118 avdd.n313 avdd.n272 0.1445
R2119 avdd.n288 avdd.n280 0.1445
R2120 avdd.n301 avdd.n280 0.1445
R2121 avdd.n301 avdd.n278 0.1445
R2122 avdd.n305 avdd.n278 0.1445
R2123 avdd.n305 avdd.n267 0.1445
R2124 avdd.n318 avdd.n267 0.1445
R2125 avdd.n287 avdd.n279 0.1445
R2126 avdd.n302 avdd.n279 0.1445
R2127 avdd.n303 avdd.n302 0.1445
R2128 avdd.n304 avdd.n303 0.1445
R2129 avdd.n304 avdd.n266 0.1445
R2130 avdd.n319 avdd.n266 0.1445
R2131 avdd.n295 avdd.n294 0.1445
R2132 avdd.n296 avdd.n295 0.1445
R2133 avdd.n296 avdd.n273 0.1445
R2134 avdd.n310 avdd.n273 0.1445
R2135 avdd.n311 avdd.n310 0.1445
R2136 avdd.n312 avdd.n311 0.1445
R2137 avdd.n383 avdd.n382 0.1445
R2138 avdd.n386 avdd.n383 0.1445
R2139 avdd.n386 avdd.n333 0.1445
R2140 avdd.n392 avdd.n333 0.1445
R2141 avdd.n377 avdd.n376 0.1445
R2142 avdd.n376 avdd.n375 0.1445
R2143 avdd.n375 avdd.n324 0.1445
R2144 avdd.n398 avdd.n324 0.1445
R2145 avdd.n378 avdd.n370 0.1445
R2146 avdd.n374 avdd.n370 0.1445
R2147 avdd.n374 avdd.n323 0.1445
R2148 avdd.n399 avdd.n323 0.1445
R2149 avdd.n381 avdd.n380 0.129071
R2150 avdd.n391 avdd.n390 0.129071
R2151 avdd.n381 avdd.n334 0.0827857
R2152 avdd.n387 avdd.n334 0.0827857
R2153 avdd.n388 avdd.n387 0.0827857
R2154 avdd.n391 avdd.n388 0.0827857
R2155 avdd.n205 avdd.n204 0.0543057
R2156 avdd.n205 avdd.n179 0.0543057
R2157 avdd.n251 avdd.n250 0.0543057
R2158 avdd.n250 avdd.n232 0.0543057
R2159 avdd.n360 avdd.n358 0.0245
R2160 avdd.n32 avdd.n26 0.0245
R2161 avdd.n357 avdd.n347 0.0149
R2162 avdd.n368 avdd.n341 0.0149
R2163 avdd.n33 avdd.n6 0.0149
R2164 avdd.n25 avdd.n15 0.0149
R2165 avdd.n348 avdd.n347 0.0081885
R2166 avdd.n352 avdd.n351 0.0081885
R2167 avdd.n354 avdd.n343 0.0081885
R2168 avdd.n359 avdd.n341 0.0081885
R2169 avdd.n363 avdd.n362 0.0081885
R2170 avdd.n365 avdd.n337 0.0081885
R2171 avdd.n359 avdd.n338 0.0081885
R2172 avdd.n362 avdd.n338 0.0081885
R2173 avdd.n363 avdd.n337 0.0081885
R2174 avdd.n348 avdd.n344 0.0081885
R2175 avdd.n351 avdd.n344 0.0081885
R2176 avdd.n352 avdd.n343 0.0081885
R2177 avdd.n6 avdd.n1 0.0081885
R2178 avdd.n30 avdd.n2 0.0081885
R2179 avdd.n29 avdd.n28 0.0081885
R2180 avdd.n15 avdd.n10 0.0081885
R2181 avdd.n22 avdd.n11 0.0081885
R2182 avdd.n21 avdd.n20 0.0081885
R2183 avdd.n23 avdd.n10 0.0081885
R2184 avdd.n23 avdd.n22 0.0081885
R2185 avdd.n21 avdd.n11 0.0081885
R2186 avdd.n31 avdd.n1 0.0081885
R2187 avdd.n31 avdd.n30 0.0081885
R2188 avdd.n29 avdd.n2 0.0081885
R2189 avdd.n353 avdd.n346 0.00328455
R2190 avdd.n356 avdd.n350 0.00328455
R2191 avdd.n355 avdd.n345 0.00328455
R2192 avdd.n358 avdd.n342 0.00328455
R2193 avdd.n364 avdd.n340 0.00328455
R2194 avdd.n367 avdd.n361 0.00328455
R2195 avdd.n366 avdd.n339 0.00328455
R2196 avdd.n369 avdd.n336 0.00328455
R2197 avdd.n364 avdd.n360 0.00328455
R2198 avdd.n361 avdd.n340 0.00328455
R2199 avdd.n367 avdd.n366 0.00328455
R2200 avdd.n339 avdd.n336 0.00328455
R2201 avdd.n353 avdd.n349 0.00328455
R2202 avdd.n350 avdd.n346 0.00328455
R2203 avdd.n356 avdd.n355 0.00328455
R2204 avdd.n345 avdd.n342 0.00328455
R2205 avdd.n5 avdd.n3 0.00328455
R2206 avdd.n8 avdd.n7 0.00328455
R2207 avdd.n27 avdd.n4 0.00328455
R2208 avdd.n32 avdd.n9 0.00328455
R2209 avdd.n14 avdd.n12 0.00328455
R2210 avdd.n17 avdd.n16 0.00328455
R2211 avdd.n19 avdd.n13 0.00328455
R2212 avdd.n24 avdd.n18 0.00328455
R2213 avdd.n26 avdd.n12 0.00328455
R2214 avdd.n16 avdd.n14 0.00328455
R2215 avdd.n19 avdd.n17 0.00328455
R2216 avdd.n18 avdd.n13 0.00328455
R2217 avdd.n34 avdd.n3 0.00328455
R2218 avdd.n7 avdd.n5 0.00328455
R2219 avdd.n27 avdd.n8 0.00328455
R2220 avdd.n9 avdd.n4 0.00328455
C0 xm4_0/a_63_n131# vb_itd 0
C1 xmcm_chain_3_0/a_1000_n131# vb_pot 0.00248f
C2 avdd xm1_0/a_63_n131# 1.02963f
C3 nvpost xm1_0/a_n63_n339# 0.00597f
C4 vpre xmcm_chain_1_0/a_1000_n131# 0
C5 vpost vb_itd 0.00164f
C6 xm7_0/a_63_n131# avdd 0.9866f
C7 xm7_0/a_63_n131# xm1_0/a_63_n131# 0.04681f
C8 avdd vb_itp 0.03118f
C9 xmcm_chain_2_0/a_1000_n131# xmcm_chain_1_0/a_1000_n131# 0.10498f
C10 xm8_0/a_63_n131# avdd 0.86265f
C11 xm9_0/a_63_n131# xm1_0/a_n63_n339# 0.05169f
C12 xmcm_chain_4_0/a_1000_n131# xmcm_chain_3_0/a_1000_n131# 0.03573f
C13 xmcm_chain_1_0/a_1000_n131# vb_pot 0.00235f
C14 xmcm_chain_3_0/a_1000_n131# vb_itd 0.17915f
C15 xm7_0/a_63_n131# vb_itp 0
C16 xm1_0/a_n63_n339# Iout 0.03466f
C17 xm7_0/a_63_n131# xm8_0/a_63_n131# 0.14657f
C18 xm8_0/a_63_n131# vb_itp 0
C19 nvpre avdd 0.03472f
C20 xm9_0/a_63_n131# xmcm_chain_1_0/a_1000_n131# 0.01586f
C21 avdd vw 7.23886f
C22 nvpre xm7_0/a_63_n131# 0.00208f
C23 xmcm_chain_4_0/a_1000_n131# xmcm_chain_1_0/a_1000_n131# 0.07064f
C24 vw xm1_0/a_63_n131# 0.49687f
C25 nvpre vb_itp 0.00646f
C26 nvpre xm8_0/a_63_n131# 0.02234f
C27 vpre avdd 0.02242f
C28 vb_itd xmcm_chain_1_0/a_1000_n131# 0.19554f
C29 vb_idep xm9_0/a_63_n131# 0.08994f
C30 vpre xm1_0/a_63_n131# 0
C31 xm7_0/a_63_n131# vw 0.02564f
C32 nvpost avdd 0.03686f
C33 xmcm_chain_2_0/a_1000_n131# avdd 0.01079f
C34 nvpost xm1_0/a_63_n131# 0.01317f
C35 xm8_0/a_63_n131# vw 0
C36 avdd vb_pot 0.00141f
C37 vb_idep vb_itd 0.00789f
C38 nvpost xm7_0/a_63_n131# 0.01282f
C39 xm7_0/a_63_n131# xmcm_chain_2_0/a_1000_n131# 0
C40 nvpost xm8_0/a_63_n131# 0.00597f
C41 xm9_0/a_63_n131# avdd 1.95479f
C42 xm7_0/a_63_n131# vb_pot 0
C43 avdd Iout 0.03747f
C44 xmcm_chain_4_0/a_1000_n131# avdd 0
C45 xm7_0/a_63_n131# xm9_0/a_63_n131# 0.48825f
C46 xm9_0/a_63_n131# vb_itp 0.02228f
C47 vb_itd avdd 0.28317f
C48 xm8_0/a_63_n131# xm9_0/a_63_n131# 0
C49 vpre vw 0
C50 xm7_0/a_63_n131# Iout 0
C51 vpost xmcm_chain_3_0/a_1000_n131# 0
C52 nvpost vw 0.00167f
C53 xm7_0/a_63_n131# vb_itd 0
C54 xm4_0/a_63_n131# xmcm_chain_1_0/a_1000_n131# 0.00332f
C55 vpre xmcm_chain_2_0/a_1000_n131# 0
C56 nvpre xm9_0/a_63_n131# 0
C57 vpost xmcm_chain_1_0/a_1000_n131# 0.00115f
C58 Iout vw 0.07066f
C59 xmcm_chain_4_0/a_1000_n131# vw 0.00597f
C60 xm9_0/a_63_n131# xmcm_chain_2_0/a_1000_n131# 0.00323f
C61 vb_itd vw 0.03463f
C62 xmcm_chain_3_0/a_1000_n131# xmcm_chain_1_0/a_1000_n131# 0.07349f
C63 vpre vb_itd 0.00164f
C64 xm9_0/a_63_n131# vb_pot 0
C65 xmcm_chain_4_0/a_1000_n131# xmcm_chain_2_0/a_1000_n131# 0.0045f
C66 xm4_0/a_63_n131# avdd 0.12937f
C67 vb_itd xmcm_chain_2_0/a_1000_n131# 0.14323f
C68 xm4_0/a_63_n131# xm1_0/a_63_n131# 0.014f
C69 vb_itd vb_pot 0.00612f
C70 vpost avdd 0.00217f
C71 vb_idep xm1_0/a_n63_n339# 0.02469f
C72 xm9_0/a_63_n131# vb_itd 0
C73 vpost xm7_0/a_63_n131# 0
C74 vb_idep xmcm_chain_1_0/a_1000_n131# 0.00135f
C75 xmcm_chain_3_0/a_1000_n131# avdd 0
C76 xmcm_chain_4_0/a_1000_n131# vb_itd 0.23536f
C77 xm7_0/a_63_n131# xmcm_chain_3_0/a_1000_n131# 0
C78 xm1_0/a_n63_n339# avdd 2.54079f
C79 xm4_0/a_63_n131# vw 0.03003f
C80 xm1_0/a_n63_n339# xm1_0/a_63_n131# 0.29211f
C81 vpre xm4_0/a_63_n131# 0.00163f
C82 xmcm_chain_1_0/a_1000_n131# avdd 0.08213f
C83 xm7_0/a_63_n131# xm1_0/a_n63_n339# 0.00852f
C84 nvpost xm4_0/a_63_n131# 0
C85 xm1_0/a_n63_n339# vb_itp 0
C86 xm4_0/a_63_n131# xmcm_chain_2_0/a_1000_n131# 0
C87 xm8_0/a_63_n131# xm1_0/a_n63_n339# 0.03953f
C88 xm7_0/a_63_n131# xmcm_chain_1_0/a_1000_n131# 0.02759f
C89 vb_idep avdd 0.04349f
C90 vpost xmcm_chain_2_0/a_1000_n131# 0
C91 nvpre xm1_0/a_n63_n339# 0.00163f
C92 xm9_0/a_63_n131# xm4_0/a_63_n131# 0.0096f
C93 vpost vb_pot 0.00598f
C94 xm1_0/a_n63_n339# vw 1.35499f
C95 xmcm_chain_3_0/a_1000_n131# xmcm_chain_2_0/a_1000_n131# 0.03573f
C96 vpost xm9_0/a_63_n131# 0.0076f
C97 Iout avss -0.06611f
C98 vb_pot avss -0.06851f
C99 vpre avss -0.05459f
C100 vpost avss -0.04887f
C101 nvpre avss -0.09281f
C102 nvpost avss -0.09624f
C103 avdd.n0 avss 0.34281f
C104 avdd.n2 avss 0.00232f
C105 avdd.n4 avss 0.00325f
C106 avdd.n5 avss 0.00325f
C107 avdd.n6 avss 0.00232f
C108 avdd.n8 avss 0.00325f
C109 avdd.n11 avss 0.00232f
C110 avdd.n13 avss 0.00325f
C111 avdd.n14 avss 0.00325f
C112 avdd.n15 avss 0.00232f
C113 avdd.n17 avss 0.00325f
C114 avdd.n20 avss 0.00377f
C115 avdd.n23 avss 0.00232f
C116 avdd.n24 avss 0.00934f
C117 avdd.n25 avss 0.00377f
C118 avdd.n26 avss 0.01016f
C119 avdd.n28 avss 0.00377f
C120 avdd.n31 avss 0.00232f
C121 avdd.n32 avss 0.01016f
C122 avdd.n33 avss 0.00377f
C123 avdd.n34 avss 0.02082f
C124 avdd.n35 avss 0
C125 avdd.n36 avss 0
C126 avdd.n37 avss 0
C127 avdd.n38 avss 0
C128 avdd.n39 avss 0.00447f
C129 avdd.n40 avss 0.0026f
C130 avdd.n41 avss 0
C131 avdd.n42 avss 0
C132 avdd.n43 avss 0
C133 avdd.n44 avss 0
C134 avdd.n45 avss 0
C135 avdd.n46 avss 0.0026f
C136 avdd.n47 avss 0
C137 avdd.n48 avss 0
C138 avdd.n49 avss 0
C139 avdd.n50 avss 0
C140 avdd.n51 avss 0
C141 avdd.n52 avss 0.0026f
C142 avdd.n53 avss 0
C143 avdd.n54 avss 0
C144 avdd.n55 avss 0
C145 avdd.n56 avss 0
C146 avdd.n57 avss 0
C147 avdd.n58 avss 0.0026f
C148 avdd.n59 avss 0
C149 avdd.n60 avss 0
C150 avdd.n61 avss 0
C151 avdd.n62 avss 0
C152 avdd.n63 avss 0
C153 avdd.n64 avss 0.0026f
C154 avdd.n65 avss 0
C155 avdd.n66 avss 0
C156 avdd.n67 avss 0
C157 avdd.n68 avss 0
C158 avdd.n69 avss 0
C159 avdd.n70 avss 0.0026f
C160 avdd.n71 avss 0
C161 avdd.n72 avss 0
C162 avdd.n73 avss 0
C163 avdd.n74 avss 0
C164 avdd.n75 avss 0
C165 avdd.n76 avss 0.0026f
C166 avdd.n77 avss 0
C167 avdd.n78 avss 0
C168 avdd.n79 avss 0
C169 avdd.n80 avss 0
C170 avdd.n81 avss 0
C171 avdd.n82 avss 0.0026f
C172 avdd.n83 avss 0
C173 avdd.n84 avss 0
C174 avdd.n85 avss 0
C175 avdd.n86 avss 0
C176 avdd.n87 avss 0
C177 avdd.n88 avss 0.0026f
C178 avdd.n89 avss 0
C179 avdd.n90 avss 0
C180 avdd.n91 avss 0
C181 avdd.n92 avss 0
C182 avdd.n93 avss 0
C183 avdd.n94 avss 0.00354f
C184 avdd.n95 avss 0
C185 avdd.n96 avss 0
C186 avdd.n98 avss 0.00447f
C187 avdd.n99 avss 0.00637f
C188 avdd.n100 avss 0
C189 avdd.n101 avss 0
C190 avdd.n102 avss 0
C191 avdd.n103 avss 0
C192 avdd.n104 avss 0.0026f
C193 avdd.n105 avss 0
C194 avdd.n106 avss 0
C195 avdd.n107 avss 0
C196 avdd.n108 avss 0
C197 avdd.n109 avss 0
C198 avdd.n110 avss 0
C199 avdd.n111 avss 0
C200 avdd.n112 avss 0.0026f
C201 avdd.n113 avss 0
C202 avdd.n114 avss 0
C203 avdd.n115 avss 0
C204 avdd.n116 avss 0
C205 avdd.n117 avss 0
C206 avdd.n118 avss 0
C207 avdd.n119 avss 0
C208 avdd.n120 avss 0.0026f
C209 avdd.n121 avss 0
C210 avdd.n122 avss 0
C211 avdd.n123 avss 0
C212 avdd.n124 avss 0
C213 avdd.n125 avss 0
C214 avdd.n126 avss 0
C215 avdd.n127 avss 0
C216 avdd.n128 avss 0.0026f
C217 avdd.n129 avss 0
C218 avdd.n130 avss 0
C219 avdd.n131 avss 0
C220 avdd.n132 avss 0
C221 avdd.n133 avss 0
C222 avdd.n134 avss 0
C223 avdd.n135 avss 0
C224 avdd.n136 avss 0.0026f
C225 avdd.n137 avss 0
C226 avdd.n138 avss 0
C227 avdd.n139 avss 0
C228 avdd.n140 avss 0
C229 avdd.n141 avss 0
C230 avdd.n142 avss 0
C231 avdd.n143 avss 0
C232 avdd.n144 avss 0.0026f
C233 avdd.n145 avss 0
C234 avdd.n146 avss 0
C235 avdd.n147 avss 0
C236 avdd.n148 avss 0
C237 avdd.n149 avss 0
C238 avdd.n150 avss 0
C239 avdd.n151 avss 0
C240 avdd.n152 avss 0.0026f
C241 avdd.n153 avss 0
C242 avdd.n154 avss 0
C243 avdd.n155 avss 0
C244 avdd.n156 avss 0
C245 avdd.n157 avss 0
C246 avdd.n158 avss 0
C247 avdd.n159 avss 0
C248 avdd.n160 avss 0.0026f
C249 avdd.n161 avss 0
C250 avdd.n162 avss 0
C251 avdd.n163 avss 0
C252 avdd.n164 avss 0
C253 avdd.n165 avss 0
C254 avdd.n166 avss 0
C255 avdd.n167 avss 0
C256 avdd.n168 avss 0.0026f
C257 avdd.n169 avss 0
C258 avdd.n170 avss 0
C259 avdd.n171 avss 0
C260 avdd.n172 avss 0
C261 avdd.n173 avss 0
C262 avdd.n174 avss 0
C263 avdd.n175 avss 0
C264 avdd.n176 avss 0
C265 avdd.n177 avss 0.00612f
C266 avdd.n178 avss 0
C267 avdd.n179 avss 0.00282f
C268 avdd.n180 avss 0
C269 avdd.n181 avss 0
C270 avdd.n182 avss 0.00423f
C271 avdd.n183 avss 0
C272 avdd.n184 avss 0
C273 avdd.n185 avss 0
C274 avdd.n186 avss 0
C275 avdd.n187 avss 0
C276 avdd.n188 avss 0
C277 avdd.n189 avss 0.00612f
C278 avdd.n190 avss 0
C279 avdd.n191 avss 0
C280 avdd.n192 avss 0.00423f
C281 avdd.n193 avss 0
C282 avdd.n194 avss 0
C283 avdd.n195 avss 0
C284 avdd.n196 avss 0
C285 avdd.n197 avss 0.00136f
C286 avdd.n198 avss 0
C287 avdd.n199 avss 0
C288 avdd.n200 avss 0.00423f
C289 avdd.n201 avss 0
C290 avdd.n202 avss 0
C291 avdd.n203 avss 0
C292 avdd.n204 avss 0.00255f
C293 avdd.n205 avss 0.00536f
C294 avdd.n206 avss 0
C295 avdd.n207 avss 0
C296 avdd.n208 avss 0.00423f
C297 avdd.n209 avss 0
C298 avdd.n210 avss 0
C299 avdd.n211 avss 0
C300 avdd.n212 avss 0
C301 avdd.n213 avss 0
C302 avdd.n214 avss 0
C303 avdd.n215 avss 0
C304 avdd.n216 avss 0
C305 avdd.n217 avss 0.00354f
C306 avdd.n219 avss 0
C307 avdd.n220 avss 0
C308 avdd.n221 avss 0
C309 avdd.n222 avss 0.00229f
C310 avdd.n223 avss 0.0095f
C311 avdd.n224 avss 0
C312 avdd.n225 avss 0
C313 avdd.n226 avss 0
C314 avdd.n227 avss 0
C315 avdd.n228 avss 0.00423f
C316 avdd.n229 avss 0
C317 avdd.n230 avss 0
C318 avdd.n231 avss 0
C319 avdd.n232 avss 0.00282f
C320 avdd.n233 avss 0
C321 avdd.n234 avss 0
C322 avdd.n235 avss 0.00423f
C323 avdd.n236 avss 0
C324 avdd.n237 avss 0
C325 avdd.n238 avss 0
C326 avdd.n239 avss 0
C327 avdd.n240 avss 0
C328 avdd.n241 avss 0
C329 avdd.n242 avss 0
C330 avdd.n243 avss 0.00136f
C331 avdd.n244 avss 0
C332 avdd.n245 avss 0
C333 avdd.n246 avss 0
C334 avdd.n247 avss 0.00423f
C335 avdd.n248 avss 0.00612f
C336 avdd.n249 avss 0
C337 avdd.n250 avss 0.00536f
C338 avdd.n251 avss 0.00255f
C339 avdd.n252 avss 0
C340 avdd.n253 avss 0
C341 avdd.n254 avss 0
C342 avdd.n255 avss 0
C343 avdd.n256 avss 0
C344 avdd.n257 avss 0.00612f
C345 avdd.n258 avss 0.00423f
C346 avdd.n259 avss 0
C347 avdd.n260 avss 0
C348 avdd.n261 avss 0
C349 avdd.n262 avss 0
C350 avdd.n263 avss 0.00379f
C351 avdd.n264 avss 0.00879f
C352 avdd.n265 avss 0
C353 avdd.n266 avss 0
C354 avdd.n267 avss 0
C355 avdd.n268 avss 0
C356 avdd.n269 avss 0.00447f
C357 avdd.n270 avss 0.0026f
C358 avdd.n271 avss 0
C359 avdd.n272 avss 0
C360 avdd.n273 avss 0
C361 avdd.n274 avss 0
C362 avdd.n275 avss 0
C363 avdd.n276 avss 0.0026f
C364 avdd.n277 avss 0
C365 avdd.n278 avss 0
C366 avdd.n279 avss 0
C367 avdd.n280 avss 0
C368 avdd.n281 avss 0
C369 avdd.n282 avss 0.0026f
C370 avdd.n283 avss 0
C371 avdd.n284 avss 0
C372 avdd.n285 avss 0.00342f
C373 avdd.n286 avss 0.00447f
C374 avdd.n287 avss 0
C375 avdd.n288 avss 0
C376 avdd.n289 avss 0
C377 avdd.n290 avss 0.00354f
C378 avdd.n292 avss 0
C379 avdd.n293 avss 0
C380 avdd.n294 avss 0
C381 avdd.n295 avss 0
C382 avdd.n296 avss 0
C383 avdd.n297 avss 0
C384 avdd.n298 avss 0
C385 avdd.n299 avss 0.0026f
C386 avdd.n300 avss 0
C387 avdd.n301 avss 0
C388 avdd.n302 avss 0
C389 avdd.n303 avss 0
C390 avdd.n304 avss 0
C391 avdd.n305 avss 0
C392 avdd.n306 avss 0
C393 avdd.n307 avss 0.0026f
C394 avdd.n308 avss 0
C395 avdd.n309 avss 0
C396 avdd.n310 avss 0
C397 avdd.n311 avss 0
C398 avdd.n312 avss 0
C399 avdd.n313 avss 0
C400 avdd.n314 avss 0
C401 avdd.n315 avss 0.00354f
C402 avdd.n317 avss 0
C403 avdd.n318 avss 0
C404 avdd.n319 avss 0
C405 avdd.n320 avss 0.00379f
C406 avdd.n321 avss 0.00497f
C407 avdd.n322 avss 0.00271f
C408 avdd.n323 avss 0
C409 avdd.n324 avss 0
C410 avdd.n325 avss 0
C411 avdd.n326 avss 0.00174f
C412 avdd.n329 avss 0.00174f
C413 avdd.n332 avss 0
C414 avdd.n333 avss 0
C415 avdd.n334 avss 0
C416 avdd.n335 avss 0
C417 avdd.n338 avss 0.00232f
C418 avdd.n339 avss 0.00325f
C419 avdd.n340 avss 0.00325f
C420 avdd.n341 avss 0.00232f
C421 avdd.n344 avss 0.00232f
C422 avdd.n345 avss 0.00325f
C423 avdd.n346 avss 0.00325f
C424 avdd.n347 avss 0.00232f
C425 avdd.n349 avss 0.00934f
C426 avdd.n352 avss 0.00232f
C427 avdd.n354 avss 0.00377f
C428 avdd.n356 avss 0.00325f
C429 avdd.n357 avss 0.00377f
C430 avdd.n358 avss 0.01016f
C431 avdd.n360 avss 0.01016f
C432 avdd.n363 avss 0.00232f
C433 avdd.n365 avss 0.00377f
C434 avdd.n367 avss 0.00325f
C435 avdd.n368 avss 0.00377f
C436 avdd.n369 avss 0.01841f
C437 avdd.n370 avss 0
C438 avdd.n371 avss 0
C439 avdd.n372 avss 0
C440 avdd.n373 avss 0
C441 avdd.n374 avss 0
C442 avdd.n375 avss 0
C443 avdd.n376 avss 0
C444 avdd.n377 avss 0
C445 avdd.n378 avss 0.00146f
C446 avdd.n379 avss 0.00671f
C447 avdd.n380 avss 0.00446f
C448 avdd.n381 avss 0
C449 avdd.n382 avss 0
C450 avdd.n383 avss 0
C451 avdd.n384 avss 0
C452 avdd.n385 avss 0
C453 avdd.n386 avss 0
C454 avdd.n387 avss 0
C455 avdd.n388 avss 0
C456 avdd.n389 avss 0.00191f
C457 avdd.n390 avss 0.01739f
C458 avdd.n391 avss 0
C459 avdd.n392 avss 0
C460 avdd.n393 avss 0
C461 avdd.n394 avss 0.01566f
C462 avdd.n395 avss 0.02777f
C463 avdd.n396 avss 0.01566f
C464 avdd.n397 avss 0
C465 avdd.n398 avss 0
C466 avdd.n399 avss 0
C467 avdd.n400 avss 0.00354f
C468 avdd.n401 avss 0.00683f
C469 avdd.n402 avss 0.02123f
C470 avdd.n403 avss 0.37879f
C471 avss.n0 avss 0.07142f
C472 avss.n1 avss 0.00152f
C473 avss.n2 avss 0
C474 avss.n3 avss 0
C475 avss.n4 avss 0
C476 avss.n5 avss 0
C477 avss.n6 avss 0
C478 avss.n7 avss 0.00146f
C479 avss.n8 avss 0
C480 avss.n9 avss 0.06736f
C481 avss.n10 avss 0
C482 avss.n11 avss 0
C483 avss.n12 avss 0
C484 avss.n13 avss 0
C485 avss.n14 avss 0
C486 avss.n15 avss 0
C487 avss.n16 avss 0.00252f
C488 avss.n17 avss 0.00146f
C489 avss.n18 avss 0
C490 avss.n19 avss 0
C491 avss.n20 avss 0
C492 avss.n21 avss 0
C493 avss.n22 avss 0
C494 avss.n23 avss 0
C495 avss.n24 avss 0.00146f
C496 avss.n25 avss 0
C497 avss.n26 avss 0
C498 avss.n27 avss 0.0016f
C499 avss.n28 avss 0
C500 avss.n29 avss 0
C501 avss.n30 avss 0
C502 avss.n31 avss 0
C503 avss.n32 avss 0
C504 avss.n33 avss 0
C505 avss.n34 avss 0
C506 avss.n35 avss 0
C507 avss.n36 avss 0.00146f
C508 avss.n37 avss 0
C509 avss.n38 avss 0
C510 avss.n39 avss 0.00194f
C511 avss.n40 avss 0
C512 avss.n41 avss 0
C513 avss.n42 avss 0
C514 avss.n43 avss 0
C515 avss.n44 avss 0
C516 avss.n45 avss 0
C517 avss.n46 avss 0
C518 avss.n47 avss 0
C519 avss.n48 avss 0.00198f
C520 avss.n49 avss 0.00146f
C521 avss.n50 avss 0
C522 avss.n51 avss 0
C523 avss.n52 avss 0
C524 avss.n53 avss 0
C525 avss.n54 avss 0
C526 avss.n55 avss 0.002f
C527 avss.n56 avss 0
C528 avss.n57 avss 0
C529 avss.n58 avss 0
C530 avss.n59 avss 0
C531 avss.n60 avss 0
C532 avss.n61 avss 0
C533 avss.n62 avss 0
C534 avss.n63 avss 0
C535 avss.n64 avss 0
C536 avss.n65 avss 0
C537 avss.n66 avss 0.00217f
C538 avss.n67 avss 0
C539 avss.n68 avss 0.00206f
C540 avss.n69 avss 0.00206f
C541 avss.n70 avss 0.00287f
C542 avss.n71 avss 0.01081f
C543 avss.n74 avss 0
C544 avss.n75 avss 0
C545 avss.n76 avss 0
C546 avss.n77 avss 0
C547 avss.n78 avss 0
C548 avss.n79 avss 0
C549 avss.n80 avss 0
C550 avss.n81 avss 0
C551 avss.n82 avss 0.00212f
C552 avss.n83 avss 0
C553 avss.n84 avss 0
C554 avss.n85 avss 0
C555 avss.n86 avss 0
C556 avss.n87 avss 0
C557 avss.n88 avss 0
C558 avss.n90 avss 0
C559 avss.n91 avss 0
C560 avss.n92 avss 0
C561 avss.n93 avss 0
C562 avss.n94 avss 0
C563 avss.n95 avss 0
C564 avss.n97 avss 0
C565 avss.n98 avss 0.09829f
C566 avss.n99 avss 0.00196f
C567 avss.n100 avss 0
C568 avss.n101 avss 0
C569 avss.n102 avss 0
C570 avss.n103 avss 0
C571 avss.n104 avss 0
C572 avss.n105 avss 0
C573 avss.n106 avss 0
C574 avss.n107 avss 0
C575 avss.n108 avss 0.00271f
C576 avss.n109 avss 0
C577 avss.n110 avss 0.00291f
C578 avss.n111 avss 0
C579 avss.n112 avss 0
C580 avss.n113 avss 0
C581 avss.n114 avss 0
C582 avss.n115 avss 0
C583 avss.n116 avss 0
C584 avss.n117 avss 0
C585 avss.n118 avss 0.00231f
C586 avss.n119 avss 0
C587 avss.n120 avss 0
C588 avss.n121 avss 0
C589 avss.n122 avss 0
C590 avss.n123 avss 0
C591 avss.n124 avss 0
C592 avss.n125 avss 0
C593 avss.n126 avss 0
C594 avss.n127 avss 0.00169f
C595 avss.n128 avss 0
C596 avss.n129 avss 0
C597 avss.n130 avss 0
C598 avss.n131 avss 0
C599 avss.n132 avss 0
C600 avss.n133 avss 0
C601 avss.n134 avss 0
C602 avss.n135 avss 0
C603 avss.n136 avss 0
C604 avss.n137 avss 0
C605 avss.n138 avss 0.00167f
C606 avss.n139 avss 0.00146f
C607 avss.n140 avss 0
C608 avss.n141 avss 0
C609 avss.n142 avss 0
C610 avss.n143 avss 0
C611 avss.n144 avss 0
C612 avss.n145 avss 0
C613 avss.n146 avss 0
C614 avss.n147 avss 0.00166f
C615 avss.n148 avss 0
C616 avss.n149 avss 0
C617 avss.n150 avss 0.00146f
C618 avss.n151 avss 0
C619 avss.n152 avss 0
C620 avss.n153 avss 0
C621 avss.n154 avss 0
C622 avss.n155 avss 0
C623 avss.n156 avss 0
C624 avss.n157 avss 0
C625 avss.n158 avss 0
C626 avss.n159 avss 0
C627 avss.n160 avss 0
C628 avss.n161 avss 0.00196f
C629 avss.n162 avss 0
C630 avss.n163 avss 0
C631 avss.n164 avss 0
C632 avss.n165 avss 0
C633 avss.n166 avss 0
C634 avss.n167 avss 0
C635 avss.n168 avss 0
C636 avss.n169 avss 0
C637 avss.n170 avss 0
C638 avss.n171 avss 0
C639 avss.n172 avss 0
C640 avss.n173 avss 0.00146f
C641 avss.n174 avss 0.00195f
C642 avss.n175 avss 0
C643 avss.n176 avss 0
C644 avss.n177 avss 0
C645 avss.n178 avss 0
C646 avss.n179 avss 0
C647 avss.n180 avss 0
C648 avss.n181 avss 0
C649 avss.n182 avss 0
C650 avss.n183 avss 0
C651 avss.n184 avss 0
C652 avss.n185 avss 0
C653 avss.n186 avss 0
C654 avss.n187 avss 0
C655 avss.n188 avss 0
C656 avss.n189 avss 0
C657 avss.n190 avss 0
C658 avss.n191 avss 0.00231f
C659 avss.n192 avss 0.00146f
C660 avss.n193 avss 0
C661 avss.n194 avss 0
C662 avss.n195 avss 0
C663 avss.n196 avss 0
C664 avss.n197 avss 0
C665 avss.n198 avss 0
C666 avss.n199 avss 0
C667 avss.n200 avss 0
C668 avss.n201 avss 0.00146f
C669 avss.n202 avss 0
C670 avss.n203 avss 0
C671 avss.n204 avss 0
C672 avss.n205 avss 0
C673 avss.n206 avss 0
C674 avss.n207 avss 0
C675 avss.n208 avss 0
C676 avss.n209 avss 0
C677 avss.n210 avss 0
C678 avss.n211 avss 0.00193f
C679 avss.n212 avss 0.00205f
C680 avss.n213 avss 0
C681 avss.n214 avss 0
C682 avss.n215 avss 0
C683 avss.n216 avss 0
C684 avss.n217 avss 0
C685 avss.n218 avss 0
C686 avss.n219 avss 0
C687 avss.n220 avss 0
C688 avss.n221 avss 0.00244f
C689 avss.n222 avss 0
C690 avss.n223 avss 0
C691 avss.n224 avss 0
C692 avss.n225 avss 0
C693 avss.n226 avss 0
C694 avss.n227 avss 0
C695 avss.n228 avss 0
C696 avss.n229 avss 0
C697 avss.n230 avss 0.00242f
C698 avss.n231 avss 0
C699 avss.n232 avss 0
C700 avss.n233 avss 0
C701 avss.n234 avss 0
C702 avss.n235 avss 0
C703 avss.n236 avss 0
C704 avss.n237 avss 0
C705 avss.n238 avss 0.00252f
C706 avss.n239 avss 0.00231f
C707 avss.n240 avss 0
C708 avss.n241 avss 0
C709 avss.n242 avss 0
C710 avss.n243 avss 0
C711 avss.n244 avss 0
C712 avss.n245 avss 0
C713 avss.n246 avss 0
C714 avss.n247 avss 0.00146f
C715 avss.n248 avss 0.00232f
C716 avss.n249 avss 0
C717 avss.n250 avss 0
C718 avss.n251 avss 0
C719 avss.n252 avss 0
C720 avss.n253 avss 0
C721 avss.n254 avss 0.00271f
C722 avss.n255 avss 0
C723 avss.n256 avss 0
C724 avss.n257 avss 0
C725 avss.n258 avss 0
C726 avss.n259 avss 0
C727 avss.n260 avss 0.00269f
C728 avss.n261 avss 0
C729 avss.n262 avss 0
C730 avss.n263 avss 0
C731 avss.n264 avss 0
C732 avss.n265 avss 0
C733 avss.n266 avss 0
C734 avss.n267 avss 0
C735 avss.n268 avss 0.00146f
C736 avss.n269 avss 0.00169f
C737 avss.n270 avss 0
C738 avss.n271 avss 0
C739 avss.n272 avss 0
C740 avss.n273 avss 0
C741 avss.n274 avss 0
C742 avss.n275 avss 0
C743 avss.n276 avss 0
C744 avss.n277 avss 0.00291f
C745 avss.n278 avss 0.00271f
C746 avss.n279 avss 0
C747 avss.n280 avss 0
C748 avss.n281 avss 0
C749 avss.n282 avss 0.00151f
C750 avss.n283 avss 0
C751 avss.n284 avss 0
C752 avss.n285 avss 0
C753 avss.n286 avss 0.00291f
C754 avss.n287 avss 0
C755 avss.n288 avss 0
C756 avss.n289 avss 0
C757 avss.n290 avss 0
C758 avss.n291 avss 0
C759 avss.n292 avss 0
C760 avss.n293 avss 0
C761 avss.n294 avss 0
C762 avss.n295 avss 0
C763 avss.n296 avss 0
C764 avss.n297 avss 0
C765 avss.n298 avss 0.00246f
C766 avss.n304 avss 0
C767 avss.n305 avss 0
C768 avss.n306 avss 0
C769 avss.n307 avss 0
C770 avss.n308 avss 0
C771 avss.n309 avss 0
C772 avss.n310 avss 0.00246f
C773 avss.n311 avss 0
C774 avss.n312 avss 0
C775 avss.n313 avss 0
C776 avss.n314 avss 0
C777 avss.n315 avss 0
C778 avss.n316 avss 0
C779 avss.n319 avss 0
C780 avss.n320 avss 0
C781 avss.n321 avss 0
C782 avss.n322 avss 0
C783 avss.n323 avss 0
C784 avss.n324 avss 0
C785 avss.n325 avss 0
C786 avss.n327 avss 0
C787 avss.n328 avss 0
C788 avss.n329 avss 0
C789 avss.n330 avss 0
C790 avss.n331 avss 0
C791 avss.n332 avss 0
C792 avss.n334 avss 0
C793 avss.n335 avss 0
C794 avss.n336 avss 0
C795 avss.n337 avss 0
C796 avss.n338 avss 0
C797 avss.n339 avss 0
C798 avss.n340 avss 0
C799 avss.n341 avss 0
C800 avss.n342 avss 0
C801 avss.n343 avss 0
C802 avss.n344 avss 0
C803 avss.n345 avss 0
C804 avss.n346 avss 0.01284f
C805 avss.n347 avss 0.01284f
C806 avss.n348 avss 0
C807 avss.n349 avss 0.01322f
C808 avss.n350 avss 0
C809 avss.n351 avss 0
C810 avss.n352 avss 0
C811 avss.n353 avss 0.03047f
C812 avss.n354 avss 0
C813 avss.n355 avss 0
C814 avss.n357 avss 0
C815 avss.n358 avss 0
C816 avss.n359 avss 0
C817 avss.n361 avss 0
C818 avss.n362 avss 0
C819 avss.n363 avss 0
C820 avss.n365 avss 0
C821 avss.n366 avss 0
C822 avss.n367 avss 0
C823 avss.n369 avss 0
C824 avss.n370 avss 0
C825 avss.n371 avss 0
C826 avss.n372 avss 0
C827 avss.n374 avss 0
C828 avss.n375 avss 0
C829 avss.n377 avss 0
C830 avss.n378 avss 0
C831 avss.n379 avss 0
C832 avss.n380 avss 0
C833 avss.n382 avss 0
C834 avss.n383 avss 0
C835 avss.n385 avss 0
C836 avss.n386 avss 0
C837 avss.n387 avss 0
C838 avss.n389 avss 0
C839 avss.n391 avss 0
C840 avss.n392 avss 0
C841 avss.n393 avss 0
C842 avss.n394 avss 0
C843 avss.n395 avss 0
C844 avss.n396 avss 0
C845 avss.n397 avss 0
C846 avss.n398 avss 0
C847 avss.n399 avss 0
C848 avss.n400 avss 0
C849 avss.n401 avss 0
C850 avss.n402 avss 0
C851 avss.n403 avss 0
C852 avss.n404 avss 0
C853 avss.n405 avss 0
C854 avss.n406 avss 0
C855 avss.n407 avss 0
C856 avss.n408 avss 0
C857 avss.n409 avss 0
C858 avss.n410 avss 0
C859 avss.n411 avss 0
C860 avss.n412 avss 0
C861 avss.n413 avss 0
C862 avss.n414 avss 0
C863 avss.n415 avss 0
C864 avss.n416 avss 0
C865 avss.n417 avss 0
C866 avss.n418 avss 0
C867 avss.n419 avss 0
C868 avss.n420 avss 0
C869 avss.n421 avss 0
C870 avss.n422 avss 0
C871 avss.n424 avss 0
C872 avss.n425 avss 0
C873 avss.n426 avss 0
C874 avss.n427 avss 0
C875 avss.n428 avss 0
C876 avss.n429 avss 0
C877 avss.n430 avss 0
C878 avss.n431 avss 0
C879 avss.n432 avss 0
C880 avss.n434 avss 0
C881 avss.n435 avss 0
C882 avss.n436 avss 0
C883 avss.n437 avss 0
C884 avss.n438 avss 0
C885 avss.n439 avss 0
C886 avss.n440 avss 0
C887 avss.n441 avss 0
C888 avss.n442 avss 0
C889 avss.n443 avss 0
C890 avss.n445 avss 0
C891 avss.n446 avss 0
C892 avss.n447 avss 0
C893 avss.n448 avss 0
C894 avss.n449 avss 0
C895 avss.n450 avss 0
C896 avss.n451 avss 0
C897 avss.n452 avss 0.01081f
C898 avss.n453 avss 0
C899 avss.n454 avss 0
C900 avss.n455 avss 0
C901 avss.n456 avss 0
C902 avss.n457 avss 0
C903 avss.n458 avss 0
C904 avss.n459 avss 0
C905 avss.n460 avss 0
C906 avss.n461 avss 0
C907 avss.n463 avss 0
C908 avss.n464 avss 0
C909 avss.n465 avss 0
C910 avss.n466 avss 0
C911 avss.n467 avss 0
C912 avss.n469 avss 0
C913 avss.n470 avss 0
C914 avss.n471 avss 0
C915 avss.n472 avss 0
C916 avss.n473 avss 0
C917 avss.n475 avss 0
C918 avss.n476 avss 0
C919 avss.n477 avss 0
C920 avss.n478 avss 0
C921 avss.n479 avss 0
C922 avss.n480 avss 0
C923 avss.n482 avss 0
C924 avss.n483 avss 0
C925 avss.n484 avss 0
C926 avss.n485 avss 0
C927 avss.n486 avss 0
C928 avss.n487 avss 0
C929 avss.n488 avss 0
C930 avss.n489 avss 0
C931 avss.n490 avss 0
C932 avss.n491 avss 0
C933 avss.n492 avss 0
C934 avss.n493 avss 0
C935 avss.n494 avss 0
C936 avss.n495 avss 0
C937 avss.n496 avss 0
C938 avss.n497 avss 0
C939 avss.n498 avss 0
C940 avss.n499 avss 0
C941 avss.n500 avss 0
C942 avss.n501 avss 0
C943 avss.n502 avss 0
C944 avss.n503 avss 0
C945 avss.n504 avss 0
C946 avss.n505 avss 0
C947 avss.n506 avss 0
C948 avss.n507 avss 0.00251f
C949 avss.n509 avss 0
C950 avss.n510 avss 0
C951 avss.n511 avss 0
C952 avss.n512 avss 0
C953 avss.n513 avss 0
C954 avss.n514 avss 0
C955 avss.n515 avss 0
C956 avss.n516 avss 0
C957 avss.n517 avss 0.00169f
C958 avss.n518 avss 0
C959 avss.n519 avss 0
C960 avss.n520 avss 0
C961 avss.n521 avss 0
C962 avss.n522 avss 0
C963 avss.n523 avss 0
C964 avss.n524 avss 0
C965 avss.n525 avss 0
C966 avss.n526 avss 0.00291f
C967 avss.n527 avss 0
C968 avss.n528 avss 0
C969 avss.n529 avss 0
C970 avss.n530 avss 0
C971 avss.n531 avss 0
C972 avss.n532 avss 0
C973 avss.n533 avss 0
C974 avss.n534 avss 0.00231f
C975 avss.n535 avss 0.00231f
C976 avss.n536 avss 0
C977 avss.n537 avss 0
C978 avss.n538 avss 0
C979 avss.n539 avss 0
C980 avss.n540 avss 0
C981 avss.n541 avss 0
C982 avss.n542 avss 0.00122f
C983 avss.n543 avss 0
C984 avss.n544 avss 0
C985 avss.n545 avss 0
C986 avss.n546 avss 0
C987 avss.n547 avss 0
C988 avss.n548 avss 0
C989 avss.n550 avss 0
C990 avss.n551 avss 0
C991 avss.n552 avss 0
C992 avss.n553 avss 0
C993 avss.n554 avss 0
C994 avss.n555 avss 0
C995 avss.n557 avss 0
C996 avss.n558 avss 0
C997 avss.n559 avss 0
C998 avss.n560 avss 0
C999 avss.n561 avss 0
C1000 avss.n562 avss 0
C1001 avss.n563 avss 0
C1002 avss.n564 avss 0
C1003 avss.n565 avss 0
C1004 avss.n566 avss 0
C1005 avss.n567 avss 0.15056f
C1006 avss.n568 avss 0.16065f
C1007 avss.n569 avss 0.00413f
C1008 avss.n570 avss 0.00159f
C1009 avss.n571 avss 0.00206f
C1010 avss.n572 avss 0.00206f
C1011 avss.n573 avss 0.00291f
C1012 avss.n574 avss 0
C1013 avss.n575 avss 0
C1014 avss.n576 avss 0
C1015 avss.n577 avss 0
C1016 avss.n578 avss 0
C1017 avss.n579 avss 0
C1018 avss.n580 avss 0
C1019 avss.n581 avss 0
C1020 avss.n582 avss 0
C1021 avss.n583 avss 0.00293f
C1022 avss.n584 avss 0.00368f
C1023 avss.n585 avss 0.00398f
C1024 avss.n586 avss 0
C1025 avss.n587 avss 0
C1026 avss.n588 avss 0
C1027 avss.n589 avss 0
C1028 avss.n590 avss 0
C1029 avss.n591 avss 0
C1030 avss.n592 avss 0.00146f
C1031 avss.n593 avss 0.00238f
C1032 avss.n594 avss 0
C1033 avss.n595 avss 0
C1034 avss.n596 avss 0
C1035 avss.n597 avss 0
C1036 avss.n598 avss 0
C1037 avss.n599 avss 0
C1038 avss.n600 avss 0
C1039 avss.n601 avss 0
C1040 avss.n602 avss 0.00199f
C1041 avss.n603 avss 0
C1042 avss.n604 avss 0
C1043 avss.n605 avss 0
C1044 avss.n606 avss 0
C1045 avss.n607 avss 0
C1046 avss.n608 avss 0
C1047 avss.n609 avss 0
C1048 avss.n610 avss 0
C1049 avss.n611 avss 0
C1050 avss.n612 avss 0
C1051 avss.n613 avss 0
C1052 avss.n614 avss 0
C1053 avss.n615 avss 0
C1054 avss.n616 avss 0
C1055 avss.n617 avss 0
C1056 avss.n618 avss 0
C1057 avss.n619 avss 0
C1058 avss.n620 avss 0
C1059 avss.n621 avss 0
C1060 avss.n622 avss 0
C1061 avss.n623 avss 0
C1062 avss.n624 avss 0
C1063 avss.n625 avss 0.00146f
C1064 avss.n626 avss 0.00164f
C1065 avss.n627 avss 0
C1066 avss.n628 avss 0
C1067 avss.n629 avss 0
C1068 avss.n630 avss 0
C1069 avss.n631 avss 0
C1070 avss.n632 avss 0
C1071 avss.n633 avss 0
C1072 avss.n634 avss 0
C1073 avss.n635 avss 0
C1074 avss.n636 avss 0
C1075 avss.n637 avss 0.00275f
C1076 avss.n638 avss 0.00206f
C1077 avss.n639 avss 0.00162f
C1078 avss.n640 avss 0.00277f
C1079 avss.n641 avss 0
C1080 avss.n642 avss 0
C1081 avss.n643 avss 0
C1082 avss.n644 avss 0
C1083 avss.n645 avss 0
C1084 avss.n646 avss 0.00237f
C1085 avss.n647 avss 0.00146f
C1086 avss.n648 avss 0
C1087 avss.n649 avss 0
C1088 avss.n650 avss 0
C1089 avss.n651 avss 0
C1090 avss.n652 avss 0
C1091 avss.n653 avss 0
C1092 avss.n654 avss 0
C1093 avss.n655 avss 0
C1094 avss.n656 avss 0
C1095 avss.n657 avss 0.00146f
C1096 avss.n658 avss 0
C1097 avss.n659 avss 0
C1098 avss.n660 avss 0
C1099 avss.n661 avss 0
C1100 avss.n662 avss 0
C1101 avss.n663 avss 0
C1102 avss.n664 avss 0
C1103 avss.n665 avss 0.04633f
C1104 avss.n666 avss 0.00252f
C1105 avss.n667 avss 0
C1106 avss.n668 avss 0
C1107 avss.n669 avss 0
C1108 avss.n670 avss 0
C1109 avss.n671 avss 0.00142f
C1110 avss.n672 avss 0.07341f
C1111 nvpost.n0 avss 0.03497f
C1112 nvpre.n0 avss 0.03103f
C1113 vpost.n0 avss 0.02706f
C1114 vpre.n0 avss 0.02396f
C1115 vb_idep.n0 avss 0.13075f
C1116 vb_itd.n0 avss 0.02916f
C1117 vb_itd.n1 avss 0.02916f
C1118 vb_itd.n2 avss 0.02916f
C1119 vb_itd.n3 avss 0.06773f
C1120 vb_itd.n4 avss 0.16634f
C1121 vb_itd.n5 avss 0.1068f
C1122 vb_itd.n6 avss 0.11559f
C1123 vb_itd.n7 avss 0.03931f
C1124 vb_itd.n8 avss 0.12604f
C1125 vb_itp.n0 avss 0.04258f
C1126 vb_pot.n0 avss 0.04018f
C1127 vw.n1 avss 0.00812f
C1128 vw.n2 avss 0.01319f
C1129 vw.n3 avss 0.00812f
C1130 vw.n5 avss 0.00812f
C1131 vw.n6 avss 0.00812f
C1132 vw.n7 avss 0.01319f
C1133 vw.n10 avss 0.02337f
C1134 vw.n12 avss 0.02337f
C1135 vw.n13 avss 0.00812f
C1136 vw.n16 avss 0.01319f
C1137 vw.n19 avss 0.00812f
C1138 vw.n20 avss 0.01319f
C1139 vw.n21 avss 0.00812f
C1140 vw.n23 avss 0.00812f
C1141 vw.n24 avss 0.00812f
C1142 vw.n25 avss 0.01319f
C1143 vw.n28 avss 0.02337f
C1144 vw.n30 avss 0.02337f
C1145 vw.n31 avss 0.00812f
C1146 vw.n34 avss 0.01319f
C1147 vw.n37 avss 0.00812f
C1148 vw.n38 avss 0.01319f
C1149 vw.n39 avss 0.00812f
C1150 vw.n41 avss 0.00812f
C1151 vw.n42 avss 0.00812f
C1152 vw.n43 avss 0.01319f
C1153 vw.n46 avss 0.02337f
C1154 vw.n48 avss 0.02337f
C1155 vw.n49 avss 0.00812f
C1156 vw.n52 avss 0.01319f
C1157 vw.n55 avss 0.00812f
C1158 vw.n56 avss 0.01319f
C1159 vw.n57 avss 0.00812f
C1160 vw.n59 avss 0.00812f
C1161 vw.n60 avss 0.00812f
C1162 vw.n61 avss 0.01319f
C1163 vw.n64 avss 0.02337f
C1164 vw.n66 avss 0.02337f
C1165 vw.n67 avss 0.00812f
C1166 vw.n70 avss 0.01319f
C1167 vw.n73 avss 0.00812f
C1168 vw.n74 avss 0.01319f
C1169 vw.n75 avss 0.00812f
C1170 vw.n77 avss 0.00812f
C1171 vw.n78 avss 0.00812f
C1172 vw.n79 avss 0.01319f
C1173 vw.n82 avss 0.02337f
C1174 vw.n84 avss 0.02337f
C1175 vw.n85 avss 0.00812f
C1176 vw.n88 avss 0.01319f
C1177 vw.n93 avss 0.02337f
C1178 vw.n95 avss 0.00812f
C1179 vw.n96 avss 0.06719f
C1180 vw.n97 avss 0.01319f
C1181 vw.n98 avss 0.07304f
C1182 vw.n102 avss 0.02337f
C1183 vw.n104 avss 0.00812f
C1184 vw.n105 avss 0.07304f
C1185 vw.n106 avss 0.01319f
C1186 vw.n107 avss 0.07304f
C1187 vw.n111 avss 0.02337f
C1188 vw.n113 avss 0.00812f
C1189 vw.n114 avss 0.07304f
C1190 vw.n115 avss 0.01319f
C1191 vw.n116 avss 0.07304f
C1192 vw.n120 avss 0.02337f
C1193 vw.n122 avss 0.00812f
C1194 vw.n123 avss 0.07304f
C1195 vw.n124 avss 0.01319f
C1196 vw.n125 avss 0.07304f
C1197 vw.n129 avss 0.02337f
C1198 vw.n131 avss 0.00812f
C1199 vw.n132 avss 0.07304f
C1200 vw.n133 avss 0.01319f
C1201 vw.n134 avss 0.12561f
C1202 vw.n135 avss 0.05841f
C1203 vw.n136 avss 0.1108f
C1204 xm7_0/a_63_n131# avss -1.06447f
C1205 xm8_0/a_63_n131# avss -0.88553f
C1206 xmcm_chain_4_0/a_1000_n131# avss -0.23314f
C1207 avdd avss -12.27922f
C1208 xm1_0/a_63_n131# avss -1.21314f
C1209 xm1_0/a_n63_n339# avss -4.63463f
C1210 vb_itd avss -1.44081f
C1211 xmcm_chain_1_0/a_1000_n131# avss 1.3018f
C1212 vb_idep avss -0.06813f
C1213 vw avss -3.32932f
C1214 vb_itp avss -0.11252f
C1215 xm9_0/a_63_n131# avss -4.81086f
C1216 xmcm_chain_2_0/a_1000_n131# avss -0.24777f
C1217 xm4_0/a_63_n131# avss 0.08061f
C1218 xmcm_chain_3_0/a_1000_n131# avss -0.26765f
.ends
