* NGSPICE file created from stdp.ext - technology: gf180mcuD

.subckt Unnamed_ea219f78 a_n393_n504# a_n63_n339# a_n183_n131#
X0 a_63_n131# a_n63_n339# a_n183_n131# a_n393_n504# nfet_03v3 ad=0.3p pd=2.2u as=0.3p ps=2.2u w=0.5u l=0.63u
.ends

.subckt Unnamed_9da4e0e1 a_63_n131# a_n393_n504# a_n63_n339# a_n183_n131#
X0 a_63_n131# a_n63_n339# a_n183_n131# a_n393_n504# nfet_03v3 ad=0.3p pd=2.2u as=0.3p ps=2.2u w=0.5u l=0.63u
.ends

.subckt Unnamed_995e29e7 a_n1120_n131# a_n1330_n504# a_n1000_n339#
X0 a_1000_n131# a_n1000_n339# a_n1120_n131# a_n1330_n504# nfet_03v3 ad=0.3p pd=2.2u as=0.3p ps=2.2u w=0.5u l=10u
.ends

.subckt Unnamed_cd9eb179 a_63_n131# a_n63_n339# a_n183_n131#
X0 a_63_n131# a_n63_n339# a_n183_n131# w_n449_n560# pfet_03v3 ad=0.3p pd=2.2u as=0.3p ps=2.2u w=0.5u l=0.63u
.ends

.subckt Unnamed_cdc668ac a_n1120_n131# a_n1330_n504# a_1000_n131# a_n1000_n339#
X0 a_1000_n131# a_n1000_n339# a_n1120_n131# a_n1330_n504# nfet_03v3 ad=0.3p pd=2.2u as=0.3p ps=2.2u w=0.5u l=10u
.ends

.subckt Unnamed_2047113f a_n280_n350# a_n400_n141# a_280_n141# a_n610_n515#
X0 a_280_n141# a_n280_n350# a_n400_n141# a_n610_n515# nfet_03v3 ad=0.366p pd=2.42u as=0.366p ps=2.42u w=0.61u l=2.8u
.ends

.subckt Unnamed_43b1223c a_n1120_n131# a_n1330_n504# a_1000_n131# a_n1000_n339#
X0 a_1000_n131# a_n1000_n339# a_n1120_n131# a_n1330_n504# nfet_03v3 ad=0.3p pd=2.2u as=0.3p ps=2.2u w=0.5u l=10u
.ends

.subckt Unnamed_4023e7f9 a_n1120_n131# a_n1330_n504# a_1000_n131# a_n1000_n339#
X0 a_1000_n131# a_n1000_n339# a_n1120_n131# a_n1330_n504# nfet_03v3 ad=0.3p pd=2.2u as=0.3p ps=2.2u w=0.5u l=10u
.ends

.subckt Unnamed_bad5f5e8 a_63_n131# a_n393_n504# a_n63_n339# a_n183_n131#
X0 a_63_n131# a_n63_n339# a_n183_n131# a_n393_n504# nfet_03v3 ad=0.3p pd=2.2u as=0.3p ps=2.2u w=0.5u l=0.63u
.ends

.subckt Unnamed_7d4e236e a_n580_n131# a_460_n131#
X0 a_460_n131# a_n460_n339# a_n580_n131# w_n846_n560# pfet_03v3 ad=0.3p pd=2.2u as=0.3p ps=2.2u w=0.5u l=4.6u
.ends

.subckt Unnamed_4a4441bb a_63_n131# a_n393_n504# a_n63_n339# a_n183_n131#
X0 a_63_n131# a_n63_n339# a_n183_n131# a_n393_n504# nfet_03v3 ad=0.3p pd=2.2u as=0.3p ps=2.2u w=0.5u l=0.63u
.ends

.subckt Unnamed_e8b16a78 a_63_n131# a_n63_n339# a_n183_n131#
X0 a_63_n131# a_n63_n339# a_n183_n131# w_n449_n560# pfet_03v3 ad=0.3p pd=2.2u as=0.3p ps=2.2u w=0.5u l=0.63u
.ends

.subckt Unnamed_26233c3f a_n1120_n131# a_n1330_n504# a_n1000_n339#
X0 a_1000_n131# a_n1000_n339# a_n1120_n131# a_n1330_n504# nfet_03v3 ad=0.3p pd=2.2u as=0.3p ps=2.2u w=0.5u l=10u
.ends

.subckt Unnamed_682a9ae3 a_n183_n131#
X0 a_63_n131# a_n63_n339# a_n183_n131# w_n449_n560# pfet_03v3 ad=0.3p pd=2.2u as=0.3p ps=2.2u w=0.5u l=0.63u
.ends

.subckt Unnamed_3293ba4a a_63_n131# a_n63_n339# w_n449_n560# a_n183_n131#
X0 a_63_n131# a_n63_n339# a_n183_n131# w_n449_n560# pfet_03v3 ad=0.3p pd=2.2u as=0.3p ps=2.2u w=0.5u l=0.63u
.ends

.subckt Unnamed_1db77b85 a_n400_n1101# a_280_n1101#
X0 a_280_n1101# a_n280_n1309# a_n400_n1101# w_n666_n1529# pfet_03v3 ad=6.12p pd=21.6u as=6.12p ps=21.6u w=10.2u l=2.8u
.ends

.subckt stdp
XUnnamed_ea219f78_0 VSUBS Unnamed_ea219f78_0/a_n63_n339# Unnamed_ea219f78_0/a_n183_n131#
+ Unnamed_ea219f78
XUnnamed_9da4e0e1_0 Unnamed_bad5f5e8_0/a_63_n131# VSUBS Unnamed_ea219f78_0/a_n63_n339#
+ VSUBS Unnamed_9da4e0e1
XUnnamed_995e29e7_0 VSUBS VSUBS VSUBS Unnamed_995e29e7
XUnnamed_cd9eb179_0 VSUBS Unnamed_e8b16a78_0/a_n63_n339# Unnamed_e8b16a78_0/a_n183_n131#
+ Unnamed_cd9eb179
XUnnamed_cdc668ac_0 VSUBS VSUBS VSUBS VSUBS Unnamed_cdc668ac
XUnnamed_2047113f_0 Unnamed_ea219f78_0/a_n63_n339# VSUBS Unnamed_3293ba4a_0/a_63_n131#
+ VSUBS Unnamed_2047113f
XUnnamed_43b1223c_0 VSUBS VSUBS VSUBS VSUBS Unnamed_43b1223c
XUnnamed_4023e7f9_0 VSUBS VSUBS VSUBS Unnamed_ea219f78_0/a_n63_n339# Unnamed_4023e7f9
XUnnamed_bad5f5e8_0 Unnamed_bad5f5e8_0/a_63_n131# VSUBS Unnamed_ea219f78_0/a_n63_n339#
+ VSUBS Unnamed_bad5f5e8
XUnnamed_7d4e236e_0 Unnamed_7d4e236e_0/a_n580_n131# Unnamed_bad5f5e8_0/a_63_n131#
+ Unnamed_7d4e236e
XUnnamed_4a4441bb_0 VSUBS VSUBS Unnamed_ea219f78_0/a_n63_n339# Unnamed_ea219f78_0/a_n183_n131#
+ Unnamed_4a4441bb
XUnnamed_e8b16a78_0 VSUBS Unnamed_e8b16a78_0/a_n63_n339# Unnamed_e8b16a78_0/a_n183_n131#
+ Unnamed_e8b16a78
XUnnamed_26233c3f_0 VSUBS VSUBS VSUBS Unnamed_26233c3f
XUnnamed_682a9ae3_0 Unnamed_7d4e236e_0/a_n580_n131# Unnamed_682a9ae3
XUnnamed_3293ba4a_0 Unnamed_3293ba4a_0/a_63_n131# Unnamed_e8b16a78_0/a_n63_n339# Unnamed_3293ba4a_0/a_63_n131#
+ Unnamed_7d4e236e_0/a_n580_n131# Unnamed_3293ba4a
XUnnamed_1db77b85_0 Unnamed_bad5f5e8_0/a_63_n131# Unnamed_bad5f5e8_0/a_63_n131# Unnamed_1db77b85
.ends
