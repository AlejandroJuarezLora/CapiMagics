* NGSPICE file created from opamp.ext - technology: gf180mcuD

.subckt opamp avdd avss vout vin1 vin2
X0 vout.t0 vb avss.t5 avss.t4 nfet_03v3 ad=3.08p pd=14.88u as=3.08p ps=14.88u w=7u l=1u
X1 vout.t4 x avdd.t15 avdd.t14 pfet_03v3 ad=1.248p pd=5.32u as=1.248p ps=5.32u w=4.8u l=1u
X2 p vb avss.t3 avss.t2 nfet_03v3 ad=3.52p pd=16.88u as=3.52p ps=16.88u w=8u l=1u
X3 vb vb avdd.t1 avdd.t0 pfet_03v3 ad=0.44p pd=2.88u as=0.44p ps=2.88u w=1u l=1u
X4 vout.t3 x avdd.t11 avdd.t10 pfet_03v3 ad=1.248p pd=5.32u as=1.248p ps=5.32u w=4.8u l=1u
X5 vout.t7 x avdd.t7 avdd.t6 pfet_03v3 ad=1.248p pd=5.32u as=2.112p ps=10.48u w=4.8u l=1u
X6 y vin1.t0 p avss.t6 nfet_03v3 ad=2.2p pd=10.88u as=2.2p ps=10.88u w=5u l=1u
X7 y y avdd.t3 avdd.t2 pfet_03v3 ad=3.96p pd=18.88u as=3.96p ps=18.88u w=9u l=1u
X8 x y avdd.t5 avdd.t4 pfet_03v3 ad=3.96p pd=18.88u as=3.96p ps=18.88u w=9u l=1u
X9 avdd.t17 x vout.t6 avdd.t16 pfet_03v3 ad=2.112p pd=10.48u as=1.248p ps=5.32u w=4.8u l=1u
X10 avdd.t9 x vout.t5 avdd.t8 pfet_03v3 ad=1.248p pd=5.32u as=1.248p ps=5.32u w=4.8u l=1u
X11 x vout.t1 cap_mim_2f0_m4m5_noshield c_width=30u c_length=30u
X12 avdd.t13 x vout.t2 avdd.t12 pfet_03v3 ad=1.248p pd=5.32u as=1.248p ps=5.32u w=4.8u l=1u
X13 vb vb avss.t1 avss.t0 nfet_03v3 ad=3.52p pd=16.88u as=3.52p ps=16.88u w=8u l=1u
X14 x vin2.t0 p avss.t7 nfet_03v3 ad=2.2p pd=10.88u as=2.2p ps=10.88u w=5u l=1u
R0 vin2 vin2.t0 35.7937
R1 vin1.n0 vin1.t0 35.1876
R2 vin1.n0 vin1 11.5205
R3 vin1.n0 vin1 0.000850195
R4 vout.n5 vout.t0 8.06781
R5 vout.n6 vout.t1 6.81147
R6 vout.n2 vout.n0 6.29972
R7 vout.n2 vout.n1 5.54195
R8 vout.n4 vout.n3 5.54026
R9 vout.n6 vout.n5 2.47679
R10 vout vout.n6 1.30445
R11 vout.n5 vout.n4 1.08762
R12 vout.n4 vout.n2 0.756708
R13 vout.n3 vout.t6 0.379667
R14 vout.n3 vout.t4 0.379667
R15 vout.n1 vout.t2 0.379667
R16 vout.n1 vout.t3 0.379667
R17 vout.n0 vout.t5 0.379667
R18 vout.n0 vout.t7 0.379667
R19 avdd.n34 avdd.n11 588.864
R20 avdd.n30 avdd.n29 143.851
R21 avdd.t8 avdd.t6 142.056
R22 avdd.n28 avdd.t14 142.029
R23 avdd.n33 avdd.n9 139.476
R24 avdd.n33 avdd.n10 139.476
R25 avdd.n37 avdd.n9 139.476
R26 avdd.n37 avdd.n10 139.476
R27 avdd.n29 avdd.n28 135.829
R28 avdd.t6 avdd.n11 135.514
R29 avdd.n37 avdd.t2 130.931
R30 avdd.n36 avdd.t4 130.631
R31 avdd.t2 avdd.n36 130.631
R32 avdd.t4 avdd.n34 127.928
R33 avdd.n35 avdd.n9 88.7255
R34 avdd.n35 avdd.n10 88.7255
R35 avdd.n15 avdd.t8 84.5799
R36 avdd.t10 avdd.t0 78.0379
R37 avdd.n27 avdd.t12 71.4958
R38 avdd.t14 avdd.n27 70.5613
R39 avdd.t0 avdd.t12 64.0192
R40 avdd.n15 avdd.t10 57.4771
R41 avdd.n26 avdd.n16 44.1005
R42 avdd.n20 avdd.n19 5.676
R43 avdd.n18 avdd.n17 5.67
R44 avdd.n21 avdd.n20 5.06342
R45 avdd.n18 avdd.n12 5.01927
R46 avdd.n14 avdd.n13 4.64451
R47 avdd.n41 avdd.n6 4.5005
R48 avdd.n43 avdd.n42 4.5005
R49 avdd.n44 avdd.n5 4.5005
R50 avdd.n46 avdd.n45 4.5005
R51 avdd.n47 avdd.n4 4.5005
R52 avdd.n49 avdd.n48 4.5005
R53 avdd.n50 avdd.n3 4.5005
R54 avdd.n52 avdd.n51 4.5005
R55 avdd.n53 avdd.n1 4.5005
R56 avdd.n55 avdd.n54 4.5005
R57 avdd.n24 avdd.t1 4.42371
R58 avdd.n22 avdd.n21 2.18091
R59 avdd.n26 avdd.n25 1.57606
R60 avdd.n27 avdd.n26 1.5755
R61 avdd.n23 avdd.n16 1.5755
R62 avdd.n16 avdd.n15 1.5755
R63 avdd.n38 avdd.n8 1.3812
R64 avdd.n13 avdd.n8 1.34943
R65 avdd.n31 avdd.t7 0.899667
R66 avdd.n14 avdd.t17 0.899667
R67 avdd.n8 avdd.n7 0.698312
R68 avdd.n40 avdd.n7 0.687915
R69 avdd.n39 avdd.n6 0.576402
R70 avdd.n29 avdd.n14 0.5255
R71 avdd.n31 avdd.n30 0.5255
R72 avdd.n30 avdd.n11 0.5255
R73 avdd.n20 avdd.n18 0.510783
R74 avdd.n38 avdd.t3 0.476406
R75 avdd.n7 avdd.t5 0.476406
R76 avdd.n56 avdd.n0 0.46055
R77 avdd.n17 avdd.t11 0.379667
R78 avdd.n17 avdd.t9 0.379667
R79 avdd.n19 avdd.t15 0.379667
R80 avdd.n19 avdd.t13 0.379667
R81 avdd avdd.n56 0.377457
R82 avdd.n38 avdd.n37 0.3005
R83 avdd.n35 avdd.n7 0.3005
R84 avdd.n36 avdd.n35 0.3005
R85 avdd.n33 avdd.n32 0.3005
R86 avdd.n34 avdd.n33 0.3005
R87 avdd.n39 avdd.n38 0.297132
R88 avdd.n21 avdd.n14 0.175763
R89 avdd.n25 avdd.n24 0.160783
R90 avdd.n12 avdd.n2 0.111879
R91 avdd.n31 avdd.n13 0.0970753
R92 avdd.n22 avdd.n0 0.0707306
R93 avdd.n23 avdd.n2 0.064875
R94 avdd.n32 avdd.n31 0.0621438
R95 avdd.n56 avdd.n55 0.0482
R96 avdd.n55 avdd.n1 0.0482
R97 avdd.n51 avdd.n1 0.0482
R98 avdd.n51 avdd.n50 0.0482
R99 avdd.n50 avdd.n49 0.0482
R100 avdd.n49 avdd.n4 0.0482
R101 avdd.n45 avdd.n4 0.0482
R102 avdd.n45 avdd.n44 0.0482
R103 avdd.n44 avdd.n43 0.0482
R104 avdd.n43 avdd.n6 0.0482
R105 avdd.n25 avdd.n22 0.0450526
R106 avdd.n28 avdd.t16 0.0265386
R107 avdd.n40 avdd.n39 0.0248852
R108 avdd.n2 avdd.n0 0.0229347
R109 avdd.n32 avdd.n12 0.0144726
R110 avdd.n54 avdd.n53 0.00591123
R111 avdd.n53 avdd.n52 0.00591123
R112 avdd.n52 avdd.n3 0.00591123
R113 avdd.n48 avdd.n3 0.00591123
R114 avdd.n48 avdd.n47 0.00591123
R115 avdd.n47 avdd.n46 0.00591123
R116 avdd.n46 avdd.n5 0.00591123
R117 avdd.n42 avdd.n5 0.00591123
R118 avdd.n42 avdd.n41 0.00591123
R119 avdd.n54 avdd.n2 0.00427765
R120 avdd.n41 avdd.n40 0.00386926
R121 avdd.n24 avdd.n23 0.003375
R122 avss.n46 avss.n45 16902.5
R123 avss.n30 avss.t6 239.214
R124 avss.t6 avss.n8 239.214
R125 avss.n47 avss.t2 239.214
R126 avss.t2 avss.n46 239.214
R127 avss.n45 avss.t0 232.143
R128 avss.n25 avss.t0 232.143
R129 avss.n39 avss.t4 232.143
R130 avss.t4 avss.n38 232.143
R131 avss.n37 avss.t7 232.143
R132 avss.n29 avss.t7 232.143
R133 avss.n47 avss.n8 167.45
R134 avss.n30 avss.n29 152.452
R135 avss.n39 avss.n25 137.685
R136 avss.n38 avss.n37 126.478
R137 avss.n48 avss.n7 117.056
R138 avss.n44 avss.n9 117.056
R139 avss.n40 avss.n24 107.334
R140 avss.n36 avss.n26 87.8894
R141 avss.n31 avss.n28 87.8894
R142 avss.n35 avss.n5 9.84474
R143 avss.n50 avss.n49 6.85664
R144 avss.n32 avss.n5 6.523
R145 avss.n43 avss.n42 6.50754
R146 avss.n42 avss.n41 4.61157
R147 avss.n52 avss.n3 4.5005
R148 avss.n54 avss.n53 4.5005
R149 avss.n55 avss.n2 4.5005
R150 avss.n57 avss.n56 4.5005
R151 avss.n58 avss.n1 4.5005
R152 avss.n16 avss.n0 4.5005
R153 avss.n18 avss.n17 4.5005
R154 avss.n19 avss.n15 4.5005
R155 avss.n21 avss.n20 4.5005
R156 avss.n41 avss.n12 3.98593
R157 avss.n50 avss.n5 3.9205
R158 avss.n35 avss.n34 2.27861
R159 avss.n44 avss.n43 1.95665
R160 avss.n43 avss.n10 1.55325
R161 avss.n27 avss.n4 1.30509
R162 avss.n34 avss.n27 1.04528
R163 avss.n13 avss.t5 0.6545
R164 avss.n4 avss.t3 0.575838
R165 avss.n10 avss.t1 0.575838
R166 avss.n23 avss.n22 0.518978
R167 avss.n52 avss.n51 0.499229
R168 avss.n20 avss.n11 0.483818
R169 avss.n32 avss.n31 0.433833
R170 avss.n31 avss.n30 0.433833
R171 avss.n36 avss.n35 0.433833
R172 avss.n37 avss.n36 0.433833
R173 avss.n33 avss.n26 0.433833
R174 avss.n29 avss.n26 0.433833
R175 avss.n28 avss.n6 0.433833
R176 avss.n28 avss.n8 0.433833
R177 avss.n23 avss.n12 0.385935
R178 avss avss.n58 0.377457
R179 avss.n51 avss.n4 0.331941
R180 avss.n41 avss.n40 0.3255
R181 avss.n40 avss.n39 0.3255
R182 avss.n24 avss.n23 0.3255
R183 avss.n38 avss.n24 0.3255
R184 avss.n14 avss.n13 0.299848
R185 avss.n45 avss.n44 0.274184
R186 avss.n10 avss.n9 0.274184
R187 avss.n25 avss.n9 0.274184
R188 avss.n49 avss.n48 0.274184
R189 avss.n48 avss.n47 0.274184
R190 avss.n7 avss.n4 0.274184
R191 avss.n46 avss.n7 0.274184
R192 avss.n27 avss.n6 0.23544
R193 avss.n34 avss.n33 0.231214
R194 avss.n13 avss.n12 0.128978
R195 avss.n49 avss.n6 0.100982
R196 avss.n20 avss.n19 0.0482
R197 avss.n19 avss.n18 0.0482
R198 avss.n18 avss.n0 0.0482
R199 avss.n58 avss.n0 0.0482
R200 avss.n58 avss.n57 0.0482
R201 avss.n57 avss.n2 0.0482
R202 avss.n53 avss.n2 0.0482
R203 avss.n53 avss.n52 0.0482
R204 avss.n14 avss.n11 0.0472313
R205 avss.n42 avss.n11 0.0345168
R206 avss.n51 avss.n50 0.0308683
R207 avss.n21 avss.n15 0.00583557
R208 avss.n17 avss.n15 0.00583557
R209 avss.n17 avss.n16 0.00583557
R210 avss.n16 avss.n1 0.00583557
R211 avss.n56 avss.n1 0.00583557
R212 avss.n56 avss.n55 0.00583557
R213 avss.n55 avss.n54 0.00583557
R214 avss.n54 avss.n3 0.00583557
R215 avss.n22 avss.n21 0.0034698
R216 avss.n33 avss.n32 0.00192857
R217 avss.n50 avss.n3 0.00180872
R218 avss.n22 avss.n14 0.00165772
C0 vout x 4.52587f
C1 y x 1.02096f
C2 x vb 2.15812f
C3 vout vin1 0.134f
C4 y vin1 0.15421f
C5 vout vin2 0.07093f
C6 y vin2 0.04491f
C7 vb vin1 0.55045f
C8 vb vin2 0.17713f
C9 avdd p 0.00932f
C10 x p 0.5526f
C11 vout y 0.00208f
C12 vout vb 0.25748f
C13 y vb 0.25752f
C14 vin1 p 0.17866f
C15 vin2 p 0.71865f
C16 avdd x 13.4419f
C17 avdd vin1 0.00529f
C18 avdd vin2 0.00576f
C19 x vin1 0.83879f
C20 x vin2 1.03302f
C21 vout p 0.00175f
C22 y p 0.27676f
C23 vb p 0.86143f
C24 vin2 vin1 0.13384f
C25 vout avdd 4.12387f
C26 y avdd 3.74242f
C27 avdd vb 3.42289f
C28 vin2 avss 4.08544f
C29 vin1 avss 2.8425f
C30 vout avss 7.65038f
C31 avdd avss 43.42216f
C32 p avss 2.49056f
C33 vb avss 7.27748f
C34 x avss 10.8197f
C35 y avss 0.95613f
C36 avdd.n0 avss 2.44403f
C37 avdd.n1 avss 0.01606f
C38 avdd.n2 avss 0.75618f
C39 avdd.n3 avss 0.14156f
C40 avdd.n4 avss 0.01606f
C41 avdd.n5 avss 0.14156f
C42 avdd.n6 avss 0.44601f
C43 avdd.t5 avss 0.08407f
C44 avdd.n7 avss 0.2167f
C45 avdd.t3 avss 0.08407f
C46 avdd.n8 avss 0.09126f
C47 avdd.n9 avss 0.11709f
C48 avdd.n10 avss 0.11709f
C49 avdd.n11 avss 0.5954f
C50 avdd.n12 avss 0.14033f
C51 avdd.t7 avss 0.04498f
C52 avdd.n13 avss 0.17111f
C53 avdd.t17 avss 0.04498f
C54 avdd.n14 avss 0.14813f
C55 avdd.t16 avss 0.26747f
C56 avdd.t12 avss 0.23505f
C57 avdd.t0 avss 0.2464f
C58 avdd.t10 avss 0.23505f
C59 avdd.t6 avss 0.47638f
C60 avdd.t8 avss 0.39286f
C61 avdd.n15 avss 0.2464f
C62 avdd.n16 avss 0.0589f
C63 avdd.t11 avss 0.01891f
C64 avdd.t9 avss 0.01891f
C65 avdd.n17 avss 0.06865f
C66 avdd.n18 avss 0.07987f
C67 avdd.t15 avss 0.01891f
C68 avdd.t13 avss 0.01891f
C69 avdd.n19 avss 0.06892f
C70 avdd.n20 avss 0.08273f
C71 avdd.n21 avss 0.05081f
C72 avdd.n22 avss 1.14299f
C73 avdd.t1 avss 0.00947f
C74 avdd.n23 avss 0.14671f
C75 avdd.n24 avss 0.09057f
C76 avdd.n25 avss 0.18058f
C77 avdd.n26 avss 0.05894f
C78 avdd.n27 avss 0.2464f
C79 avdd.t14 avss 0.36937f
C80 avdd.n28 avss 0.21948f
C81 avdd.n29 avss 0.51837f
C82 avdd.n30 avss 0.18325f
C83 avdd.n31 avss 0.14675f
C84 avdd.n32 avss 0.06105f
C85 avdd.n33 avss 0.08836f
C86 avdd.n34 avss 0.32156f
C87 avdd.t4 avss 0.48263f
C88 avdd.n35 avss 0.0553f
C89 avdd.n36 avss 0.48767f
C90 avdd.t2 avss 0.48847f
C91 avdd.n37 avss 0.43231f
C92 avdd.n38 avss 0.49512f
C93 avdd.n39 avss 1.4218f
C94 avdd.n40 avss 0.48264f
C95 avdd.n41 avss 0.11485f
C96 avdd.n42 avss 0.14156f
C97 avdd.n43 avss 0.01606f
C98 avdd.n44 avss 0.01606f
C99 avdd.n45 avss 0.01606f
C100 avdd.n46 avss 0.14156f
C101 avdd.n47 avss 0.14156f
C102 avdd.n48 avss 0.14156f
C103 avdd.n49 avss 0.01606f
C104 avdd.n50 avss 0.01606f
C105 avdd.n51 avss 0.01606f
C106 avdd.n52 avss 0.14156f
C107 avdd.n53 avss 0.14156f
C108 avdd.n54 avss 0.12019f
C109 avdd.n55 avss 0.01606f
C110 avdd.n56 avss 3.6247f
C111 vout.t5 avss 0.04654f
C112 vout.t7 avss 0.04654f
C113 vout.n0 avss 0.15645f
C114 vout.t2 avss 0.04654f
C115 vout.t3 avss 0.04654f
C116 vout.n1 avss 0.15072f
C117 vout.n2 avss 0.1396f
C118 vout.t6 avss 0.04654f
C119 vout.t4 avss 0.04654f
C120 vout.n3 avss 0.15158f
C121 vout.n4 avss 0.10877f
C122 vout.t0 avss 0.34768f
C123 vout.n5 avss 0.38537f
C124 vout.t1 avss 6.25935f
C125 vout.n6 avss 1.0004f
C126 vin1.t0 avss 0.62792f
C127 vin1.n0 avss 1.36748f
C128 vin2.t0 avss 0.72651f
.ends
