* NGSPICE file created from layer_input.ext - technology: gf180mcuD

* Black-box entry subcircuit for neurona_lvs abstract view
.subckt neurona_lvs vss vdd spike spike_neg Iin
.ends

.subckt layer_input Iext1 Iext2 Iext3 Iext4 VDD VSS nvout_1 nvout_2 nvout_3 nvout_4
+ vdd vout_1 vout_2 vout_3 vout_4 vss
Xx1 vss vdd vout_1 nvout_1 Iext1 neurona_lvs
Xx2 vss vdd vout_2 nvout_2 Iext2 neurona_lvs
Xx3 vss vdd vout_3 nvout_3 Iext3 neurona_lvs
Xx4 vss vdd vout_4 nvout_4 Iext4 neurona_lvs
.ends
