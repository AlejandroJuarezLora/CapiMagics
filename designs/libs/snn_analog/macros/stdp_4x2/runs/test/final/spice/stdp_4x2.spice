* NGSPICE file created from stdp_4x2.ext - technology: gf180mcuD

* Black-box entry subcircuit for gf180mcu_fd_sc_mcu7t5v0__antenna abstract view
.subckt gf180mcu_fd_sc_mcu7t5v0__antenna I VDD VNW VPW VSS
.ends

* Black-box entry subcircuit for stdp abstract view
.subckt stdp avdd avss nvpost nvpre vpost vpre vb_idep vb_itd vb_itp vb_pot vw Iout
.ends

* Black-box entry subcircuit for Current_limit abstract view
.subckt Current_limit i_SUM ifwd avdd avss
.ends

.subckt stdp_4x2 A B avdd avss ifwd1 ifwd2 nvpost1 nvpost2 nvpre1 nvpre2 nvpre3 nvpre4
+ vpost1 vpost2 vpre1 vpre2 vpre3 vpre4 vw11 vw42
XANTENNA_5 vpre1 ANTENNA_5/VDD ANTENNA_5/VNW avss ANTENNA_5/VSS gf180mcu_fd_sc_mcu7t5v0__antenna
XANTENNA_6 vpre4 ANTENNA_6/VDD ANTENNA_6/VNW avss ANTENNA_6/VSS gf180mcu_fd_sc_mcu7t5v0__antenna
Xx1 x1/avdd avss nvpost1 nvpre1 vpost1 vpre1 B A B A vw11 x4/Iout stdp
XANTENNA_7 vpre4 ANTENNA_7/VDD ANTENNA_7/VNW avss ANTENNA_7/VSS gf180mcu_fd_sc_mcu7t5v0__antenna
Xx2 x2/avdd avss nvpost1 nvpre2 vpost1 vpre2 B A B A x2/vw x4/Iout stdp
Xx3 x3/avdd avss nvpost1 nvpre3 vpost1 vpre3 B A B A x3/vw x4/Iout stdp
XANTENNA_8 nvpre1 ANTENNA_8/VDD ANTENNA_8/VNW avss ANTENNA_8/VSS gf180mcu_fd_sc_mcu7t5v0__antenna
Xx4 x4/avdd avss nvpost1 nvpre4 vpost1 vpre4 B A B A x4/vw x4/Iout stdp
XANTENNA_9 nvpre1 ANTENNA_9/VDD ANTENNA_9/VNW avss ANTENNA_9/VSS gf180mcu_fd_sc_mcu7t5v0__antenna
Xx5 avdd avss nvpost2 nvpre1 vpost2 vpre1 B A B A x5/vw x8/Iout stdp
Xx6 avdd avss nvpost2 nvpre2 vpost2 vpre2 B A B A x6/vw x8/Iout stdp
Xx7 avdd avss nvpost2 nvpre3 vpost2 vpre3 B A B A x7/vw x8/Iout stdp
Xx8 avdd avss nvpost2 nvpre4 vpost2 vpre4 B A B A vw42 x8/Iout stdp
Xx9 x4/Iout ifwd1 x9/avdd avss Current_limit
XANTENNA_10 nvpre2 ANTENNA_10/VDD ANTENNA_10/VNW avss ANTENNA_10/VSS gf180mcu_fd_sc_mcu7t5v0__antenna
XANTENNA_11 nvpre3 ANTENNA_11/VDD ANTENNA_11/VNW avss ANTENNA_11/VSS gf180mcu_fd_sc_mcu7t5v0__antenna
Xx10 x8/Iout ifwd2 x10/avdd avss Current_limit
XANTENNA_1 nvpre1 ANTENNA_1/VDD ANTENNA_1/VNW avss ANTENNA_1/VSS gf180mcu_fd_sc_mcu7t5v0__antenna
XANTENNA_2 nvpre2 ANTENNA_2/VDD ANTENNA_2/VNW avss ANTENNA_2/VSS gf180mcu_fd_sc_mcu7t5v0__antenna
XANTENNA_3 nvpre4 ANTENNA_3/VDD ANTENNA_3/VNW avss ANTENNA_3/VSS gf180mcu_fd_sc_mcu7t5v0__antenna
XANTENNA_4 vpre1 ANTENNA_4/VDD ANTENNA_4/VNW avss ANTENNA_4/VSS gf180mcu_fd_sc_mcu7t5v0__antenna
.ends
