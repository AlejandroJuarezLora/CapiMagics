* NGSPICE file created from layer_output.ext - technology: gf180mcuD

* Black-box entry subcircuit for neurona_lvs abstract view
.subckt neurona_lvs vss vdd Iin spike_neg spike
.ends

.subckt layer_output Iext1 Iext2 nvout_1 nvout_2 vdd vout_1 vout_2 vss
Xx1 vss vdd Iext1 nvout_1 vout_1 neurona_lvs
Xx2 vss vdd Iext2 nvout_2 vout_2 neurona_lvs
.ends
