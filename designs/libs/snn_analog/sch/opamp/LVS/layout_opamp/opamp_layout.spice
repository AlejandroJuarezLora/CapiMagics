* NGSPICE file created from opamp.ext - technology: gf180mcuD

.subckt opamp avdd avss vin1 vin2 vout
X0 x vin2 p avss nfet_03v3 ad=2.2p pd=10.88u as=2.2p ps=10.88u w=5u l=1u
X1 y y avdd avdd pfet_03v3 ad=3.96p pd=18.88u as=3.96p ps=18.88u w=9u l=1u
X2 vb vb avdd avdd pfet_03v3 ad=0.44p pd=2.88u as=0.44p ps=2.88u w=1u l=1u
X3 vout x avdd avdd pfet_03v3 ad=1.248p pd=5.32u as=1.248p ps=5.32u w=4.8u l=1u
X4 x vout cap_mim_2f0_m4m5_noshield c_width=30u c_length=30u
X5 vout x avdd avdd pfet_03v3 ad=1.248p pd=5.32u as=2.112p ps=10.48u w=4.8u l=1u
X6 avdd x vout avdd pfet_03v3 ad=1.248p pd=5.32u as=1.248p ps=5.32u w=4.8u l=1u
X7 vout vb avss avss nfet_03v3 ad=3.08p pd=14.88u as=3.08p ps=14.88u w=7u l=1u
X8 avdd x vout avdd pfet_03v3 ad=2.112p pd=10.48u as=1.248p ps=5.32u w=4.8u l=1u
X9 p vb avss avss nfet_03v3 ad=3.52p pd=16.88u as=3.52p ps=16.88u w=8u l=1u
X10 avdd x vout avdd pfet_03v3 ad=1.248p pd=5.32u as=1.248p ps=5.32u w=4.8u l=1u
X11 y vin1 p avss nfet_03v3 ad=2.2p pd=10.88u as=2.2p ps=10.88u w=5u l=1u
X12 vb vb avss avss nfet_03v3 ad=3.52p pd=16.88u as=3.52p ps=16.88u w=8u l=1u
X13 x y avdd avdd pfet_03v3 ad=3.96p pd=18.88u as=3.96p ps=18.88u w=9u l=1u
X14 vout x avdd avdd pfet_03v3 ad=1.248p pd=5.32u as=1.248p ps=5.32u w=4.8u l=1u
.ends
