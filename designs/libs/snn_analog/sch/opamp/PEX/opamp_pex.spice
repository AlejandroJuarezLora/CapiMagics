* NGSPICE file created from opamp.ext - technology: gf180mcuD

.subckt opamp_pex avdd vin1 vin2 vout avss
X0 x vin2.t0 p avss.t1 nfet_03v3 ad=2.2p pd=10.88u as=2.2p ps=10.88u w=5u l=1u
X1 y y avdd.t15 avdd.t14 pfet_03v3 ad=3.96p pd=18.88u as=3.96p ps=18.88u w=9u l=1u
X2 vb vb avdd.t17 avdd.t16 pfet_03v3 ad=0.44p pd=2.88u as=0.44p ps=2.88u w=1u l=1u
X3 vout.t2 x avdd.t5 avdd.t4 pfet_03v3 ad=1.248p pd=5.32u as=1.248p ps=5.32u w=4.8u l=1u
X4 x vout.t0 cap_mim_2f0_m4m5_noshield c_width=30u c_length=30u
X5 vout.t6 x avdd.t1 avdd.t0 pfet_03v3 ad=1.248p pd=5.32u as=2.112p ps=10.48u w=4.8u l=1u
X6 avdd.t7 x vout.t5 avdd.t6 pfet_03v3 ad=1.248p pd=5.32u as=1.248p ps=5.32u w=4.8u l=1u
X7 vout.t7 vb avss.t5 avss.t4 nfet_03v3 ad=3.08p pd=14.88u as=3.08p ps=14.88u w=7u l=1u
X8 avdd.t11 x vout.t4 avdd.t10 pfet_03v3 ad=2.112p pd=10.48u as=1.248p ps=5.32u w=4.8u l=1u
X9 p vb avss.t3 avss.t2 nfet_03v3 ad=3.52p pd=16.88u as=3.52p ps=16.88u w=8u l=1u
X10 avdd.t3 x vout.t1 avdd.t2 pfet_03v3 ad=1.248p pd=5.32u as=1.248p ps=5.32u w=4.8u l=1u
X11 y vin1.t0 p avss.t0 nfet_03v3 ad=2.2p pd=10.88u as=2.2p ps=10.88u w=5u l=1u
X12 vb vb avss.t7 avss.t6 nfet_03v3 ad=3.52p pd=16.88u as=3.52p ps=16.88u w=8u l=1u
X13 x y avdd.t13 avdd.t12 pfet_03v3 ad=3.96p pd=18.88u as=3.96p ps=18.88u w=9u l=1u
X14 vout.t3 x avdd.t9 avdd.t8 pfet_03v3 ad=1.248p pd=5.32u as=1.248p ps=5.32u w=4.8u l=1u
R0 vin2 vin2.t0 35.2612
R1 vin1 vin1.t0 31.9804
R2 vout.n6 vout.t0 10.9982
R3 vout.n5 vout.t7 8.06781
R4 vout.n2 vout.n0 6.29972
R5 vout.n2 vout.n1 5.54195
R6 vout.n4 vout.n3 5.54026
R7 vout vout.n6 4.54707
R8 vout.n5 vout.n4 1.08762
R9 vout.n4 vout.n2 0.756708
R10 vout.n3 vout.t4 0.379667
R11 vout.n3 vout.t3 0.379667
R12 vout.n1 vout.t5 0.379667
R13 vout.n1 vout.t2 0.379667
R14 vout.n0 vout.t1 0.379667
R15 vout.n0 vout.t6 0.379667
R16 vout.n6 vout.n5 0.373724
R17 avdd.n23 avdd.t16 224.13
R18 avdd.t10 avdd.t8 220.291
R19 avdd.t8 avdd.t6 220.291
R20 avdd.t6 avdd.t4 220.291
R21 avdd.t4 avdd.t2 220.291
R22 avdd.t2 avdd.t0 220.291
R23 avdd.n15 avdd.t10 210.671
R24 avdd.t0 avdd.n14 210.671
R25 avdd.n15 avdd.n14 143.851
R26 avdd.n11 avdd.n6 139.476
R27 avdd.n8 avdd.n6 139.476
R28 avdd.n8 avdd.n7 139.476
R29 avdd.n11 avdd.n7 139.476
R30 avdd.n11 avdd.t12 130.931
R31 avdd.t14 avdd.n8 130.931
R32 avdd.t12 avdd.n10 130.631
R33 avdd.n10 avdd.t14 130.631
R34 avdd.n9 avdd.n6 88.7255
R35 avdd.n9 avdd.n7 88.7255
R36 avdd.n23 avdd.n22 22.6598
R37 avdd.n24 avdd.n23 22.6365
R38 avdd.n20 avdd.n19 5.676
R39 avdd.n18 avdd.n17 5.67
R40 avdd.n21 avdd.n20 5.06342
R41 avdd.n18 avdd.n2 5.01927
R42 avdd.n16 avdd.n5 4.64451
R43 avdd.n3 avdd.t17 4.42371
R44 avdd.n4 avdd.n0 1.3812
R45 avdd.n5 avdd.n4 1.34943
R46 avdd.n16 avdd.t11 0.899667
R47 avdd.n13 avdd.t1 0.899667
R48 avdd.n4 avdd.n1 0.698312
R49 avdd.n26 avdd.n1 0.687915
R50 avdd.n14 avdd.n13 0.5255
R51 avdd.n16 avdd.n15 0.5255
R52 avdd.n20 avdd.n18 0.510783
R53 avdd.n1 avdd.t13 0.476406
R54 avdd.n0 avdd.t15 0.476406
R55 avdd.n17 avdd.t5 0.379667
R56 avdd.n17 avdd.t3 0.379667
R57 avdd.n19 avdd.t9 0.379667
R58 avdd.n19 avdd.t7 0.379667
R59 avdd.n22 avdd.n21 0.349893
R60 avdd.n8 avdd.n0 0.3005
R61 avdd.n12 avdd.n11 0.3005
R62 avdd.n9 avdd.n1 0.3005
R63 avdd.n10 avdd.n9 0.3005
R64 avdd.n27 avdd.n0 0.281807
R65 avdd.n27 avdd.n26 0.19732
R66 avdd.n26 avdd.n25 0.178031
R67 avdd.n21 avdd.n16 0.175763
R68 avdd.n13 avdd.n5 0.0970753
R69 avdd.n22 avdd.n3 0.0836018
R70 avdd.n25 avdd.n24 0.0797
R71 avdd.n25 avdd.n2 0.0635041
R72 avdd.n13 avdd.n12 0.0621438
R73 avdd.n28 avdd 0.04775
R74 avdd.n28 avdd.n27 0.0326639
R75 avdd avdd.n28 0.0314836
R76 avdd.n12 avdd.n2 0.0144726
R77 avdd.n24 avdd.n3 0.00251951
R78 avss.n36 avss.n35 35217
R79 avss.n37 avss.n36 12234.3
R80 avss.n36 avss.n5 9111.28
R81 avss.t0 avss.n4 331.866
R82 avss.n38 avss.t2 331.866
R83 avss.t2 avss.n37 331.866
R84 avss.n34 avss.t0 329.779
R85 avss.t6 avss.n5 318.413
R86 avss.n16 avss.t6 318.413
R87 avss.n15 avss.t4 318.413
R88 avss.n27 avss.t4 318.413
R89 avss.n28 avss.t1 318.413
R90 avss.t1 avss.n6 318.413
R91 avss.n38 avss.n4 232.306
R92 avss.n16 avss.n15 188.851
R93 avss.n35 avss.n6 180.069
R94 avss.n28 avss.n27 173.481
R95 avss.n39 avss.n3 117.056
R96 avss.n18 avss.n17 117.056
R97 avss.n26 avss.n11 107.334
R98 avss.n33 avss.n7 87.8894
R99 avss.n30 avss.n29 87.8894
R100 avss.n35 avss.n34 24.1559
R101 avss.n20 avss.n12 3.98593
R102 avss.n10 avss.n9 2.27861
R103 avss.n21 avss.n20 1.59311
R104 avss.n19 avss.n18 1.44423
R105 avss.n8 avss.n0 1.30509
R106 avss.n22 avss.n10 1.22724
R107 avss.n9 avss.n8 1.04528
R108 avss.n13 avss.t5 0.6545
R109 avss.n25 avss.n24 0.629485
R110 avss.n0 avss.t3 0.575838
R111 avss.n14 avss.t7 0.575838
R112 avss.n42 avss.n41 0.442009
R113 avss.n29 avss.n10 0.433833
R114 avss.n29 avss.n28 0.433833
R115 avss.n31 avss.n30 0.433833
R116 avss.n30 avss.n6 0.433833
R117 avss.n33 avss.n32 0.433833
R118 avss.n34 avss.n33 0.433833
R119 avss.n7 avss.n2 0.433833
R120 avss.n7 avss.n4 0.433833
R121 avss.n23 avss.n21 0.388938
R122 avss.n25 avss.n12 0.385935
R123 avss.n19 avss.n14 0.384251
R124 avss.n20 avss.n11 0.3255
R125 avss.n15 avss.n11 0.3255
R126 avss.n26 avss.n25 0.3255
R127 avss.n27 avss.n26 0.3255
R128 avss.n24 avss.n13 0.299848
R129 avss.n21 avss.n19 0.281692
R130 avss.n18 avss.n5 0.274184
R131 avss.n17 avss.n14 0.274184
R132 avss.n17 avss.n16 0.274184
R133 avss.n40 avss.n39 0.274184
R134 avss.n39 avss.n38 0.274184
R135 avss.n3 avss.n0 0.274184
R136 avss.n37 avss.n3 0.274184
R137 avss.n42 avss.n0 0.244971
R138 avss.n8 avss.n2 0.23544
R139 avss.n31 avss.n9 0.231214
R140 avss.n32 avss.n1 0.223
R141 avss.n41 avss.n40 0.168219
R142 avss.n13 avss.n12 0.128978
R143 avss.n24 avss.n23 0.112715
R144 avss.n40 avss.n2 0.100982
R145 avss.n22 avss.n1 0.0756511
R146 avss avss.n42 0.0707353
R147 avss.n41 avss.n1 0.0594403
R148 avss.n42 avss 0.053566
R149 avss.n23 avss.n22 0.00310705
R150 avss.n32 avss.n31 0.00192857
C0 vb vout 0.275f
C1 y vout 0.00268f
C2 avdd p 0.00762f
C3 vout vin1 0.00671f
C4 avdd vin2 0.06596f
C5 avdd vb 3.14448f
C6 avdd y 3.72333f
C7 p vin2 0.72297f
C8 avdd vin1 0.00529f
C9 vb p 0.85508f
C10 p y 0.27676f
C11 x vout 4.42808f
C12 vb vin2 0.25171f
C13 p vin1 0.21752f
C14 vin2 y 0.05274f
C15 vb y 0.25954f
C16 vin2 vin1 0.17789f
C17 avdd x 10.2746f
C18 vb vin1 0.22915f
C19 y vin1 0.15002f
C20 x p 0.54873f
C21 avdd vout 2.18437f
C22 x vin2 0.96888f
C23 x vb 2.23663f
C24 x y 1.0259f
C25 p vout 0.00175f
C26 x vin1 0.52862f
C27 vin2 vout 0.01104f
C28 vin2 avss 3.51501f
C29 vin1 avss 2.87275f
C30 vout avss 6.65675f
C31 avdd avss 22.20212f
C32 p avss 2.48751f
C33 vb avss 7.76433f
C34 x avss 11.1171f
C35 y avss 0.95585f
C36 avdd.t15 avss 0.16262f
C37 avdd.n0 avss 0.84132f
C38 avdd.t13 avss 0.16262f
C39 avdd.n1 avss 0.41919f
C40 avdd.n2 avss 0.09218f
C41 avdd.t17 avss 0.01832f
C42 avdd.n3 avss 0.36689f
C43 avdd.t11 avss 0.08701f
C44 avdd.n4 avss 0.17654f
C45 avdd.n5 avss 0.331f
C46 avdd.n6 avss 0.22649f
C47 avdd.n7 avss 0.22649f
C48 avdd.n8 avss 0.83627f
C49 avdd.t14 avss 0.94489f
C50 avdd.n9 avss 0.10698f
C51 avdd.n10 avss 0.94336f
C52 avdd.t12 avss 0.94489f
C53 avdd.n11 avss 0.83627f
C54 avdd.n12 avss 0.11809f
C55 avdd.t1 avss 0.08701f
C56 avdd.n13 avss 0.28387f
C57 avdd.n14 avss 0.76799f
C58 avdd.t0 avss 0.6016f
C59 avdd.t2 avss 0.61472f
C60 avdd.t4 avss 0.61472f
C61 avdd.t6 avss 0.61472f
C62 avdd.t8 avss 0.61472f
C63 avdd.t10 avss 0.6016f
C64 avdd.n15 avss 0.76799f
C65 avdd.n16 avss 0.28654f
C66 avdd.t5 avss 0.03657f
C67 avdd.t3 avss 0.03657f
C68 avdd.n17 avss 0.1328f
C69 avdd.n18 avss 0.1545f
C70 avdd.t9 avss 0.03657f
C71 avdd.t7 avss 0.03657f
C72 avdd.n19 avss 0.13332f
C73 avdd.n20 avss 0.16003f
C74 avdd.n21 avss 0.11713f
C75 avdd.n22 avss 1.69707f
C76 avdd.t16 avss 0.26471f
C77 avdd.n23 avss 0.04292f
C78 avdd.n24 avss 0.97336f
C79 avdd.n25 avss 1.05991f
C80 avdd.n26 avss 0.37419f
C81 avdd.n27 avss 0.39735f
C82 avdd.n28 avss 0.0632f
C83 vout.t0 avss 5.24694f
C84 vout.t1 avss 0.04089f
C85 vout.t6 avss 0.04089f
C86 vout.n0 avss 0.13745f
C87 vout.t5 avss 0.04089f
C88 vout.t2 avss 0.04089f
C89 vout.n1 avss 0.13242f
C90 vout.n2 avss 0.12265f
C91 vout.t4 avss 0.04089f
C92 vout.t3 avss 0.04089f
C93 vout.n3 avss 0.13317f
C94 vout.n4 avss 0.09556f
C95 vout.t7 avss 0.30546f
C96 vout.n5 avss 0.24494f
C97 vout.n6 avss 0.1754f
C98 vin1.t0 avss 0.50649f
C99 vin2.t0 avss 0.83524f
.ends
