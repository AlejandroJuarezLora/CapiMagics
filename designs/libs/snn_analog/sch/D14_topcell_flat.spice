* NGSPICE file created from D14_topcell_flat.ext - technology: gf180mcuD

.subckt full_4x2_pex avdd avss Vin Vin_neg vpre1 vpre2 vw11 vw42 vpost1 vpost2
X0 a_35466_63369# current_mirror_0.A a_38698_63369# avss.t135 nfet_03v3 ad=0.3p pd=2.2u as=0.3p ps=2.2u w=0.5u l=10u
X1 a_58428_55960# current_mirror_0.A avss.t145 avss.t144 nfet_03v3 ad=0.366p pd=2.42u as=0.366p ps=2.42u w=0.61u l=2.8u
X2 stdp_4x2_0.stdp_0.vw layer_output_0.nvout_1 a_35712_33960# avdd.t61 pfet_03v3 ad=0.3p pd=2.2u as=0.3p ps=2.2u w=0.5u l=0.63u
X3 stdp_4x2_0.Current_limit_0.i_SUM vw42.t12 avdd.t51 avdd.t50 pfet_03v3 ad=0.3p pd=2.2u as=0.3p ps=2.2u w=0.5u l=15u
X4 avss.t114 avss.t112 avss.t114 avss.t113 nfet_03v3 ad=0.3p pd=2.2u as=0 ps=0 w=0.5u l=5u
X5 a_56944_64741# avss.t108 cap_mim_2f0_m4m5_noshield c_width=5u c_length=5u
X6 a_55466_53749# a_56944_53541# avss.t6 avss.t5 nfet_03v3 ad=0.3p pd=2.2u as=0.3p ps=2.2u w=0.5u l=0.63u
X7 avdd.t169 a_35586_66952# cap_mim_2f0_m4m5_noshield c_width=5u c_length=5u
X8 avdd.t166 a_35586_55752# cap_mim_2f0_m4m5_noshield c_width=5u c_length=5u
X9 a_58302_31541# current_mirror_0.B avdd.t117 avdd.t116 pfet_03v3 ad=6.12p pd=21.6u as=6.12p ps=21.6u w=10.2u l=2.8u
X10 stdp_4x2_0.stdp_6.vw avss.t76 cap_mim_2f0_m4m5_noshield c_width=5u c_length=5u
X11 stdp_4x2_0.stdp_6.vw avss.t76 cap_mim_2f0_m4m5_noshield c_width=5u c_length=5u
X12 layer_input_0.Iext2 a_8786_49529# avss.t204 avss.t7 nfet_03v3 ad=1.38p pd=5.8u as=1.38p ps=5.8u w=2.3u l=50u
X13 a_56944_31541# current_mirror_0.A a_57586_30169# avss.t169 nfet_03v3 ad=0.3p pd=2.2u as=0.3p ps=2.2u w=0.5u l=10u
X14 stdp_4x2_0.stdp_0.vw avss.t70 cap_mim_2f0_m4m5_noshield c_width=5u c_length=5u
X15 a_38302_64741# vpost1.t5 a_36944_64741# avss.t58 nfet_03v3 ad=0.3p pd=2.2u as=0.3p ps=2.2u w=0.5u l=0.63u
X16 a_38302_44752# layer_input_0.nvout_3 a_35586_44752# avdd.t13 pfet_03v3 ad=0.3p pd=2.2u as=0.3p ps=2.2u w=0.5u l=0.63u
X17 vpost1.t0 layer_output_0.nvout_1 avss.t87 avss.t86 nfet_03v3 ad=0.375p pd=2.5u as=0.375p ps=2.5u w=0.5u l=0.28u
X18 avdd.t155 a_55586_33752# cap_mim_2f0_m4m5_noshield c_width=5u c_length=5u
X19 a_36944_31541# avss.t208 cap_mim_2f0_m4m5_noshield c_width=5u c_length=5u
X20 stdp_4x2_0.stdp_3.vw avss.t45 cap_mim_2f0_m4m5_noshield c_width=5u c_length=5u
X21 stdp_4x2_0.stdp_3.vw avss.t45 cap_mim_2f0_m4m5_noshield c_width=5u c_length=5u
X22 stdp_4x2_0.stdp_5.vw avss.t92 cap_mim_2f0_m4m5_noshield c_width=5u c_length=5u
X23 layer_input_0.Iext4 a_8786_33529# avss.t207 avss.t206 nfet_03v3 ad=1.38p pd=5.8u as=1.38p ps=5.8u w=2.3u l=50u
X24 a_38428_33960# a_38302_33752# avdd.t149 avdd.t148 pfet_03v3 ad=0.3p pd=2.2u as=0.3p ps=2.2u w=0.5u l=0.63u
X25 a_55586_33752# current_mirror_0.B avdd.t125 avdd.t124 pfet_03v3 ad=0.3p pd=2.2u as=0.3p ps=2.2u w=0.5u l=4.6u
X26 a_58698_30169# current_mirror_0.A a_61930_30169# avss.t181 nfet_03v3 ad=0.3p pd=2.2u as=0.3p ps=2.2u w=0.5u l=10u
X27 stdp_4x2_0.stdp_5.vw avss.t92 cap_mim_2f0_m4m5_noshield c_width=5u c_length=5u
X28 a_55712_67160# a_55586_66952# avdd.t73 avdd.t72 pfet_03v3 ad=0.3p pd=2.2u as=0.3p ps=2.2u w=0.5u l=0.63u
X29 a_41930_30169# current_mirror_0.A avss.t178 avss.t177 nfet_03v3 ad=0.3p pd=2.2u as=0.3p ps=2.2u w=0.5u l=10u
X30 a_58302_53541# a_58302_53541# avss.t34 avss.t33 nfet_03v3 ad=0.3p pd=2.2u as=0.3p ps=2.2u w=0.5u l=0.63u
X31 a_8786_49529# layer_input_0.nvout_2 avss.t32 avss.t31 nfet_03v3 ad=0.375p pd=2.5u as=0.375p ps=2.5u w=0.5u l=0.28u
X32 a_35712_55960# a_35586_55752# avdd.t49 avdd.t48 pfet_03v3 ad=0.3p pd=2.2u as=0.3p ps=2.2u w=0.5u l=0.63u
X33 avdd.t164 a_35586_44752# cap_mim_2f0_m4m5_noshield c_width=5u c_length=5u
X34 a_38428_67160# current_mirror_0.A avss.t131 avss.t130 nfet_03v3 ad=0.366p pd=2.42u as=0.366p ps=2.42u w=0.61u l=2.8u
X35 a_57586_52169# current_mirror_0.A a_55466_52169# avss.t150 nfet_03v3 ad=0.3p pd=2.2u as=0.3p ps=2.2u w=0.5u l=10u
X36 stdp_4x2_0.stdp_4.vw avss.t197 cap_mim_2f0_m4m5_noshield c_width=5u c_length=5u
X37 stdp_4x2_0.stdp_0.vw avss.t69 cap_mim_2f0_m4m5_noshield c_width=5u c_length=5u
X38 stdp_4x2_0.stdp_0.vw avss.t69 cap_mim_2f0_m4m5_noshield c_width=5u c_length=5u
X39 stdp_4x2_0.stdp_2.vw avss.t35 cap_mim_2f0_m4m5_noshield c_width=5u c_length=5u
X40 layer_input_0.Iext3 a_10290_71650# avdd.t5 avdd.t4 pfet_03v3 ad=0.558p pd=3.06u as=0.558p ps=3.06u w=0.93u l=1.86u
X41 a_8786_33529# layer_input_0.nvout_4 avss.t39 avss.t38 nfet_03v3 ad=0.375p pd=2.5u as=0.375p ps=2.5u w=0.5u l=0.28u
X42 layer_input_0.Iext2 a_4794_71649# avdd.t127 avdd.t126 pfet_03v3 ad=0.558p pd=3.06u as=0.558p ps=3.06u w=0.93u l=1.86u
X43 a_36944_64741# avss.t79 cap_mim_2f0_m4m5_noshield c_width=5u c_length=5u
X44 avdd.t160 a_55586_66952# cap_mim_2f0_m4m5_noshield c_width=5u c_length=5u
X45 a_10290_71650# Vin_neg.t0 a_4666_70229# avss.t98 nfet_03v3 ad=0.3p pd=2.2u as=0.3p ps=2.2u w=0.5u l=10u
X46 a_35466_64949# a_36944_64741# avss.t81 avss.t80 nfet_03v3 ad=0.3p pd=2.2u as=0.3p ps=2.2u w=0.5u l=0.63u
X47 stdp_4x2_0.stdp_6.vw layer_output_0.nvout_1 a_35712_44960# avdd.t60 pfet_03v3 ad=0.3p pd=2.2u as=0.3p ps=2.2u w=0.5u l=0.63u
X48 stdp_4x2_0.Current_limit_0.i_SUM stdp_4x2_0.stdp_3.vw avdd.t40 avdd.t39 pfet_03v3 ad=0.3p pd=2.2u as=0.3p ps=2.2u w=0.5u l=15u
X49 stdp_4x2_0.stdp_0.vw layer_input_0.vout_4 a_35466_31749# avss.t94 nfet_03v3 ad=0.3p pd=2.2u as=0.3p ps=2.2u w=0.5u l=0.63u
X50 vw42.t9 avss.t55 cap_mim_2f0_m4m5_noshield c_width=5u c_length=5u
X51 vw42.t10 avss.t55 cap_mim_2f0_m4m5_noshield c_width=5u c_length=5u
X52 layer_input_0.nvout_2 layer_input_0.Iext2 avdd.t7 avdd.t6 pfet_03v3 ad=0.375p pd=2.5u as=0.375p ps=2.5u w=0.5u l=0.28u
X53 current_mirror_0.A current_mirror_0.A avss.t176 avss.t175 nfet_03v3 ad=3p pd=9.5u as=3p ps=9.5u w=4u l=0.28u
X54 a_56944_53541# avss.t3 cap_mim_2f0_m4m5_noshield c_width=5u c_length=5u
X55 vpre2.t1 layer_input_0.nvout_2 avdd.t26 avdd.t25 pfet_03v3 ad=0.375p pd=2.5u as=0.375p ps=2.5u w=0.5u l=0.28u
X56 layer_output_0.nvout_2 layer_output_0.Iext2 avss.t11 avss.t10 nfet_03v3 ad=0.375p pd=2.5u as=0.375p ps=2.5u w=0.5u l=0.28u
X57 a_58302_42541# current_mirror_0.B avdd.t121 avdd.t120 pfet_03v3 ad=6.12p pd=21.6u as=6.12p ps=21.6u w=10.2u l=2.8u
X58 a_58302_66952# layer_input_0.nvout_1 a_55586_66952# avdd.t81 pfet_03v3 ad=0.3p pd=2.2u as=0.3p ps=2.2u w=0.5u l=0.63u
X59 a_35466_30169# current_mirror_0.A a_38698_30169# avss.t171 nfet_03v3 ad=0.3p pd=2.2u as=0.3p ps=2.2u w=0.5u l=10u
X60 avdd.t162 a_35586_33752# cap_mim_2f0_m4m5_noshield c_width=5u c_length=5u
X61 a_56944_42541# current_mirror_0.A a_57586_41169# avss.t133 nfet_03v3 ad=0.3p pd=2.2u as=0.3p ps=2.2u w=0.5u l=10u
X62 vw11.t4 avss.t43 cap_mim_2f0_m4m5_noshield c_width=5u c_length=5u
X63 stdp_4x2_0.stdp_3.vw avss.t47 cap_mim_2f0_m4m5_noshield c_width=5u c_length=5u
X64 stdp_4x2_0.stdp_6.vw avss.t75 cap_mim_2f0_m4m5_noshield c_width=5u c_length=5u
X65 layer_output_0.Iext1 layer_output_0.Iext1 a_49420_23589# avdd.t43 pfet_03v3 ad=0.3p pd=2.2u as=0.3p ps=2.2u w=0.5u l=5u
X66 vw11.t11 avss.t42 cap_mim_2f0_m4m5_noshield c_width=5u c_length=5u
X67 a_38302_55752# layer_input_0.nvout_2 a_35586_55752# avdd.t21 pfet_03v3 ad=0.3p pd=2.2u as=0.3p ps=2.2u w=0.5u l=0.63u
X68 a_38302_64741# a_38302_64741# avss.t185 avss.t184 nfet_03v3 ad=0.3p pd=2.2u as=0.3p ps=2.2u w=0.5u l=0.63u
X69 a_38428_44960# a_38302_44752# avdd.t87 avdd.t86 pfet_03v3 ad=0.3p pd=2.2u as=0.3p ps=2.2u w=0.5u l=0.63u
X70 a_55586_44752# current_mirror_0.B avdd.t113 avdd.t112 pfet_03v3 ad=0.3p pd=2.2u as=0.3p ps=2.2u w=0.5u l=4.6u
X71 stdp_4x2_0.stdp_4.vw avss.t196 cap_mim_2f0_m4m5_noshield c_width=5u c_length=5u
X72 a_58698_41169# current_mirror_0.A a_61930_41169# avss.t164 nfet_03v3 ad=0.3p pd=2.2u as=0.3p ps=2.2u w=0.5u l=10u
X73 a_55712_33960# a_55586_33752# avdd.t153 avdd.t152 pfet_03v3 ad=0.3p pd=2.2u as=0.3p ps=2.2u w=0.5u l=0.63u
X74 vpost2.t1 layer_output_0.nvout_2 avss.t192 avss.t191 nfet_03v3 ad=0.375p pd=2.5u as=0.375p ps=2.5u w=0.5u l=0.28u
X75 stdp_4x2_0.stdp_4.vw avss.t196 cap_mim_2f0_m4m5_noshield c_width=5u c_length=5u
X76 stdp_4x2_0.stdp_5.vw avss.t91 cap_mim_2f0_m4m5_noshield c_width=5u c_length=5u
X77 a_37586_63369# current_mirror_0.A a_35466_63369# avss.t134 nfet_03v3 ad=0.3p pd=2.2u as=0.3p ps=2.2u w=0.5u l=10u
X78 a_45786_9329# layer_output_0.nvout_2 avdd.t145 avdd.t144 pfet_03v3 ad=0.375p pd=2.5u as=0.375p ps=2.5u w=0.5u l=0.28u
X79 a_41930_41169# current_mirror_0.A avss.t156 avss.t137 nfet_03v3 ad=0.3p pd=2.2u as=0.3p ps=2.2u w=0.5u l=10u
X80 current_mirror_0.B current_mirror_0.B avdd.t119 avdd.t118 pfet_03v3 ad=4.8p pd=17.2u as=4.8p ps=17.2u w=8u l=0.5u
X81 avss.t117 avss.t115 avss.t117 avss.t116 nfet_03v3 ad=0.3p pd=2.2u as=0 ps=0 w=0.5u l=5u
X82 vw11.t3 avss.t44 cap_mim_2f0_m4m5_noshield c_width=5u c_length=5u
X83 a_56944_42541# avss.t64 cap_mim_2f0_m4m5_noshield c_width=5u c_length=5u
X84 stdp_4x2_0.stdp_2.vw avss.t37 cap_mim_2f0_m4m5_noshield c_width=5u c_length=5u
X85 a_38302_31541# vpost1.t2 a_36944_31541# avss.t61 nfet_03v3 ad=0.3p pd=2.2u as=0.3p ps=2.2u w=0.5u l=0.63u
X86 a_10290_71650# a_10290_71650# avdd.t1 avdd.t0 pfet_03v3 ad=1.5p pd=5.5u as=1.5p ps=5.5u w=2u l=0.28u
X87 stdp_4x2_0.stdp_5.vw layer_output_0.nvout_2 a_55712_67160# avdd.t140 pfet_03v3 ad=0.3p pd=2.2u as=0.3p ps=2.2u w=0.5u l=0.63u
X88 stdp_4x2_0.stdp_0.vw avss.t68 cap_mim_2f0_m4m5_noshield c_width=5u c_length=5u
X89 stdp_4x2_0.stdp_2.vw layer_output_0.nvout_1 a_35712_55960# avdd.t59 pfet_03v3 ad=0.3p pd=2.2u as=0.3p ps=2.2u w=0.5u l=0.63u
X90 stdp_4x2_0.Current_limit_0.i_SUM stdp_4x2_0.stdp_4.vw avdd.t151 avdd.t150 pfet_03v3 ad=0.3p pd=2.2u as=0.3p ps=2.2u w=0.5u l=15u
X91 a_36944_53541# avss.t201 cap_mim_2f0_m4m5_noshield c_width=5u c_length=5u
X92 layer_output_0.Iext2 avss.t9 cap_mim_2f0_m4m5_noshield c_width=28u c_length=5u
X93 avdd.t158 a_55586_55752# cap_mim_2f0_m4m5_noshield c_width=5u c_length=5u
X94 layer_input_0.Iext1 a_8786_57529# avss.t90 avss.t7 nfet_03v3 ad=1.38p pd=5.8u as=1.38p ps=5.8u w=2.3u l=50u
X95 stdp_4x2_0.stdp_6.vw layer_input_0.vout_3 a_35466_42749# avss.t48 nfet_03v3 ad=0.3p pd=2.2u as=0.3p ps=2.2u w=0.5u l=0.63u
X96 stdp_4x2_0.stdp_3.vw avss.t46 cap_mim_2f0_m4m5_noshield c_width=5u c_length=5u
X97 avdd.t161 a_55586_66952# cap_mim_2f0_m4m5_noshield c_width=5u c_length=5u
X98 a_38428_33960# current_mirror_0.A avss.t167 avss.t166 nfet_03v3 ad=0.366p pd=2.42u as=0.366p ps=2.42u w=0.61u l=2.8u
X99 stdp_4x2_0.stdp_3.vw avss.t46 cap_mim_2f0_m4m5_noshield c_width=5u c_length=5u
X100 a_61930_63369# current_mirror_0.A avss.t143 avss.t142 nfet_03v3 ad=0.3p pd=2.2u as=0.3p ps=2.2u w=0.5u l=10u
X101 vw42.t3 avss.t57 cap_mim_2f0_m4m5_noshield c_width=5u c_length=5u
X102 a_58302_53541# current_mirror_0.B avdd.t109 avdd.t108 pfet_03v3 ad=6.12p pd=21.6u as=6.12p ps=21.6u w=10.2u l=2.8u
X103 a_56944_31541# avss.t82 cap_mim_2f0_m4m5_noshield c_width=5u c_length=5u
X104 stdp_4x2_0.stdp_6.vw avss.t77 cap_mim_2f0_m4m5_noshield c_width=5u c_length=5u
X105 layer_input_0.Iext3 a_8786_41529# avss.t8 avss.t7 nfet_03v3 ad=1.38p pd=5.8u as=1.38p ps=5.8u w=2.3u l=50u
X106 a_35466_41169# current_mirror_0.A a_38698_41169# avss.t160 nfet_03v3 ad=0.3p pd=2.2u as=0.3p ps=2.2u w=0.5u l=10u
X107 a_58302_33752# layer_input_0.nvout_4 a_55586_33752# avdd.t34 pfet_03v3 ad=0.3p pd=2.2u as=0.3p ps=2.2u w=0.5u l=0.63u
X108 a_56944_53541# current_mirror_0.A a_57586_52169# avss.t133 nfet_03v3 ad=0.3p pd=2.2u as=0.3p ps=2.2u w=0.5u l=10u
X109 a_35466_31749# a_36944_31541# avss.t211 avss.t210 nfet_03v3 ad=0.3p pd=2.2u as=0.3p ps=2.2u w=0.5u l=0.63u
X110 layer_input_0.Iext2 avss.t0 cap_mim_2f0_m4m5_noshield c_width=28u c_length=5u
X111 a_58428_67160# a_58302_66952# avdd.t38 avdd.t37 pfet_03v3 ad=0.3p pd=2.2u as=0.3p ps=2.2u w=0.5u l=0.63u
X112 a_8786_57529# layer_input_0.nvout_1 avss.t105 avss.t104 nfet_03v3 ad=0.375p pd=2.5u as=0.375p ps=2.5u w=0.5u l=0.28u
X113 layer_output_0.nvout_1 layer_output_0.Iext1 avss.t52 avss.t51 nfet_03v3 ad=0.375p pd=2.5u as=0.375p ps=2.5u w=0.5u l=0.28u
X114 stdp_4x2_0.stdp_2.vw avss.t36 cap_mim_2f0_m4m5_noshield c_width=5u c_length=5u
X115 stdp_4x2_0.stdp_2.vw avss.t35 cap_mim_2f0_m4m5_noshield c_width=5u c_length=5u
X116 a_38428_55960# a_38302_55752# avdd.t47 avdd.t46 pfet_03v3 ad=0.3p pd=2.2u as=0.3p ps=2.2u w=0.5u l=0.63u
X117 a_49420_23589# a_49420_23589# stdp_4x2_0.Current_limit_1.i_SUM avdd.t135 pfet_03v3 ad=0.3p pd=2.2u as=0.3p ps=2.2u w=0.5u l=5u
X118 a_7926_70021# a_7926_70021# avdd.t89 avdd.t88 pfet_03v3 ad=0.375p pd=2.5u as=0.375p ps=2.5u w=0.5u l=0.28u
X119 stdp_4x2_0.stdp_5.vw vpre1.t2 a_55466_64949# avss.t28 nfet_03v3 ad=0.3p pd=2.2u as=0.3p ps=2.2u w=0.5u l=0.63u
X120 a_55586_55752# current_mirror_0.B avdd.t107 avdd.t106 pfet_03v3 ad=0.3p pd=2.2u as=0.3p ps=2.2u w=0.5u l=4.6u
X121 a_58698_52169# current_mirror_0.A a_61930_52169# avss.t152 nfet_03v3 ad=0.3p pd=2.2u as=0.3p ps=2.2u w=0.5u l=10u
X122 a_55712_44960# a_55586_44752# avdd.t42 avdd.t41 pfet_03v3 ad=0.3p pd=2.2u as=0.3p ps=2.2u w=0.5u l=0.63u
X123 avdd.t156 a_55586_44752# cap_mim_2f0_m4m5_noshield c_width=5u c_length=5u
X124 a_36944_42541# avss.t13 cap_mim_2f0_m4m5_noshield c_width=5u c_length=5u
X125 layer_input_0.nvout_2 layer_input_0.Iext2 avss.t2 avss.t1 nfet_03v3 ad=0.375p pd=2.5u as=0.375p ps=2.5u w=0.5u l=0.28u
X126 a_8786_33529# layer_input_0.nvout_4 avdd.t32 avdd.t31 pfet_03v3 ad=0.375p pd=2.5u as=0.375p ps=2.5u w=0.5u l=0.28u
X127 vw42.t5 avss.t56 cap_mim_2f0_m4m5_noshield c_width=5u c_length=5u
X128 stdp_4x2_0.stdp_4.vw avss.t195 cap_mim_2f0_m4m5_noshield c_width=5u c_length=5u
X129 a_41930_52169# current_mirror_0.A avss.t149 avss.t137 nfet_03v3 ad=0.3p pd=2.2u as=0.3p ps=2.2u w=0.5u l=10u
X130 a_8786_41529# layer_input_0.nvout_3 avss.t17 avss.t16 nfet_03v3 ad=0.375p pd=2.5u as=0.375p ps=2.5u w=0.5u l=0.28u
X131 vw42.t6 avss.t56 cap_mim_2f0_m4m5_noshield c_width=5u c_length=5u
X132 a_38302_42541# vpost1.t3 a_36944_42541# avss.t60 nfet_03v3 ad=0.3p pd=2.2u as=0.3p ps=2.2u w=0.5u l=0.63u
X133 vpre2.t0 layer_input_0.nvout_2 avss.t30 avss.t29 nfet_03v3 ad=0.375p pd=2.5u as=0.375p ps=2.5u w=0.5u l=0.28u
X134 a_56944_64741# avss.t109 cap_mim_2f0_m4m5_noshield c_width=5u c_length=5u
X135 stdp_4x2_0.Current_limit_1.i_SUM vw11.t12 avdd.t36 avdd.t35 pfet_03v3 ad=0.3p pd=2.2u as=0.3p ps=2.2u w=0.5u l=15u
X136 a_55466_63369# current_mirror_0.A a_58698_63369# avss.t140 nfet_03v3 ad=0.3p pd=2.2u as=0.3p ps=2.2u w=0.5u l=10u
X137 a_38302_31541# a_38302_31541# avss.t100 avss.t99 nfet_03v3 ad=0.3p pd=2.2u as=0.3p ps=2.2u w=0.5u l=0.63u
X138 vw42.t1 layer_output_0.nvout_2 a_55712_33960# avdd.t143 pfet_03v3 ad=0.3p pd=2.2u as=0.3p ps=2.2u w=0.5u l=0.63u
X139 layer_input_0.nvout_4 layer_input_0.Iext4 avss.t22 avss.t21 nfet_03v3 ad=0.375p pd=2.5u as=0.375p ps=2.5u w=0.5u l=0.28u
X140 a_37586_30169# current_mirror_0.A a_35466_30169# avss.t170 nfet_03v3 ad=0.3p pd=2.2u as=0.3p ps=2.2u w=0.5u l=10u
X141 layer_output_0.Iext2 layer_output_0.Iext2 a_69620_23589# avdd.t10 pfet_03v3 ad=0.3p pd=2.2u as=0.3p ps=2.2u w=0.5u l=5u
X142 stdp_4x2_0.stdp_6.vw avss.t76 cap_mim_2f0_m4m5_noshield c_width=5u c_length=5u
X143 stdp_4x2_0.stdp_6.vw avss.t75 cap_mim_2f0_m4m5_noshield c_width=5u c_length=5u
X144 layer_input_0.vout_4 layer_input_0.nvout_4 avss.t41 avss.t40 nfet_03v3 ad=0.375p pd=2.5u as=0.375p ps=2.5u w=0.5u l=0.28u
X145 vw11.t7 avss.t43 cap_mim_2f0_m4m5_noshield c_width=5u c_length=5u
X146 a_38302_64741# current_mirror_0.B avdd.t99 avdd.t98 pfet_03v3 ad=6.12p pd=21.6u as=6.12p ps=21.6u w=10.2u l=2.8u
X147 stdp_4x2_0.stdp_2.vw vpre2.t3 a_35466_53749# avss.t62 nfet_03v3 ad=0.3p pd=2.2u as=0.3p ps=2.2u w=0.5u l=0.63u
X148 stdp_4x2_0.stdp_0.vw avss.t70 cap_mim_2f0_m4m5_noshield c_width=5u c_length=5u
X149 a_36944_31541# avss.t209 cap_mim_2f0_m4m5_noshield c_width=5u c_length=5u
X150 avdd.t154 a_55586_33752# cap_mim_2f0_m4m5_noshield c_width=5u c_length=5u
X151 a_36944_64741# current_mirror_0.A a_37586_63369# avss.t132 nfet_03v3 ad=0.3p pd=2.2u as=0.3p ps=2.2u w=0.5u l=10u
X152 a_38428_44960# current_mirror_0.A avss.t125 avss.t124 nfet_03v3 ad=0.366p pd=2.42u as=0.366p ps=2.42u w=0.61u l=2.8u
X153 current_mirror_0.A current_mirror_0.A avdd.t91 avdd.t90 pfet_03v3 ad=0.96p pd=4.4u as=0.96p ps=4.4u w=1.6u l=0.5u
X154 stdp_4x2_0.stdp_3.vw avss.t45 cap_mim_2f0_m4m5_noshield c_width=5u c_length=5u
X155 stdp_4x2_0.stdp_5.vw avss.t92 cap_mim_2f0_m4m5_noshield c_width=5u c_length=5u
X156 stdp_4x2_0.stdp_5.vw avss.t91 cap_mim_2f0_m4m5_noshield c_width=5u c_length=5u
X157 layer_input_0.Iext1 a_4794_71649# avdd.t131 avdd.t130 pfet_03v3 ad=0.558p pd=3.06u as=0.558p ps=3.06u w=0.93u l=1.86u
X158 a_58302_64741# vpost2.t5 a_56944_64741# avss.t23 nfet_03v3 ad=0.3p pd=2.2u as=0.3p ps=2.2u w=0.5u l=0.63u
X159 a_35466_52169# current_mirror_0.A a_38698_52169# avss.t147 nfet_03v3 ad=0.3p pd=2.2u as=0.3p ps=2.2u w=0.5u l=10u
X160 a_58302_44752# layer_input_0.nvout_3 a_55586_44752# avdd.t14 pfet_03v3 ad=0.3p pd=2.2u as=0.3p ps=2.2u w=0.5u l=0.63u
X161 a_35466_42749# a_36944_42541# avss.t15 avss.t14 nfet_03v3 ad=0.3p pd=2.2u as=0.3p ps=2.2u w=0.5u l=0.63u
X162 a_38698_63369# current_mirror_0.A a_41930_63369# avss.t136 nfet_03v3 ad=0.3p pd=2.2u as=0.3p ps=2.2u w=0.5u l=10u
X163 a_58428_33960# a_58302_33752# avdd.t9 avdd.t8 pfet_03v3 ad=0.3p pd=2.2u as=0.3p ps=2.2u w=0.5u l=0.63u
X164 stdp_4x2_0.stdp_0.vw avss.t69 cap_mim_2f0_m4m5_noshield c_width=5u c_length=5u
X165 stdp_4x2_0.stdp_0.vw avss.t68 cap_mim_2f0_m4m5_noshield c_width=5u c_length=5u
X166 a_61930_30169# current_mirror_0.A avss.t174 avss.t173 nfet_03v3 ad=0.3p pd=2.2u as=0.3p ps=2.2u w=0.5u l=10u
X167 stdp_4x2_0.stdp_4.vw avss.t197 cap_mim_2f0_m4m5_noshield c_width=5u c_length=5u
X168 stdp_4x2_0.stdp_5.vw avss.t93 cap_mim_2f0_m4m5_noshield c_width=5u c_length=5u
X169 a_4794_71649# Vin.t0 a_4666_70229# avss.t205 nfet_03v3 ad=0.3p pd=2.2u as=0.3p ps=2.2u w=0.5u l=10u
X170 a_55712_55960# a_55586_55752# avdd.t134 avdd.t133 pfet_03v3 ad=0.3p pd=2.2u as=0.3p ps=2.2u w=0.5u l=0.63u
X171 a_58428_67160# current_mirror_0.A avss.t127 avss.t126 nfet_03v3 ad=0.366p pd=2.42u as=0.366p ps=2.42u w=0.61u l=2.8u
X172 layer_input_0.Iext4 avss.t20 cap_mim_2f0_m4m5_noshield c_width=28u c_length=5u
X173 a_35586_66952# current_mirror_0.B avdd.t97 avdd.t96 pfet_03v3 ad=0.3p pd=2.2u as=0.3p ps=2.2u w=0.5u l=4.6u
X174 vpost2.t0 layer_output_0.nvout_2 avdd.t147 avdd.t146 pfet_03v3 ad=0.375p pd=2.5u as=0.375p ps=2.5u w=0.5u l=0.28u
X175 vw42.t8 avss.t55 cap_mim_2f0_m4m5_noshield c_width=5u c_length=5u
X176 a_38302_53541# vpost1.t4 a_36944_53541# avss.t59 nfet_03v3 ad=0.3p pd=2.2u as=0.3p ps=2.2u w=0.5u l=0.63u
X177 a_38302_42541# a_38302_42541# avss.t72 avss.t71 nfet_03v3 ad=0.3p pd=2.2u as=0.3p ps=2.2u w=0.5u l=0.63u
X178 a_33386_9329# layer_output_0.nvout_1 avdd.t63 avdd.t62 pfet_03v3 ad=0.375p pd=2.5u as=0.375p ps=2.5u w=0.5u l=0.28u
X179 a_56944_53541# avss.t4 cap_mim_2f0_m4m5_noshield c_width=5u c_length=5u
X180 a_55466_64949# a_56944_64741# avss.t111 avss.t110 nfet_03v3 ad=0.3p pd=2.2u as=0.3p ps=2.2u w=0.5u l=0.63u
X181 stdp_4x2_0.stdp_3.vw layer_output_0.nvout_2 a_55712_44960# avdd.t142 pfet_03v3 ad=0.3p pd=2.2u as=0.3p ps=2.2u w=0.5u l=0.63u
X182 vw42.t0 layer_input_0.vout_4 a_55466_31749# avss.t95 nfet_03v3 ad=0.3p pd=2.2u as=0.3p ps=2.2u w=0.5u l=0.63u
X183 a_37586_41169# current_mirror_0.A a_35466_41169# avss.t159 nfet_03v3 ad=0.3p pd=2.2u as=0.3p ps=2.2u w=0.5u l=10u
X184 a_33386_9329# layer_output_0.nvout_1 avss.t89 avss.t88 nfet_03v3 ad=0.375p pd=2.5u as=0.375p ps=2.5u w=0.5u l=0.28u
X185 vw11.t9 avss.t42 cap_mim_2f0_m4m5_noshield c_width=5u c_length=5u
X186 stdp_4x2_0.stdp_2.vw avss.t36 cap_mim_2f0_m4m5_noshield c_width=5u c_length=5u
X187 a_8786_57529# layer_input_0.nvout_1 avdd.t85 avdd.t84 pfet_03v3 ad=0.375p pd=2.5u as=0.375p ps=2.5u w=0.5u l=0.28u
X188 a_69620_23589# a_69620_23589# stdp_4x2_0.Current_limit_0.i_SUM avdd.t132 pfet_03v3 ad=0.3p pd=2.2u as=0.3p ps=2.2u w=0.5u l=5u
X189 vw11.t10 avss.t42 cap_mim_2f0_m4m5_noshield c_width=5u c_length=5u
X190 stdp_4x2_0.stdp_3.vw avss.t47 cap_mim_2f0_m4m5_noshield c_width=5u c_length=5u
X191 a_38428_55960# current_mirror_0.A avss.t129 avss.t128 nfet_03v3 ad=0.366p pd=2.42u as=0.366p ps=2.42u w=0.61u l=2.8u
X192 a_55466_30169# current_mirror_0.A a_58698_30169# avss.t180 nfet_03v3 ad=0.3p pd=2.2u as=0.3p ps=2.2u w=0.5u l=10u
X193 layer_output_0.Iext2 a_45786_9329# avss.t54 avss.t53 nfet_03v3 ad=1.38p pd=5.8u as=1.38p ps=5.8u w=2.3u l=50u
X194 stdp_4x2_0.Current_limit_1.i_SUM stdp_4x2_0.stdp_0.vw avdd.t55 avdd.t54 pfet_03v3 ad=0.3p pd=2.2u as=0.3p ps=2.2u w=0.5u l=15u
X195 layer_output_0.Iext1 avss.t50 cap_mim_2f0_m4m5_noshield c_width=28u c_length=5u
X196 stdp_4x2_0.stdp_4.vw avss.t196 cap_mim_2f0_m4m5_noshield c_width=5u c_length=5u
X197 stdp_4x2_0.stdp_4.vw avss.t195 cap_mim_2f0_m4m5_noshield c_width=5u c_length=5u
X198 a_58302_55752# layer_input_0.nvout_2 a_55586_55752# avdd.t22 pfet_03v3 ad=0.3p pd=2.2u as=0.3p ps=2.2u w=0.5u l=0.63u
X199 a_35466_53749# a_36944_53541# avss.t203 avss.t202 nfet_03v3 ad=0.3p pd=2.2u as=0.3p ps=2.2u w=0.5u l=0.63u
X200 a_58302_64741# a_58302_64741# avss.t194 avss.t193 nfet_03v3 ad=0.3p pd=2.2u as=0.3p ps=2.2u w=0.5u l=0.63u
X201 layer_input_0.nvout_1 layer_input_0.Iext1 avss.t103 avss.t102 nfet_03v3 ad=0.375p pd=2.5u as=0.375p ps=2.5u w=0.5u l=0.28u
X202 a_58428_44960# a_58302_44752# avdd.t139 avdd.t138 pfet_03v3 ad=0.3p pd=2.2u as=0.3p ps=2.2u w=0.5u l=0.63u
X203 a_8786_41529# layer_input_0.nvout_3 avdd.t16 avdd.t15 pfet_03v3 ad=0.375p pd=2.5u as=0.375p ps=2.5u w=0.5u l=0.28u
X204 a_56944_42541# avss.t65 cap_mim_2f0_m4m5_noshield c_width=5u c_length=5u
X205 a_38302_31541# current_mirror_0.B avdd.t123 avdd.t122 pfet_03v3 ad=6.12p pd=21.6u as=6.12p ps=21.6u w=10.2u l=2.8u
X206 vw11.t2 avss.t44 cap_mim_2f0_m4m5_noshield c_width=5u c_length=5u
X207 a_4666_70229# a_7926_70021# avss.t121 avss.t120 nfet_03v3 ad=0.375p pd=2.5u as=0.375p ps=2.5u w=0.5u l=0.28u
X208 a_57586_63369# current_mirror_0.A a_55466_63369# avss.t139 nfet_03v3 ad=0.3p pd=2.2u as=0.3p ps=2.2u w=0.5u l=10u
X209 vpre1.t0 layer_input_0.nvout_1 avss.t107 avss.t106 nfet_03v3 ad=0.375p pd=2.5u as=0.375p ps=2.5u w=0.5u l=0.28u
X210 a_61930_41169# current_mirror_0.A avss.t165 avss.t142 nfet_03v3 ad=0.3p pd=2.2u as=0.3p ps=2.2u w=0.5u l=10u
X211 a_36944_31541# current_mirror_0.A a_37586_30169# avss.t168 nfet_03v3 ad=0.3p pd=2.2u as=0.3p ps=2.2u w=0.5u l=10u
X212 avdd.t167 a_35586_55752# cap_mim_2f0_m4m5_noshield c_width=5u c_length=5u
X213 layer_input_0.nvout_4 layer_input_0.Iext4 avdd.t20 avdd.t19 pfet_03v3 ad=0.375p pd=2.5u as=0.375p ps=2.5u w=0.5u l=0.28u
X214 a_58302_31541# vpost2.t2 a_56944_31541# avss.t26 nfet_03v3 ad=0.3p pd=2.2u as=0.3p ps=2.2u w=0.5u l=0.63u
X215 stdp_4x2_0.stdp_6.vw avss.t76 cap_mim_2f0_m4m5_noshield c_width=5u c_length=5u
X216 layer_input_0.nvout_3 layer_input_0.Iext3 avss.t188 avss.t187 nfet_03v3 ad=0.375p pd=2.5u as=0.375p ps=2.5u w=0.5u l=0.28u
X217 a_4794_71649# a_4794_71649# avdd.t129 avdd.t128 pfet_03v3 ad=1.5p pd=5.5u as=1.5p ps=5.5u w=2u l=0.28u
X218 layer_input_0.vout_4 layer_input_0.nvout_4 avdd.t30 avdd.t29 pfet_03v3 ad=0.375p pd=2.5u as=0.375p ps=2.5u w=0.5u l=0.28u
X219 a_35586_33752# current_mirror_0.B avdd.t115 avdd.t114 pfet_03v3 ad=0.3p pd=2.2u as=0.3p ps=2.2u w=0.5u l=4.6u
X220 a_38698_30169# current_mirror_0.A a_41930_30169# avss.t172 nfet_03v3 ad=0.3p pd=2.2u as=0.3p ps=2.2u w=0.5u l=10u
X221 a_35712_67160# a_35586_66952# avdd.t79 avdd.t78 pfet_03v3 ad=0.3p pd=2.2u as=0.3p ps=2.2u w=0.5u l=0.63u
X222 layer_input_0.vout_3 layer_input_0.nvout_3 avss.t19 avss.t18 nfet_03v3 ad=0.375p pd=2.5u as=0.375p ps=2.5u w=0.5u l=0.28u
X223 stdp_4x2_0.stdp_3.vw avss.t46 cap_mim_2f0_m4m5_noshield c_width=5u c_length=5u
X224 stdp_4x2_0.stdp_3.vw avss.t45 cap_mim_2f0_m4m5_noshield c_width=5u c_length=5u
X225 stdp_4x2_0.stdp_5.vw avss.t92 cap_mim_2f0_m4m5_noshield c_width=5u c_length=5u
X226 stdp_4x2_0.stdp_4.vw layer_output_0.nvout_2 a_55712_55960# avdd.t141 pfet_03v3 ad=0.3p pd=2.2u as=0.3p ps=2.2u w=0.5u l=0.63u
X227 a_38302_53541# a_38302_53541# avss.t97 avss.t96 nfet_03v3 ad=0.3p pd=2.2u as=0.3p ps=2.2u w=0.5u l=0.63u
X228 stdp_4x2_0.stdp_3.vw layer_input_0.vout_3 a_55466_42749# avss.t49 nfet_03v3 ad=0.3p pd=2.2u as=0.3p ps=2.2u w=0.5u l=0.63u
X229 vw42.t2 avss.t57 cap_mim_2f0_m4m5_noshield c_width=5u c_length=5u
X230 a_56944_31541# avss.t83 cap_mim_2f0_m4m5_noshield c_width=5u c_length=5u
X231 a_7926_70021# a_7926_70021# avss.t123 avss.t122 nfet_03v3 ad=0.375p pd=2.5u as=0.375p ps=2.5u w=0.5u l=0.28u
X232 a_37586_52169# current_mirror_0.A a_35466_52169# avss.t146 nfet_03v3 ad=0.3p pd=2.2u as=0.3p ps=2.2u w=0.5u l=10u
X233 layer_output_0.nvout_2 layer_output_0.Iext2 avdd.t12 avdd.t11 pfet_03v3 ad=0.375p pd=2.5u as=0.375p ps=2.5u w=0.5u l=0.28u
X234 a_58428_33960# current_mirror_0.A avss.t155 avss.t154 nfet_03v3 ad=0.366p pd=2.42u as=0.366p ps=2.42u w=0.61u l=2.8u
X235 layer_input_0.Iext1 avss.t101 cap_mim_2f0_m4m5_noshield c_width=28u c_length=5u
X236 avdd.t165 a_35586_44752# cap_mim_2f0_m4m5_noshield c_width=5u c_length=5u
X237 a_55466_41169# current_mirror_0.A a_58698_41169# avss.t163 nfet_03v3 ad=0.3p pd=2.2u as=0.3p ps=2.2u w=0.5u l=10u
X238 stdp_4x2_0.stdp_0.vw avss.t69 cap_mim_2f0_m4m5_noshield c_width=5u c_length=5u
X239 stdp_4x2_0.stdp_2.vw avss.t35 cap_mim_2f0_m4m5_noshield c_width=5u c_length=5u
X240 stdp_4x2_0.stdp_2.vw avss.t35 cap_mim_2f0_m4m5_noshield c_width=5u c_length=5u
X241 stdp_4x2_0.Current_limit_1.i_SUM stdp_4x2_0.stdp_6.vw avdd.t57 avdd.t56 pfet_03v3 ad=0.3p pd=2.2u as=0.3p ps=2.2u w=0.5u l=15u
X242 a_55466_31749# a_56944_31541# avss.t85 avss.t84 nfet_03v3 ad=0.3p pd=2.2u as=0.3p ps=2.2u w=0.5u l=0.63u
X243 a_45786_9329# layer_output_0.nvout_2 avss.t190 avss.t189 nfet_03v3 ad=0.375p pd=2.5u as=0.375p ps=2.5u w=0.5u l=0.28u
X244 a_36944_64741# avss.t78 cap_mim_2f0_m4m5_noshield c_width=5u c_length=5u
X245 a_58428_55960# a_58302_55752# avdd.t71 avdd.t70 pfet_03v3 ad=0.3p pd=2.2u as=0.3p ps=2.2u w=0.5u l=0.63u
X246 vw42.t4 avss.t56 cap_mim_2f0_m4m5_noshield c_width=5u c_length=5u
X247 vw42.t11 avss.t55 cap_mim_2f0_m4m5_noshield c_width=5u c_length=5u
X248 a_38302_42541# current_mirror_0.B avdd.t111 avdd.t110 pfet_03v3 ad=6.12p pd=21.6u as=6.12p ps=21.6u w=10.2u l=2.8u
X249 layer_output_0.Iext1 a_33386_9329# avss.t119 avss.t118 nfet_03v3 ad=1.38p pd=5.8u as=1.38p ps=5.8u w=2.3u l=50u
X250 a_38302_66952# layer_input_0.nvout_1 a_35586_66952# avdd.t80 pfet_03v3 ad=0.3p pd=2.2u as=0.3p ps=2.2u w=0.5u l=0.63u
X251 a_61930_52169# current_mirror_0.A avss.t153 avss.t142 nfet_03v3 ad=0.3p pd=2.2u as=0.3p ps=2.2u w=0.5u l=10u
X252 a_36944_42541# current_mirror_0.A a_37586_41169# avss.t132 nfet_03v3 ad=0.3p pd=2.2u as=0.3p ps=2.2u w=0.5u l=10u
X253 layer_input_0.Iext4 a_10290_71650# avdd.t3 avdd.t2 pfet_03v3 ad=0.558p pd=3.06u as=0.558p ps=3.06u w=0.93u l=1.86u
X254 a_58302_42541# vpost2.t3 a_56944_42541# avss.t25 nfet_03v3 ad=0.3p pd=2.2u as=0.3p ps=2.2u w=0.5u l=0.63u
X255 avdd.t163 a_35586_33752# cap_mim_2f0_m4m5_noshield c_width=5u c_length=5u
X256 stdp_4x2_0.stdp_6.vw avss.t75 cap_mim_2f0_m4m5_noshield c_width=5u c_length=5u
X257 stdp_4x2_0.Current_limit_0.i_SUM stdp_4x2_0.stdp_5.vw avdd.t67 avdd.t66 pfet_03v3 ad=0.3p pd=2.2u as=0.3p ps=2.2u w=0.5u l=15u
X258 a_35586_44752# current_mirror_0.B avdd.t105 avdd.t104 pfet_03v3 ad=0.3p pd=2.2u as=0.3p ps=2.2u w=0.5u l=4.6u
X259 a_58302_31541# a_58302_31541# avss.t74 avss.t73 nfet_03v3 ad=0.3p pd=2.2u as=0.3p ps=2.2u w=0.5u l=0.63u
X260 vw11.t6 avss.t43 cap_mim_2f0_m4m5_noshield c_width=5u c_length=5u
X261 vw11.t5 avss.t43 cap_mim_2f0_m4m5_noshield c_width=5u c_length=5u
X262 stdp_4x2_0.stdp_6.vw avss.t75 cap_mim_2f0_m4m5_noshield c_width=5u c_length=5u
X263 a_38698_41169# current_mirror_0.A a_41930_41169# avss.t161 nfet_03v3 ad=0.3p pd=2.2u as=0.3p ps=2.2u w=0.5u l=10u
X264 a_35712_33960# a_35586_33752# avdd.t53 avdd.t52 pfet_03v3 ad=0.3p pd=2.2u as=0.3p ps=2.2u w=0.5u l=0.63u
X265 a_57586_30169# current_mirror_0.A a_55466_30169# avss.t179 nfet_03v3 ad=0.3p pd=2.2u as=0.3p ps=2.2u w=0.5u l=10u
X266 stdp_4x2_0.stdp_4.vw avss.t196 cap_mim_2f0_m4m5_noshield c_width=5u c_length=5u
X267 stdp_4x2_0.stdp_4.vw vpre2.t2 a_55466_53749# avss.t63 nfet_03v3 ad=0.3p pd=2.2u as=0.3p ps=2.2u w=0.5u l=0.63u
X268 vpost1.t1 layer_output_0.nvout_1 avdd.t65 avdd.t64 pfet_03v3 ad=0.375p pd=2.5u as=0.375p ps=2.5u w=0.5u l=0.28u
X269 stdp_4x2_0.stdp_5.vw avss.t91 cap_mim_2f0_m4m5_noshield c_width=5u c_length=5u
X270 stdp_4x2_0.stdp_5.vw avss.t91 cap_mim_2f0_m4m5_noshield c_width=5u c_length=5u
X271 a_58302_64741# current_mirror_0.B avdd.t101 avdd.t100 pfet_03v3 ad=6.12p pd=21.6u as=6.12p ps=21.6u w=10.2u l=2.8u
X272 a_58428_44960# current_mirror_0.A avss.t158 avss.t157 nfet_03v3 ad=0.366p pd=2.42u as=0.366p ps=2.42u w=0.61u l=2.8u
X273 stdp_4x2_0.stdp_2.vw avss.t37 cap_mim_2f0_m4m5_noshield c_width=5u c_length=5u
X274 vw11.t1 layer_output_0.nvout_1 a_35712_67160# avdd.t58 pfet_03v3 ad=0.3p pd=2.2u as=0.3p ps=2.2u w=0.5u l=0.63u
X275 a_56944_64741# current_mirror_0.A a_57586_63369# avss.t133 nfet_03v3 ad=0.3p pd=2.2u as=0.3p ps=2.2u w=0.5u l=10u
X276 layer_input_0.nvout_1 layer_input_0.Iext1 avdd.t77 avdd.t76 pfet_03v3 ad=0.375p pd=2.5u as=0.375p ps=2.5u w=0.5u l=0.28u
X277 a_8786_49529# layer_input_0.nvout_2 avdd.t24 avdd.t23 pfet_03v3 ad=0.375p pd=2.5u as=0.375p ps=2.5u w=0.5u l=0.28u
X278 stdp_4x2_0.Current_limit_1.i_SUM stdp_4x2_0.stdp_2.vw avdd.t28 avdd.t27 pfet_03v3 ad=0.3p pd=2.2u as=0.3p ps=2.2u w=0.5u l=15u
X279 a_55466_52169# current_mirror_0.A a_58698_52169# avss.t151 nfet_03v3 ad=0.3p pd=2.2u as=0.3p ps=2.2u w=0.5u l=10u
X280 a_55466_42749# a_56944_42541# avss.t67 avss.t66 nfet_03v3 ad=0.3p pd=2.2u as=0.3p ps=2.2u w=0.5u l=0.63u
X281 avdd.t168 a_35586_66952# cap_mim_2f0_m4m5_noshield c_width=5u c_length=5u
X282 stdp_4x2_0.stdp_0.vw avss.t68 cap_mim_2f0_m4m5_noshield c_width=5u c_length=5u
X283 a_58698_63369# current_mirror_0.A a_61930_63369# avss.t141 nfet_03v3 ad=0.3p pd=2.2u as=0.3p ps=2.2u w=0.5u l=10u
X284 vpre1.t1 layer_input_0.nvout_1 avdd.t83 avdd.t82 pfet_03v3 ad=0.375p pd=2.5u as=0.375p ps=2.5u w=0.5u l=0.28u
X285 stdp_4x2_0.stdp_5.vw avss.t93 cap_mim_2f0_m4m5_noshield c_width=5u c_length=5u
X286 stdp_4x2_0.stdp_0.vw avss.t68 cap_mim_2f0_m4m5_noshield c_width=5u c_length=5u
X287 a_41930_63369# current_mirror_0.A avss.t138 avss.t137 nfet_03v3 ad=0.3p pd=2.2u as=0.3p ps=2.2u w=0.5u l=10u
X288 layer_input_0.nvout_3 layer_input_0.Iext3 avdd.t137 avdd.t136 pfet_03v3 ad=0.375p pd=2.5u as=0.375p ps=2.5u w=0.5u l=0.28u
X289 a_36944_53541# avss.t200 cap_mim_2f0_m4m5_noshield c_width=5u c_length=5u
X290 avdd.t159 a_55586_55752# cap_mim_2f0_m4m5_noshield c_width=5u c_length=5u
X291 a_38302_53541# current_mirror_0.B avdd.t103 avdd.t102 pfet_03v3 ad=6.12p pd=21.6u as=6.12p ps=21.6u w=10.2u l=2.8u
X292 layer_output_0.nvout_1 layer_output_0.Iext1 avdd.t45 avdd.t44 pfet_03v3 ad=0.375p pd=2.5u as=0.375p ps=2.5u w=0.5u l=0.28u
X293 stdp_4x2_0.stdp_3.vw avss.t46 cap_mim_2f0_m4m5_noshield c_width=5u c_length=5u
X294 layer_input_0.vout_3 layer_input_0.nvout_3 avdd.t18 avdd.t17 pfet_03v3 ad=0.375p pd=2.5u as=0.375p ps=2.5u w=0.5u l=0.28u
X295 a_38302_33752# layer_input_0.nvout_4 a_35586_33752# avdd.t33 pfet_03v3 ad=0.3p pd=2.2u as=0.3p ps=2.2u w=0.5u l=0.63u
X296 a_36944_53541# current_mirror_0.A a_37586_52169# avss.t132 nfet_03v3 ad=0.3p pd=2.2u as=0.3p ps=2.2u w=0.5u l=10u
X297 a_38428_67160# a_38302_66952# avdd.t69 avdd.t68 pfet_03v3 ad=0.3p pd=2.2u as=0.3p ps=2.2u w=0.5u l=0.63u
X298 a_55586_66952# current_mirror_0.B avdd.t95 avdd.t94 pfet_03v3 ad=0.3p pd=2.2u as=0.3p ps=2.2u w=0.5u l=4.6u
X299 stdp_4x2_0.stdp_6.vw avss.t77 cap_mim_2f0_m4m5_noshield c_width=5u c_length=5u
X300 a_58302_53541# vpost2.t4 a_56944_53541# avss.t24 nfet_03v3 ad=0.3p pd=2.2u as=0.3p ps=2.2u w=0.5u l=0.63u
X301 a_58302_42541# a_58302_42541# avss.t199 avss.t198 nfet_03v3 ad=0.3p pd=2.2u as=0.3p ps=2.2u w=0.5u l=0.63u
X302 layer_input_0.Iext3 avss.t186 cap_mim_2f0_m4m5_noshield c_width=28u c_length=5u
X303 vw11.t0 vpre1.t3 a_35466_64949# avss.t27 nfet_03v3 ad=0.3p pd=2.2u as=0.3p ps=2.2u w=0.5u l=0.63u
X304 a_35586_55752# current_mirror_0.B avdd.t93 avdd.t92 pfet_03v3 ad=0.3p pd=2.2u as=0.3p ps=2.2u w=0.5u l=4.6u
X305 a_38698_52169# current_mirror_0.A a_41930_52169# avss.t148 nfet_03v3 ad=0.3p pd=2.2u as=0.3p ps=2.2u w=0.5u l=10u
X306 a_35712_44960# a_35586_44752# avdd.t75 avdd.t74 pfet_03v3 ad=0.3p pd=2.2u as=0.3p ps=2.2u w=0.5u l=0.63u
X307 stdp_4x2_0.stdp_2.vw avss.t36 cap_mim_2f0_m4m5_noshield c_width=5u c_length=5u
X308 current_mirror_0.B current_mirror_0.A avss.t183 avss.t182 nfet_03v3 ad=2.4p pd=9.2u as=2.4p ps=9.2u w=4u l=4u
X309 vw11.t8 avss.t42 cap_mim_2f0_m4m5_noshield c_width=5u c_length=5u
X310 stdp_4x2_0.stdp_2.vw avss.t36 cap_mim_2f0_m4m5_noshield c_width=5u c_length=5u
X311 a_57586_41169# current_mirror_0.A a_55466_41169# avss.t162 nfet_03v3 ad=0.3p pd=2.2u as=0.3p ps=2.2u w=0.5u l=10u
X312 avdd.t157 a_55586_44752# cap_mim_2f0_m4m5_noshield c_width=5u c_length=5u
X313 a_36944_42541# avss.t12 cap_mim_2f0_m4m5_noshield c_width=5u c_length=5u
X314 vw42.t7 avss.t56 cap_mim_2f0_m4m5_noshield c_width=5u c_length=5u
X315 stdp_4x2_0.stdp_4.vw avss.t195 cap_mim_2f0_m4m5_noshield c_width=5u c_length=5u
X316 stdp_4x2_0.stdp_4.vw avss.t195 cap_mim_2f0_m4m5_noshield c_width=5u c_length=5u
R0 vw42 vw42.n136 47.0682
R1 vw42.n129 vw42.t0 29.5281
R2 vw42.n130 vw42.t1 26.2938
R3 vw42.n129 vw42.t12 16.8801
R4 vw42.n131 vw42.n130 11.0327
R5 vw42 vw42.n133 9.0005
R6 vw42.n136 vw42.n135 4.6445
R7 vw42.n132 vw42.n131 4.51898
R8 vw42.n133 vw42.n132 4.5077
R9 vw42.n133 vw42.n0 4.5077
R10 vw42.n95 vw42.n75 4.5005
R11 vw42.n95 vw42.t2 4.5005
R12 vw42.n95 vw42.n76 4.5005
R13 vw42.n95 vw42.n73 4.5005
R14 vw42.n91 vw42.n73 4.5005
R15 vw42.n82 vw42.t2 4.5005
R16 vw42.n82 vw42.n76 4.5005
R17 vw42.n82 vw42.n73 4.5005
R18 vw42.n93 vw42.t2 4.5005
R19 vw42.n93 vw42.n76 4.5005
R20 vw42.n93 vw42.n73 4.5005
R21 vw42.n95 vw42.n77 4.5005
R22 vw42.n95 vw42.n72 4.5005
R23 vw42.n95 vw42.n94 4.5005
R24 vw42.n91 vw42.n77 4.5005
R25 vw42.n82 vw42.n77 4.5005
R26 vw42.n82 vw42.n72 4.5005
R27 vw42.t3 vw42.n82 4.5005
R28 vw42.n83 vw42.n82 4.5005
R29 vw42.n94 vw42.n82 4.5005
R30 vw42.n80 vw42.n77 4.5005
R31 vw42.n80 vw42.n72 4.5005
R32 vw42.t3 vw42.n80 4.5005
R33 vw42.n94 vw42.n80 4.5005
R34 vw42.n93 vw42.t3 4.5005
R35 vw42.n94 vw42.n93 4.5005
R36 vw42.n103 vw42.n58 4.5005
R37 vw42.n103 vw42.t4 4.5005
R38 vw42.n103 vw42.n59 4.5005
R39 vw42.n103 vw42.n56 4.5005
R40 vw42.n99 vw42.n56 4.5005
R41 vw42.n65 vw42.t4 4.5005
R42 vw42.n65 vw42.n59 4.5005
R43 vw42.n65 vw42.n56 4.5005
R44 vw42.n101 vw42.t4 4.5005
R45 vw42.n101 vw42.n59 4.5005
R46 vw42.n101 vw42.n56 4.5005
R47 vw42.n103 vw42.n60 4.5005
R48 vw42.n103 vw42.n55 4.5005
R49 vw42.n103 vw42.n102 4.5005
R50 vw42.n99 vw42.n60 4.5005
R51 vw42.n65 vw42.n60 4.5005
R52 vw42.n65 vw42.n55 4.5005
R53 vw42.t5 vw42.n65 4.5005
R54 vw42.n66 vw42.n65 4.5005
R55 vw42.n102 vw42.n65 4.5005
R56 vw42.n63 vw42.n60 4.5005
R57 vw42.n63 vw42.n55 4.5005
R58 vw42.t5 vw42.n63 4.5005
R59 vw42.n102 vw42.n63 4.5005
R60 vw42.n101 vw42.t5 4.5005
R61 vw42.n102 vw42.n101 4.5005
R62 vw42.n111 vw42.n41 4.5005
R63 vw42.n111 vw42.t6 4.5005
R64 vw42.n111 vw42.n42 4.5005
R65 vw42.n111 vw42.n39 4.5005
R66 vw42.n107 vw42.n39 4.5005
R67 vw42.n48 vw42.t6 4.5005
R68 vw42.n48 vw42.n42 4.5005
R69 vw42.n48 vw42.n39 4.5005
R70 vw42.n109 vw42.t6 4.5005
R71 vw42.n109 vw42.n42 4.5005
R72 vw42.n109 vw42.n39 4.5005
R73 vw42.n111 vw42.n43 4.5005
R74 vw42.n111 vw42.n38 4.5005
R75 vw42.n111 vw42.n110 4.5005
R76 vw42.n107 vw42.n43 4.5005
R77 vw42.n48 vw42.n43 4.5005
R78 vw42.n48 vw42.n38 4.5005
R79 vw42.t7 vw42.n48 4.5005
R80 vw42.n49 vw42.n48 4.5005
R81 vw42.n110 vw42.n48 4.5005
R82 vw42.n46 vw42.n43 4.5005
R83 vw42.n46 vw42.n38 4.5005
R84 vw42.t7 vw42.n46 4.5005
R85 vw42.n110 vw42.n46 4.5005
R86 vw42.n109 vw42.t7 4.5005
R87 vw42.n110 vw42.n109 4.5005
R88 vw42.n119 vw42.n24 4.5005
R89 vw42.n119 vw42.t8 4.5005
R90 vw42.n119 vw42.n25 4.5005
R91 vw42.n119 vw42.n22 4.5005
R92 vw42.n115 vw42.n22 4.5005
R93 vw42.n31 vw42.t8 4.5005
R94 vw42.n31 vw42.n25 4.5005
R95 vw42.n31 vw42.n22 4.5005
R96 vw42.n117 vw42.t8 4.5005
R97 vw42.n117 vw42.n25 4.5005
R98 vw42.n117 vw42.n22 4.5005
R99 vw42.n119 vw42.n26 4.5005
R100 vw42.n119 vw42.n21 4.5005
R101 vw42.n119 vw42.n118 4.5005
R102 vw42.n115 vw42.n26 4.5005
R103 vw42.n31 vw42.n26 4.5005
R104 vw42.n31 vw42.n21 4.5005
R105 vw42.t9 vw42.n31 4.5005
R106 vw42.n32 vw42.n31 4.5005
R107 vw42.n118 vw42.n31 4.5005
R108 vw42.n29 vw42.n26 4.5005
R109 vw42.n29 vw42.n21 4.5005
R110 vw42.t9 vw42.n29 4.5005
R111 vw42.n118 vw42.n29 4.5005
R112 vw42.n117 vw42.t9 4.5005
R113 vw42.n118 vw42.n117 4.5005
R114 vw42.n127 vw42.n7 4.5005
R115 vw42.n127 vw42.t10 4.5005
R116 vw42.n127 vw42.n8 4.5005
R117 vw42.n127 vw42.n5 4.5005
R118 vw42.n123 vw42.n5 4.5005
R119 vw42.n14 vw42.t10 4.5005
R120 vw42.n14 vw42.n8 4.5005
R121 vw42.n14 vw42.n5 4.5005
R122 vw42.n125 vw42.t10 4.5005
R123 vw42.n125 vw42.n8 4.5005
R124 vw42.n125 vw42.n5 4.5005
R125 vw42.n127 vw42.n9 4.5005
R126 vw42.n127 vw42.n4 4.5005
R127 vw42.n127 vw42.n126 4.5005
R128 vw42.n123 vw42.n9 4.5005
R129 vw42.n14 vw42.n9 4.5005
R130 vw42.n14 vw42.n4 4.5005
R131 vw42.t11 vw42.n14 4.5005
R132 vw42.n15 vw42.n14 4.5005
R133 vw42.n126 vw42.n14 4.5005
R134 vw42.n12 vw42.n9 4.5005
R135 vw42.n12 vw42.n4 4.5005
R136 vw42.t11 vw42.n12 4.5005
R137 vw42.n126 vw42.n12 4.5005
R138 vw42.n125 vw42.t11 4.5005
R139 vw42.n126 vw42.n125 4.5005
R140 vw42.n128 vw42.n2 4.5005
R141 vw42 vw42.n1 4.5005
R142 vw42.n135 vw42.n134 4.5005
R143 vw42.n86 vw42.n74 2.25044
R144 vw42.n90 vw42.n75 2.25044
R145 vw42.n86 vw42.n85 2.25044
R146 vw42.n84 vw42.n83 2.25044
R147 vw42.n69 vw42.n57 2.25044
R148 vw42.n98 vw42.n58 2.25044
R149 vw42.n69 vw42.n68 2.25044
R150 vw42.n67 vw42.n66 2.25044
R151 vw42.n52 vw42.n40 2.25044
R152 vw42.n106 vw42.n41 2.25044
R153 vw42.n52 vw42.n51 2.25044
R154 vw42.n50 vw42.n49 2.25044
R155 vw42.n35 vw42.n23 2.25044
R156 vw42.n114 vw42.n24 2.25044
R157 vw42.n35 vw42.n34 2.25044
R158 vw42.n33 vw42.n32 2.25044
R159 vw42.n18 vw42.n6 2.25044
R160 vw42.n122 vw42.n7 2.25044
R161 vw42.n18 vw42.n17 2.25044
R162 vw42.n16 vw42.n15 2.25044
R163 vw42.n91 vw42.n89 2.24741
R164 vw42.n80 vw42.n78 2.24741
R165 vw42.n80 vw42.n79 2.24741
R166 vw42.n93 vw42.n87 2.24741
R167 vw42.n95 vw42.n71 2.24741
R168 vw42.n92 vw42.n91 2.24741
R169 vw42.n91 vw42.n81 2.24741
R170 vw42.n93 vw42.n88 2.24741
R171 vw42.n99 vw42.n97 2.24741
R172 vw42.n63 vw42.n61 2.24741
R173 vw42.n63 vw42.n62 2.24741
R174 vw42.n101 vw42.n70 2.24741
R175 vw42.n103 vw42.n54 2.24741
R176 vw42.n100 vw42.n99 2.24741
R177 vw42.n99 vw42.n64 2.24741
R178 vw42.n101 vw42.n96 2.24741
R179 vw42.n107 vw42.n105 2.24741
R180 vw42.n46 vw42.n44 2.24741
R181 vw42.n46 vw42.n45 2.24741
R182 vw42.n109 vw42.n53 2.24741
R183 vw42.n111 vw42.n37 2.24741
R184 vw42.n108 vw42.n107 2.24741
R185 vw42.n107 vw42.n47 2.24741
R186 vw42.n109 vw42.n104 2.24741
R187 vw42.n115 vw42.n113 2.24741
R188 vw42.n29 vw42.n27 2.24741
R189 vw42.n29 vw42.n28 2.24741
R190 vw42.n117 vw42.n36 2.24741
R191 vw42.n119 vw42.n20 2.24741
R192 vw42.n116 vw42.n115 2.24741
R193 vw42.n115 vw42.n30 2.24741
R194 vw42.n117 vw42.n112 2.24741
R195 vw42.n123 vw42.n121 2.24741
R196 vw42.n12 vw42.n10 2.24741
R197 vw42.n12 vw42.n11 2.24741
R198 vw42.n125 vw42.n19 2.24741
R199 vw42.n127 vw42.n3 2.24741
R200 vw42.n124 vw42.n123 2.24741
R201 vw42.n123 vw42.n13 2.24741
R202 vw42.n125 vw42.n120 2.24741
R203 vw42.n130 vw42.n129 1.1363
R204 vw42.n135 vw42.n1 0.1445
R205 vw42.n128 vw42.n1 0.1445
R206 vw42.n131 vw42.n128 0.1445
R207 vw42.n134 vw42 0.0365
R208 vw42 vw42.n2 0.0365
R209 vw42.n136 vw42.n0 0.0189766
R210 vw42.n134 vw42.n0 0.0189516
R211 vw42.n132 vw42.n2 0.0189516
R212 vw42.n125 vw42.n119 0.0121667
R213 vw42.n117 vw42.n111 0.0121667
R214 vw42.n109 vw42.n103 0.0121667
R215 vw42.n101 vw42.n95 0.0121667
R216 vw42.n15 vw42.n13 0.0081885
R217 vw42.n15 vw42.n3 0.0081885
R218 vw42.n124 vw42.n4 0.0081885
R219 vw42.n120 vw42.n9 0.0081885
R220 vw42.n11 vw42.n8 0.0081885
R221 vw42.n121 vw42.t10 0.0081885
R222 vw42.n10 vw42.n7 0.0081885
R223 vw42.n19 vw42.n18 0.0081885
R224 vw42.n32 vw42.n30 0.0081885
R225 vw42.n32 vw42.n20 0.0081885
R226 vw42.n116 vw42.n21 0.0081885
R227 vw42.n112 vw42.n26 0.0081885
R228 vw42.n28 vw42.n25 0.0081885
R229 vw42.n113 vw42.t8 0.0081885
R230 vw42.n27 vw42.n24 0.0081885
R231 vw42.n36 vw42.n35 0.0081885
R232 vw42.n49 vw42.n47 0.0081885
R233 vw42.n49 vw42.n37 0.0081885
R234 vw42.n108 vw42.n38 0.0081885
R235 vw42.n104 vw42.n43 0.0081885
R236 vw42.n45 vw42.n42 0.0081885
R237 vw42.n105 vw42.t6 0.0081885
R238 vw42.n44 vw42.n41 0.0081885
R239 vw42.n53 vw42.n52 0.0081885
R240 vw42.n66 vw42.n64 0.0081885
R241 vw42.n66 vw42.n54 0.0081885
R242 vw42.n100 vw42.n55 0.0081885
R243 vw42.n96 vw42.n60 0.0081885
R244 vw42.n62 vw42.n59 0.0081885
R245 vw42.n97 vw42.t4 0.0081885
R246 vw42.n61 vw42.n58 0.0081885
R247 vw42.n70 vw42.n69 0.0081885
R248 vw42.n83 vw42.n81 0.0081885
R249 vw42.n83 vw42.n71 0.0081885
R250 vw42.n92 vw42.n72 0.0081885
R251 vw42.n88 vw42.n77 0.0081885
R252 vw42.n79 vw42.n76 0.0081885
R253 vw42.n89 vw42.t2 0.0081885
R254 vw42.n78 vw42.n75 0.0081885
R255 vw42.n87 vw42.n86 0.0081885
R256 vw42.n89 vw42.n76 0.0081885
R257 vw42.n78 vw42.t2 0.0081885
R258 vw42.n79 vw42.n73 0.0081885
R259 vw42.n87 vw42.n75 0.0081885
R260 vw42.t3 vw42.n71 0.0081885
R261 vw42.t3 vw42.n92 0.0081885
R262 vw42.n94 vw42.n81 0.0081885
R263 vw42.n88 vw42.n72 0.0081885
R264 vw42.n97 vw42.n59 0.0081885
R265 vw42.n61 vw42.t4 0.0081885
R266 vw42.n62 vw42.n56 0.0081885
R267 vw42.n70 vw42.n58 0.0081885
R268 vw42.t5 vw42.n54 0.0081885
R269 vw42.t5 vw42.n100 0.0081885
R270 vw42.n102 vw42.n64 0.0081885
R271 vw42.n96 vw42.n55 0.0081885
R272 vw42.n105 vw42.n42 0.0081885
R273 vw42.n44 vw42.t6 0.0081885
R274 vw42.n45 vw42.n39 0.0081885
R275 vw42.n53 vw42.n41 0.0081885
R276 vw42.t7 vw42.n37 0.0081885
R277 vw42.t7 vw42.n108 0.0081885
R278 vw42.n110 vw42.n47 0.0081885
R279 vw42.n104 vw42.n38 0.0081885
R280 vw42.n113 vw42.n25 0.0081885
R281 vw42.n27 vw42.t8 0.0081885
R282 vw42.n28 vw42.n22 0.0081885
R283 vw42.n36 vw42.n24 0.0081885
R284 vw42.t9 vw42.n20 0.0081885
R285 vw42.t9 vw42.n116 0.0081885
R286 vw42.n118 vw42.n30 0.0081885
R287 vw42.n112 vw42.n21 0.0081885
R288 vw42.n121 vw42.n8 0.0081885
R289 vw42.n10 vw42.t10 0.0081885
R290 vw42.n11 vw42.n5 0.0081885
R291 vw42.n19 vw42.n7 0.0081885
R292 vw42.t11 vw42.n3 0.0081885
R293 vw42.t11 vw42.n124 0.0081885
R294 vw42.n126 vw42.n13 0.0081885
R295 vw42.n120 vw42.n4 0.0081885
R296 vw42.n133 vw42.n127 0.00577778
R297 vw42.n123 vw42.n6 0.00211084
R298 vw42.n123 vw42.n122 0.00211084
R299 vw42.n17 vw42.n12 0.00211084
R300 vw42.n125 vw42.n16 0.00211084
R301 vw42.n115 vw42.n23 0.00211084
R302 vw42.n115 vw42.n114 0.00211084
R303 vw42.n34 vw42.n29 0.00211084
R304 vw42.n117 vw42.n33 0.00211084
R305 vw42.n107 vw42.n40 0.00211084
R306 vw42.n107 vw42.n106 0.00211084
R307 vw42.n51 vw42.n46 0.00211084
R308 vw42.n109 vw42.n50 0.00211084
R309 vw42.n99 vw42.n57 0.00211084
R310 vw42.n99 vw42.n98 0.00211084
R311 vw42.n68 vw42.n63 0.00211084
R312 vw42.n101 vw42.n67 0.00211084
R313 vw42.n91 vw42.n74 0.00211084
R314 vw42.n91 vw42.n90 0.00211084
R315 vw42.n85 vw42.n80 0.00211084
R316 vw42.n93 vw42.n84 0.00211084
R317 vw42.n95 vw42.n74 0.00211084
R318 vw42.n85 vw42.n82 0.00211084
R319 vw42.n90 vw42.n82 0.00211084
R320 vw42.n84 vw42.n80 0.00211084
R321 vw42.n103 vw42.n57 0.00211084
R322 vw42.n68 vw42.n65 0.00211084
R323 vw42.n98 vw42.n65 0.00211084
R324 vw42.n67 vw42.n63 0.00211084
R325 vw42.n111 vw42.n40 0.00211084
R326 vw42.n51 vw42.n48 0.00211084
R327 vw42.n106 vw42.n48 0.00211084
R328 vw42.n50 vw42.n46 0.00211084
R329 vw42.n119 vw42.n23 0.00211084
R330 vw42.n34 vw42.n31 0.00211084
R331 vw42.n114 vw42.n31 0.00211084
R332 vw42.n33 vw42.n29 0.00211084
R333 vw42.n127 vw42.n6 0.00211084
R334 vw42.n17 vw42.n14 0.00211084
R335 vw42.n122 vw42.n14 0.00211084
R336 vw42.n16 vw42.n12 0.00211084
R337 vpre2.n3 vpre2 56.4209
R338 vpre2.n0 vpre2 34.2319
R339 vpre2 vpre2.t3 29.0513
R340 vpre2 vpre2.t2 29.0513
R341 vpre2.n1 vpre2.t0 28.4508
R342 vpre2.n4 vpre2.n3 23.6577
R343 vpre2.n4 vpre2.n0 22.7416
R344 vpre2.n2 vpre2 22.4571
R345 vpre2.n1 vpre2.t1 16.2546
R346 vpre2 vpre2.n1 15.8855
R347 vpre2.n3 vpre2.n2 14.233
R348 vpre2.n0 vpre2 4.56565
R349 vpre2 vpre2.n4 0.0583571
R350 vpre2.n2 vpre2 0.01562
R351 vpost2 vpost2.n2 45.1502
R352 vpost2.n2 vpost2.n1 43.9205
R353 vpost2.n1 vpost2 30.2509
R354 vpost2 vpost2.t2 29.0513
R355 vpost2 vpost2.t3 29.0513
R356 vpost2 vpost2.t4 29.0513
R357 vpost2 vpost2.t5 29.0513
R358 vpost2.n0 vpost2.t1 28.4508
R359 vpost2.n2 vpost2 20.3855
R360 vpost2.n0 vpost2.t0 16.2546
R361 vpost2 vpost2.n0 15.8855
R362 vpost2.n1 vpost2 0.1565
R363 vpost1.n4 vpost1 55.8262
R364 vpost1.n4 vpost1 40.5455
R365 vpost1.n4 vpost1.n3 31.9999
R366 vpost1 vpost1.t2 29.0513
R367 vpost1 vpost1.t5 29.0513
R368 vpost1 vpost1.t4 29.0513
R369 vpost1 vpost1.t3 29.0513
R370 vpost1.n2 vpost1.t0 28.4508
R371 vpost1 vpost1.n1 23.1803
R372 vpost1.n0 vpost1 23.1056
R373 vpost1.n1 vpost1.n0 17.6405
R374 vpost1.n2 vpost1.t1 16.2546
R375 vpost1.n3 vpost1.n2 15.8855
R376 vpost1.n1 vpost1 5.66255
R377 vpost1.n0 vpost1 5.36032
R378 vpost1 vpost1.n4 0.0221
R379 vpost1.n3 vpost1 0.01175
R380 vpre1.n1 vpre1 70.2905
R381 vpre1.n2 vpre1.n1 29.6105
R382 vpre1 vpre1.t3 29.0513
R383 vpre1 vpre1.t2 29.0513
R384 vpre1.n0 vpre1.t0 28.4508
R385 vpre1.n2 vpre1 24.454
R386 vpre1.n0 vpre1.t1 16.2546
R387 vpre1 vpre1.n0 15.8855
R388 vpre1.n1 vpre1 0.606929
R389 vpre1 vpre1.n2 0.238357
R390 vw11.n137 vw11 42.8635
R391 vw11.n129 vw11.t0 29.5281
R392 vw11.n130 vw11.t1 26.2938
R393 vw11.n129 vw11.t12 16.8801
R394 vw11.n131 vw11.n130 11.0327
R395 vw11.n137 vw11.n136 9.60636
R396 vw11 vw11.n133 9.0005
R397 vw11.n136 vw11.n135 4.6445
R398 vw11.n132 vw11.n131 4.51898
R399 vw11.n133 vw11.n132 4.5077
R400 vw11.n133 vw11.n0 4.5077
R401 vw11.n95 vw11.n75 4.5005
R402 vw11.n95 vw11.t2 4.5005
R403 vw11.n95 vw11.n76 4.5005
R404 vw11.n95 vw11.n73 4.5005
R405 vw11.n91 vw11.n73 4.5005
R406 vw11.n82 vw11.t2 4.5005
R407 vw11.n82 vw11.n76 4.5005
R408 vw11.n82 vw11.n73 4.5005
R409 vw11.n93 vw11.t2 4.5005
R410 vw11.n93 vw11.n76 4.5005
R411 vw11.n93 vw11.n73 4.5005
R412 vw11.n95 vw11.n77 4.5005
R413 vw11.n95 vw11.n72 4.5005
R414 vw11.n95 vw11.n94 4.5005
R415 vw11.n91 vw11.n77 4.5005
R416 vw11.n82 vw11.n77 4.5005
R417 vw11.n82 vw11.n72 4.5005
R418 vw11.t3 vw11.n82 4.5005
R419 vw11.n83 vw11.n82 4.5005
R420 vw11.n94 vw11.n82 4.5005
R421 vw11.n80 vw11.n77 4.5005
R422 vw11.n80 vw11.n72 4.5005
R423 vw11.t3 vw11.n80 4.5005
R424 vw11.n94 vw11.n80 4.5005
R425 vw11.n93 vw11.t3 4.5005
R426 vw11.n94 vw11.n93 4.5005
R427 vw11.n103 vw11.n58 4.5005
R428 vw11.n103 vw11.t4 4.5005
R429 vw11.n103 vw11.n59 4.5005
R430 vw11.n103 vw11.n56 4.5005
R431 vw11.n99 vw11.n56 4.5005
R432 vw11.n65 vw11.t4 4.5005
R433 vw11.n65 vw11.n59 4.5005
R434 vw11.n65 vw11.n56 4.5005
R435 vw11.n101 vw11.t4 4.5005
R436 vw11.n101 vw11.n59 4.5005
R437 vw11.n101 vw11.n56 4.5005
R438 vw11.n103 vw11.n60 4.5005
R439 vw11.n103 vw11.n55 4.5005
R440 vw11.n103 vw11.n102 4.5005
R441 vw11.n99 vw11.n60 4.5005
R442 vw11.n65 vw11.n60 4.5005
R443 vw11.n65 vw11.n55 4.5005
R444 vw11.t5 vw11.n65 4.5005
R445 vw11.n66 vw11.n65 4.5005
R446 vw11.n102 vw11.n65 4.5005
R447 vw11.n63 vw11.n60 4.5005
R448 vw11.n63 vw11.n55 4.5005
R449 vw11.t5 vw11.n63 4.5005
R450 vw11.n102 vw11.n63 4.5005
R451 vw11.n101 vw11.t5 4.5005
R452 vw11.n102 vw11.n101 4.5005
R453 vw11.n111 vw11.n41 4.5005
R454 vw11.n111 vw11.t6 4.5005
R455 vw11.n111 vw11.n42 4.5005
R456 vw11.n111 vw11.n39 4.5005
R457 vw11.n107 vw11.n39 4.5005
R458 vw11.n48 vw11.t6 4.5005
R459 vw11.n48 vw11.n42 4.5005
R460 vw11.n48 vw11.n39 4.5005
R461 vw11.n109 vw11.t6 4.5005
R462 vw11.n109 vw11.n42 4.5005
R463 vw11.n109 vw11.n39 4.5005
R464 vw11.n111 vw11.n43 4.5005
R465 vw11.n111 vw11.n38 4.5005
R466 vw11.n111 vw11.n110 4.5005
R467 vw11.n107 vw11.n43 4.5005
R468 vw11.n48 vw11.n43 4.5005
R469 vw11.n48 vw11.n38 4.5005
R470 vw11.t7 vw11.n48 4.5005
R471 vw11.n49 vw11.n48 4.5005
R472 vw11.n110 vw11.n48 4.5005
R473 vw11.n46 vw11.n43 4.5005
R474 vw11.n46 vw11.n38 4.5005
R475 vw11.t7 vw11.n46 4.5005
R476 vw11.n110 vw11.n46 4.5005
R477 vw11.n109 vw11.t7 4.5005
R478 vw11.n110 vw11.n109 4.5005
R479 vw11.n119 vw11.n24 4.5005
R480 vw11.n119 vw11.t8 4.5005
R481 vw11.n119 vw11.n25 4.5005
R482 vw11.n119 vw11.n22 4.5005
R483 vw11.n115 vw11.n22 4.5005
R484 vw11.n31 vw11.t8 4.5005
R485 vw11.n31 vw11.n25 4.5005
R486 vw11.n31 vw11.n22 4.5005
R487 vw11.n117 vw11.t8 4.5005
R488 vw11.n117 vw11.n25 4.5005
R489 vw11.n117 vw11.n22 4.5005
R490 vw11.n119 vw11.n26 4.5005
R491 vw11.n119 vw11.n21 4.5005
R492 vw11.n119 vw11.n118 4.5005
R493 vw11.n115 vw11.n26 4.5005
R494 vw11.n31 vw11.n26 4.5005
R495 vw11.n31 vw11.n21 4.5005
R496 vw11.t9 vw11.n31 4.5005
R497 vw11.n32 vw11.n31 4.5005
R498 vw11.n118 vw11.n31 4.5005
R499 vw11.n29 vw11.n26 4.5005
R500 vw11.n29 vw11.n21 4.5005
R501 vw11.t9 vw11.n29 4.5005
R502 vw11.n118 vw11.n29 4.5005
R503 vw11.n117 vw11.t9 4.5005
R504 vw11.n118 vw11.n117 4.5005
R505 vw11.n127 vw11.n7 4.5005
R506 vw11.n127 vw11.t10 4.5005
R507 vw11.n127 vw11.n8 4.5005
R508 vw11.n127 vw11.n5 4.5005
R509 vw11.n123 vw11.n5 4.5005
R510 vw11.n14 vw11.t10 4.5005
R511 vw11.n14 vw11.n8 4.5005
R512 vw11.n14 vw11.n5 4.5005
R513 vw11.n125 vw11.t10 4.5005
R514 vw11.n125 vw11.n8 4.5005
R515 vw11.n125 vw11.n5 4.5005
R516 vw11.n127 vw11.n9 4.5005
R517 vw11.n127 vw11.n4 4.5005
R518 vw11.n127 vw11.n126 4.5005
R519 vw11.n123 vw11.n9 4.5005
R520 vw11.n14 vw11.n9 4.5005
R521 vw11.n14 vw11.n4 4.5005
R522 vw11.t11 vw11.n14 4.5005
R523 vw11.n15 vw11.n14 4.5005
R524 vw11.n126 vw11.n14 4.5005
R525 vw11.n12 vw11.n9 4.5005
R526 vw11.n12 vw11.n4 4.5005
R527 vw11.t11 vw11.n12 4.5005
R528 vw11.n126 vw11.n12 4.5005
R529 vw11.n125 vw11.t11 4.5005
R530 vw11.n126 vw11.n125 4.5005
R531 vw11.n128 vw11.n2 4.5005
R532 vw11 vw11.n1 4.5005
R533 vw11.n135 vw11.n134 4.5005
R534 vw11.n86 vw11.n74 2.25044
R535 vw11.n90 vw11.n75 2.25044
R536 vw11.n86 vw11.n85 2.25044
R537 vw11.n84 vw11.n83 2.25044
R538 vw11.n69 vw11.n57 2.25044
R539 vw11.n98 vw11.n58 2.25044
R540 vw11.n69 vw11.n68 2.25044
R541 vw11.n67 vw11.n66 2.25044
R542 vw11.n52 vw11.n40 2.25044
R543 vw11.n106 vw11.n41 2.25044
R544 vw11.n52 vw11.n51 2.25044
R545 vw11.n50 vw11.n49 2.25044
R546 vw11.n35 vw11.n23 2.25044
R547 vw11.n114 vw11.n24 2.25044
R548 vw11.n35 vw11.n34 2.25044
R549 vw11.n33 vw11.n32 2.25044
R550 vw11.n18 vw11.n6 2.25044
R551 vw11.n122 vw11.n7 2.25044
R552 vw11.n18 vw11.n17 2.25044
R553 vw11.n16 vw11.n15 2.25044
R554 vw11.n91 vw11.n89 2.24741
R555 vw11.n80 vw11.n78 2.24741
R556 vw11.n80 vw11.n79 2.24741
R557 vw11.n93 vw11.n87 2.24741
R558 vw11.n95 vw11.n71 2.24741
R559 vw11.n92 vw11.n91 2.24741
R560 vw11.n91 vw11.n81 2.24741
R561 vw11.n93 vw11.n88 2.24741
R562 vw11.n99 vw11.n97 2.24741
R563 vw11.n63 vw11.n61 2.24741
R564 vw11.n63 vw11.n62 2.24741
R565 vw11.n101 vw11.n70 2.24741
R566 vw11.n103 vw11.n54 2.24741
R567 vw11.n100 vw11.n99 2.24741
R568 vw11.n99 vw11.n64 2.24741
R569 vw11.n101 vw11.n96 2.24741
R570 vw11.n107 vw11.n105 2.24741
R571 vw11.n46 vw11.n44 2.24741
R572 vw11.n46 vw11.n45 2.24741
R573 vw11.n109 vw11.n53 2.24741
R574 vw11.n111 vw11.n37 2.24741
R575 vw11.n108 vw11.n107 2.24741
R576 vw11.n107 vw11.n47 2.24741
R577 vw11.n109 vw11.n104 2.24741
R578 vw11.n115 vw11.n113 2.24741
R579 vw11.n29 vw11.n27 2.24741
R580 vw11.n29 vw11.n28 2.24741
R581 vw11.n117 vw11.n36 2.24741
R582 vw11.n119 vw11.n20 2.24741
R583 vw11.n116 vw11.n115 2.24741
R584 vw11.n115 vw11.n30 2.24741
R585 vw11.n117 vw11.n112 2.24741
R586 vw11.n123 vw11.n121 2.24741
R587 vw11.n12 vw11.n10 2.24741
R588 vw11.n12 vw11.n11 2.24741
R589 vw11.n125 vw11.n19 2.24741
R590 vw11.n127 vw11.n3 2.24741
R591 vw11.n124 vw11.n123 2.24741
R592 vw11.n123 vw11.n13 2.24741
R593 vw11.n125 vw11.n120 2.24741
R594 vw11.n130 vw11.n129 1.1363
R595 vw11.n135 vw11.n1 0.1445
R596 vw11.n128 vw11.n1 0.1445
R597 vw11.n131 vw11.n128 0.1445
R598 vw11.n134 vw11 0.0365
R599 vw11 vw11.n2 0.0365
R600 vw11 vw11.n137 0.0275
R601 vw11.n136 vw11.n0 0.0189766
R602 vw11.n134 vw11.n0 0.0189516
R603 vw11.n132 vw11.n2 0.0189516
R604 vw11.n125 vw11.n119 0.0121667
R605 vw11.n117 vw11.n111 0.0121667
R606 vw11.n109 vw11.n103 0.0121667
R607 vw11.n101 vw11.n95 0.0121667
R608 vw11.n15 vw11.n13 0.0081885
R609 vw11.n15 vw11.n3 0.0081885
R610 vw11.n124 vw11.n4 0.0081885
R611 vw11.n120 vw11.n9 0.0081885
R612 vw11.n11 vw11.n8 0.0081885
R613 vw11.n121 vw11.t10 0.0081885
R614 vw11.n10 vw11.n7 0.0081885
R615 vw11.n19 vw11.n18 0.0081885
R616 vw11.n32 vw11.n30 0.0081885
R617 vw11.n32 vw11.n20 0.0081885
R618 vw11.n116 vw11.n21 0.0081885
R619 vw11.n112 vw11.n26 0.0081885
R620 vw11.n28 vw11.n25 0.0081885
R621 vw11.n113 vw11.t8 0.0081885
R622 vw11.n27 vw11.n24 0.0081885
R623 vw11.n36 vw11.n35 0.0081885
R624 vw11.n49 vw11.n47 0.0081885
R625 vw11.n49 vw11.n37 0.0081885
R626 vw11.n108 vw11.n38 0.0081885
R627 vw11.n104 vw11.n43 0.0081885
R628 vw11.n45 vw11.n42 0.0081885
R629 vw11.n105 vw11.t6 0.0081885
R630 vw11.n44 vw11.n41 0.0081885
R631 vw11.n53 vw11.n52 0.0081885
R632 vw11.n66 vw11.n64 0.0081885
R633 vw11.n66 vw11.n54 0.0081885
R634 vw11.n100 vw11.n55 0.0081885
R635 vw11.n96 vw11.n60 0.0081885
R636 vw11.n62 vw11.n59 0.0081885
R637 vw11.n97 vw11.t4 0.0081885
R638 vw11.n61 vw11.n58 0.0081885
R639 vw11.n70 vw11.n69 0.0081885
R640 vw11.n83 vw11.n81 0.0081885
R641 vw11.n83 vw11.n71 0.0081885
R642 vw11.n92 vw11.n72 0.0081885
R643 vw11.n88 vw11.n77 0.0081885
R644 vw11.n79 vw11.n76 0.0081885
R645 vw11.n89 vw11.t2 0.0081885
R646 vw11.n78 vw11.n75 0.0081885
R647 vw11.n87 vw11.n86 0.0081885
R648 vw11.n89 vw11.n76 0.0081885
R649 vw11.n78 vw11.t2 0.0081885
R650 vw11.n79 vw11.n73 0.0081885
R651 vw11.n87 vw11.n75 0.0081885
R652 vw11.t3 vw11.n71 0.0081885
R653 vw11.t3 vw11.n92 0.0081885
R654 vw11.n94 vw11.n81 0.0081885
R655 vw11.n88 vw11.n72 0.0081885
R656 vw11.n97 vw11.n59 0.0081885
R657 vw11.n61 vw11.t4 0.0081885
R658 vw11.n62 vw11.n56 0.0081885
R659 vw11.n70 vw11.n58 0.0081885
R660 vw11.t5 vw11.n54 0.0081885
R661 vw11.t5 vw11.n100 0.0081885
R662 vw11.n102 vw11.n64 0.0081885
R663 vw11.n96 vw11.n55 0.0081885
R664 vw11.n105 vw11.n42 0.0081885
R665 vw11.n44 vw11.t6 0.0081885
R666 vw11.n45 vw11.n39 0.0081885
R667 vw11.n53 vw11.n41 0.0081885
R668 vw11.t7 vw11.n37 0.0081885
R669 vw11.t7 vw11.n108 0.0081885
R670 vw11.n110 vw11.n47 0.0081885
R671 vw11.n104 vw11.n38 0.0081885
R672 vw11.n113 vw11.n25 0.0081885
R673 vw11.n27 vw11.t8 0.0081885
R674 vw11.n28 vw11.n22 0.0081885
R675 vw11.n36 vw11.n24 0.0081885
R676 vw11.t9 vw11.n20 0.0081885
R677 vw11.t9 vw11.n116 0.0081885
R678 vw11.n118 vw11.n30 0.0081885
R679 vw11.n112 vw11.n21 0.0081885
R680 vw11.n121 vw11.n8 0.0081885
R681 vw11.n10 vw11.t10 0.0081885
R682 vw11.n11 vw11.n5 0.0081885
R683 vw11.n19 vw11.n7 0.0081885
R684 vw11.t11 vw11.n3 0.0081885
R685 vw11.t11 vw11.n124 0.0081885
R686 vw11.n126 vw11.n13 0.0081885
R687 vw11.n120 vw11.n4 0.0081885
R688 vw11.n133 vw11.n127 0.00577778
R689 vw11.n123 vw11.n6 0.00211084
R690 vw11.n123 vw11.n122 0.00211084
R691 vw11.n17 vw11.n12 0.00211084
R692 vw11.n125 vw11.n16 0.00211084
R693 vw11.n115 vw11.n23 0.00211084
R694 vw11.n115 vw11.n114 0.00211084
R695 vw11.n34 vw11.n29 0.00211084
R696 vw11.n117 vw11.n33 0.00211084
R697 vw11.n107 vw11.n40 0.00211084
R698 vw11.n107 vw11.n106 0.00211084
R699 vw11.n51 vw11.n46 0.00211084
R700 vw11.n109 vw11.n50 0.00211084
R701 vw11.n99 vw11.n57 0.00211084
R702 vw11.n99 vw11.n98 0.00211084
R703 vw11.n68 vw11.n63 0.00211084
R704 vw11.n101 vw11.n67 0.00211084
R705 vw11.n91 vw11.n74 0.00211084
R706 vw11.n91 vw11.n90 0.00211084
R707 vw11.n85 vw11.n80 0.00211084
R708 vw11.n93 vw11.n84 0.00211084
R709 vw11.n95 vw11.n74 0.00211084
R710 vw11.n85 vw11.n82 0.00211084
R711 vw11.n90 vw11.n82 0.00211084
R712 vw11.n84 vw11.n80 0.00211084
R713 vw11.n103 vw11.n57 0.00211084
R714 vw11.n68 vw11.n65 0.00211084
R715 vw11.n98 vw11.n65 0.00211084
R716 vw11.n67 vw11.n63 0.00211084
R717 vw11.n111 vw11.n40 0.00211084
R718 vw11.n51 vw11.n48 0.00211084
R719 vw11.n106 vw11.n48 0.00211084
R720 vw11.n50 vw11.n46 0.00211084
R721 vw11.n119 vw11.n23 0.00211084
R722 vw11.n34 vw11.n31 0.00211084
R723 vw11.n114 vw11.n31 0.00211084
R724 vw11.n33 vw11.n29 0.00211084
R725 vw11.n127 vw11.n6 0.00211084
R726 vw11.n17 vw11.n14 0.00211084
R727 vw11.n122 vw11.n14 0.00211084
R728 vw11.n16 vw11.n12 0.00211084
R729 Vin_neg Vin_neg.t0 9.80856
R730 Vin Vin.t0 9.79731
R731 avdd.n2539 avdd.n2508 144.812
R732 avdd.n2526 avdd.n2519 144.812
R733 avdd.n643 avdd.n612 144.812
R734 avdd.n630 avdd.n623 144.812
R735 avdd.n1018 avdd.n987 144.812
R736 avdd.n1005 avdd.n998 144.812
R737 avdd.n2919 avdd.n2888 144.812
R738 avdd.n2906 avdd.n2899 144.812
R739 avdd.n3294 avdd.n3263 144.812
R740 avdd.n3281 avdd.n3274 144.812
R741 avdd.n3670 avdd.n3639 144.812
R742 avdd.n3657 avdd.n3650 144.812
R743 avdd.n1866 avdd.n1835 144.812
R744 avdd.n1853 avdd.n1846 144.812
R745 avdd.n1491 avdd.n1460 144.812
R746 avdd.n1478 avdd.n1471 144.812
R747 avdd.n1944 avdd.n1934 142.857
R748 avdd.n1944 avdd.n1928 142.857
R749 avdd.n1952 avdd.n1928 142.857
R750 avdd.n1960 avdd.n1922 142.857
R751 avdd.n1960 avdd.n1916 142.857
R752 avdd.n2032 avdd.n1916 142.857
R753 avdd.n1998 avdd.n1988 142.857
R754 avdd.n1998 avdd.n1982 142.857
R755 avdd.n2006 avdd.n1982 142.857
R756 avdd.n2014 avdd.n1976 142.857
R757 avdd.n2014 avdd.n1970 142.857
R758 avdd.n2022 avdd.n1970 142.857
R759 avdd.n2078 avdd.n2068 142.857
R760 avdd.n2078 avdd.n2062 142.857
R761 avdd.n2086 avdd.n2062 142.857
R762 avdd.n2094 avdd.n2056 142.857
R763 avdd.n2094 avdd.n2050 142.857
R764 avdd.n2166 avdd.n2050 142.857
R765 avdd.n2132 avdd.n2122 142.857
R766 avdd.n2132 avdd.n2116 142.857
R767 avdd.n2140 avdd.n2116 142.857
R768 avdd.n2148 avdd.n2110 142.857
R769 avdd.n2148 avdd.n2104 142.857
R770 avdd.n2156 avdd.n2104 142.857
R771 avdd.n2281 avdd.n2270 142.857
R772 avdd.n2281 avdd.n2264 142.857
R773 avdd.n2289 avdd.n2264 142.857
R774 avdd.n2289 avdd.n2258 142.857
R775 avdd.n2297 avdd.n2258 142.857
R776 avdd.n2297 avdd.n2252 142.857
R777 avdd.n2305 avdd.n2252 142.857
R778 avdd.n2305 avdd.n2246 142.857
R779 avdd.n2313 avdd.n2246 142.857
R780 avdd.n2321 avdd.n2240 142.857
R781 avdd.n2321 avdd.n2234 142.857
R782 avdd.n2329 avdd.n2234 142.857
R783 avdd.n2329 avdd.n2228 142.857
R784 avdd.n2337 avdd.n2228 142.857
R785 avdd.n2337 avdd.n2222 142.857
R786 avdd.n2345 avdd.n2222 142.857
R787 avdd.n2345 avdd.n2216 142.857
R788 avdd.n2397 avdd.n2216 142.857
R789 avdd.n2472 avdd.n2463 142.857
R790 avdd.n2481 avdd.n2463 142.857
R791 avdd.n2481 avdd.t124 142.857
R792 avdd.n2489 avdd.t124 142.857
R793 avdd.n2489 avdd.n2452 142.857
R794 avdd.n2497 avdd.n2452 142.857
R795 avdd.n385 avdd.n374 142.857
R796 avdd.n385 avdd.n368 142.857
R797 avdd.n393 avdd.n368 142.857
R798 avdd.n393 avdd.n362 142.857
R799 avdd.n401 avdd.n362 142.857
R800 avdd.n401 avdd.n356 142.857
R801 avdd.n409 avdd.n356 142.857
R802 avdd.n409 avdd.n350 142.857
R803 avdd.n417 avdd.n350 142.857
R804 avdd.n425 avdd.n344 142.857
R805 avdd.n425 avdd.n338 142.857
R806 avdd.n433 avdd.n338 142.857
R807 avdd.n433 avdd.n332 142.857
R808 avdd.n441 avdd.n332 142.857
R809 avdd.n441 avdd.n326 142.857
R810 avdd.n449 avdd.n326 142.857
R811 avdd.n449 avdd.n320 142.857
R812 avdd.n501 avdd.n320 142.857
R813 avdd.n576 avdd.n567 142.857
R814 avdd.n585 avdd.n567 142.857
R815 avdd.n585 avdd.t112 142.857
R816 avdd.n593 avdd.t112 142.857
R817 avdd.n593 avdd.n556 142.857
R818 avdd.n601 avdd.n556 142.857
R819 avdd.n760 avdd.n749 142.857
R820 avdd.n760 avdd.n743 142.857
R821 avdd.n768 avdd.n743 142.857
R822 avdd.n768 avdd.n737 142.857
R823 avdd.n776 avdd.n737 142.857
R824 avdd.n776 avdd.n731 142.857
R825 avdd.n784 avdd.n731 142.857
R826 avdd.n784 avdd.n725 142.857
R827 avdd.n792 avdd.n725 142.857
R828 avdd.n800 avdd.n719 142.857
R829 avdd.n800 avdd.n713 142.857
R830 avdd.n808 avdd.n713 142.857
R831 avdd.n808 avdd.n707 142.857
R832 avdd.n816 avdd.n707 142.857
R833 avdd.n816 avdd.n701 142.857
R834 avdd.n824 avdd.n701 142.857
R835 avdd.n824 avdd.n695 142.857
R836 avdd.n876 avdd.n695 142.857
R837 avdd.n951 avdd.n942 142.857
R838 avdd.n960 avdd.n942 142.857
R839 avdd.n960 avdd.t114 142.857
R840 avdd.n968 avdd.t114 142.857
R841 avdd.n968 avdd.n931 142.857
R842 avdd.n976 avdd.n931 142.857
R843 avdd.n2661 avdd.n2650 142.857
R844 avdd.n2661 avdd.n2644 142.857
R845 avdd.n2669 avdd.n2644 142.857
R846 avdd.n2669 avdd.n2638 142.857
R847 avdd.n2677 avdd.n2638 142.857
R848 avdd.n2677 avdd.n2632 142.857
R849 avdd.n2685 avdd.n2632 142.857
R850 avdd.n2685 avdd.n2626 142.857
R851 avdd.n2693 avdd.n2626 142.857
R852 avdd.n2701 avdd.n2620 142.857
R853 avdd.n2701 avdd.n2614 142.857
R854 avdd.n2709 avdd.n2614 142.857
R855 avdd.n2709 avdd.n2608 142.857
R856 avdd.n2717 avdd.n2608 142.857
R857 avdd.n2717 avdd.n2602 142.857
R858 avdd.n2725 avdd.n2602 142.857
R859 avdd.n2725 avdd.n2596 142.857
R860 avdd.n2777 avdd.n2596 142.857
R861 avdd.n2852 avdd.n2843 142.857
R862 avdd.n2861 avdd.n2843 142.857
R863 avdd.n2861 avdd.t104 142.857
R864 avdd.n2869 avdd.t104 142.857
R865 avdd.n2869 avdd.n2832 142.857
R866 avdd.n2877 avdd.n2832 142.857
R867 avdd.n3036 avdd.n3025 142.857
R868 avdd.n3036 avdd.n3019 142.857
R869 avdd.n3044 avdd.n3019 142.857
R870 avdd.n3044 avdd.n3013 142.857
R871 avdd.n3052 avdd.n3013 142.857
R872 avdd.n3052 avdd.n3007 142.857
R873 avdd.n3060 avdd.n3007 142.857
R874 avdd.n3060 avdd.n3001 142.857
R875 avdd.n3068 avdd.n3001 142.857
R876 avdd.n3076 avdd.n2995 142.857
R877 avdd.n3076 avdd.n2989 142.857
R878 avdd.n3084 avdd.n2989 142.857
R879 avdd.n3084 avdd.n2983 142.857
R880 avdd.n3092 avdd.n2983 142.857
R881 avdd.n3092 avdd.n2977 142.857
R882 avdd.n3100 avdd.n2977 142.857
R883 avdd.n3100 avdd.n2971 142.857
R884 avdd.n3152 avdd.n2971 142.857
R885 avdd.n3227 avdd.n3218 142.857
R886 avdd.n3236 avdd.n3218 142.857
R887 avdd.n3236 avdd.t92 142.857
R888 avdd.n3244 avdd.t92 142.857
R889 avdd.n3244 avdd.n3207 142.857
R890 avdd.n3252 avdd.n3207 142.857
R891 avdd.n3412 avdd.n3401 142.857
R892 avdd.n3412 avdd.n3395 142.857
R893 avdd.n3420 avdd.n3395 142.857
R894 avdd.n3420 avdd.n3389 142.857
R895 avdd.n3428 avdd.n3389 142.857
R896 avdd.n3428 avdd.n3383 142.857
R897 avdd.n3436 avdd.n3383 142.857
R898 avdd.n3436 avdd.n3377 142.857
R899 avdd.n3444 avdd.n3377 142.857
R900 avdd.n3452 avdd.n3371 142.857
R901 avdd.n3452 avdd.n3365 142.857
R902 avdd.n3460 avdd.n3365 142.857
R903 avdd.n3460 avdd.n3359 142.857
R904 avdd.n3468 avdd.n3359 142.857
R905 avdd.n3468 avdd.n3353 142.857
R906 avdd.n3476 avdd.n3353 142.857
R907 avdd.n3476 avdd.n3347 142.857
R908 avdd.n3528 avdd.n3347 142.857
R909 avdd.n3603 avdd.n3594 142.857
R910 avdd.n3612 avdd.n3594 142.857
R911 avdd.n3612 avdd.t96 142.857
R912 avdd.n3620 avdd.t96 142.857
R913 avdd.n3620 avdd.n3583 142.857
R914 avdd.n3628 avdd.n3583 142.857
R915 avdd.n1608 avdd.n1597 142.857
R916 avdd.n1608 avdd.n1591 142.857
R917 avdd.n1616 avdd.n1591 142.857
R918 avdd.n1616 avdd.n1585 142.857
R919 avdd.n1624 avdd.n1585 142.857
R920 avdd.n1624 avdd.n1579 142.857
R921 avdd.n1632 avdd.n1579 142.857
R922 avdd.n1632 avdd.n1573 142.857
R923 avdd.n1640 avdd.n1573 142.857
R924 avdd.n1648 avdd.n1567 142.857
R925 avdd.n1648 avdd.n1561 142.857
R926 avdd.n1656 avdd.n1561 142.857
R927 avdd.n1656 avdd.n1555 142.857
R928 avdd.n1664 avdd.n1555 142.857
R929 avdd.n1664 avdd.n1549 142.857
R930 avdd.n1672 avdd.n1549 142.857
R931 avdd.n1672 avdd.n1543 142.857
R932 avdd.n1724 avdd.n1543 142.857
R933 avdd.n1799 avdd.n1790 142.857
R934 avdd.n1808 avdd.n1790 142.857
R935 avdd.n1808 avdd.t106 142.857
R936 avdd.n1816 avdd.t106 142.857
R937 avdd.n1816 avdd.n1779 142.857
R938 avdd.n1824 avdd.n1779 142.857
R939 avdd.n1233 avdd.n1222 142.857
R940 avdd.n1233 avdd.n1216 142.857
R941 avdd.n1241 avdd.n1216 142.857
R942 avdd.n1241 avdd.n1210 142.857
R943 avdd.n1249 avdd.n1210 142.857
R944 avdd.n1249 avdd.n1204 142.857
R945 avdd.n1257 avdd.n1204 142.857
R946 avdd.n1257 avdd.n1198 142.857
R947 avdd.n1265 avdd.n1198 142.857
R948 avdd.n1273 avdd.n1192 142.857
R949 avdd.n1273 avdd.n1186 142.857
R950 avdd.n1281 avdd.n1186 142.857
R951 avdd.n1281 avdd.n1180 142.857
R952 avdd.n1289 avdd.n1180 142.857
R953 avdd.n1289 avdd.n1174 142.857
R954 avdd.n1297 avdd.n1174 142.857
R955 avdd.n1297 avdd.n1168 142.857
R956 avdd.n1349 avdd.n1168 142.857
R957 avdd.n1424 avdd.n1415 142.857
R958 avdd.n1433 avdd.n1415 142.857
R959 avdd.n1433 avdd.t94 142.857
R960 avdd.n1441 avdd.t94 142.857
R961 avdd.n1441 avdd.n1404 142.857
R962 avdd.n1449 avdd.n1404 142.857
R963 avdd.n4307 avdd.n4306 132.671
R964 avdd.n4317 avdd.n4316 132.671
R965 avdd.n4340 avdd.n4339 132.671
R966 avdd.n4350 avdd.n4349 132.671
R967 avdd.n4222 avdd.n4221 132.671
R968 avdd.n4232 avdd.n4231 132.671
R969 avdd.n4255 avdd.n4254 132.671
R970 avdd.n4265 avdd.n4264 132.671
R971 avdd.n169 avdd.n158 126.439
R972 avdd.n164 avdd.n157 126.439
R973 avdd.n4287 avdd.n4274 74.638
R974 avdd.n4279 avdd.n4273 74.638
R975 avdd.n4192 avdd.n4189 74.638
R976 avdd.n4191 avdd.n4190 74.638
R977 avdd.n1952 avdd.t132 71.4291
R978 avdd.t132 avdd.n1922 71.4291
R979 avdd.n2006 avdd.t10 71.4291
R980 avdd.t10 avdd.n1976 71.4291
R981 avdd.n2086 avdd.t135 71.4291
R982 avdd.t135 avdd.n2056 71.4291
R983 avdd.n2140 avdd.t43 71.4291
R984 avdd.t43 avdd.n2110 71.4291
R985 avdd.n2313 avdd.t50 71.4291
R986 avdd.t50 avdd.n2240 71.4291
R987 avdd.n2378 avdd.t152 71.4291
R988 avdd.n2387 avdd.t152 71.4291
R989 avdd.t143 avdd.n2374 71.4291
R990 avdd.n2375 avdd.t143 71.4291
R991 avdd.n2431 avdd.t8 71.4291
R992 avdd.t8 avdd.n2430 71.4291
R993 avdd.n2408 avdd.t34 71.4291
R994 avdd.n2439 avdd.t34 71.4291
R995 avdd.n417 avdd.t39 71.4291
R996 avdd.t39 avdd.n344 71.4291
R997 avdd.n482 avdd.t41 71.4291
R998 avdd.n491 avdd.t41 71.4291
R999 avdd.t142 avdd.n478 71.4291
R1000 avdd.n479 avdd.t142 71.4291
R1001 avdd.n535 avdd.t138 71.4291
R1002 avdd.t138 avdd.n534 71.4291
R1003 avdd.n512 avdd.t14 71.4291
R1004 avdd.n543 avdd.t14 71.4291
R1005 avdd.n792 avdd.t54 71.4291
R1006 avdd.t54 avdd.n719 71.4291
R1007 avdd.n857 avdd.t52 71.4291
R1008 avdd.n866 avdd.t52 71.4291
R1009 avdd.t61 avdd.n853 71.4291
R1010 avdd.n854 avdd.t61 71.4291
R1011 avdd.n910 avdd.t148 71.4291
R1012 avdd.t148 avdd.n909 71.4291
R1013 avdd.n887 avdd.t33 71.4291
R1014 avdd.n918 avdd.t33 71.4291
R1015 avdd.n2693 avdd.t56 71.4291
R1016 avdd.t56 avdd.n2620 71.4291
R1017 avdd.n2758 avdd.t74 71.4291
R1018 avdd.n2767 avdd.t74 71.4291
R1019 avdd.t60 avdd.n2754 71.4291
R1020 avdd.n2755 avdd.t60 71.4291
R1021 avdd.n2811 avdd.t86 71.4291
R1022 avdd.t86 avdd.n2810 71.4291
R1023 avdd.n2788 avdd.t13 71.4291
R1024 avdd.n2819 avdd.t13 71.4291
R1025 avdd.n3068 avdd.t27 71.4291
R1026 avdd.t27 avdd.n2995 71.4291
R1027 avdd.n3133 avdd.t48 71.4291
R1028 avdd.n3142 avdd.t48 71.4291
R1029 avdd.t59 avdd.n3129 71.4291
R1030 avdd.n3130 avdd.t59 71.4291
R1031 avdd.n3186 avdd.t46 71.4291
R1032 avdd.t46 avdd.n3185 71.4291
R1033 avdd.n3163 avdd.t21 71.4291
R1034 avdd.n3194 avdd.t21 71.4291
R1035 avdd.n3444 avdd.t35 71.4291
R1036 avdd.t35 avdd.n3371 71.4291
R1037 avdd.n3509 avdd.t78 71.4291
R1038 avdd.n3518 avdd.t78 71.4291
R1039 avdd.t58 avdd.n3505 71.4291
R1040 avdd.n3506 avdd.t58 71.4291
R1041 avdd.n3562 avdd.t68 71.4291
R1042 avdd.t68 avdd.n3561 71.4291
R1043 avdd.n3539 avdd.t80 71.4291
R1044 avdd.n3570 avdd.t80 71.4291
R1045 avdd.n1640 avdd.t150 71.4291
R1046 avdd.t150 avdd.n1567 71.4291
R1047 avdd.n1705 avdd.t133 71.4291
R1048 avdd.n1714 avdd.t133 71.4291
R1049 avdd.t141 avdd.n1701 71.4291
R1050 avdd.n1702 avdd.t141 71.4291
R1051 avdd.n1758 avdd.t70 71.4291
R1052 avdd.t70 avdd.n1757 71.4291
R1053 avdd.n1735 avdd.t22 71.4291
R1054 avdd.n1766 avdd.t22 71.4291
R1055 avdd.n1265 avdd.t66 71.4291
R1056 avdd.t66 avdd.n1192 71.4291
R1057 avdd.n1330 avdd.t72 71.4291
R1058 avdd.n1339 avdd.t72 71.4291
R1059 avdd.t140 avdd.n1326 71.4291
R1060 avdd.n1327 avdd.t140 71.4291
R1061 avdd.n1383 avdd.t37 71.4291
R1062 avdd.t37 avdd.n1382 71.4291
R1063 avdd.n1360 avdd.t81 71.4291
R1064 avdd.n1391 avdd.t81 71.4291
R1065 avdd.n3876 avdd.t44 71.4291
R1066 avdd.t44 avdd.n3875 71.4291
R1067 avdd.n3894 avdd.t62 71.4291
R1068 avdd.t62 avdd.n3893 71.4291
R1069 avdd.n3913 avdd.t64 71.4291
R1070 avdd.t64 avdd.n3912 71.4291
R1071 avdd.n3770 avdd.t11 71.4291
R1072 avdd.t11 avdd.n3769 71.4291
R1073 avdd.n3788 avdd.t144 71.4291
R1074 avdd.t144 avdd.n3787 71.4291
R1075 avdd.n3807 avdd.t146 71.4291
R1076 avdd.t146 avdd.n3806 71.4291
R1077 avdd.n4067 avdd.t19 71.4291
R1078 avdd.t19 avdd.n4066 71.4291
R1079 avdd.n4085 avdd.t31 71.4291
R1080 avdd.t31 avdd.n4084 71.4291
R1081 avdd.n4104 avdd.t29 71.4291
R1082 avdd.t29 avdd.n4103 71.4291
R1083 avdd.n79 avdd.t136 71.4291
R1084 avdd.t136 avdd.n78 71.4291
R1085 avdd.n97 avdd.t15 71.4291
R1086 avdd.t15 avdd.n96 71.4291
R1087 avdd.n116 avdd.t17 71.4291
R1088 avdd.t17 avdd.n115 71.4291
R1089 avdd.n4134 avdd.t6 71.4291
R1090 avdd.t6 avdd.n4133 71.4291
R1091 avdd.n4152 avdd.t23 71.4291
R1092 avdd.t23 avdd.n4151 71.4291
R1093 avdd.n4171 avdd.t25 71.4291
R1094 avdd.t25 avdd.n4170 71.4291
R1095 avdd.n22 avdd.t76 71.4291
R1096 avdd.t76 avdd.n21 71.4291
R1097 avdd.n40 avdd.t84 71.4291
R1098 avdd.t84 avdd.n39 71.4291
R1099 avdd.n59 avdd.t82 71.4291
R1100 avdd.t82 avdd.n58 71.4291
R1101 avdd.n4370 avdd.t88 71.4291
R1102 avdd.t88 avdd.n4369 71.4291
R1103 avdd.n147 avdd.n136 70.438
R1104 avdd.n142 avdd.n135 70.438
R1105 avdd.n4307 avdd.t126 66.3355
R1106 avdd.n4317 avdd.t126 66.3355
R1107 avdd.n4340 avdd.t130 66.3355
R1108 avdd.n4350 avdd.t130 66.3355
R1109 avdd.n4222 avdd.t4 66.3355
R1110 avdd.n4232 avdd.t4 66.3355
R1111 avdd.n4255 avdd.t2 66.3355
R1112 avdd.n4265 avdd.t2 66.3355
R1113 avdd.n4297 avdd.n4293 62.563
R1114 avdd.n4303 avdd.n4301 62.563
R1115 avdd.n4330 avdd.n4326 62.563
R1116 avdd.n4336 avdd.n4334 62.563
R1117 avdd.n4212 avdd.n4208 62.563
R1118 avdd.n4218 avdd.n4216 62.563
R1119 avdd.n4245 avdd.n4241 62.563
R1120 avdd.n4251 avdd.n4249 62.563
R1121 avdd.n2386 avdd.n2354 62.038
R1122 avdd.n2380 avdd.n2353 62.038
R1123 avdd.n2373 avdd.n2362 62.038
R1124 avdd.n2377 avdd.n2359 62.038
R1125 avdd.n2433 avdd.n2415 62.038
R1126 avdd.n2429 avdd.n2418 62.038
R1127 avdd.n2438 avdd.n2406 62.038
R1128 avdd.n2407 avdd.n2405 62.038
R1129 avdd.n490 avdd.n458 62.038
R1130 avdd.n484 avdd.n457 62.038
R1131 avdd.n477 avdd.n466 62.038
R1132 avdd.n481 avdd.n463 62.038
R1133 avdd.n537 avdd.n519 62.038
R1134 avdd.n533 avdd.n522 62.038
R1135 avdd.n542 avdd.n510 62.038
R1136 avdd.n511 avdd.n509 62.038
R1137 avdd.n865 avdd.n833 62.038
R1138 avdd.n859 avdd.n832 62.038
R1139 avdd.n852 avdd.n841 62.038
R1140 avdd.n856 avdd.n838 62.038
R1141 avdd.n912 avdd.n894 62.038
R1142 avdd.n908 avdd.n897 62.038
R1143 avdd.n917 avdd.n885 62.038
R1144 avdd.n886 avdd.n884 62.038
R1145 avdd.n2766 avdd.n2734 62.038
R1146 avdd.n2760 avdd.n2733 62.038
R1147 avdd.n2753 avdd.n2742 62.038
R1148 avdd.n2757 avdd.n2739 62.038
R1149 avdd.n2813 avdd.n2795 62.038
R1150 avdd.n2809 avdd.n2798 62.038
R1151 avdd.n2818 avdd.n2786 62.038
R1152 avdd.n2787 avdd.n2785 62.038
R1153 avdd.n3141 avdd.n3109 62.038
R1154 avdd.n3135 avdd.n3108 62.038
R1155 avdd.n3128 avdd.n3117 62.038
R1156 avdd.n3132 avdd.n3114 62.038
R1157 avdd.n3188 avdd.n3170 62.038
R1158 avdd.n3184 avdd.n3173 62.038
R1159 avdd.n3193 avdd.n3161 62.038
R1160 avdd.n3162 avdd.n3160 62.038
R1161 avdd.n3517 avdd.n3485 62.038
R1162 avdd.n3511 avdd.n3484 62.038
R1163 avdd.n3504 avdd.n3493 62.038
R1164 avdd.n3508 avdd.n3490 62.038
R1165 avdd.n3564 avdd.n3546 62.038
R1166 avdd.n3560 avdd.n3549 62.038
R1167 avdd.n3569 avdd.n3537 62.038
R1168 avdd.n3538 avdd.n3536 62.038
R1169 avdd.n1713 avdd.n1681 62.038
R1170 avdd.n1707 avdd.n1680 62.038
R1171 avdd.n1700 avdd.n1689 62.038
R1172 avdd.n1704 avdd.n1686 62.038
R1173 avdd.n1760 avdd.n1742 62.038
R1174 avdd.n1756 avdd.n1745 62.038
R1175 avdd.n1765 avdd.n1733 62.038
R1176 avdd.n1734 avdd.n1732 62.038
R1177 avdd.n1338 avdd.n1306 62.038
R1178 avdd.n1332 avdd.n1305 62.038
R1179 avdd.n1325 avdd.n1314 62.038
R1180 avdd.n1329 avdd.n1311 62.038
R1181 avdd.n1385 avdd.n1367 62.038
R1182 avdd.n1381 avdd.n1370 62.038
R1183 avdd.n1390 avdd.n1358 62.038
R1184 avdd.n1359 avdd.n1357 62.038
R1185 avdd.n2396 avdd.n2215 61.7755
R1186 avdd.n2274 avdd.n2271 61.7755
R1187 avdd.n2496 avdd.n2451 61.7755
R1188 avdd.n2471 avdd.n2467 61.7755
R1189 avdd.n500 avdd.n319 61.7755
R1190 avdd.n378 avdd.n375 61.7755
R1191 avdd.n600 avdd.n555 61.7755
R1192 avdd.n575 avdd.n571 61.7755
R1193 avdd.n875 avdd.n694 61.7755
R1194 avdd.n753 avdd.n750 61.7755
R1195 avdd.n975 avdd.n930 61.7755
R1196 avdd.n950 avdd.n946 61.7755
R1197 avdd.n2776 avdd.n2595 61.7755
R1198 avdd.n2654 avdd.n2651 61.7755
R1199 avdd.n2876 avdd.n2831 61.7755
R1200 avdd.n2851 avdd.n2847 61.7755
R1201 avdd.n3151 avdd.n2970 61.7755
R1202 avdd.n3029 avdd.n3026 61.7755
R1203 avdd.n3251 avdd.n3206 61.7755
R1204 avdd.n3226 avdd.n3222 61.7755
R1205 avdd.n3527 avdd.n3346 61.7755
R1206 avdd.n3405 avdd.n3402 61.7755
R1207 avdd.n3627 avdd.n3582 61.7755
R1208 avdd.n3602 avdd.n3598 61.7755
R1209 avdd.n1723 avdd.n1542 61.7755
R1210 avdd.n1601 avdd.n1598 61.7755
R1211 avdd.n1823 avdd.n1778 61.7755
R1212 avdd.n1798 avdd.n1794 61.7755
R1213 avdd.n1348 avdd.n1167 61.7755
R1214 avdd.n1226 avdd.n1223 61.7755
R1215 avdd.n1448 avdd.n1403 61.7755
R1216 avdd.n1423 avdd.n1419 61.7755
R1217 avdd.n3867 avdd.n3864 61.6005
R1218 avdd.n3866 avdd.n3865 61.6005
R1219 avdd.n3885 avdd.n3882 61.6005
R1220 avdd.n3884 avdd.n3883 61.6005
R1221 avdd.n3904 avdd.n3901 61.6005
R1222 avdd.n3903 avdd.n3902 61.6005
R1223 avdd.n3761 avdd.n3758 61.6005
R1224 avdd.n3760 avdd.n3759 61.6005
R1225 avdd.n3779 avdd.n3776 61.6005
R1226 avdd.n3778 avdd.n3777 61.6005
R1227 avdd.n3798 avdd.n3795 61.6005
R1228 avdd.n3797 avdd.n3796 61.6005
R1229 avdd.n4058 avdd.n4055 61.6005
R1230 avdd.n4057 avdd.n4056 61.6005
R1231 avdd.n4076 avdd.n4073 61.6005
R1232 avdd.n4075 avdd.n4074 61.6005
R1233 avdd.n4095 avdd.n4092 61.6005
R1234 avdd.n4094 avdd.n4093 61.6005
R1235 avdd.n70 avdd.n67 61.6005
R1236 avdd.n69 avdd.n68 61.6005
R1237 avdd.n88 avdd.n85 61.6005
R1238 avdd.n87 avdd.n86 61.6005
R1239 avdd.n107 avdd.n104 61.6005
R1240 avdd.n106 avdd.n105 61.6005
R1241 avdd.n4125 avdd.n4122 61.6005
R1242 avdd.n4124 avdd.n4123 61.6005
R1243 avdd.n4143 avdd.n4140 61.6005
R1244 avdd.n4142 avdd.n4141 61.6005
R1245 avdd.n4162 avdd.n4159 61.6005
R1246 avdd.n4161 avdd.n4160 61.6005
R1247 avdd.n13 avdd.n10 61.6005
R1248 avdd.n12 avdd.n11 61.6005
R1249 avdd.n31 avdd.n28 61.6005
R1250 avdd.n30 avdd.n29 61.6005
R1251 avdd.n50 avdd.n47 61.6005
R1252 avdd.n49 avdd.n48 61.6005
R1253 avdd.n4361 avdd.n4358 61.6005
R1254 avdd.n4360 avdd.n4359 61.6005
R1255 avdd.n140 avdd.t90 59.7912
R1256 avdd.n148 avdd.t90 59.7912
R1257 avdd.n2031 avdd.n1915 58.2755
R1258 avdd.n1938 avdd.n1935 58.2755
R1259 avdd.n2021 avdd.n1969 58.2755
R1260 avdd.n1992 avdd.n1989 58.2755
R1261 avdd.n2165 avdd.n2049 58.2755
R1262 avdd.n2072 avdd.n2069 58.2755
R1263 avdd.n2155 avdd.n2103 58.2755
R1264 avdd.n2126 avdd.n2123 58.2755
R1265 avdd.n4277 avdd.t128 56.418
R1266 avdd.n4286 avdd.t128 56.418
R1267 avdd.n4201 avdd.t0 56.418
R1268 avdd.t0 avdd.n4200 56.418
R1269 avdd.n171 avdd.n158 54.6708
R1270 avdd.n164 avdd.n163 54.6708
R1271 avdd.n4285 avdd.n4274 52.5417
R1272 avdd.n4279 avdd.n4278 52.5417
R1273 avdd.n4202 avdd.n4190 52.5417
R1274 avdd.n4199 avdd.n4192 52.5417
R1275 avdd.n2525 avdd.n2515 52.3223
R1276 avdd.t116 avdd.n2515 52.3223
R1277 avdd.t116 avdd.n2509 52.3223
R1278 avdd.n2540 avdd.n2509 52.3223
R1279 avdd.n629 avdd.n619 52.3223
R1280 avdd.t120 avdd.n619 52.3223
R1281 avdd.t120 avdd.n613 52.3223
R1282 avdd.n644 avdd.n613 52.3223
R1283 avdd.n1004 avdd.n994 52.3223
R1284 avdd.t122 avdd.n994 52.3223
R1285 avdd.t122 avdd.n988 52.3223
R1286 avdd.n1019 avdd.n988 52.3223
R1287 avdd.n2905 avdd.n2895 52.3223
R1288 avdd.t110 avdd.n2895 52.3223
R1289 avdd.t110 avdd.n2889 52.3223
R1290 avdd.n2920 avdd.n2889 52.3223
R1291 avdd.n3280 avdd.n3270 52.3223
R1292 avdd.t102 avdd.n3270 52.3223
R1293 avdd.t102 avdd.n3264 52.3223
R1294 avdd.n3295 avdd.n3264 52.3223
R1295 avdd.n3656 avdd.n3646 52.3223
R1296 avdd.t98 avdd.n3646 52.3223
R1297 avdd.t98 avdd.n3640 52.3223
R1298 avdd.n3671 avdd.n3640 52.3223
R1299 avdd.n1852 avdd.n1842 52.3223
R1300 avdd.t108 avdd.n1842 52.3223
R1301 avdd.t108 avdd.n1836 52.3223
R1302 avdd.n1867 avdd.n1836 52.3223
R1303 avdd.n1477 avdd.n1467 52.3223
R1304 avdd.t100 avdd.n1467 52.3223
R1305 avdd.t100 avdd.n1461 52.3223
R1306 avdd.n1492 avdd.n1461 52.3223
R1307 avdd.n2541 avdd.n2508 51.4554
R1308 avdd.n2524 avdd.n2519 51.4554
R1309 avdd.n645 avdd.n612 51.4554
R1310 avdd.n628 avdd.n623 51.4554
R1311 avdd.n1020 avdd.n987 51.4554
R1312 avdd.n1003 avdd.n998 51.4554
R1313 avdd.n2921 avdd.n2888 51.4554
R1314 avdd.n2904 avdd.n2899 51.4554
R1315 avdd.n3296 avdd.n3263 51.4554
R1316 avdd.n3279 avdd.n3274 51.4554
R1317 avdd.n3672 avdd.n3639 51.4554
R1318 avdd.n3655 avdd.n3650 51.4554
R1319 avdd.n1868 avdd.n1835 51.4554
R1320 avdd.n1851 avdd.n1846 51.4554
R1321 avdd.n1493 avdd.n1460 51.4554
R1322 avdd.n1476 avdd.n1471 51.4554
R1323 avdd.n149 avdd.n136 50.7651
R1324 avdd.n142 avdd.n141 50.7651
R1325 avdd.n2388 avdd.n2354 48.6461
R1326 avdd.n2380 avdd.n2379 48.6461
R1327 avdd.n2377 avdd.n2376 48.6461
R1328 avdd.n2362 avdd.n2361 48.6461
R1329 avdd.n2418 avdd.n2417 48.6461
R1330 avdd.n2433 avdd.n2432 48.6461
R1331 avdd.n2440 avdd.n2406 48.6461
R1332 avdd.n2409 avdd.n2407 48.6461
R1333 avdd.n492 avdd.n458 48.6461
R1334 avdd.n484 avdd.n483 48.6461
R1335 avdd.n481 avdd.n480 48.6461
R1336 avdd.n466 avdd.n465 48.6461
R1337 avdd.n522 avdd.n521 48.6461
R1338 avdd.n537 avdd.n536 48.6461
R1339 avdd.n544 avdd.n510 48.6461
R1340 avdd.n513 avdd.n511 48.6461
R1341 avdd.n867 avdd.n833 48.6461
R1342 avdd.n859 avdd.n858 48.6461
R1343 avdd.n856 avdd.n855 48.6461
R1344 avdd.n841 avdd.n840 48.6461
R1345 avdd.n897 avdd.n896 48.6461
R1346 avdd.n912 avdd.n911 48.6461
R1347 avdd.n919 avdd.n885 48.6461
R1348 avdd.n888 avdd.n886 48.6461
R1349 avdd.n2768 avdd.n2734 48.6461
R1350 avdd.n2760 avdd.n2759 48.6461
R1351 avdd.n2757 avdd.n2756 48.6461
R1352 avdd.n2742 avdd.n2741 48.6461
R1353 avdd.n2798 avdd.n2797 48.6461
R1354 avdd.n2813 avdd.n2812 48.6461
R1355 avdd.n2820 avdd.n2786 48.6461
R1356 avdd.n2789 avdd.n2787 48.6461
R1357 avdd.n3143 avdd.n3109 48.6461
R1358 avdd.n3135 avdd.n3134 48.6461
R1359 avdd.n3132 avdd.n3131 48.6461
R1360 avdd.n3117 avdd.n3116 48.6461
R1361 avdd.n3173 avdd.n3172 48.6461
R1362 avdd.n3188 avdd.n3187 48.6461
R1363 avdd.n3195 avdd.n3161 48.6461
R1364 avdd.n3164 avdd.n3162 48.6461
R1365 avdd.n3519 avdd.n3485 48.6461
R1366 avdd.n3511 avdd.n3510 48.6461
R1367 avdd.n3508 avdd.n3507 48.6461
R1368 avdd.n3493 avdd.n3492 48.6461
R1369 avdd.n3549 avdd.n3548 48.6461
R1370 avdd.n3564 avdd.n3563 48.6461
R1371 avdd.n3571 avdd.n3537 48.6461
R1372 avdd.n3540 avdd.n3538 48.6461
R1373 avdd.n1715 avdd.n1681 48.6461
R1374 avdd.n1707 avdd.n1706 48.6461
R1375 avdd.n1704 avdd.n1703 48.6461
R1376 avdd.n1689 avdd.n1688 48.6461
R1377 avdd.n1745 avdd.n1744 48.6461
R1378 avdd.n1760 avdd.n1759 48.6461
R1379 avdd.n1767 avdd.n1733 48.6461
R1380 avdd.n1736 avdd.n1734 48.6461
R1381 avdd.n1340 avdd.n1306 48.6461
R1382 avdd.n1332 avdd.n1331 48.6461
R1383 avdd.n1329 avdd.n1328 48.6461
R1384 avdd.n1314 avdd.n1313 48.6461
R1385 avdd.n1370 avdd.n1369 48.6461
R1386 avdd.n1385 avdd.n1384 48.6461
R1387 avdd.n1392 avdd.n1358 48.6461
R1388 avdd.n1361 avdd.n1359 48.6461
R1389 avdd.n2398 avdd.n2215 48.3669
R1390 avdd.n2274 avdd.n2273 48.3669
R1391 avdd.n2498 avdd.n2451 48.3669
R1392 avdd.n2473 avdd.n2467 48.3669
R1393 avdd.n502 avdd.n319 48.3669
R1394 avdd.n378 avdd.n377 48.3669
R1395 avdd.n602 avdd.n555 48.3669
R1396 avdd.n577 avdd.n571 48.3669
R1397 avdd.n877 avdd.n694 48.3669
R1398 avdd.n753 avdd.n752 48.3669
R1399 avdd.n977 avdd.n930 48.3669
R1400 avdd.n952 avdd.n946 48.3669
R1401 avdd.n2778 avdd.n2595 48.3669
R1402 avdd.n2654 avdd.n2653 48.3669
R1403 avdd.n2878 avdd.n2831 48.3669
R1404 avdd.n2853 avdd.n2847 48.3669
R1405 avdd.n3153 avdd.n2970 48.3669
R1406 avdd.n3029 avdd.n3028 48.3669
R1407 avdd.n3253 avdd.n3206 48.3669
R1408 avdd.n3228 avdd.n3222 48.3669
R1409 avdd.n3529 avdd.n3346 48.3669
R1410 avdd.n3405 avdd.n3404 48.3669
R1411 avdd.n3629 avdd.n3582 48.3669
R1412 avdd.n3604 avdd.n3598 48.3669
R1413 avdd.n1725 avdd.n1542 48.3669
R1414 avdd.n1601 avdd.n1600 48.3669
R1415 avdd.n1825 avdd.n1778 48.3669
R1416 avdd.n1800 avdd.n1794 48.3669
R1417 avdd.n1350 avdd.n1167 48.3669
R1418 avdd.n1226 avdd.n1225 48.3669
R1419 avdd.n1450 avdd.n1403 48.3669
R1420 avdd.n1425 avdd.n1419 48.3669
R1421 avdd.n3877 avdd.n3865 48.1804
R1422 avdd.n3874 avdd.n3867 48.1804
R1423 avdd.n3895 avdd.n3883 48.1804
R1424 avdd.n3892 avdd.n3885 48.1804
R1425 avdd.n3914 avdd.n3902 48.1804
R1426 avdd.n3911 avdd.n3904 48.1804
R1427 avdd.n3771 avdd.n3759 48.1804
R1428 avdd.n3768 avdd.n3761 48.1804
R1429 avdd.n3789 avdd.n3777 48.1804
R1430 avdd.n3786 avdd.n3779 48.1804
R1431 avdd.n3808 avdd.n3796 48.1804
R1432 avdd.n3805 avdd.n3798 48.1804
R1433 avdd.n4068 avdd.n4056 48.1804
R1434 avdd.n4065 avdd.n4058 48.1804
R1435 avdd.n4086 avdd.n4074 48.1804
R1436 avdd.n4083 avdd.n4076 48.1804
R1437 avdd.n4105 avdd.n4093 48.1804
R1438 avdd.n4102 avdd.n4095 48.1804
R1439 avdd.n80 avdd.n68 48.1804
R1440 avdd.n77 avdd.n70 48.1804
R1441 avdd.n98 avdd.n86 48.1804
R1442 avdd.n95 avdd.n88 48.1804
R1443 avdd.n117 avdd.n105 48.1804
R1444 avdd.n114 avdd.n107 48.1804
R1445 avdd.n4135 avdd.n4123 48.1804
R1446 avdd.n4132 avdd.n4125 48.1804
R1447 avdd.n4153 avdd.n4141 48.1804
R1448 avdd.n4150 avdd.n4143 48.1804
R1449 avdd.n4172 avdd.n4160 48.1804
R1450 avdd.n4169 avdd.n4162 48.1804
R1451 avdd.n23 avdd.n11 48.1804
R1452 avdd.n20 avdd.n13 48.1804
R1453 avdd.n41 avdd.n29 48.1804
R1454 avdd.n38 avdd.n31 48.1804
R1455 avdd.n60 avdd.n48 48.1804
R1456 avdd.n57 avdd.n50 48.1804
R1457 avdd.n4371 avdd.n4359 48.1804
R1458 avdd.n4368 avdd.n4361 48.1804
R1459 avdd.n4305 avdd.n4303 46.5273
R1460 avdd.n4315 avdd.n4297 46.5273
R1461 avdd.n4338 avdd.n4336 46.5273
R1462 avdd.n4348 avdd.n4330 46.5273
R1463 avdd.n4220 avdd.n4218 46.5273
R1464 avdd.n4230 avdd.n4212 46.5273
R1465 avdd.n4253 avdd.n4251 46.5273
R1466 avdd.n4263 avdd.n4245 46.5273
R1467 avdd.n2033 avdd.n1915 44.5622
R1468 avdd.n1938 avdd.n1937 44.5622
R1469 avdd.n2023 avdd.n1969 44.5622
R1470 avdd.n1992 avdd.n1991 44.5622
R1471 avdd.n2167 avdd.n2049 44.5622
R1472 avdd.n2072 avdd.n2071 44.5622
R1473 avdd.n2157 avdd.n2103 44.5622
R1474 avdd.n2126 avdd.n2125 44.5622
R1475 avdd.n162 avdd.t118 30.5582
R1476 avdd.n170 avdd.t118 30.5582
R1477 avdd.n2276 avdd.t51 21.3295
R1478 avdd.n380 avdd.t40 21.3295
R1479 avdd.n755 avdd.t55 21.3295
R1480 avdd.n2656 avdd.t57 21.3295
R1481 avdd.n3031 avdd.t28 21.3295
R1482 avdd.n3407 avdd.t36 21.3295
R1483 avdd.n1603 avdd.t151 21.3295
R1484 avdd.n1228 avdd.t67 21.3295
R1485 avdd.n4357 avdd.t89 20.8339
R1486 avdd.n3862 avdd.t45 20.6359
R1487 avdd.n3880 avdd.t63 20.6359
R1488 avdd.n3899 avdd.t65 20.6359
R1489 avdd.n3756 avdd.t12 20.6359
R1490 avdd.n3774 avdd.t145 20.6359
R1491 avdd.n3793 avdd.t147 20.6359
R1492 avdd.n4053 avdd.t20 20.6359
R1493 avdd.n4071 avdd.t32 20.6359
R1494 avdd.n4090 avdd.t30 20.6359
R1495 avdd.n65 avdd.t137 20.6359
R1496 avdd.n83 avdd.t16 20.6359
R1497 avdd.n102 avdd.t18 20.6359
R1498 avdd.n4120 avdd.t7 20.6359
R1499 avdd.n4138 avdd.t24 20.6359
R1500 avdd.n4157 avdd.t26 20.6359
R1501 avdd.n8 avdd.t77 20.6359
R1502 avdd.n26 avdd.t85 20.6359
R1503 avdd.n45 avdd.t83 20.6359
R1504 avdd avdd.n2037 20.0131
R1505 avdd avdd.n2171 20.0131
R1506 avdd.n191 avdd.n190 19.5005
R1507 avdd.n192 avdd.n187 19.5005
R1508 avdd.n194 avdd.n193 19.5005
R1509 avdd.n195 avdd.n186 19.5005
R1510 avdd.n198 avdd.n197 19.5005
R1511 avdd.n2468 avdd.t125 19.4575
R1512 avdd.n572 avdd.t113 19.4575
R1513 avdd.n947 avdd.t115 19.4575
R1514 avdd.n2848 avdd.t105 19.4575
R1515 avdd.n3223 avdd.t93 19.4575
R1516 avdd.n3599 avdd.t97 19.4575
R1517 avdd.n1795 avdd.t107 19.4575
R1518 avdd.n1420 avdd.t95 19.4575
R1519 avdd.n1062 avdd.n1058 18.9089
R1520 avdd.n2358 avdd.t153 18.7429
R1521 avdd.n2414 avdd.t9 18.7429
R1522 avdd.n462 avdd.t42 18.7429
R1523 avdd.n518 avdd.t139 18.7429
R1524 avdd.n837 avdd.t53 18.7429
R1525 avdd.n893 avdd.t149 18.7429
R1526 avdd.n2738 avdd.t75 18.7429
R1527 avdd.n2794 avdd.t87 18.7429
R1528 avdd.n3113 avdd.t49 18.7429
R1529 avdd.n3169 avdd.t47 18.7429
R1530 avdd.n3489 avdd.t79 18.7429
R1531 avdd.n3545 avdd.t69 18.7429
R1532 avdd.n1685 avdd.t134 18.7429
R1533 avdd.n1741 avdd.t71 18.7429
R1534 avdd.n1310 avdd.t73 18.7429
R1535 avdd.n1366 avdd.t38 18.7429
R1536 avdd.n4291 avdd.t127 17.1939
R1537 avdd.n4324 avdd.t131 17.1939
R1538 avdd.n4206 avdd.t5 17.1939
R1539 avdd.n4239 avdd.t3 17.1939
R1540 avdd avdd.n3917 15.5255
R1541 avdd avdd.n3811 15.5255
R1542 avdd avdd.n4108 15.5255
R1543 avdd avdd.n120 15.5255
R1544 avdd avdd.n4175 15.5255
R1545 avdd avdd.n63 15.5255
R1546 avdd.n1945 avdd.n1933 14.0005
R1547 avdd.n1945 avdd.n1929 14.0005
R1548 avdd.n1951 avdd.n1929 14.0005
R1549 avdd.n1951 avdd.n1921 14.0005
R1550 avdd.n1961 avdd.n1921 14.0005
R1551 avdd.n1961 avdd.n1917 14.0005
R1552 avdd.n2031 avdd.n1917 14.0005
R1553 avdd.n1943 avdd.n1935 14.0005
R1554 avdd.n1943 avdd.n1927 14.0005
R1555 avdd.n1953 avdd.n1927 14.0005
R1556 avdd.n1953 avdd.n1923 14.0005
R1557 avdd.n1959 avdd.n1923 14.0005
R1558 avdd.n1959 avdd.n1914 14.0005
R1559 avdd.n2034 avdd.n1914 14.0005
R1560 avdd.n1999 avdd.n1987 14.0005
R1561 avdd.n1999 avdd.n1983 14.0005
R1562 avdd.n2005 avdd.n1983 14.0005
R1563 avdd.n2005 avdd.n1975 14.0005
R1564 avdd.n2015 avdd.n1975 14.0005
R1565 avdd.n2015 avdd.n1971 14.0005
R1566 avdd.n2021 avdd.n1971 14.0005
R1567 avdd.n1997 avdd.n1989 14.0005
R1568 avdd.n1997 avdd.n1981 14.0005
R1569 avdd.n2007 avdd.n1981 14.0005
R1570 avdd.n2007 avdd.n1977 14.0005
R1571 avdd.n2013 avdd.n1977 14.0005
R1572 avdd.n2013 avdd.n1968 14.0005
R1573 avdd.n2024 avdd.n1968 14.0005
R1574 avdd.n2079 avdd.n2067 14.0005
R1575 avdd.n2079 avdd.n2063 14.0005
R1576 avdd.n2085 avdd.n2063 14.0005
R1577 avdd.n2085 avdd.n2055 14.0005
R1578 avdd.n2095 avdd.n2055 14.0005
R1579 avdd.n2095 avdd.n2051 14.0005
R1580 avdd.n2165 avdd.n2051 14.0005
R1581 avdd.n2077 avdd.n2069 14.0005
R1582 avdd.n2077 avdd.n2061 14.0005
R1583 avdd.n2087 avdd.n2061 14.0005
R1584 avdd.n2087 avdd.n2057 14.0005
R1585 avdd.n2093 avdd.n2057 14.0005
R1586 avdd.n2093 avdd.n2048 14.0005
R1587 avdd.n2168 avdd.n2048 14.0005
R1588 avdd.n2133 avdd.n2121 14.0005
R1589 avdd.n2133 avdd.n2117 14.0005
R1590 avdd.n2139 avdd.n2117 14.0005
R1591 avdd.n2139 avdd.n2109 14.0005
R1592 avdd.n2149 avdd.n2109 14.0005
R1593 avdd.n2149 avdd.n2105 14.0005
R1594 avdd.n2155 avdd.n2105 14.0005
R1595 avdd.n2131 avdd.n2123 14.0005
R1596 avdd.n2131 avdd.n2115 14.0005
R1597 avdd.n2141 avdd.n2115 14.0005
R1598 avdd.n2141 avdd.n2111 14.0005
R1599 avdd.n2147 avdd.n2111 14.0005
R1600 avdd.n2147 avdd.n2102 14.0005
R1601 avdd.n2158 avdd.n2102 14.0005
R1602 avdd.n2282 avdd.n2269 14.0005
R1603 avdd.n2282 avdd.n2265 14.0005
R1604 avdd.n2288 avdd.n2265 14.0005
R1605 avdd.n2288 avdd.n2257 14.0005
R1606 avdd.n2298 avdd.n2257 14.0005
R1607 avdd.n2298 avdd.n2253 14.0005
R1608 avdd.n2304 avdd.n2253 14.0005
R1609 avdd.n2304 avdd.n2245 14.0005
R1610 avdd.n2314 avdd.n2245 14.0005
R1611 avdd.n2314 avdd.n2241 14.0005
R1612 avdd.n2320 avdd.n2241 14.0005
R1613 avdd.n2320 avdd.n2233 14.0005
R1614 avdd.n2330 avdd.n2233 14.0005
R1615 avdd.n2330 avdd.n2229 14.0005
R1616 avdd.n2336 avdd.n2229 14.0005
R1617 avdd.n2336 avdd.n2221 14.0005
R1618 avdd.n2346 avdd.n2221 14.0005
R1619 avdd.n2346 avdd.n2217 14.0005
R1620 avdd.n2396 avdd.n2217 14.0005
R1621 avdd.n2280 avdd.n2271 14.0005
R1622 avdd.n2280 avdd.n2263 14.0005
R1623 avdd.n2290 avdd.n2263 14.0005
R1624 avdd.n2290 avdd.n2259 14.0005
R1625 avdd.n2296 avdd.n2259 14.0005
R1626 avdd.n2296 avdd.n2251 14.0005
R1627 avdd.n2306 avdd.n2251 14.0005
R1628 avdd.n2306 avdd.n2247 14.0005
R1629 avdd.n2312 avdd.n2247 14.0005
R1630 avdd.n2312 avdd.n2239 14.0005
R1631 avdd.n2322 avdd.n2239 14.0005
R1632 avdd.n2322 avdd.n2235 14.0005
R1633 avdd.n2328 avdd.n2235 14.0005
R1634 avdd.n2328 avdd.n2227 14.0005
R1635 avdd.n2338 avdd.n2227 14.0005
R1636 avdd.n2338 avdd.n2223 14.0005
R1637 avdd.n2344 avdd.n2223 14.0005
R1638 avdd.n2344 avdd.n2214 14.0005
R1639 avdd.n2399 avdd.n2214 14.0005
R1640 avdd.n2386 avdd.n2355 14.0005
R1641 avdd.n2389 avdd.n2353 14.0005
R1642 avdd.n2373 avdd.n2359 14.0005
R1643 avdd.n2364 avdd.n2360 14.0005
R1644 avdd.n2429 avdd.n2415 14.0005
R1645 avdd.n2423 avdd.n2416 14.0005
R1646 avdd.n2438 avdd.n2410 14.0005
R1647 avdd.n2441 avdd.n2405 14.0005
R1648 avdd.n2474 avdd.n2464 14.0005
R1649 avdd.n2480 avdd.n2464 14.0005
R1650 avdd.n2480 avdd.n2457 14.0005
R1651 avdd.n2490 avdd.n2457 14.0005
R1652 avdd.n2490 avdd.n2453 14.0005
R1653 avdd.n2496 avdd.n2453 14.0005
R1654 avdd.n2471 avdd.n2462 14.0005
R1655 avdd.n2482 avdd.n2462 14.0005
R1656 avdd.n2482 avdd.n2458 14.0005
R1657 avdd.n2488 avdd.n2458 14.0005
R1658 avdd.n2488 avdd.n2450 14.0005
R1659 avdd.n2499 avdd.n2450 14.0005
R1660 avdd.n2523 avdd.n2514 14.0005
R1661 avdd.n2533 avdd.n2514 14.0005
R1662 avdd.n2533 avdd.n2510 14.0005
R1663 avdd.n2539 avdd.n2510 14.0005
R1664 avdd.n2526 avdd.n2516 14.0005
R1665 avdd.n2532 avdd.n2516 14.0005
R1666 avdd.n2532 avdd.n2507 14.0005
R1667 avdd.n2542 avdd.n2507 14.0005
R1668 avdd.n386 avdd.n373 14.0005
R1669 avdd.n386 avdd.n369 14.0005
R1670 avdd.n392 avdd.n369 14.0005
R1671 avdd.n392 avdd.n361 14.0005
R1672 avdd.n402 avdd.n361 14.0005
R1673 avdd.n402 avdd.n357 14.0005
R1674 avdd.n408 avdd.n357 14.0005
R1675 avdd.n408 avdd.n349 14.0005
R1676 avdd.n418 avdd.n349 14.0005
R1677 avdd.n418 avdd.n345 14.0005
R1678 avdd.n424 avdd.n345 14.0005
R1679 avdd.n424 avdd.n337 14.0005
R1680 avdd.n434 avdd.n337 14.0005
R1681 avdd.n434 avdd.n333 14.0005
R1682 avdd.n440 avdd.n333 14.0005
R1683 avdd.n440 avdd.n325 14.0005
R1684 avdd.n450 avdd.n325 14.0005
R1685 avdd.n450 avdd.n321 14.0005
R1686 avdd.n500 avdd.n321 14.0005
R1687 avdd.n384 avdd.n375 14.0005
R1688 avdd.n384 avdd.n367 14.0005
R1689 avdd.n394 avdd.n367 14.0005
R1690 avdd.n394 avdd.n363 14.0005
R1691 avdd.n400 avdd.n363 14.0005
R1692 avdd.n400 avdd.n355 14.0005
R1693 avdd.n410 avdd.n355 14.0005
R1694 avdd.n410 avdd.n351 14.0005
R1695 avdd.n416 avdd.n351 14.0005
R1696 avdd.n416 avdd.n343 14.0005
R1697 avdd.n426 avdd.n343 14.0005
R1698 avdd.n426 avdd.n339 14.0005
R1699 avdd.n432 avdd.n339 14.0005
R1700 avdd.n432 avdd.n331 14.0005
R1701 avdd.n442 avdd.n331 14.0005
R1702 avdd.n442 avdd.n327 14.0005
R1703 avdd.n448 avdd.n327 14.0005
R1704 avdd.n448 avdd.n318 14.0005
R1705 avdd.n503 avdd.n318 14.0005
R1706 avdd.n490 avdd.n459 14.0005
R1707 avdd.n493 avdd.n457 14.0005
R1708 avdd.n477 avdd.n463 14.0005
R1709 avdd.n468 avdd.n464 14.0005
R1710 avdd.n533 avdd.n519 14.0005
R1711 avdd.n527 avdd.n520 14.0005
R1712 avdd.n542 avdd.n514 14.0005
R1713 avdd.n545 avdd.n509 14.0005
R1714 avdd.n578 avdd.n568 14.0005
R1715 avdd.n584 avdd.n568 14.0005
R1716 avdd.n584 avdd.n561 14.0005
R1717 avdd.n594 avdd.n561 14.0005
R1718 avdd.n594 avdd.n557 14.0005
R1719 avdd.n600 avdd.n557 14.0005
R1720 avdd.n575 avdd.n566 14.0005
R1721 avdd.n586 avdd.n566 14.0005
R1722 avdd.n586 avdd.n562 14.0005
R1723 avdd.n592 avdd.n562 14.0005
R1724 avdd.n592 avdd.n554 14.0005
R1725 avdd.n603 avdd.n554 14.0005
R1726 avdd.n627 avdd.n618 14.0005
R1727 avdd.n637 avdd.n618 14.0005
R1728 avdd.n637 avdd.n614 14.0005
R1729 avdd.n643 avdd.n614 14.0005
R1730 avdd.n630 avdd.n620 14.0005
R1731 avdd.n636 avdd.n620 14.0005
R1732 avdd.n636 avdd.n611 14.0005
R1733 avdd.n646 avdd.n611 14.0005
R1734 avdd.n761 avdd.n748 14.0005
R1735 avdd.n761 avdd.n744 14.0005
R1736 avdd.n767 avdd.n744 14.0005
R1737 avdd.n767 avdd.n736 14.0005
R1738 avdd.n777 avdd.n736 14.0005
R1739 avdd.n777 avdd.n732 14.0005
R1740 avdd.n783 avdd.n732 14.0005
R1741 avdd.n783 avdd.n724 14.0005
R1742 avdd.n793 avdd.n724 14.0005
R1743 avdd.n793 avdd.n720 14.0005
R1744 avdd.n799 avdd.n720 14.0005
R1745 avdd.n799 avdd.n712 14.0005
R1746 avdd.n809 avdd.n712 14.0005
R1747 avdd.n809 avdd.n708 14.0005
R1748 avdd.n815 avdd.n708 14.0005
R1749 avdd.n815 avdd.n700 14.0005
R1750 avdd.n825 avdd.n700 14.0005
R1751 avdd.n825 avdd.n696 14.0005
R1752 avdd.n875 avdd.n696 14.0005
R1753 avdd.n759 avdd.n750 14.0005
R1754 avdd.n759 avdd.n742 14.0005
R1755 avdd.n769 avdd.n742 14.0005
R1756 avdd.n769 avdd.n738 14.0005
R1757 avdd.n775 avdd.n738 14.0005
R1758 avdd.n775 avdd.n730 14.0005
R1759 avdd.n785 avdd.n730 14.0005
R1760 avdd.n785 avdd.n726 14.0005
R1761 avdd.n791 avdd.n726 14.0005
R1762 avdd.n791 avdd.n718 14.0005
R1763 avdd.n801 avdd.n718 14.0005
R1764 avdd.n801 avdd.n714 14.0005
R1765 avdd.n807 avdd.n714 14.0005
R1766 avdd.n807 avdd.n706 14.0005
R1767 avdd.n817 avdd.n706 14.0005
R1768 avdd.n817 avdd.n702 14.0005
R1769 avdd.n823 avdd.n702 14.0005
R1770 avdd.n823 avdd.n693 14.0005
R1771 avdd.n878 avdd.n693 14.0005
R1772 avdd.n865 avdd.n834 14.0005
R1773 avdd.n868 avdd.n832 14.0005
R1774 avdd.n852 avdd.n838 14.0005
R1775 avdd.n843 avdd.n839 14.0005
R1776 avdd.n908 avdd.n894 14.0005
R1777 avdd.n902 avdd.n895 14.0005
R1778 avdd.n917 avdd.n889 14.0005
R1779 avdd.n920 avdd.n884 14.0005
R1780 avdd.n953 avdd.n943 14.0005
R1781 avdd.n959 avdd.n943 14.0005
R1782 avdd.n959 avdd.n936 14.0005
R1783 avdd.n969 avdd.n936 14.0005
R1784 avdd.n969 avdd.n932 14.0005
R1785 avdd.n975 avdd.n932 14.0005
R1786 avdd.n950 avdd.n941 14.0005
R1787 avdd.n961 avdd.n941 14.0005
R1788 avdd.n961 avdd.n937 14.0005
R1789 avdd.n967 avdd.n937 14.0005
R1790 avdd.n967 avdd.n929 14.0005
R1791 avdd.n978 avdd.n929 14.0005
R1792 avdd.n1002 avdd.n993 14.0005
R1793 avdd.n1012 avdd.n993 14.0005
R1794 avdd.n1012 avdd.n989 14.0005
R1795 avdd.n1018 avdd.n989 14.0005
R1796 avdd.n1005 avdd.n995 14.0005
R1797 avdd.n1011 avdd.n995 14.0005
R1798 avdd.n1011 avdd.n986 14.0005
R1799 avdd.n1021 avdd.n986 14.0005
R1800 avdd.n2662 avdd.n2649 14.0005
R1801 avdd.n2662 avdd.n2645 14.0005
R1802 avdd.n2668 avdd.n2645 14.0005
R1803 avdd.n2668 avdd.n2637 14.0005
R1804 avdd.n2678 avdd.n2637 14.0005
R1805 avdd.n2678 avdd.n2633 14.0005
R1806 avdd.n2684 avdd.n2633 14.0005
R1807 avdd.n2684 avdd.n2625 14.0005
R1808 avdd.n2694 avdd.n2625 14.0005
R1809 avdd.n2694 avdd.n2621 14.0005
R1810 avdd.n2700 avdd.n2621 14.0005
R1811 avdd.n2700 avdd.n2613 14.0005
R1812 avdd.n2710 avdd.n2613 14.0005
R1813 avdd.n2710 avdd.n2609 14.0005
R1814 avdd.n2716 avdd.n2609 14.0005
R1815 avdd.n2716 avdd.n2601 14.0005
R1816 avdd.n2726 avdd.n2601 14.0005
R1817 avdd.n2726 avdd.n2597 14.0005
R1818 avdd.n2776 avdd.n2597 14.0005
R1819 avdd.n2660 avdd.n2651 14.0005
R1820 avdd.n2660 avdd.n2643 14.0005
R1821 avdd.n2670 avdd.n2643 14.0005
R1822 avdd.n2670 avdd.n2639 14.0005
R1823 avdd.n2676 avdd.n2639 14.0005
R1824 avdd.n2676 avdd.n2631 14.0005
R1825 avdd.n2686 avdd.n2631 14.0005
R1826 avdd.n2686 avdd.n2627 14.0005
R1827 avdd.n2692 avdd.n2627 14.0005
R1828 avdd.n2692 avdd.n2619 14.0005
R1829 avdd.n2702 avdd.n2619 14.0005
R1830 avdd.n2702 avdd.n2615 14.0005
R1831 avdd.n2708 avdd.n2615 14.0005
R1832 avdd.n2708 avdd.n2607 14.0005
R1833 avdd.n2718 avdd.n2607 14.0005
R1834 avdd.n2718 avdd.n2603 14.0005
R1835 avdd.n2724 avdd.n2603 14.0005
R1836 avdd.n2724 avdd.n2594 14.0005
R1837 avdd.n2779 avdd.n2594 14.0005
R1838 avdd.n2766 avdd.n2735 14.0005
R1839 avdd.n2769 avdd.n2733 14.0005
R1840 avdd.n2753 avdd.n2739 14.0005
R1841 avdd.n2744 avdd.n2740 14.0005
R1842 avdd.n2809 avdd.n2795 14.0005
R1843 avdd.n2803 avdd.n2796 14.0005
R1844 avdd.n2818 avdd.n2790 14.0005
R1845 avdd.n2821 avdd.n2785 14.0005
R1846 avdd.n2854 avdd.n2844 14.0005
R1847 avdd.n2860 avdd.n2844 14.0005
R1848 avdd.n2860 avdd.n2837 14.0005
R1849 avdd.n2870 avdd.n2837 14.0005
R1850 avdd.n2870 avdd.n2833 14.0005
R1851 avdd.n2876 avdd.n2833 14.0005
R1852 avdd.n2851 avdd.n2842 14.0005
R1853 avdd.n2862 avdd.n2842 14.0005
R1854 avdd.n2862 avdd.n2838 14.0005
R1855 avdd.n2868 avdd.n2838 14.0005
R1856 avdd.n2868 avdd.n2830 14.0005
R1857 avdd.n2879 avdd.n2830 14.0005
R1858 avdd.n2903 avdd.n2894 14.0005
R1859 avdd.n2913 avdd.n2894 14.0005
R1860 avdd.n2913 avdd.n2890 14.0005
R1861 avdd.n2919 avdd.n2890 14.0005
R1862 avdd.n2906 avdd.n2896 14.0005
R1863 avdd.n2912 avdd.n2896 14.0005
R1864 avdd.n2912 avdd.n2887 14.0005
R1865 avdd.n2922 avdd.n2887 14.0005
R1866 avdd.n3037 avdd.n3024 14.0005
R1867 avdd.n3037 avdd.n3020 14.0005
R1868 avdd.n3043 avdd.n3020 14.0005
R1869 avdd.n3043 avdd.n3012 14.0005
R1870 avdd.n3053 avdd.n3012 14.0005
R1871 avdd.n3053 avdd.n3008 14.0005
R1872 avdd.n3059 avdd.n3008 14.0005
R1873 avdd.n3059 avdd.n3000 14.0005
R1874 avdd.n3069 avdd.n3000 14.0005
R1875 avdd.n3069 avdd.n2996 14.0005
R1876 avdd.n3075 avdd.n2996 14.0005
R1877 avdd.n3075 avdd.n2988 14.0005
R1878 avdd.n3085 avdd.n2988 14.0005
R1879 avdd.n3085 avdd.n2984 14.0005
R1880 avdd.n3091 avdd.n2984 14.0005
R1881 avdd.n3091 avdd.n2976 14.0005
R1882 avdd.n3101 avdd.n2976 14.0005
R1883 avdd.n3101 avdd.n2972 14.0005
R1884 avdd.n3151 avdd.n2972 14.0005
R1885 avdd.n3035 avdd.n3026 14.0005
R1886 avdd.n3035 avdd.n3018 14.0005
R1887 avdd.n3045 avdd.n3018 14.0005
R1888 avdd.n3045 avdd.n3014 14.0005
R1889 avdd.n3051 avdd.n3014 14.0005
R1890 avdd.n3051 avdd.n3006 14.0005
R1891 avdd.n3061 avdd.n3006 14.0005
R1892 avdd.n3061 avdd.n3002 14.0005
R1893 avdd.n3067 avdd.n3002 14.0005
R1894 avdd.n3067 avdd.n2994 14.0005
R1895 avdd.n3077 avdd.n2994 14.0005
R1896 avdd.n3077 avdd.n2990 14.0005
R1897 avdd.n3083 avdd.n2990 14.0005
R1898 avdd.n3083 avdd.n2982 14.0005
R1899 avdd.n3093 avdd.n2982 14.0005
R1900 avdd.n3093 avdd.n2978 14.0005
R1901 avdd.n3099 avdd.n2978 14.0005
R1902 avdd.n3099 avdd.n2969 14.0005
R1903 avdd.n3154 avdd.n2969 14.0005
R1904 avdd.n3141 avdd.n3110 14.0005
R1905 avdd.n3144 avdd.n3108 14.0005
R1906 avdd.n3128 avdd.n3114 14.0005
R1907 avdd.n3119 avdd.n3115 14.0005
R1908 avdd.n3184 avdd.n3170 14.0005
R1909 avdd.n3178 avdd.n3171 14.0005
R1910 avdd.n3193 avdd.n3165 14.0005
R1911 avdd.n3196 avdd.n3160 14.0005
R1912 avdd.n3229 avdd.n3219 14.0005
R1913 avdd.n3235 avdd.n3219 14.0005
R1914 avdd.n3235 avdd.n3212 14.0005
R1915 avdd.n3245 avdd.n3212 14.0005
R1916 avdd.n3245 avdd.n3208 14.0005
R1917 avdd.n3251 avdd.n3208 14.0005
R1918 avdd.n3226 avdd.n3217 14.0005
R1919 avdd.n3237 avdd.n3217 14.0005
R1920 avdd.n3237 avdd.n3213 14.0005
R1921 avdd.n3243 avdd.n3213 14.0005
R1922 avdd.n3243 avdd.n3205 14.0005
R1923 avdd.n3254 avdd.n3205 14.0005
R1924 avdd.n3278 avdd.n3269 14.0005
R1925 avdd.n3288 avdd.n3269 14.0005
R1926 avdd.n3288 avdd.n3265 14.0005
R1927 avdd.n3294 avdd.n3265 14.0005
R1928 avdd.n3281 avdd.n3271 14.0005
R1929 avdd.n3287 avdd.n3271 14.0005
R1930 avdd.n3287 avdd.n3262 14.0005
R1931 avdd.n3297 avdd.n3262 14.0005
R1932 avdd.n3413 avdd.n3400 14.0005
R1933 avdd.n3413 avdd.n3396 14.0005
R1934 avdd.n3419 avdd.n3396 14.0005
R1935 avdd.n3419 avdd.n3388 14.0005
R1936 avdd.n3429 avdd.n3388 14.0005
R1937 avdd.n3429 avdd.n3384 14.0005
R1938 avdd.n3435 avdd.n3384 14.0005
R1939 avdd.n3435 avdd.n3376 14.0005
R1940 avdd.n3445 avdd.n3376 14.0005
R1941 avdd.n3445 avdd.n3372 14.0005
R1942 avdd.n3451 avdd.n3372 14.0005
R1943 avdd.n3451 avdd.n3364 14.0005
R1944 avdd.n3461 avdd.n3364 14.0005
R1945 avdd.n3461 avdd.n3360 14.0005
R1946 avdd.n3467 avdd.n3360 14.0005
R1947 avdd.n3467 avdd.n3352 14.0005
R1948 avdd.n3477 avdd.n3352 14.0005
R1949 avdd.n3477 avdd.n3348 14.0005
R1950 avdd.n3527 avdd.n3348 14.0005
R1951 avdd.n3411 avdd.n3402 14.0005
R1952 avdd.n3411 avdd.n3394 14.0005
R1953 avdd.n3421 avdd.n3394 14.0005
R1954 avdd.n3421 avdd.n3390 14.0005
R1955 avdd.n3427 avdd.n3390 14.0005
R1956 avdd.n3427 avdd.n3382 14.0005
R1957 avdd.n3437 avdd.n3382 14.0005
R1958 avdd.n3437 avdd.n3378 14.0005
R1959 avdd.n3443 avdd.n3378 14.0005
R1960 avdd.n3443 avdd.n3370 14.0005
R1961 avdd.n3453 avdd.n3370 14.0005
R1962 avdd.n3453 avdd.n3366 14.0005
R1963 avdd.n3459 avdd.n3366 14.0005
R1964 avdd.n3459 avdd.n3358 14.0005
R1965 avdd.n3469 avdd.n3358 14.0005
R1966 avdd.n3469 avdd.n3354 14.0005
R1967 avdd.n3475 avdd.n3354 14.0005
R1968 avdd.n3475 avdd.n3345 14.0005
R1969 avdd.n3530 avdd.n3345 14.0005
R1970 avdd.n3517 avdd.n3486 14.0005
R1971 avdd.n3520 avdd.n3484 14.0005
R1972 avdd.n3504 avdd.n3490 14.0005
R1973 avdd.n3495 avdd.n3491 14.0005
R1974 avdd.n3560 avdd.n3546 14.0005
R1975 avdd.n3554 avdd.n3547 14.0005
R1976 avdd.n3569 avdd.n3541 14.0005
R1977 avdd.n3572 avdd.n3536 14.0005
R1978 avdd.n3605 avdd.n3595 14.0005
R1979 avdd.n3611 avdd.n3595 14.0005
R1980 avdd.n3611 avdd.n3588 14.0005
R1981 avdd.n3621 avdd.n3588 14.0005
R1982 avdd.n3621 avdd.n3584 14.0005
R1983 avdd.n3627 avdd.n3584 14.0005
R1984 avdd.n3602 avdd.n3593 14.0005
R1985 avdd.n3613 avdd.n3593 14.0005
R1986 avdd.n3613 avdd.n3589 14.0005
R1987 avdd.n3619 avdd.n3589 14.0005
R1988 avdd.n3619 avdd.n3581 14.0005
R1989 avdd.n3630 avdd.n3581 14.0005
R1990 avdd.n3654 avdd.n3645 14.0005
R1991 avdd.n3664 avdd.n3645 14.0005
R1992 avdd.n3664 avdd.n3641 14.0005
R1993 avdd.n3670 avdd.n3641 14.0005
R1994 avdd.n3657 avdd.n3647 14.0005
R1995 avdd.n3663 avdd.n3647 14.0005
R1996 avdd.n3663 avdd.n3638 14.0005
R1997 avdd.n3673 avdd.n3638 14.0005
R1998 avdd.n1609 avdd.n1596 14.0005
R1999 avdd.n1609 avdd.n1592 14.0005
R2000 avdd.n1615 avdd.n1592 14.0005
R2001 avdd.n1615 avdd.n1584 14.0005
R2002 avdd.n1625 avdd.n1584 14.0005
R2003 avdd.n1625 avdd.n1580 14.0005
R2004 avdd.n1631 avdd.n1580 14.0005
R2005 avdd.n1631 avdd.n1572 14.0005
R2006 avdd.n1641 avdd.n1572 14.0005
R2007 avdd.n1641 avdd.n1568 14.0005
R2008 avdd.n1647 avdd.n1568 14.0005
R2009 avdd.n1647 avdd.n1560 14.0005
R2010 avdd.n1657 avdd.n1560 14.0005
R2011 avdd.n1657 avdd.n1556 14.0005
R2012 avdd.n1663 avdd.n1556 14.0005
R2013 avdd.n1663 avdd.n1548 14.0005
R2014 avdd.n1673 avdd.n1548 14.0005
R2015 avdd.n1673 avdd.n1544 14.0005
R2016 avdd.n1723 avdd.n1544 14.0005
R2017 avdd.n1607 avdd.n1598 14.0005
R2018 avdd.n1607 avdd.n1590 14.0005
R2019 avdd.n1617 avdd.n1590 14.0005
R2020 avdd.n1617 avdd.n1586 14.0005
R2021 avdd.n1623 avdd.n1586 14.0005
R2022 avdd.n1623 avdd.n1578 14.0005
R2023 avdd.n1633 avdd.n1578 14.0005
R2024 avdd.n1633 avdd.n1574 14.0005
R2025 avdd.n1639 avdd.n1574 14.0005
R2026 avdd.n1639 avdd.n1566 14.0005
R2027 avdd.n1649 avdd.n1566 14.0005
R2028 avdd.n1649 avdd.n1562 14.0005
R2029 avdd.n1655 avdd.n1562 14.0005
R2030 avdd.n1655 avdd.n1554 14.0005
R2031 avdd.n1665 avdd.n1554 14.0005
R2032 avdd.n1665 avdd.n1550 14.0005
R2033 avdd.n1671 avdd.n1550 14.0005
R2034 avdd.n1671 avdd.n1541 14.0005
R2035 avdd.n1726 avdd.n1541 14.0005
R2036 avdd.n1713 avdd.n1682 14.0005
R2037 avdd.n1716 avdd.n1680 14.0005
R2038 avdd.n1700 avdd.n1686 14.0005
R2039 avdd.n1691 avdd.n1687 14.0005
R2040 avdd.n1756 avdd.n1742 14.0005
R2041 avdd.n1750 avdd.n1743 14.0005
R2042 avdd.n1765 avdd.n1737 14.0005
R2043 avdd.n1768 avdd.n1732 14.0005
R2044 avdd.n1801 avdd.n1791 14.0005
R2045 avdd.n1807 avdd.n1791 14.0005
R2046 avdd.n1807 avdd.n1784 14.0005
R2047 avdd.n1817 avdd.n1784 14.0005
R2048 avdd.n1817 avdd.n1780 14.0005
R2049 avdd.n1823 avdd.n1780 14.0005
R2050 avdd.n1798 avdd.n1789 14.0005
R2051 avdd.n1809 avdd.n1789 14.0005
R2052 avdd.n1809 avdd.n1785 14.0005
R2053 avdd.n1815 avdd.n1785 14.0005
R2054 avdd.n1815 avdd.n1777 14.0005
R2055 avdd.n1826 avdd.n1777 14.0005
R2056 avdd.n1850 avdd.n1841 14.0005
R2057 avdd.n1860 avdd.n1841 14.0005
R2058 avdd.n1860 avdd.n1837 14.0005
R2059 avdd.n1866 avdd.n1837 14.0005
R2060 avdd.n1853 avdd.n1843 14.0005
R2061 avdd.n1859 avdd.n1843 14.0005
R2062 avdd.n1859 avdd.n1834 14.0005
R2063 avdd.n1869 avdd.n1834 14.0005
R2064 avdd.n1234 avdd.n1221 14.0005
R2065 avdd.n1234 avdd.n1217 14.0005
R2066 avdd.n1240 avdd.n1217 14.0005
R2067 avdd.n1240 avdd.n1209 14.0005
R2068 avdd.n1250 avdd.n1209 14.0005
R2069 avdd.n1250 avdd.n1205 14.0005
R2070 avdd.n1256 avdd.n1205 14.0005
R2071 avdd.n1256 avdd.n1197 14.0005
R2072 avdd.n1266 avdd.n1197 14.0005
R2073 avdd.n1266 avdd.n1193 14.0005
R2074 avdd.n1272 avdd.n1193 14.0005
R2075 avdd.n1272 avdd.n1185 14.0005
R2076 avdd.n1282 avdd.n1185 14.0005
R2077 avdd.n1282 avdd.n1181 14.0005
R2078 avdd.n1288 avdd.n1181 14.0005
R2079 avdd.n1288 avdd.n1173 14.0005
R2080 avdd.n1298 avdd.n1173 14.0005
R2081 avdd.n1298 avdd.n1169 14.0005
R2082 avdd.n1348 avdd.n1169 14.0005
R2083 avdd.n1232 avdd.n1223 14.0005
R2084 avdd.n1232 avdd.n1215 14.0005
R2085 avdd.n1242 avdd.n1215 14.0005
R2086 avdd.n1242 avdd.n1211 14.0005
R2087 avdd.n1248 avdd.n1211 14.0005
R2088 avdd.n1248 avdd.n1203 14.0005
R2089 avdd.n1258 avdd.n1203 14.0005
R2090 avdd.n1258 avdd.n1199 14.0005
R2091 avdd.n1264 avdd.n1199 14.0005
R2092 avdd.n1264 avdd.n1191 14.0005
R2093 avdd.n1274 avdd.n1191 14.0005
R2094 avdd.n1274 avdd.n1187 14.0005
R2095 avdd.n1280 avdd.n1187 14.0005
R2096 avdd.n1280 avdd.n1179 14.0005
R2097 avdd.n1290 avdd.n1179 14.0005
R2098 avdd.n1290 avdd.n1175 14.0005
R2099 avdd.n1296 avdd.n1175 14.0005
R2100 avdd.n1296 avdd.n1166 14.0005
R2101 avdd.n1351 avdd.n1166 14.0005
R2102 avdd.n1338 avdd.n1307 14.0005
R2103 avdd.n1341 avdd.n1305 14.0005
R2104 avdd.n1325 avdd.n1311 14.0005
R2105 avdd.n1316 avdd.n1312 14.0005
R2106 avdd.n1381 avdd.n1367 14.0005
R2107 avdd.n1375 avdd.n1368 14.0005
R2108 avdd.n1390 avdd.n1362 14.0005
R2109 avdd.n1393 avdd.n1357 14.0005
R2110 avdd.n1426 avdd.n1416 14.0005
R2111 avdd.n1432 avdd.n1416 14.0005
R2112 avdd.n1432 avdd.n1409 14.0005
R2113 avdd.n1442 avdd.n1409 14.0005
R2114 avdd.n1442 avdd.n1405 14.0005
R2115 avdd.n1448 avdd.n1405 14.0005
R2116 avdd.n1423 avdd.n1414 14.0005
R2117 avdd.n1434 avdd.n1414 14.0005
R2118 avdd.n1434 avdd.n1410 14.0005
R2119 avdd.n1440 avdd.n1410 14.0005
R2120 avdd.n1440 avdd.n1402 14.0005
R2121 avdd.n1451 avdd.n1402 14.0005
R2122 avdd.n1475 avdd.n1466 14.0005
R2123 avdd.n1485 avdd.n1466 14.0005
R2124 avdd.n1485 avdd.n1462 14.0005
R2125 avdd.n1491 avdd.n1462 14.0005
R2126 avdd.n1478 avdd.n1468 14.0005
R2127 avdd.n1484 avdd.n1468 14.0005
R2128 avdd.n1484 avdd.n1459 14.0005
R2129 avdd.n1494 avdd.n1459 14.0005
R2130 avdd.n147 avdd.n137 14.0005
R2131 avdd.n150 avdd.n135 14.0005
R2132 avdd.n169 avdd.n159 14.0005
R2133 avdd.n172 avdd.n157 14.0005
R2134 avdd.n3873 avdd.n3866 14.0005
R2135 avdd.n3891 avdd.n3884 14.0005
R2136 avdd.n3910 avdd.n3903 14.0005
R2137 avdd.n3767 avdd.n3760 14.0005
R2138 avdd.n3785 avdd.n3778 14.0005
R2139 avdd.n3804 avdd.n3797 14.0005
R2140 avdd.n4064 avdd.n4057 14.0005
R2141 avdd.n4082 avdd.n4075 14.0005
R2142 avdd.n4101 avdd.n4094 14.0005
R2143 avdd.n76 avdd.n69 14.0005
R2144 avdd.n94 avdd.n87 14.0005
R2145 avdd.n113 avdd.n106 14.0005
R2146 avdd.n4131 avdd.n4124 14.0005
R2147 avdd.n4149 avdd.n4142 14.0005
R2148 avdd.n4168 avdd.n4161 14.0005
R2149 avdd.n19 avdd.n12 14.0005
R2150 avdd.n37 avdd.n30 14.0005
R2151 avdd.n56 avdd.n49 14.0005
R2152 avdd.n4284 avdd.n4275 14.0005
R2153 avdd.n4308 avdd.n4301 14.0005
R2154 avdd.n4308 avdd.n4296 14.0005
R2155 avdd.n4314 avdd.n4296 14.0005
R2156 avdd.n4304 avdd.n4295 14.0005
R2157 avdd.n4318 avdd.n4295 14.0005
R2158 avdd.n4318 avdd.n4293 14.0005
R2159 avdd.n4341 avdd.n4334 14.0005
R2160 avdd.n4341 avdd.n4329 14.0005
R2161 avdd.n4347 avdd.n4329 14.0005
R2162 avdd.n4337 avdd.n4328 14.0005
R2163 avdd.n4351 avdd.n4328 14.0005
R2164 avdd.n4351 avdd.n4326 14.0005
R2165 avdd.n4198 avdd.n4191 14.0005
R2166 avdd.n4223 avdd.n4216 14.0005
R2167 avdd.n4223 avdd.n4211 14.0005
R2168 avdd.n4229 avdd.n4211 14.0005
R2169 avdd.n4219 avdd.n4210 14.0005
R2170 avdd.n4233 avdd.n4210 14.0005
R2171 avdd.n4233 avdd.n4208 14.0005
R2172 avdd.n4256 avdd.n4249 14.0005
R2173 avdd.n4256 avdd.n4244 14.0005
R2174 avdd.n4262 avdd.n4244 14.0005
R2175 avdd.n4252 avdd.n4243 14.0005
R2176 avdd.n4266 avdd.n4243 14.0005
R2177 avdd.n4266 avdd.n4241 14.0005
R2178 avdd.n4367 avdd.n4360 14.0005
R2179 avdd.n139 avdd.t91 13.5321
R2180 avdd avdd.n176 13.5293
R2181 avdd avdd.n4374 13.5005
R2182 avdd.n3742 avdd.n3741 13.4561
R2183 avdd.n3744 avdd.n3741 13.4561
R2184 avdd.n4272 avdd.t129 12.9932
R2185 avdd.n4188 avdd.t1 12.9932
R2186 avdd.n4038 avdd.n4037 12.7505
R2187 avdd.n4037 avdd.n179 12.7505
R2188 avdd.n4034 avdd.n178 12.7505
R2189 avdd.n4034 avdd.n4033 12.7505
R2190 avdd.n4031 avdd.n4030 12.7505
R2191 avdd.n4032 avdd.n4031 12.7505
R2192 avdd.n4029 avdd.n4028 12.7505
R2193 avdd.n4028 avdd.n182 12.7505
R2194 avdd.n4021 avdd.n4020 12.7505
R2195 avdd.n4022 avdd.n4021 12.7505
R2196 avdd.n4019 avdd.n4018 12.7505
R2197 avdd.n4018 avdd.n205 12.7505
R2198 avdd.n4015 avdd.n206 12.7505
R2199 avdd.n4015 avdd.n4014 12.7505
R2200 avdd.n4012 avdd.n4011 12.7505
R2201 avdd.n4013 avdd.n4012 12.7505
R2202 avdd.n200 avdd.n199 12.7505
R2203 avdd.n3744 avdd.n3743 12.7505
R2204 avdd.n3743 avdd.n3742 12.7505
R2205 avdd.n3978 avdd.n223 12.7505
R2206 avdd.n3979 avdd.n3978 12.7505
R2207 avdd.n3982 avdd.n3981 12.7505
R2208 avdd.n3981 avdd.n3980 12.7505
R2209 avdd.n3984 avdd.n3983 12.7505
R2210 avdd.n3984 avdd.n221 12.7505
R2211 avdd.n3987 avdd.n220 12.7505
R2212 avdd.n3988 avdd.n3987 12.7505
R2213 avdd.n3991 avdd.n3990 12.7505
R2214 avdd.n3990 avdd.n3989 12.7505
R2215 avdd.n3997 avdd.n215 12.7505
R2216 avdd.n3998 avdd.n3997 12.7505
R2217 avdd.n4001 avdd.n4000 12.7505
R2218 avdd.n4000 avdd.n3999 12.7505
R2219 avdd.n4003 avdd.n4002 12.7505
R2220 avdd.n4003 avdd.n212 12.7505
R2221 avdd.n4006 avdd.n213 12.7505
R2222 avdd.n4007 avdd.n4006 12.7505
R2223 avdd.n2518 avdd.t117 11.2316
R2224 avdd.n622 avdd.t121 11.2316
R2225 avdd.n997 avdd.t123 11.2316
R2226 avdd.n2898 avdd.t111 11.2316
R2227 avdd.n3273 avdd.t103 11.2316
R2228 avdd.n3649 avdd.t99 11.2316
R2229 avdd.n1845 avdd.t109 11.2316
R2230 avdd.n1470 avdd.t101 11.2316
R2231 avdd.n4043 avdd.n129 11.1629
R2232 avdd.n161 avdd.t119 10.8172
R2233 avdd.n1066 avdd.n1065 10.7282
R2234 avdd.n2446 avdd.n2402 10.3984
R2235 avdd.n550 avdd.n506 10.3984
R2236 avdd.n925 avdd.n881 10.3984
R2237 avdd.n2826 avdd.n2782 10.3984
R2238 avdd.n3201 avdd.n3157 10.3984
R2239 avdd.n3577 avdd.n3533 10.3984
R2240 avdd.n1773 avdd.n1729 10.3984
R2241 avdd.n1398 avdd.n1354 10.3984
R2242 avdd.n2446 avdd.n2445 7.63485
R2243 avdd.n2503 avdd.n2502 7.63485
R2244 avdd.n550 avdd.n549 7.63485
R2245 avdd.n607 avdd.n606 7.63485
R2246 avdd.n925 avdd.n924 7.63485
R2247 avdd.n982 avdd.n981 7.63485
R2248 avdd.n2826 avdd.n2825 7.63485
R2249 avdd.n2883 avdd.n2882 7.63485
R2250 avdd.n3201 avdd.n3200 7.63485
R2251 avdd.n3258 avdd.n3257 7.63485
R2252 avdd.n3577 avdd.n3576 7.63485
R2253 avdd.n3634 avdd.n3633 7.63485
R2254 avdd.n1773 avdd.n1772 7.63485
R2255 avdd.n1830 avdd.n1829 7.63485
R2256 avdd.n1398 avdd.n1397 7.63485
R2257 avdd.n1455 avdd.n1454 7.63485
R2258 avdd.n3741 avdd.n225 7.4561
R2259 avdd.n176 avdd.n153 6.88949
R2260 avdd.n4037 avdd.n4036 6.7505
R2261 avdd.n4035 avdd.n4034 6.7505
R2262 avdd.n4031 avdd.n181 6.7505
R2263 avdd.n4028 avdd.n4027 6.7505
R2264 avdd.n4021 avdd.n184 6.7505
R2265 avdd.n4018 avdd.n4017 6.7505
R2266 avdd.n4016 avdd.n4015 6.7505
R2267 avdd.n4012 avdd.n207 6.7505
R2268 avdd.n199 avdd.n180 6.7505
R2269 avdd.n4039 avdd.n129 6.7505
R2270 avdd.n4006 avdd.n4005 6.7505
R2271 avdd.n4004 avdd.n4003 6.7505
R2272 avdd.n4000 avdd.n214 6.7505
R2273 avdd.n3997 avdd.n3996 6.7505
R2274 avdd.n3990 avdd.n217 6.7505
R2275 avdd.n3987 avdd.n3986 6.7505
R2276 avdd.n3985 avdd.n3984 6.7505
R2277 avdd.n3981 avdd.n222 6.7505
R2278 avdd.n3978 avdd.n3977 6.7505
R2279 avdd.n3743 avdd.n225 6.7505
R2280 avdd.n4320 avdd.n4293 6.37187
R2281 avdd.n4304 avdd.n4292 6.37187
R2282 avdd.n4353 avdd.n4326 6.37187
R2283 avdd.n4337 avdd.n4325 6.37187
R2284 avdd.n4235 avdd.n4208 6.37187
R2285 avdd.n4219 avdd.n4207 6.37187
R2286 avdd.n4268 avdd.n4241 6.37187
R2287 avdd.n4252 avdd.n4240 6.37187
R2288 avdd.n2546 avdd.n2545 6.33474
R2289 avdd.n650 avdd.n649 6.33474
R2290 avdd.n1025 avdd.n1024 6.33474
R2291 avdd.n2926 avdd.n2925 6.33474
R2292 avdd.n3301 avdd.n3300 6.33474
R2293 avdd.n3677 avdd.n3676 6.33474
R2294 avdd.n1873 avdd.n1872 6.33474
R2295 avdd.n1498 avdd.n1497 6.33474
R2296 avdd.n2031 avdd.n2030 6.3005
R2297 avdd.n2032 avdd.n2031 6.3005
R2298 avdd.n1918 avdd.n1917 6.3005
R2299 avdd.n1917 avdd.n1916 6.3005
R2300 avdd.n1962 avdd.n1961 6.3005
R2301 avdd.n1961 avdd.n1960 6.3005
R2302 avdd.n1921 avdd.n1920 6.3005
R2303 avdd.n1922 avdd.n1921 6.3005
R2304 avdd.n1951 avdd.n1950 6.3005
R2305 avdd.n1952 avdd.n1951 6.3005
R2306 avdd.n1930 avdd.n1929 6.3005
R2307 avdd.n1929 avdd.n1928 6.3005
R2308 avdd.n1946 avdd.n1945 6.3005
R2309 avdd.n1945 avdd.n1944 6.3005
R2310 avdd.n1933 avdd.n1932 6.3005
R2311 avdd.n2035 avdd.n2034 6.3005
R2312 avdd.n1914 avdd.n1913 6.3005
R2313 avdd.n1916 avdd.n1914 6.3005
R2314 avdd.n1959 avdd.n1958 6.3005
R2315 avdd.n1960 avdd.n1959 6.3005
R2316 avdd.n1924 avdd.n1923 6.3005
R2317 avdd.n1923 avdd.n1922 6.3005
R2318 avdd.n1954 avdd.n1953 6.3005
R2319 avdd.n1953 avdd.n1952 6.3005
R2320 avdd.n1927 avdd.n1926 6.3005
R2321 avdd.n1928 avdd.n1927 6.3005
R2322 avdd.n1943 avdd.n1942 6.3005
R2323 avdd.n1944 avdd.n1943 6.3005
R2324 avdd.n1936 avdd.n1935 6.3005
R2325 avdd.n1935 avdd.n1934 6.3005
R2326 avdd.n2021 avdd.n2020 6.3005
R2327 avdd.n2022 avdd.n2021 6.3005
R2328 avdd.n1972 avdd.n1971 6.3005
R2329 avdd.n1971 avdd.n1970 6.3005
R2330 avdd.n2016 avdd.n2015 6.3005
R2331 avdd.n2015 avdd.n2014 6.3005
R2332 avdd.n1975 avdd.n1974 6.3005
R2333 avdd.n1976 avdd.n1975 6.3005
R2334 avdd.n2005 avdd.n2004 6.3005
R2335 avdd.n2006 avdd.n2005 6.3005
R2336 avdd.n1984 avdd.n1983 6.3005
R2337 avdd.n1983 avdd.n1982 6.3005
R2338 avdd.n2000 avdd.n1999 6.3005
R2339 avdd.n1999 avdd.n1998 6.3005
R2340 avdd.n1987 avdd.n1986 6.3005
R2341 avdd.n2025 avdd.n2024 6.3005
R2342 avdd.n1968 avdd.n1967 6.3005
R2343 avdd.n1970 avdd.n1968 6.3005
R2344 avdd.n2013 avdd.n2012 6.3005
R2345 avdd.n2014 avdd.n2013 6.3005
R2346 avdd.n1978 avdd.n1977 6.3005
R2347 avdd.n1977 avdd.n1976 6.3005
R2348 avdd.n2008 avdd.n2007 6.3005
R2349 avdd.n2007 avdd.n2006 6.3005
R2350 avdd.n1981 avdd.n1980 6.3005
R2351 avdd.n1982 avdd.n1981 6.3005
R2352 avdd.n1997 avdd.n1996 6.3005
R2353 avdd.n1998 avdd.n1997 6.3005
R2354 avdd.n1990 avdd.n1989 6.3005
R2355 avdd.n1989 avdd.n1988 6.3005
R2356 avdd.n2165 avdd.n2164 6.3005
R2357 avdd.n2166 avdd.n2165 6.3005
R2358 avdd.n2052 avdd.n2051 6.3005
R2359 avdd.n2051 avdd.n2050 6.3005
R2360 avdd.n2096 avdd.n2095 6.3005
R2361 avdd.n2095 avdd.n2094 6.3005
R2362 avdd.n2055 avdd.n2054 6.3005
R2363 avdd.n2056 avdd.n2055 6.3005
R2364 avdd.n2085 avdd.n2084 6.3005
R2365 avdd.n2086 avdd.n2085 6.3005
R2366 avdd.n2064 avdd.n2063 6.3005
R2367 avdd.n2063 avdd.n2062 6.3005
R2368 avdd.n2080 avdd.n2079 6.3005
R2369 avdd.n2079 avdd.n2078 6.3005
R2370 avdd.n2067 avdd.n2066 6.3005
R2371 avdd.n2169 avdd.n2168 6.3005
R2372 avdd.n2048 avdd.n2047 6.3005
R2373 avdd.n2050 avdd.n2048 6.3005
R2374 avdd.n2093 avdd.n2092 6.3005
R2375 avdd.n2094 avdd.n2093 6.3005
R2376 avdd.n2058 avdd.n2057 6.3005
R2377 avdd.n2057 avdd.n2056 6.3005
R2378 avdd.n2088 avdd.n2087 6.3005
R2379 avdd.n2087 avdd.n2086 6.3005
R2380 avdd.n2061 avdd.n2060 6.3005
R2381 avdd.n2062 avdd.n2061 6.3005
R2382 avdd.n2077 avdd.n2076 6.3005
R2383 avdd.n2078 avdd.n2077 6.3005
R2384 avdd.n2070 avdd.n2069 6.3005
R2385 avdd.n2069 avdd.n2068 6.3005
R2386 avdd.n2155 avdd.n2154 6.3005
R2387 avdd.n2156 avdd.n2155 6.3005
R2388 avdd.n2106 avdd.n2105 6.3005
R2389 avdd.n2105 avdd.n2104 6.3005
R2390 avdd.n2150 avdd.n2149 6.3005
R2391 avdd.n2149 avdd.n2148 6.3005
R2392 avdd.n2109 avdd.n2108 6.3005
R2393 avdd.n2110 avdd.n2109 6.3005
R2394 avdd.n2139 avdd.n2138 6.3005
R2395 avdd.n2140 avdd.n2139 6.3005
R2396 avdd.n2118 avdd.n2117 6.3005
R2397 avdd.n2117 avdd.n2116 6.3005
R2398 avdd.n2134 avdd.n2133 6.3005
R2399 avdd.n2133 avdd.n2132 6.3005
R2400 avdd.n2121 avdd.n2120 6.3005
R2401 avdd.n2159 avdd.n2158 6.3005
R2402 avdd.n2102 avdd.n2101 6.3005
R2403 avdd.n2104 avdd.n2102 6.3005
R2404 avdd.n2147 avdd.n2146 6.3005
R2405 avdd.n2148 avdd.n2147 6.3005
R2406 avdd.n2112 avdd.n2111 6.3005
R2407 avdd.n2111 avdd.n2110 6.3005
R2408 avdd.n2142 avdd.n2141 6.3005
R2409 avdd.n2141 avdd.n2140 6.3005
R2410 avdd.n2115 avdd.n2114 6.3005
R2411 avdd.n2116 avdd.n2115 6.3005
R2412 avdd.n2131 avdd.n2130 6.3005
R2413 avdd.n2132 avdd.n2131 6.3005
R2414 avdd.n2124 avdd.n2123 6.3005
R2415 avdd.n2123 avdd.n2122 6.3005
R2416 avdd.n2396 avdd.n2395 6.3005
R2417 avdd.n2397 avdd.n2396 6.3005
R2418 avdd.n2218 avdd.n2217 6.3005
R2419 avdd.n2217 avdd.n2216 6.3005
R2420 avdd.n2347 avdd.n2346 6.3005
R2421 avdd.n2346 avdd.n2345 6.3005
R2422 avdd.n2221 avdd.n2220 6.3005
R2423 avdd.n2222 avdd.n2221 6.3005
R2424 avdd.n2336 avdd.n2335 6.3005
R2425 avdd.n2337 avdd.n2336 6.3005
R2426 avdd.n2230 avdd.n2229 6.3005
R2427 avdd.n2229 avdd.n2228 6.3005
R2428 avdd.n2331 avdd.n2330 6.3005
R2429 avdd.n2330 avdd.n2329 6.3005
R2430 avdd.n2233 avdd.n2232 6.3005
R2431 avdd.n2234 avdd.n2233 6.3005
R2432 avdd.n2320 avdd.n2319 6.3005
R2433 avdd.n2321 avdd.n2320 6.3005
R2434 avdd.n2242 avdd.n2241 6.3005
R2435 avdd.n2241 avdd.n2240 6.3005
R2436 avdd.n2315 avdd.n2314 6.3005
R2437 avdd.n2314 avdd.n2313 6.3005
R2438 avdd.n2245 avdd.n2244 6.3005
R2439 avdd.n2246 avdd.n2245 6.3005
R2440 avdd.n2304 avdd.n2303 6.3005
R2441 avdd.n2305 avdd.n2304 6.3005
R2442 avdd.n2254 avdd.n2253 6.3005
R2443 avdd.n2253 avdd.n2252 6.3005
R2444 avdd.n2299 avdd.n2298 6.3005
R2445 avdd.n2298 avdd.n2297 6.3005
R2446 avdd.n2257 avdd.n2256 6.3005
R2447 avdd.n2258 avdd.n2257 6.3005
R2448 avdd.n2288 avdd.n2287 6.3005
R2449 avdd.n2289 avdd.n2288 6.3005
R2450 avdd.n2266 avdd.n2265 6.3005
R2451 avdd.n2265 avdd.n2264 6.3005
R2452 avdd.n2283 avdd.n2282 6.3005
R2453 avdd.n2282 avdd.n2281 6.3005
R2454 avdd.n2269 avdd.n2268 6.3005
R2455 avdd.n2400 avdd.n2399 6.3005
R2456 avdd.n2214 avdd.n2213 6.3005
R2457 avdd.n2216 avdd.n2214 6.3005
R2458 avdd.n2344 avdd.n2343 6.3005
R2459 avdd.n2345 avdd.n2344 6.3005
R2460 avdd.n2224 avdd.n2223 6.3005
R2461 avdd.n2223 avdd.n2222 6.3005
R2462 avdd.n2339 avdd.n2338 6.3005
R2463 avdd.n2338 avdd.n2337 6.3005
R2464 avdd.n2227 avdd.n2226 6.3005
R2465 avdd.n2228 avdd.n2227 6.3005
R2466 avdd.n2328 avdd.n2327 6.3005
R2467 avdd.n2329 avdd.n2328 6.3005
R2468 avdd.n2236 avdd.n2235 6.3005
R2469 avdd.n2235 avdd.n2234 6.3005
R2470 avdd.n2323 avdd.n2322 6.3005
R2471 avdd.n2322 avdd.n2321 6.3005
R2472 avdd.n2239 avdd.n2238 6.3005
R2473 avdd.n2240 avdd.n2239 6.3005
R2474 avdd.n2312 avdd.n2311 6.3005
R2475 avdd.n2313 avdd.n2312 6.3005
R2476 avdd.n2248 avdd.n2247 6.3005
R2477 avdd.n2247 avdd.n2246 6.3005
R2478 avdd.n2307 avdd.n2306 6.3005
R2479 avdd.n2306 avdd.n2305 6.3005
R2480 avdd.n2251 avdd.n2250 6.3005
R2481 avdd.n2252 avdd.n2251 6.3005
R2482 avdd.n2296 avdd.n2295 6.3005
R2483 avdd.n2297 avdd.n2296 6.3005
R2484 avdd.n2260 avdd.n2259 6.3005
R2485 avdd.n2259 avdd.n2258 6.3005
R2486 avdd.n2291 avdd.n2290 6.3005
R2487 avdd.n2290 avdd.n2289 6.3005
R2488 avdd.n2263 avdd.n2262 6.3005
R2489 avdd.n2264 avdd.n2263 6.3005
R2490 avdd.n2280 avdd.n2279 6.3005
R2491 avdd.n2281 avdd.n2280 6.3005
R2492 avdd.n2272 avdd.n2271 6.3005
R2493 avdd.n2271 avdd.n2270 6.3005
R2494 avdd.n2386 avdd.n2385 6.3005
R2495 avdd.n2387 avdd.n2386 6.3005
R2496 avdd.n2356 avdd.n2355 6.3005
R2497 avdd.n2390 avdd.n2389 6.3005
R2498 avdd.n2353 avdd.n2352 6.3005
R2499 avdd.n2378 avdd.n2353 6.3005
R2500 avdd.n2363 avdd.n2359 6.3005
R2501 avdd.n2375 avdd.n2359 6.3005
R2502 avdd.n2373 avdd.n2372 6.3005
R2503 avdd.n2374 avdd.n2373 6.3005
R2504 avdd.n2365 avdd.n2360 6.3005
R2505 avdd.n2366 avdd.n2364 6.3005
R2506 avdd.n2429 avdd.n2428 6.3005
R2507 avdd.n2430 avdd.n2429 6.3005
R2508 avdd.n2419 avdd.n2415 6.3005
R2509 avdd.n2431 avdd.n2415 6.3005
R2510 avdd.n2424 avdd.n2423 6.3005
R2511 avdd.n2422 avdd.n2416 6.3005
R2512 avdd.n2438 avdd.n2437 6.3005
R2513 avdd.n2439 avdd.n2438 6.3005
R2514 avdd.n2411 avdd.n2410 6.3005
R2515 avdd.n2442 avdd.n2441 6.3005
R2516 avdd.n2443 avdd.n2405 6.3005
R2517 avdd.n2408 avdd.n2405 6.3005
R2518 avdd.n2496 avdd.n2495 6.3005
R2519 avdd.n2497 avdd.n2496 6.3005
R2520 avdd.n2454 avdd.n2453 6.3005
R2521 avdd.n2453 avdd.n2452 6.3005
R2522 avdd.n2491 avdd.n2490 6.3005
R2523 avdd.n2490 avdd.n2489 6.3005
R2524 avdd.n2457 avdd.n2456 6.3005
R2525 avdd.t124 avdd.n2457 6.3005
R2526 avdd.n2480 avdd.n2479 6.3005
R2527 avdd.n2481 avdd.n2480 6.3005
R2528 avdd.n2465 avdd.n2464 6.3005
R2529 avdd.n2464 avdd.n2463 6.3005
R2530 avdd.n2475 avdd.n2474 6.3005
R2531 avdd.n2500 avdd.n2499 6.3005
R2532 avdd.n2450 avdd.n2449 6.3005
R2533 avdd.n2452 avdd.n2450 6.3005
R2534 avdd.n2488 avdd.n2487 6.3005
R2535 avdd.n2489 avdd.n2488 6.3005
R2536 avdd.n2459 avdd.n2458 6.3005
R2537 avdd.n2458 avdd.t124 6.3005
R2538 avdd.n2483 avdd.n2482 6.3005
R2539 avdd.n2482 avdd.n2481 6.3005
R2540 avdd.n2462 avdd.n2461 6.3005
R2541 avdd.n2463 avdd.n2462 6.3005
R2542 avdd.n2471 avdd.n2470 6.3005
R2543 avdd.n2472 avdd.n2471 6.3005
R2544 avdd.n2539 avdd.n2538 6.3005
R2545 avdd.n2540 avdd.n2539 6.3005
R2546 avdd.n2511 avdd.n2510 6.3005
R2547 avdd.n2510 avdd.n2509 6.3005
R2548 avdd.n2534 avdd.n2533 6.3005
R2549 avdd.n2533 avdd.t116 6.3005
R2550 avdd.n2514 avdd.n2513 6.3005
R2551 avdd.n2515 avdd.n2514 6.3005
R2552 avdd.n2523 avdd.n2522 6.3005
R2553 avdd.n2543 avdd.n2542 6.3005
R2554 avdd.n2507 avdd.n2506 6.3005
R2555 avdd.n2509 avdd.n2507 6.3005
R2556 avdd.n2532 avdd.n2531 6.3005
R2557 avdd.t116 avdd.n2532 6.3005
R2558 avdd.n2517 avdd.n2516 6.3005
R2559 avdd.n2516 avdd.n2515 6.3005
R2560 avdd.n2527 avdd.n2526 6.3005
R2561 avdd.n2526 avdd.n2525 6.3005
R2562 avdd.n500 avdd.n499 6.3005
R2563 avdd.n501 avdd.n500 6.3005
R2564 avdd.n322 avdd.n321 6.3005
R2565 avdd.n321 avdd.n320 6.3005
R2566 avdd.n451 avdd.n450 6.3005
R2567 avdd.n450 avdd.n449 6.3005
R2568 avdd.n325 avdd.n324 6.3005
R2569 avdd.n326 avdd.n325 6.3005
R2570 avdd.n440 avdd.n439 6.3005
R2571 avdd.n441 avdd.n440 6.3005
R2572 avdd.n334 avdd.n333 6.3005
R2573 avdd.n333 avdd.n332 6.3005
R2574 avdd.n435 avdd.n434 6.3005
R2575 avdd.n434 avdd.n433 6.3005
R2576 avdd.n337 avdd.n336 6.3005
R2577 avdd.n338 avdd.n337 6.3005
R2578 avdd.n424 avdd.n423 6.3005
R2579 avdd.n425 avdd.n424 6.3005
R2580 avdd.n346 avdd.n345 6.3005
R2581 avdd.n345 avdd.n344 6.3005
R2582 avdd.n419 avdd.n418 6.3005
R2583 avdd.n418 avdd.n417 6.3005
R2584 avdd.n349 avdd.n348 6.3005
R2585 avdd.n350 avdd.n349 6.3005
R2586 avdd.n408 avdd.n407 6.3005
R2587 avdd.n409 avdd.n408 6.3005
R2588 avdd.n358 avdd.n357 6.3005
R2589 avdd.n357 avdd.n356 6.3005
R2590 avdd.n403 avdd.n402 6.3005
R2591 avdd.n402 avdd.n401 6.3005
R2592 avdd.n361 avdd.n360 6.3005
R2593 avdd.n362 avdd.n361 6.3005
R2594 avdd.n392 avdd.n391 6.3005
R2595 avdd.n393 avdd.n392 6.3005
R2596 avdd.n370 avdd.n369 6.3005
R2597 avdd.n369 avdd.n368 6.3005
R2598 avdd.n387 avdd.n386 6.3005
R2599 avdd.n386 avdd.n385 6.3005
R2600 avdd.n373 avdd.n372 6.3005
R2601 avdd.n504 avdd.n503 6.3005
R2602 avdd.n318 avdd.n317 6.3005
R2603 avdd.n320 avdd.n318 6.3005
R2604 avdd.n448 avdd.n447 6.3005
R2605 avdd.n449 avdd.n448 6.3005
R2606 avdd.n328 avdd.n327 6.3005
R2607 avdd.n327 avdd.n326 6.3005
R2608 avdd.n443 avdd.n442 6.3005
R2609 avdd.n442 avdd.n441 6.3005
R2610 avdd.n331 avdd.n330 6.3005
R2611 avdd.n332 avdd.n331 6.3005
R2612 avdd.n432 avdd.n431 6.3005
R2613 avdd.n433 avdd.n432 6.3005
R2614 avdd.n340 avdd.n339 6.3005
R2615 avdd.n339 avdd.n338 6.3005
R2616 avdd.n427 avdd.n426 6.3005
R2617 avdd.n426 avdd.n425 6.3005
R2618 avdd.n343 avdd.n342 6.3005
R2619 avdd.n344 avdd.n343 6.3005
R2620 avdd.n416 avdd.n415 6.3005
R2621 avdd.n417 avdd.n416 6.3005
R2622 avdd.n352 avdd.n351 6.3005
R2623 avdd.n351 avdd.n350 6.3005
R2624 avdd.n411 avdd.n410 6.3005
R2625 avdd.n410 avdd.n409 6.3005
R2626 avdd.n355 avdd.n354 6.3005
R2627 avdd.n356 avdd.n355 6.3005
R2628 avdd.n400 avdd.n399 6.3005
R2629 avdd.n401 avdd.n400 6.3005
R2630 avdd.n364 avdd.n363 6.3005
R2631 avdd.n363 avdd.n362 6.3005
R2632 avdd.n395 avdd.n394 6.3005
R2633 avdd.n394 avdd.n393 6.3005
R2634 avdd.n367 avdd.n366 6.3005
R2635 avdd.n368 avdd.n367 6.3005
R2636 avdd.n384 avdd.n383 6.3005
R2637 avdd.n385 avdd.n384 6.3005
R2638 avdd.n376 avdd.n375 6.3005
R2639 avdd.n375 avdd.n374 6.3005
R2640 avdd.n490 avdd.n489 6.3005
R2641 avdd.n491 avdd.n490 6.3005
R2642 avdd.n460 avdd.n459 6.3005
R2643 avdd.n494 avdd.n493 6.3005
R2644 avdd.n457 avdd.n456 6.3005
R2645 avdd.n482 avdd.n457 6.3005
R2646 avdd.n467 avdd.n463 6.3005
R2647 avdd.n479 avdd.n463 6.3005
R2648 avdd.n477 avdd.n476 6.3005
R2649 avdd.n478 avdd.n477 6.3005
R2650 avdd.n469 avdd.n464 6.3005
R2651 avdd.n470 avdd.n468 6.3005
R2652 avdd.n533 avdd.n532 6.3005
R2653 avdd.n534 avdd.n533 6.3005
R2654 avdd.n523 avdd.n519 6.3005
R2655 avdd.n535 avdd.n519 6.3005
R2656 avdd.n528 avdd.n527 6.3005
R2657 avdd.n526 avdd.n520 6.3005
R2658 avdd.n542 avdd.n541 6.3005
R2659 avdd.n543 avdd.n542 6.3005
R2660 avdd.n515 avdd.n514 6.3005
R2661 avdd.n546 avdd.n545 6.3005
R2662 avdd.n547 avdd.n509 6.3005
R2663 avdd.n512 avdd.n509 6.3005
R2664 avdd.n600 avdd.n599 6.3005
R2665 avdd.n601 avdd.n600 6.3005
R2666 avdd.n558 avdd.n557 6.3005
R2667 avdd.n557 avdd.n556 6.3005
R2668 avdd.n595 avdd.n594 6.3005
R2669 avdd.n594 avdd.n593 6.3005
R2670 avdd.n561 avdd.n560 6.3005
R2671 avdd.t112 avdd.n561 6.3005
R2672 avdd.n584 avdd.n583 6.3005
R2673 avdd.n585 avdd.n584 6.3005
R2674 avdd.n569 avdd.n568 6.3005
R2675 avdd.n568 avdd.n567 6.3005
R2676 avdd.n579 avdd.n578 6.3005
R2677 avdd.n604 avdd.n603 6.3005
R2678 avdd.n554 avdd.n553 6.3005
R2679 avdd.n556 avdd.n554 6.3005
R2680 avdd.n592 avdd.n591 6.3005
R2681 avdd.n593 avdd.n592 6.3005
R2682 avdd.n563 avdd.n562 6.3005
R2683 avdd.n562 avdd.t112 6.3005
R2684 avdd.n587 avdd.n586 6.3005
R2685 avdd.n586 avdd.n585 6.3005
R2686 avdd.n566 avdd.n565 6.3005
R2687 avdd.n567 avdd.n566 6.3005
R2688 avdd.n575 avdd.n574 6.3005
R2689 avdd.n576 avdd.n575 6.3005
R2690 avdd.n643 avdd.n642 6.3005
R2691 avdd.n644 avdd.n643 6.3005
R2692 avdd.n615 avdd.n614 6.3005
R2693 avdd.n614 avdd.n613 6.3005
R2694 avdd.n638 avdd.n637 6.3005
R2695 avdd.n637 avdd.t120 6.3005
R2696 avdd.n618 avdd.n617 6.3005
R2697 avdd.n619 avdd.n618 6.3005
R2698 avdd.n627 avdd.n626 6.3005
R2699 avdd.n647 avdd.n646 6.3005
R2700 avdd.n611 avdd.n610 6.3005
R2701 avdd.n613 avdd.n611 6.3005
R2702 avdd.n636 avdd.n635 6.3005
R2703 avdd.t120 avdd.n636 6.3005
R2704 avdd.n621 avdd.n620 6.3005
R2705 avdd.n620 avdd.n619 6.3005
R2706 avdd.n631 avdd.n630 6.3005
R2707 avdd.n630 avdd.n629 6.3005
R2708 avdd.n875 avdd.n874 6.3005
R2709 avdd.n876 avdd.n875 6.3005
R2710 avdd.n697 avdd.n696 6.3005
R2711 avdd.n696 avdd.n695 6.3005
R2712 avdd.n826 avdd.n825 6.3005
R2713 avdd.n825 avdd.n824 6.3005
R2714 avdd.n700 avdd.n699 6.3005
R2715 avdd.n701 avdd.n700 6.3005
R2716 avdd.n815 avdd.n814 6.3005
R2717 avdd.n816 avdd.n815 6.3005
R2718 avdd.n709 avdd.n708 6.3005
R2719 avdd.n708 avdd.n707 6.3005
R2720 avdd.n810 avdd.n809 6.3005
R2721 avdd.n809 avdd.n808 6.3005
R2722 avdd.n712 avdd.n711 6.3005
R2723 avdd.n713 avdd.n712 6.3005
R2724 avdd.n799 avdd.n798 6.3005
R2725 avdd.n800 avdd.n799 6.3005
R2726 avdd.n721 avdd.n720 6.3005
R2727 avdd.n720 avdd.n719 6.3005
R2728 avdd.n794 avdd.n793 6.3005
R2729 avdd.n793 avdd.n792 6.3005
R2730 avdd.n724 avdd.n723 6.3005
R2731 avdd.n725 avdd.n724 6.3005
R2732 avdd.n783 avdd.n782 6.3005
R2733 avdd.n784 avdd.n783 6.3005
R2734 avdd.n733 avdd.n732 6.3005
R2735 avdd.n732 avdd.n731 6.3005
R2736 avdd.n778 avdd.n777 6.3005
R2737 avdd.n777 avdd.n776 6.3005
R2738 avdd.n736 avdd.n735 6.3005
R2739 avdd.n737 avdd.n736 6.3005
R2740 avdd.n767 avdd.n766 6.3005
R2741 avdd.n768 avdd.n767 6.3005
R2742 avdd.n745 avdd.n744 6.3005
R2743 avdd.n744 avdd.n743 6.3005
R2744 avdd.n762 avdd.n761 6.3005
R2745 avdd.n761 avdd.n760 6.3005
R2746 avdd.n748 avdd.n747 6.3005
R2747 avdd.n879 avdd.n878 6.3005
R2748 avdd.n693 avdd.n692 6.3005
R2749 avdd.n695 avdd.n693 6.3005
R2750 avdd.n823 avdd.n822 6.3005
R2751 avdd.n824 avdd.n823 6.3005
R2752 avdd.n703 avdd.n702 6.3005
R2753 avdd.n702 avdd.n701 6.3005
R2754 avdd.n818 avdd.n817 6.3005
R2755 avdd.n817 avdd.n816 6.3005
R2756 avdd.n706 avdd.n705 6.3005
R2757 avdd.n707 avdd.n706 6.3005
R2758 avdd.n807 avdd.n806 6.3005
R2759 avdd.n808 avdd.n807 6.3005
R2760 avdd.n715 avdd.n714 6.3005
R2761 avdd.n714 avdd.n713 6.3005
R2762 avdd.n802 avdd.n801 6.3005
R2763 avdd.n801 avdd.n800 6.3005
R2764 avdd.n718 avdd.n717 6.3005
R2765 avdd.n719 avdd.n718 6.3005
R2766 avdd.n791 avdd.n790 6.3005
R2767 avdd.n792 avdd.n791 6.3005
R2768 avdd.n727 avdd.n726 6.3005
R2769 avdd.n726 avdd.n725 6.3005
R2770 avdd.n786 avdd.n785 6.3005
R2771 avdd.n785 avdd.n784 6.3005
R2772 avdd.n730 avdd.n729 6.3005
R2773 avdd.n731 avdd.n730 6.3005
R2774 avdd.n775 avdd.n774 6.3005
R2775 avdd.n776 avdd.n775 6.3005
R2776 avdd.n739 avdd.n738 6.3005
R2777 avdd.n738 avdd.n737 6.3005
R2778 avdd.n770 avdd.n769 6.3005
R2779 avdd.n769 avdd.n768 6.3005
R2780 avdd.n742 avdd.n741 6.3005
R2781 avdd.n743 avdd.n742 6.3005
R2782 avdd.n759 avdd.n758 6.3005
R2783 avdd.n760 avdd.n759 6.3005
R2784 avdd.n751 avdd.n750 6.3005
R2785 avdd.n750 avdd.n749 6.3005
R2786 avdd.n865 avdd.n864 6.3005
R2787 avdd.n866 avdd.n865 6.3005
R2788 avdd.n835 avdd.n834 6.3005
R2789 avdd.n869 avdd.n868 6.3005
R2790 avdd.n832 avdd.n831 6.3005
R2791 avdd.n857 avdd.n832 6.3005
R2792 avdd.n842 avdd.n838 6.3005
R2793 avdd.n854 avdd.n838 6.3005
R2794 avdd.n852 avdd.n851 6.3005
R2795 avdd.n853 avdd.n852 6.3005
R2796 avdd.n844 avdd.n839 6.3005
R2797 avdd.n845 avdd.n843 6.3005
R2798 avdd.n908 avdd.n907 6.3005
R2799 avdd.n909 avdd.n908 6.3005
R2800 avdd.n898 avdd.n894 6.3005
R2801 avdd.n910 avdd.n894 6.3005
R2802 avdd.n903 avdd.n902 6.3005
R2803 avdd.n901 avdd.n895 6.3005
R2804 avdd.n917 avdd.n916 6.3005
R2805 avdd.n918 avdd.n917 6.3005
R2806 avdd.n890 avdd.n889 6.3005
R2807 avdd.n921 avdd.n920 6.3005
R2808 avdd.n922 avdd.n884 6.3005
R2809 avdd.n887 avdd.n884 6.3005
R2810 avdd.n975 avdd.n974 6.3005
R2811 avdd.n976 avdd.n975 6.3005
R2812 avdd.n933 avdd.n932 6.3005
R2813 avdd.n932 avdd.n931 6.3005
R2814 avdd.n970 avdd.n969 6.3005
R2815 avdd.n969 avdd.n968 6.3005
R2816 avdd.n936 avdd.n935 6.3005
R2817 avdd.t114 avdd.n936 6.3005
R2818 avdd.n959 avdd.n958 6.3005
R2819 avdd.n960 avdd.n959 6.3005
R2820 avdd.n944 avdd.n943 6.3005
R2821 avdd.n943 avdd.n942 6.3005
R2822 avdd.n954 avdd.n953 6.3005
R2823 avdd.n979 avdd.n978 6.3005
R2824 avdd.n929 avdd.n928 6.3005
R2825 avdd.n931 avdd.n929 6.3005
R2826 avdd.n967 avdd.n966 6.3005
R2827 avdd.n968 avdd.n967 6.3005
R2828 avdd.n938 avdd.n937 6.3005
R2829 avdd.n937 avdd.t114 6.3005
R2830 avdd.n962 avdd.n961 6.3005
R2831 avdd.n961 avdd.n960 6.3005
R2832 avdd.n941 avdd.n940 6.3005
R2833 avdd.n942 avdd.n941 6.3005
R2834 avdd.n950 avdd.n949 6.3005
R2835 avdd.n951 avdd.n950 6.3005
R2836 avdd.n1018 avdd.n1017 6.3005
R2837 avdd.n1019 avdd.n1018 6.3005
R2838 avdd.n990 avdd.n989 6.3005
R2839 avdd.n989 avdd.n988 6.3005
R2840 avdd.n1013 avdd.n1012 6.3005
R2841 avdd.n1012 avdd.t122 6.3005
R2842 avdd.n993 avdd.n992 6.3005
R2843 avdd.n994 avdd.n993 6.3005
R2844 avdd.n1002 avdd.n1001 6.3005
R2845 avdd.n1022 avdd.n1021 6.3005
R2846 avdd.n986 avdd.n985 6.3005
R2847 avdd.n988 avdd.n986 6.3005
R2848 avdd.n1011 avdd.n1010 6.3005
R2849 avdd.t122 avdd.n1011 6.3005
R2850 avdd.n996 avdd.n995 6.3005
R2851 avdd.n995 avdd.n994 6.3005
R2852 avdd.n1006 avdd.n1005 6.3005
R2853 avdd.n1005 avdd.n1004 6.3005
R2854 avdd.n2776 avdd.n2775 6.3005
R2855 avdd.n2777 avdd.n2776 6.3005
R2856 avdd.n2598 avdd.n2597 6.3005
R2857 avdd.n2597 avdd.n2596 6.3005
R2858 avdd.n2727 avdd.n2726 6.3005
R2859 avdd.n2726 avdd.n2725 6.3005
R2860 avdd.n2601 avdd.n2600 6.3005
R2861 avdd.n2602 avdd.n2601 6.3005
R2862 avdd.n2716 avdd.n2715 6.3005
R2863 avdd.n2717 avdd.n2716 6.3005
R2864 avdd.n2610 avdd.n2609 6.3005
R2865 avdd.n2609 avdd.n2608 6.3005
R2866 avdd.n2711 avdd.n2710 6.3005
R2867 avdd.n2710 avdd.n2709 6.3005
R2868 avdd.n2613 avdd.n2612 6.3005
R2869 avdd.n2614 avdd.n2613 6.3005
R2870 avdd.n2700 avdd.n2699 6.3005
R2871 avdd.n2701 avdd.n2700 6.3005
R2872 avdd.n2622 avdd.n2621 6.3005
R2873 avdd.n2621 avdd.n2620 6.3005
R2874 avdd.n2695 avdd.n2694 6.3005
R2875 avdd.n2694 avdd.n2693 6.3005
R2876 avdd.n2625 avdd.n2624 6.3005
R2877 avdd.n2626 avdd.n2625 6.3005
R2878 avdd.n2684 avdd.n2683 6.3005
R2879 avdd.n2685 avdd.n2684 6.3005
R2880 avdd.n2634 avdd.n2633 6.3005
R2881 avdd.n2633 avdd.n2632 6.3005
R2882 avdd.n2679 avdd.n2678 6.3005
R2883 avdd.n2678 avdd.n2677 6.3005
R2884 avdd.n2637 avdd.n2636 6.3005
R2885 avdd.n2638 avdd.n2637 6.3005
R2886 avdd.n2668 avdd.n2667 6.3005
R2887 avdd.n2669 avdd.n2668 6.3005
R2888 avdd.n2646 avdd.n2645 6.3005
R2889 avdd.n2645 avdd.n2644 6.3005
R2890 avdd.n2663 avdd.n2662 6.3005
R2891 avdd.n2662 avdd.n2661 6.3005
R2892 avdd.n2649 avdd.n2648 6.3005
R2893 avdd.n2780 avdd.n2779 6.3005
R2894 avdd.n2594 avdd.n2593 6.3005
R2895 avdd.n2596 avdd.n2594 6.3005
R2896 avdd.n2724 avdd.n2723 6.3005
R2897 avdd.n2725 avdd.n2724 6.3005
R2898 avdd.n2604 avdd.n2603 6.3005
R2899 avdd.n2603 avdd.n2602 6.3005
R2900 avdd.n2719 avdd.n2718 6.3005
R2901 avdd.n2718 avdd.n2717 6.3005
R2902 avdd.n2607 avdd.n2606 6.3005
R2903 avdd.n2608 avdd.n2607 6.3005
R2904 avdd.n2708 avdd.n2707 6.3005
R2905 avdd.n2709 avdd.n2708 6.3005
R2906 avdd.n2616 avdd.n2615 6.3005
R2907 avdd.n2615 avdd.n2614 6.3005
R2908 avdd.n2703 avdd.n2702 6.3005
R2909 avdd.n2702 avdd.n2701 6.3005
R2910 avdd.n2619 avdd.n2618 6.3005
R2911 avdd.n2620 avdd.n2619 6.3005
R2912 avdd.n2692 avdd.n2691 6.3005
R2913 avdd.n2693 avdd.n2692 6.3005
R2914 avdd.n2628 avdd.n2627 6.3005
R2915 avdd.n2627 avdd.n2626 6.3005
R2916 avdd.n2687 avdd.n2686 6.3005
R2917 avdd.n2686 avdd.n2685 6.3005
R2918 avdd.n2631 avdd.n2630 6.3005
R2919 avdd.n2632 avdd.n2631 6.3005
R2920 avdd.n2676 avdd.n2675 6.3005
R2921 avdd.n2677 avdd.n2676 6.3005
R2922 avdd.n2640 avdd.n2639 6.3005
R2923 avdd.n2639 avdd.n2638 6.3005
R2924 avdd.n2671 avdd.n2670 6.3005
R2925 avdd.n2670 avdd.n2669 6.3005
R2926 avdd.n2643 avdd.n2642 6.3005
R2927 avdd.n2644 avdd.n2643 6.3005
R2928 avdd.n2660 avdd.n2659 6.3005
R2929 avdd.n2661 avdd.n2660 6.3005
R2930 avdd.n2652 avdd.n2651 6.3005
R2931 avdd.n2651 avdd.n2650 6.3005
R2932 avdd.n2766 avdd.n2765 6.3005
R2933 avdd.n2767 avdd.n2766 6.3005
R2934 avdd.n2736 avdd.n2735 6.3005
R2935 avdd.n2770 avdd.n2769 6.3005
R2936 avdd.n2733 avdd.n2732 6.3005
R2937 avdd.n2758 avdd.n2733 6.3005
R2938 avdd.n2743 avdd.n2739 6.3005
R2939 avdd.n2755 avdd.n2739 6.3005
R2940 avdd.n2753 avdd.n2752 6.3005
R2941 avdd.n2754 avdd.n2753 6.3005
R2942 avdd.n2745 avdd.n2740 6.3005
R2943 avdd.n2746 avdd.n2744 6.3005
R2944 avdd.n2809 avdd.n2808 6.3005
R2945 avdd.n2810 avdd.n2809 6.3005
R2946 avdd.n2799 avdd.n2795 6.3005
R2947 avdd.n2811 avdd.n2795 6.3005
R2948 avdd.n2804 avdd.n2803 6.3005
R2949 avdd.n2802 avdd.n2796 6.3005
R2950 avdd.n2818 avdd.n2817 6.3005
R2951 avdd.n2819 avdd.n2818 6.3005
R2952 avdd.n2791 avdd.n2790 6.3005
R2953 avdd.n2822 avdd.n2821 6.3005
R2954 avdd.n2823 avdd.n2785 6.3005
R2955 avdd.n2788 avdd.n2785 6.3005
R2956 avdd.n2876 avdd.n2875 6.3005
R2957 avdd.n2877 avdd.n2876 6.3005
R2958 avdd.n2834 avdd.n2833 6.3005
R2959 avdd.n2833 avdd.n2832 6.3005
R2960 avdd.n2871 avdd.n2870 6.3005
R2961 avdd.n2870 avdd.n2869 6.3005
R2962 avdd.n2837 avdd.n2836 6.3005
R2963 avdd.t104 avdd.n2837 6.3005
R2964 avdd.n2860 avdd.n2859 6.3005
R2965 avdd.n2861 avdd.n2860 6.3005
R2966 avdd.n2845 avdd.n2844 6.3005
R2967 avdd.n2844 avdd.n2843 6.3005
R2968 avdd.n2855 avdd.n2854 6.3005
R2969 avdd.n2880 avdd.n2879 6.3005
R2970 avdd.n2830 avdd.n2829 6.3005
R2971 avdd.n2832 avdd.n2830 6.3005
R2972 avdd.n2868 avdd.n2867 6.3005
R2973 avdd.n2869 avdd.n2868 6.3005
R2974 avdd.n2839 avdd.n2838 6.3005
R2975 avdd.n2838 avdd.t104 6.3005
R2976 avdd.n2863 avdd.n2862 6.3005
R2977 avdd.n2862 avdd.n2861 6.3005
R2978 avdd.n2842 avdd.n2841 6.3005
R2979 avdd.n2843 avdd.n2842 6.3005
R2980 avdd.n2851 avdd.n2850 6.3005
R2981 avdd.n2852 avdd.n2851 6.3005
R2982 avdd.n2919 avdd.n2918 6.3005
R2983 avdd.n2920 avdd.n2919 6.3005
R2984 avdd.n2891 avdd.n2890 6.3005
R2985 avdd.n2890 avdd.n2889 6.3005
R2986 avdd.n2914 avdd.n2913 6.3005
R2987 avdd.n2913 avdd.t110 6.3005
R2988 avdd.n2894 avdd.n2893 6.3005
R2989 avdd.n2895 avdd.n2894 6.3005
R2990 avdd.n2903 avdd.n2902 6.3005
R2991 avdd.n2923 avdd.n2922 6.3005
R2992 avdd.n2887 avdd.n2886 6.3005
R2993 avdd.n2889 avdd.n2887 6.3005
R2994 avdd.n2912 avdd.n2911 6.3005
R2995 avdd.t110 avdd.n2912 6.3005
R2996 avdd.n2897 avdd.n2896 6.3005
R2997 avdd.n2896 avdd.n2895 6.3005
R2998 avdd.n2907 avdd.n2906 6.3005
R2999 avdd.n2906 avdd.n2905 6.3005
R3000 avdd.n3151 avdd.n3150 6.3005
R3001 avdd.n3152 avdd.n3151 6.3005
R3002 avdd.n2973 avdd.n2972 6.3005
R3003 avdd.n2972 avdd.n2971 6.3005
R3004 avdd.n3102 avdd.n3101 6.3005
R3005 avdd.n3101 avdd.n3100 6.3005
R3006 avdd.n2976 avdd.n2975 6.3005
R3007 avdd.n2977 avdd.n2976 6.3005
R3008 avdd.n3091 avdd.n3090 6.3005
R3009 avdd.n3092 avdd.n3091 6.3005
R3010 avdd.n2985 avdd.n2984 6.3005
R3011 avdd.n2984 avdd.n2983 6.3005
R3012 avdd.n3086 avdd.n3085 6.3005
R3013 avdd.n3085 avdd.n3084 6.3005
R3014 avdd.n2988 avdd.n2987 6.3005
R3015 avdd.n2989 avdd.n2988 6.3005
R3016 avdd.n3075 avdd.n3074 6.3005
R3017 avdd.n3076 avdd.n3075 6.3005
R3018 avdd.n2997 avdd.n2996 6.3005
R3019 avdd.n2996 avdd.n2995 6.3005
R3020 avdd.n3070 avdd.n3069 6.3005
R3021 avdd.n3069 avdd.n3068 6.3005
R3022 avdd.n3000 avdd.n2999 6.3005
R3023 avdd.n3001 avdd.n3000 6.3005
R3024 avdd.n3059 avdd.n3058 6.3005
R3025 avdd.n3060 avdd.n3059 6.3005
R3026 avdd.n3009 avdd.n3008 6.3005
R3027 avdd.n3008 avdd.n3007 6.3005
R3028 avdd.n3054 avdd.n3053 6.3005
R3029 avdd.n3053 avdd.n3052 6.3005
R3030 avdd.n3012 avdd.n3011 6.3005
R3031 avdd.n3013 avdd.n3012 6.3005
R3032 avdd.n3043 avdd.n3042 6.3005
R3033 avdd.n3044 avdd.n3043 6.3005
R3034 avdd.n3021 avdd.n3020 6.3005
R3035 avdd.n3020 avdd.n3019 6.3005
R3036 avdd.n3038 avdd.n3037 6.3005
R3037 avdd.n3037 avdd.n3036 6.3005
R3038 avdd.n3024 avdd.n3023 6.3005
R3039 avdd.n3155 avdd.n3154 6.3005
R3040 avdd.n2969 avdd.n2968 6.3005
R3041 avdd.n2971 avdd.n2969 6.3005
R3042 avdd.n3099 avdd.n3098 6.3005
R3043 avdd.n3100 avdd.n3099 6.3005
R3044 avdd.n2979 avdd.n2978 6.3005
R3045 avdd.n2978 avdd.n2977 6.3005
R3046 avdd.n3094 avdd.n3093 6.3005
R3047 avdd.n3093 avdd.n3092 6.3005
R3048 avdd.n2982 avdd.n2981 6.3005
R3049 avdd.n2983 avdd.n2982 6.3005
R3050 avdd.n3083 avdd.n3082 6.3005
R3051 avdd.n3084 avdd.n3083 6.3005
R3052 avdd.n2991 avdd.n2990 6.3005
R3053 avdd.n2990 avdd.n2989 6.3005
R3054 avdd.n3078 avdd.n3077 6.3005
R3055 avdd.n3077 avdd.n3076 6.3005
R3056 avdd.n2994 avdd.n2993 6.3005
R3057 avdd.n2995 avdd.n2994 6.3005
R3058 avdd.n3067 avdd.n3066 6.3005
R3059 avdd.n3068 avdd.n3067 6.3005
R3060 avdd.n3003 avdd.n3002 6.3005
R3061 avdd.n3002 avdd.n3001 6.3005
R3062 avdd.n3062 avdd.n3061 6.3005
R3063 avdd.n3061 avdd.n3060 6.3005
R3064 avdd.n3006 avdd.n3005 6.3005
R3065 avdd.n3007 avdd.n3006 6.3005
R3066 avdd.n3051 avdd.n3050 6.3005
R3067 avdd.n3052 avdd.n3051 6.3005
R3068 avdd.n3015 avdd.n3014 6.3005
R3069 avdd.n3014 avdd.n3013 6.3005
R3070 avdd.n3046 avdd.n3045 6.3005
R3071 avdd.n3045 avdd.n3044 6.3005
R3072 avdd.n3018 avdd.n3017 6.3005
R3073 avdd.n3019 avdd.n3018 6.3005
R3074 avdd.n3035 avdd.n3034 6.3005
R3075 avdd.n3036 avdd.n3035 6.3005
R3076 avdd.n3027 avdd.n3026 6.3005
R3077 avdd.n3026 avdd.n3025 6.3005
R3078 avdd.n3141 avdd.n3140 6.3005
R3079 avdd.n3142 avdd.n3141 6.3005
R3080 avdd.n3111 avdd.n3110 6.3005
R3081 avdd.n3145 avdd.n3144 6.3005
R3082 avdd.n3108 avdd.n3107 6.3005
R3083 avdd.n3133 avdd.n3108 6.3005
R3084 avdd.n3118 avdd.n3114 6.3005
R3085 avdd.n3130 avdd.n3114 6.3005
R3086 avdd.n3128 avdd.n3127 6.3005
R3087 avdd.n3129 avdd.n3128 6.3005
R3088 avdd.n3120 avdd.n3115 6.3005
R3089 avdd.n3121 avdd.n3119 6.3005
R3090 avdd.n3184 avdd.n3183 6.3005
R3091 avdd.n3185 avdd.n3184 6.3005
R3092 avdd.n3174 avdd.n3170 6.3005
R3093 avdd.n3186 avdd.n3170 6.3005
R3094 avdd.n3179 avdd.n3178 6.3005
R3095 avdd.n3177 avdd.n3171 6.3005
R3096 avdd.n3193 avdd.n3192 6.3005
R3097 avdd.n3194 avdd.n3193 6.3005
R3098 avdd.n3166 avdd.n3165 6.3005
R3099 avdd.n3197 avdd.n3196 6.3005
R3100 avdd.n3198 avdd.n3160 6.3005
R3101 avdd.n3163 avdd.n3160 6.3005
R3102 avdd.n3251 avdd.n3250 6.3005
R3103 avdd.n3252 avdd.n3251 6.3005
R3104 avdd.n3209 avdd.n3208 6.3005
R3105 avdd.n3208 avdd.n3207 6.3005
R3106 avdd.n3246 avdd.n3245 6.3005
R3107 avdd.n3245 avdd.n3244 6.3005
R3108 avdd.n3212 avdd.n3211 6.3005
R3109 avdd.t92 avdd.n3212 6.3005
R3110 avdd.n3235 avdd.n3234 6.3005
R3111 avdd.n3236 avdd.n3235 6.3005
R3112 avdd.n3220 avdd.n3219 6.3005
R3113 avdd.n3219 avdd.n3218 6.3005
R3114 avdd.n3230 avdd.n3229 6.3005
R3115 avdd.n3255 avdd.n3254 6.3005
R3116 avdd.n3205 avdd.n3204 6.3005
R3117 avdd.n3207 avdd.n3205 6.3005
R3118 avdd.n3243 avdd.n3242 6.3005
R3119 avdd.n3244 avdd.n3243 6.3005
R3120 avdd.n3214 avdd.n3213 6.3005
R3121 avdd.n3213 avdd.t92 6.3005
R3122 avdd.n3238 avdd.n3237 6.3005
R3123 avdd.n3237 avdd.n3236 6.3005
R3124 avdd.n3217 avdd.n3216 6.3005
R3125 avdd.n3218 avdd.n3217 6.3005
R3126 avdd.n3226 avdd.n3225 6.3005
R3127 avdd.n3227 avdd.n3226 6.3005
R3128 avdd.n3294 avdd.n3293 6.3005
R3129 avdd.n3295 avdd.n3294 6.3005
R3130 avdd.n3266 avdd.n3265 6.3005
R3131 avdd.n3265 avdd.n3264 6.3005
R3132 avdd.n3289 avdd.n3288 6.3005
R3133 avdd.n3288 avdd.t102 6.3005
R3134 avdd.n3269 avdd.n3268 6.3005
R3135 avdd.n3270 avdd.n3269 6.3005
R3136 avdd.n3278 avdd.n3277 6.3005
R3137 avdd.n3298 avdd.n3297 6.3005
R3138 avdd.n3262 avdd.n3261 6.3005
R3139 avdd.n3264 avdd.n3262 6.3005
R3140 avdd.n3287 avdd.n3286 6.3005
R3141 avdd.t102 avdd.n3287 6.3005
R3142 avdd.n3272 avdd.n3271 6.3005
R3143 avdd.n3271 avdd.n3270 6.3005
R3144 avdd.n3282 avdd.n3281 6.3005
R3145 avdd.n3281 avdd.n3280 6.3005
R3146 avdd.n3527 avdd.n3526 6.3005
R3147 avdd.n3528 avdd.n3527 6.3005
R3148 avdd.n3349 avdd.n3348 6.3005
R3149 avdd.n3348 avdd.n3347 6.3005
R3150 avdd.n3478 avdd.n3477 6.3005
R3151 avdd.n3477 avdd.n3476 6.3005
R3152 avdd.n3352 avdd.n3351 6.3005
R3153 avdd.n3353 avdd.n3352 6.3005
R3154 avdd.n3467 avdd.n3466 6.3005
R3155 avdd.n3468 avdd.n3467 6.3005
R3156 avdd.n3361 avdd.n3360 6.3005
R3157 avdd.n3360 avdd.n3359 6.3005
R3158 avdd.n3462 avdd.n3461 6.3005
R3159 avdd.n3461 avdd.n3460 6.3005
R3160 avdd.n3364 avdd.n3363 6.3005
R3161 avdd.n3365 avdd.n3364 6.3005
R3162 avdd.n3451 avdd.n3450 6.3005
R3163 avdd.n3452 avdd.n3451 6.3005
R3164 avdd.n3373 avdd.n3372 6.3005
R3165 avdd.n3372 avdd.n3371 6.3005
R3166 avdd.n3446 avdd.n3445 6.3005
R3167 avdd.n3445 avdd.n3444 6.3005
R3168 avdd.n3376 avdd.n3375 6.3005
R3169 avdd.n3377 avdd.n3376 6.3005
R3170 avdd.n3435 avdd.n3434 6.3005
R3171 avdd.n3436 avdd.n3435 6.3005
R3172 avdd.n3385 avdd.n3384 6.3005
R3173 avdd.n3384 avdd.n3383 6.3005
R3174 avdd.n3430 avdd.n3429 6.3005
R3175 avdd.n3429 avdd.n3428 6.3005
R3176 avdd.n3388 avdd.n3387 6.3005
R3177 avdd.n3389 avdd.n3388 6.3005
R3178 avdd.n3419 avdd.n3418 6.3005
R3179 avdd.n3420 avdd.n3419 6.3005
R3180 avdd.n3397 avdd.n3396 6.3005
R3181 avdd.n3396 avdd.n3395 6.3005
R3182 avdd.n3414 avdd.n3413 6.3005
R3183 avdd.n3413 avdd.n3412 6.3005
R3184 avdd.n3400 avdd.n3399 6.3005
R3185 avdd.n3531 avdd.n3530 6.3005
R3186 avdd.n3345 avdd.n3344 6.3005
R3187 avdd.n3347 avdd.n3345 6.3005
R3188 avdd.n3475 avdd.n3474 6.3005
R3189 avdd.n3476 avdd.n3475 6.3005
R3190 avdd.n3355 avdd.n3354 6.3005
R3191 avdd.n3354 avdd.n3353 6.3005
R3192 avdd.n3470 avdd.n3469 6.3005
R3193 avdd.n3469 avdd.n3468 6.3005
R3194 avdd.n3358 avdd.n3357 6.3005
R3195 avdd.n3359 avdd.n3358 6.3005
R3196 avdd.n3459 avdd.n3458 6.3005
R3197 avdd.n3460 avdd.n3459 6.3005
R3198 avdd.n3367 avdd.n3366 6.3005
R3199 avdd.n3366 avdd.n3365 6.3005
R3200 avdd.n3454 avdd.n3453 6.3005
R3201 avdd.n3453 avdd.n3452 6.3005
R3202 avdd.n3370 avdd.n3369 6.3005
R3203 avdd.n3371 avdd.n3370 6.3005
R3204 avdd.n3443 avdd.n3442 6.3005
R3205 avdd.n3444 avdd.n3443 6.3005
R3206 avdd.n3379 avdd.n3378 6.3005
R3207 avdd.n3378 avdd.n3377 6.3005
R3208 avdd.n3438 avdd.n3437 6.3005
R3209 avdd.n3437 avdd.n3436 6.3005
R3210 avdd.n3382 avdd.n3381 6.3005
R3211 avdd.n3383 avdd.n3382 6.3005
R3212 avdd.n3427 avdd.n3426 6.3005
R3213 avdd.n3428 avdd.n3427 6.3005
R3214 avdd.n3391 avdd.n3390 6.3005
R3215 avdd.n3390 avdd.n3389 6.3005
R3216 avdd.n3422 avdd.n3421 6.3005
R3217 avdd.n3421 avdd.n3420 6.3005
R3218 avdd.n3394 avdd.n3393 6.3005
R3219 avdd.n3395 avdd.n3394 6.3005
R3220 avdd.n3411 avdd.n3410 6.3005
R3221 avdd.n3412 avdd.n3411 6.3005
R3222 avdd.n3403 avdd.n3402 6.3005
R3223 avdd.n3402 avdd.n3401 6.3005
R3224 avdd.n3517 avdd.n3516 6.3005
R3225 avdd.n3518 avdd.n3517 6.3005
R3226 avdd.n3487 avdd.n3486 6.3005
R3227 avdd.n3521 avdd.n3520 6.3005
R3228 avdd.n3484 avdd.n3483 6.3005
R3229 avdd.n3509 avdd.n3484 6.3005
R3230 avdd.n3494 avdd.n3490 6.3005
R3231 avdd.n3506 avdd.n3490 6.3005
R3232 avdd.n3504 avdd.n3503 6.3005
R3233 avdd.n3505 avdd.n3504 6.3005
R3234 avdd.n3496 avdd.n3491 6.3005
R3235 avdd.n3497 avdd.n3495 6.3005
R3236 avdd.n3560 avdd.n3559 6.3005
R3237 avdd.n3561 avdd.n3560 6.3005
R3238 avdd.n3550 avdd.n3546 6.3005
R3239 avdd.n3562 avdd.n3546 6.3005
R3240 avdd.n3555 avdd.n3554 6.3005
R3241 avdd.n3553 avdd.n3547 6.3005
R3242 avdd.n3569 avdd.n3568 6.3005
R3243 avdd.n3570 avdd.n3569 6.3005
R3244 avdd.n3542 avdd.n3541 6.3005
R3245 avdd.n3573 avdd.n3572 6.3005
R3246 avdd.n3574 avdd.n3536 6.3005
R3247 avdd.n3539 avdd.n3536 6.3005
R3248 avdd.n3627 avdd.n3626 6.3005
R3249 avdd.n3628 avdd.n3627 6.3005
R3250 avdd.n3585 avdd.n3584 6.3005
R3251 avdd.n3584 avdd.n3583 6.3005
R3252 avdd.n3622 avdd.n3621 6.3005
R3253 avdd.n3621 avdd.n3620 6.3005
R3254 avdd.n3588 avdd.n3587 6.3005
R3255 avdd.t96 avdd.n3588 6.3005
R3256 avdd.n3611 avdd.n3610 6.3005
R3257 avdd.n3612 avdd.n3611 6.3005
R3258 avdd.n3596 avdd.n3595 6.3005
R3259 avdd.n3595 avdd.n3594 6.3005
R3260 avdd.n3606 avdd.n3605 6.3005
R3261 avdd.n3631 avdd.n3630 6.3005
R3262 avdd.n3581 avdd.n3580 6.3005
R3263 avdd.n3583 avdd.n3581 6.3005
R3264 avdd.n3619 avdd.n3618 6.3005
R3265 avdd.n3620 avdd.n3619 6.3005
R3266 avdd.n3590 avdd.n3589 6.3005
R3267 avdd.n3589 avdd.t96 6.3005
R3268 avdd.n3614 avdd.n3613 6.3005
R3269 avdd.n3613 avdd.n3612 6.3005
R3270 avdd.n3593 avdd.n3592 6.3005
R3271 avdd.n3594 avdd.n3593 6.3005
R3272 avdd.n3602 avdd.n3601 6.3005
R3273 avdd.n3603 avdd.n3602 6.3005
R3274 avdd.n3670 avdd.n3669 6.3005
R3275 avdd.n3671 avdd.n3670 6.3005
R3276 avdd.n3642 avdd.n3641 6.3005
R3277 avdd.n3641 avdd.n3640 6.3005
R3278 avdd.n3665 avdd.n3664 6.3005
R3279 avdd.n3664 avdd.t98 6.3005
R3280 avdd.n3645 avdd.n3644 6.3005
R3281 avdd.n3646 avdd.n3645 6.3005
R3282 avdd.n3654 avdd.n3653 6.3005
R3283 avdd.n3674 avdd.n3673 6.3005
R3284 avdd.n3638 avdd.n3637 6.3005
R3285 avdd.n3640 avdd.n3638 6.3005
R3286 avdd.n3663 avdd.n3662 6.3005
R3287 avdd.t98 avdd.n3663 6.3005
R3288 avdd.n3648 avdd.n3647 6.3005
R3289 avdd.n3647 avdd.n3646 6.3005
R3290 avdd.n3658 avdd.n3657 6.3005
R3291 avdd.n3657 avdd.n3656 6.3005
R3292 avdd.n1723 avdd.n1722 6.3005
R3293 avdd.n1724 avdd.n1723 6.3005
R3294 avdd.n1545 avdd.n1544 6.3005
R3295 avdd.n1544 avdd.n1543 6.3005
R3296 avdd.n1674 avdd.n1673 6.3005
R3297 avdd.n1673 avdd.n1672 6.3005
R3298 avdd.n1548 avdd.n1547 6.3005
R3299 avdd.n1549 avdd.n1548 6.3005
R3300 avdd.n1663 avdd.n1662 6.3005
R3301 avdd.n1664 avdd.n1663 6.3005
R3302 avdd.n1557 avdd.n1556 6.3005
R3303 avdd.n1556 avdd.n1555 6.3005
R3304 avdd.n1658 avdd.n1657 6.3005
R3305 avdd.n1657 avdd.n1656 6.3005
R3306 avdd.n1560 avdd.n1559 6.3005
R3307 avdd.n1561 avdd.n1560 6.3005
R3308 avdd.n1647 avdd.n1646 6.3005
R3309 avdd.n1648 avdd.n1647 6.3005
R3310 avdd.n1569 avdd.n1568 6.3005
R3311 avdd.n1568 avdd.n1567 6.3005
R3312 avdd.n1642 avdd.n1641 6.3005
R3313 avdd.n1641 avdd.n1640 6.3005
R3314 avdd.n1572 avdd.n1571 6.3005
R3315 avdd.n1573 avdd.n1572 6.3005
R3316 avdd.n1631 avdd.n1630 6.3005
R3317 avdd.n1632 avdd.n1631 6.3005
R3318 avdd.n1581 avdd.n1580 6.3005
R3319 avdd.n1580 avdd.n1579 6.3005
R3320 avdd.n1626 avdd.n1625 6.3005
R3321 avdd.n1625 avdd.n1624 6.3005
R3322 avdd.n1584 avdd.n1583 6.3005
R3323 avdd.n1585 avdd.n1584 6.3005
R3324 avdd.n1615 avdd.n1614 6.3005
R3325 avdd.n1616 avdd.n1615 6.3005
R3326 avdd.n1593 avdd.n1592 6.3005
R3327 avdd.n1592 avdd.n1591 6.3005
R3328 avdd.n1610 avdd.n1609 6.3005
R3329 avdd.n1609 avdd.n1608 6.3005
R3330 avdd.n1596 avdd.n1595 6.3005
R3331 avdd.n1727 avdd.n1726 6.3005
R3332 avdd.n1541 avdd.n1540 6.3005
R3333 avdd.n1543 avdd.n1541 6.3005
R3334 avdd.n1671 avdd.n1670 6.3005
R3335 avdd.n1672 avdd.n1671 6.3005
R3336 avdd.n1551 avdd.n1550 6.3005
R3337 avdd.n1550 avdd.n1549 6.3005
R3338 avdd.n1666 avdd.n1665 6.3005
R3339 avdd.n1665 avdd.n1664 6.3005
R3340 avdd.n1554 avdd.n1553 6.3005
R3341 avdd.n1555 avdd.n1554 6.3005
R3342 avdd.n1655 avdd.n1654 6.3005
R3343 avdd.n1656 avdd.n1655 6.3005
R3344 avdd.n1563 avdd.n1562 6.3005
R3345 avdd.n1562 avdd.n1561 6.3005
R3346 avdd.n1650 avdd.n1649 6.3005
R3347 avdd.n1649 avdd.n1648 6.3005
R3348 avdd.n1566 avdd.n1565 6.3005
R3349 avdd.n1567 avdd.n1566 6.3005
R3350 avdd.n1639 avdd.n1638 6.3005
R3351 avdd.n1640 avdd.n1639 6.3005
R3352 avdd.n1575 avdd.n1574 6.3005
R3353 avdd.n1574 avdd.n1573 6.3005
R3354 avdd.n1634 avdd.n1633 6.3005
R3355 avdd.n1633 avdd.n1632 6.3005
R3356 avdd.n1578 avdd.n1577 6.3005
R3357 avdd.n1579 avdd.n1578 6.3005
R3358 avdd.n1623 avdd.n1622 6.3005
R3359 avdd.n1624 avdd.n1623 6.3005
R3360 avdd.n1587 avdd.n1586 6.3005
R3361 avdd.n1586 avdd.n1585 6.3005
R3362 avdd.n1618 avdd.n1617 6.3005
R3363 avdd.n1617 avdd.n1616 6.3005
R3364 avdd.n1590 avdd.n1589 6.3005
R3365 avdd.n1591 avdd.n1590 6.3005
R3366 avdd.n1607 avdd.n1606 6.3005
R3367 avdd.n1608 avdd.n1607 6.3005
R3368 avdd.n1599 avdd.n1598 6.3005
R3369 avdd.n1598 avdd.n1597 6.3005
R3370 avdd.n1713 avdd.n1712 6.3005
R3371 avdd.n1714 avdd.n1713 6.3005
R3372 avdd.n1683 avdd.n1682 6.3005
R3373 avdd.n1717 avdd.n1716 6.3005
R3374 avdd.n1680 avdd.n1679 6.3005
R3375 avdd.n1705 avdd.n1680 6.3005
R3376 avdd.n1690 avdd.n1686 6.3005
R3377 avdd.n1702 avdd.n1686 6.3005
R3378 avdd.n1700 avdd.n1699 6.3005
R3379 avdd.n1701 avdd.n1700 6.3005
R3380 avdd.n1692 avdd.n1687 6.3005
R3381 avdd.n1693 avdd.n1691 6.3005
R3382 avdd.n1756 avdd.n1755 6.3005
R3383 avdd.n1757 avdd.n1756 6.3005
R3384 avdd.n1746 avdd.n1742 6.3005
R3385 avdd.n1758 avdd.n1742 6.3005
R3386 avdd.n1751 avdd.n1750 6.3005
R3387 avdd.n1749 avdd.n1743 6.3005
R3388 avdd.n1765 avdd.n1764 6.3005
R3389 avdd.n1766 avdd.n1765 6.3005
R3390 avdd.n1738 avdd.n1737 6.3005
R3391 avdd.n1769 avdd.n1768 6.3005
R3392 avdd.n1770 avdd.n1732 6.3005
R3393 avdd.n1735 avdd.n1732 6.3005
R3394 avdd.n1823 avdd.n1822 6.3005
R3395 avdd.n1824 avdd.n1823 6.3005
R3396 avdd.n1781 avdd.n1780 6.3005
R3397 avdd.n1780 avdd.n1779 6.3005
R3398 avdd.n1818 avdd.n1817 6.3005
R3399 avdd.n1817 avdd.n1816 6.3005
R3400 avdd.n1784 avdd.n1783 6.3005
R3401 avdd.t106 avdd.n1784 6.3005
R3402 avdd.n1807 avdd.n1806 6.3005
R3403 avdd.n1808 avdd.n1807 6.3005
R3404 avdd.n1792 avdd.n1791 6.3005
R3405 avdd.n1791 avdd.n1790 6.3005
R3406 avdd.n1802 avdd.n1801 6.3005
R3407 avdd.n1827 avdd.n1826 6.3005
R3408 avdd.n1777 avdd.n1776 6.3005
R3409 avdd.n1779 avdd.n1777 6.3005
R3410 avdd.n1815 avdd.n1814 6.3005
R3411 avdd.n1816 avdd.n1815 6.3005
R3412 avdd.n1786 avdd.n1785 6.3005
R3413 avdd.n1785 avdd.t106 6.3005
R3414 avdd.n1810 avdd.n1809 6.3005
R3415 avdd.n1809 avdd.n1808 6.3005
R3416 avdd.n1789 avdd.n1788 6.3005
R3417 avdd.n1790 avdd.n1789 6.3005
R3418 avdd.n1798 avdd.n1797 6.3005
R3419 avdd.n1799 avdd.n1798 6.3005
R3420 avdd.n1866 avdd.n1865 6.3005
R3421 avdd.n1867 avdd.n1866 6.3005
R3422 avdd.n1838 avdd.n1837 6.3005
R3423 avdd.n1837 avdd.n1836 6.3005
R3424 avdd.n1861 avdd.n1860 6.3005
R3425 avdd.n1860 avdd.t108 6.3005
R3426 avdd.n1841 avdd.n1840 6.3005
R3427 avdd.n1842 avdd.n1841 6.3005
R3428 avdd.n1850 avdd.n1849 6.3005
R3429 avdd.n1870 avdd.n1869 6.3005
R3430 avdd.n1834 avdd.n1833 6.3005
R3431 avdd.n1836 avdd.n1834 6.3005
R3432 avdd.n1859 avdd.n1858 6.3005
R3433 avdd.t108 avdd.n1859 6.3005
R3434 avdd.n1844 avdd.n1843 6.3005
R3435 avdd.n1843 avdd.n1842 6.3005
R3436 avdd.n1854 avdd.n1853 6.3005
R3437 avdd.n1853 avdd.n1852 6.3005
R3438 avdd.n1348 avdd.n1347 6.3005
R3439 avdd.n1349 avdd.n1348 6.3005
R3440 avdd.n1170 avdd.n1169 6.3005
R3441 avdd.n1169 avdd.n1168 6.3005
R3442 avdd.n1299 avdd.n1298 6.3005
R3443 avdd.n1298 avdd.n1297 6.3005
R3444 avdd.n1173 avdd.n1172 6.3005
R3445 avdd.n1174 avdd.n1173 6.3005
R3446 avdd.n1288 avdd.n1287 6.3005
R3447 avdd.n1289 avdd.n1288 6.3005
R3448 avdd.n1182 avdd.n1181 6.3005
R3449 avdd.n1181 avdd.n1180 6.3005
R3450 avdd.n1283 avdd.n1282 6.3005
R3451 avdd.n1282 avdd.n1281 6.3005
R3452 avdd.n1185 avdd.n1184 6.3005
R3453 avdd.n1186 avdd.n1185 6.3005
R3454 avdd.n1272 avdd.n1271 6.3005
R3455 avdd.n1273 avdd.n1272 6.3005
R3456 avdd.n1194 avdd.n1193 6.3005
R3457 avdd.n1193 avdd.n1192 6.3005
R3458 avdd.n1267 avdd.n1266 6.3005
R3459 avdd.n1266 avdd.n1265 6.3005
R3460 avdd.n1197 avdd.n1196 6.3005
R3461 avdd.n1198 avdd.n1197 6.3005
R3462 avdd.n1256 avdd.n1255 6.3005
R3463 avdd.n1257 avdd.n1256 6.3005
R3464 avdd.n1206 avdd.n1205 6.3005
R3465 avdd.n1205 avdd.n1204 6.3005
R3466 avdd.n1251 avdd.n1250 6.3005
R3467 avdd.n1250 avdd.n1249 6.3005
R3468 avdd.n1209 avdd.n1208 6.3005
R3469 avdd.n1210 avdd.n1209 6.3005
R3470 avdd.n1240 avdd.n1239 6.3005
R3471 avdd.n1241 avdd.n1240 6.3005
R3472 avdd.n1218 avdd.n1217 6.3005
R3473 avdd.n1217 avdd.n1216 6.3005
R3474 avdd.n1235 avdd.n1234 6.3005
R3475 avdd.n1234 avdd.n1233 6.3005
R3476 avdd.n1221 avdd.n1220 6.3005
R3477 avdd.n1352 avdd.n1351 6.3005
R3478 avdd.n1166 avdd.n1165 6.3005
R3479 avdd.n1168 avdd.n1166 6.3005
R3480 avdd.n1296 avdd.n1295 6.3005
R3481 avdd.n1297 avdd.n1296 6.3005
R3482 avdd.n1176 avdd.n1175 6.3005
R3483 avdd.n1175 avdd.n1174 6.3005
R3484 avdd.n1291 avdd.n1290 6.3005
R3485 avdd.n1290 avdd.n1289 6.3005
R3486 avdd.n1179 avdd.n1178 6.3005
R3487 avdd.n1180 avdd.n1179 6.3005
R3488 avdd.n1280 avdd.n1279 6.3005
R3489 avdd.n1281 avdd.n1280 6.3005
R3490 avdd.n1188 avdd.n1187 6.3005
R3491 avdd.n1187 avdd.n1186 6.3005
R3492 avdd.n1275 avdd.n1274 6.3005
R3493 avdd.n1274 avdd.n1273 6.3005
R3494 avdd.n1191 avdd.n1190 6.3005
R3495 avdd.n1192 avdd.n1191 6.3005
R3496 avdd.n1264 avdd.n1263 6.3005
R3497 avdd.n1265 avdd.n1264 6.3005
R3498 avdd.n1200 avdd.n1199 6.3005
R3499 avdd.n1199 avdd.n1198 6.3005
R3500 avdd.n1259 avdd.n1258 6.3005
R3501 avdd.n1258 avdd.n1257 6.3005
R3502 avdd.n1203 avdd.n1202 6.3005
R3503 avdd.n1204 avdd.n1203 6.3005
R3504 avdd.n1248 avdd.n1247 6.3005
R3505 avdd.n1249 avdd.n1248 6.3005
R3506 avdd.n1212 avdd.n1211 6.3005
R3507 avdd.n1211 avdd.n1210 6.3005
R3508 avdd.n1243 avdd.n1242 6.3005
R3509 avdd.n1242 avdd.n1241 6.3005
R3510 avdd.n1215 avdd.n1214 6.3005
R3511 avdd.n1216 avdd.n1215 6.3005
R3512 avdd.n1232 avdd.n1231 6.3005
R3513 avdd.n1233 avdd.n1232 6.3005
R3514 avdd.n1224 avdd.n1223 6.3005
R3515 avdd.n1223 avdd.n1222 6.3005
R3516 avdd.n1338 avdd.n1337 6.3005
R3517 avdd.n1339 avdd.n1338 6.3005
R3518 avdd.n1308 avdd.n1307 6.3005
R3519 avdd.n1342 avdd.n1341 6.3005
R3520 avdd.n1305 avdd.n1304 6.3005
R3521 avdd.n1330 avdd.n1305 6.3005
R3522 avdd.n1315 avdd.n1311 6.3005
R3523 avdd.n1327 avdd.n1311 6.3005
R3524 avdd.n1325 avdd.n1324 6.3005
R3525 avdd.n1326 avdd.n1325 6.3005
R3526 avdd.n1317 avdd.n1312 6.3005
R3527 avdd.n1318 avdd.n1316 6.3005
R3528 avdd.n1381 avdd.n1380 6.3005
R3529 avdd.n1382 avdd.n1381 6.3005
R3530 avdd.n1371 avdd.n1367 6.3005
R3531 avdd.n1383 avdd.n1367 6.3005
R3532 avdd.n1376 avdd.n1375 6.3005
R3533 avdd.n1374 avdd.n1368 6.3005
R3534 avdd.n1390 avdd.n1389 6.3005
R3535 avdd.n1391 avdd.n1390 6.3005
R3536 avdd.n1363 avdd.n1362 6.3005
R3537 avdd.n1394 avdd.n1393 6.3005
R3538 avdd.n1395 avdd.n1357 6.3005
R3539 avdd.n1360 avdd.n1357 6.3005
R3540 avdd.n1448 avdd.n1447 6.3005
R3541 avdd.n1449 avdd.n1448 6.3005
R3542 avdd.n1406 avdd.n1405 6.3005
R3543 avdd.n1405 avdd.n1404 6.3005
R3544 avdd.n1443 avdd.n1442 6.3005
R3545 avdd.n1442 avdd.n1441 6.3005
R3546 avdd.n1409 avdd.n1408 6.3005
R3547 avdd.t94 avdd.n1409 6.3005
R3548 avdd.n1432 avdd.n1431 6.3005
R3549 avdd.n1433 avdd.n1432 6.3005
R3550 avdd.n1417 avdd.n1416 6.3005
R3551 avdd.n1416 avdd.n1415 6.3005
R3552 avdd.n1427 avdd.n1426 6.3005
R3553 avdd.n1452 avdd.n1451 6.3005
R3554 avdd.n1402 avdd.n1401 6.3005
R3555 avdd.n1404 avdd.n1402 6.3005
R3556 avdd.n1440 avdd.n1439 6.3005
R3557 avdd.n1441 avdd.n1440 6.3005
R3558 avdd.n1411 avdd.n1410 6.3005
R3559 avdd.n1410 avdd.t94 6.3005
R3560 avdd.n1435 avdd.n1434 6.3005
R3561 avdd.n1434 avdd.n1433 6.3005
R3562 avdd.n1414 avdd.n1413 6.3005
R3563 avdd.n1415 avdd.n1414 6.3005
R3564 avdd.n1423 avdd.n1422 6.3005
R3565 avdd.n1424 avdd.n1423 6.3005
R3566 avdd.n1491 avdd.n1490 6.3005
R3567 avdd.n1492 avdd.n1491 6.3005
R3568 avdd.n1463 avdd.n1462 6.3005
R3569 avdd.n1462 avdd.n1461 6.3005
R3570 avdd.n1486 avdd.n1485 6.3005
R3571 avdd.n1485 avdd.t100 6.3005
R3572 avdd.n1466 avdd.n1465 6.3005
R3573 avdd.n1467 avdd.n1466 6.3005
R3574 avdd.n1475 avdd.n1474 6.3005
R3575 avdd.n1495 avdd.n1494 6.3005
R3576 avdd.n1459 avdd.n1458 6.3005
R3577 avdd.n1461 avdd.n1459 6.3005
R3578 avdd.n1484 avdd.n1483 6.3005
R3579 avdd.t100 avdd.n1484 6.3005
R3580 avdd.n1469 avdd.n1468 6.3005
R3581 avdd.n1468 avdd.n1467 6.3005
R3582 avdd.n1479 avdd.n1478 6.3005
R3583 avdd.n1478 avdd.n1477 6.3005
R3584 avdd.n147 avdd.n146 6.3005
R3585 avdd.n148 avdd.n147 6.3005
R3586 avdd.n138 avdd.n137 6.3005
R3587 avdd.n151 avdd.n150 6.3005
R3588 avdd.n135 avdd.n134 6.3005
R3589 avdd.n140 avdd.n135 6.3005
R3590 avdd.n169 avdd.n168 6.3005
R3591 avdd.n170 avdd.n169 6.3005
R3592 avdd.n160 avdd.n159 6.3005
R3593 avdd.n173 avdd.n172 6.3005
R3594 avdd.n157 avdd.n156 6.3005
R3595 avdd.n162 avdd.n157 6.3005
R3596 avdd.n3873 avdd.n3872 6.3005
R3597 avdd.n3868 avdd.n3866 6.3005
R3598 avdd.n3876 avdd.n3866 6.3005
R3599 avdd.n3875 avdd.n3864 6.3005
R3600 avdd.n3891 avdd.n3890 6.3005
R3601 avdd.n3886 avdd.n3884 6.3005
R3602 avdd.n3894 avdd.n3884 6.3005
R3603 avdd.n3893 avdd.n3882 6.3005
R3604 avdd.n3910 avdd.n3909 6.3005
R3605 avdd.n3905 avdd.n3903 6.3005
R3606 avdd.n3913 avdd.n3903 6.3005
R3607 avdd.n3912 avdd.n3901 6.3005
R3608 avdd.n3767 avdd.n3766 6.3005
R3609 avdd.n3762 avdd.n3760 6.3005
R3610 avdd.n3770 avdd.n3760 6.3005
R3611 avdd.n3769 avdd.n3758 6.3005
R3612 avdd.n3785 avdd.n3784 6.3005
R3613 avdd.n3780 avdd.n3778 6.3005
R3614 avdd.n3788 avdd.n3778 6.3005
R3615 avdd.n3787 avdd.n3776 6.3005
R3616 avdd.n3804 avdd.n3803 6.3005
R3617 avdd.n3799 avdd.n3797 6.3005
R3618 avdd.n3807 avdd.n3797 6.3005
R3619 avdd.n3806 avdd.n3795 6.3005
R3620 avdd.n4064 avdd.n4063 6.3005
R3621 avdd.n4059 avdd.n4057 6.3005
R3622 avdd.n4067 avdd.n4057 6.3005
R3623 avdd.n4066 avdd.n4055 6.3005
R3624 avdd.n4082 avdd.n4081 6.3005
R3625 avdd.n4077 avdd.n4075 6.3005
R3626 avdd.n4085 avdd.n4075 6.3005
R3627 avdd.n4084 avdd.n4073 6.3005
R3628 avdd.n4101 avdd.n4100 6.3005
R3629 avdd.n4096 avdd.n4094 6.3005
R3630 avdd.n4104 avdd.n4094 6.3005
R3631 avdd.n4103 avdd.n4092 6.3005
R3632 avdd.n76 avdd.n75 6.3005
R3633 avdd.n71 avdd.n69 6.3005
R3634 avdd.n79 avdd.n69 6.3005
R3635 avdd.n78 avdd.n67 6.3005
R3636 avdd.n94 avdd.n93 6.3005
R3637 avdd.n89 avdd.n87 6.3005
R3638 avdd.n97 avdd.n87 6.3005
R3639 avdd.n96 avdd.n85 6.3005
R3640 avdd.n113 avdd.n112 6.3005
R3641 avdd.n108 avdd.n106 6.3005
R3642 avdd.n116 avdd.n106 6.3005
R3643 avdd.n115 avdd.n104 6.3005
R3644 avdd.n4131 avdd.n4130 6.3005
R3645 avdd.n4126 avdd.n4124 6.3005
R3646 avdd.n4134 avdd.n4124 6.3005
R3647 avdd.n4133 avdd.n4122 6.3005
R3648 avdd.n4149 avdd.n4148 6.3005
R3649 avdd.n4144 avdd.n4142 6.3005
R3650 avdd.n4152 avdd.n4142 6.3005
R3651 avdd.n4151 avdd.n4140 6.3005
R3652 avdd.n4168 avdd.n4167 6.3005
R3653 avdd.n4163 avdd.n4161 6.3005
R3654 avdd.n4171 avdd.n4161 6.3005
R3655 avdd.n4170 avdd.n4159 6.3005
R3656 avdd.n19 avdd.n18 6.3005
R3657 avdd.n14 avdd.n12 6.3005
R3658 avdd.n22 avdd.n12 6.3005
R3659 avdd.n21 avdd.n10 6.3005
R3660 avdd.n37 avdd.n36 6.3005
R3661 avdd.n32 avdd.n30 6.3005
R3662 avdd.n40 avdd.n30 6.3005
R3663 avdd.n39 avdd.n28 6.3005
R3664 avdd.n56 avdd.n55 6.3005
R3665 avdd.n51 avdd.n49 6.3005
R3666 avdd.n59 avdd.n49 6.3005
R3667 avdd.n58 avdd.n47 6.3005
R3668 avdd.n4284 avdd.n4283 6.3005
R3669 avdd.n4276 avdd.n4275 6.3005
R3670 avdd.n4277 avdd.n4273 6.3005
R3671 avdd.n4287 avdd.n4286 6.3005
R3672 avdd.n4314 avdd.n4313 6.3005
R3673 avdd.n4298 avdd.n4296 6.3005
R3674 avdd.n4317 avdd.n4296 6.3005
R3675 avdd.n4309 avdd.n4308 6.3005
R3676 avdd.n4308 avdd.n4307 6.3005
R3677 avdd.n4301 avdd.n4300 6.3005
R3678 avdd.n4306 avdd.n4301 6.3005
R3679 avdd.n4316 avdd.n4293 6.3005
R3680 avdd.n4319 avdd.n4318 6.3005
R3681 avdd.n4318 avdd.n4317 6.3005
R3682 avdd.n4295 avdd.n4294 6.3005
R3683 avdd.n4307 avdd.n4295 6.3005
R3684 avdd.n4347 avdd.n4346 6.3005
R3685 avdd.n4331 avdd.n4329 6.3005
R3686 avdd.n4350 avdd.n4329 6.3005
R3687 avdd.n4342 avdd.n4341 6.3005
R3688 avdd.n4341 avdd.n4340 6.3005
R3689 avdd.n4334 avdd.n4333 6.3005
R3690 avdd.n4339 avdd.n4334 6.3005
R3691 avdd.n4349 avdd.n4326 6.3005
R3692 avdd.n4352 avdd.n4351 6.3005
R3693 avdd.n4351 avdd.n4350 6.3005
R3694 avdd.n4328 avdd.n4327 6.3005
R3695 avdd.n4340 avdd.n4328 6.3005
R3696 avdd.n4198 avdd.n4197 6.3005
R3697 avdd.n4193 avdd.n4191 6.3005
R3698 avdd.n4201 avdd.n4191 6.3005
R3699 avdd.n4200 avdd.n4189 6.3005
R3700 avdd.n4229 avdd.n4228 6.3005
R3701 avdd.n4213 avdd.n4211 6.3005
R3702 avdd.n4232 avdd.n4211 6.3005
R3703 avdd.n4224 avdd.n4223 6.3005
R3704 avdd.n4223 avdd.n4222 6.3005
R3705 avdd.n4216 avdd.n4215 6.3005
R3706 avdd.n4221 avdd.n4216 6.3005
R3707 avdd.n4231 avdd.n4208 6.3005
R3708 avdd.n4234 avdd.n4233 6.3005
R3709 avdd.n4233 avdd.n4232 6.3005
R3710 avdd.n4210 avdd.n4209 6.3005
R3711 avdd.n4222 avdd.n4210 6.3005
R3712 avdd.n4262 avdd.n4261 6.3005
R3713 avdd.n4246 avdd.n4244 6.3005
R3714 avdd.n4265 avdd.n4244 6.3005
R3715 avdd.n4257 avdd.n4256 6.3005
R3716 avdd.n4256 avdd.n4255 6.3005
R3717 avdd.n4249 avdd.n4248 6.3005
R3718 avdd.n4254 avdd.n4249 6.3005
R3719 avdd.n4264 avdd.n4241 6.3005
R3720 avdd.n4267 avdd.n4266 6.3005
R3721 avdd.n4266 avdd.n4265 6.3005
R3722 avdd.n4243 avdd.n4242 6.3005
R3723 avdd.n4255 avdd.n4243 6.3005
R3724 avdd.n4367 avdd.n4366 6.3005
R3725 avdd.n4362 avdd.n4360 6.3005
R3726 avdd.n4370 avdd.n4360 6.3005
R3727 avdd.n4369 avdd.n4358 6.3005
R3728 avdd.n2521 avdd.n2520 6.12735
R3729 avdd.n2537 avdd.n2504 6.12735
R3730 avdd.n625 avdd.n624 6.12735
R3731 avdd.n641 avdd.n608 6.12735
R3732 avdd.n1000 avdd.n999 6.12735
R3733 avdd.n1016 avdd.n983 6.12735
R3734 avdd.n2901 avdd.n2900 6.12735
R3735 avdd.n2917 avdd.n2884 6.12735
R3736 avdd.n3276 avdd.n3275 6.12735
R3737 avdd.n3292 avdd.n3259 6.12735
R3738 avdd.n3652 avdd.n3651 6.12735
R3739 avdd.n3668 avdd.n3635 6.12735
R3740 avdd.n1848 avdd.n1847 6.12735
R3741 avdd.n1864 avdd.n1831 6.12735
R3742 avdd.n1473 avdd.n1472 6.12735
R3743 avdd.n1489 avdd.n1456 6.12735
R3744 avdd.n199 avdd.n129 6.0005
R3745 avdd.n166 avdd.n165 5.92113
R3746 avdd.n167 avdd.n154 5.92113
R3747 avdd.n1065 avdd.n1064 5.5628
R3748 avdd.n4281 avdd.n4280 5.34137
R3749 avdd.n4282 avdd.n4271 5.34137
R3750 avdd.n4195 avdd.n4194 5.34137
R3751 avdd.n4196 avdd.n4187 5.34137
R3752 avdd.n4010 avdd.n4008 5.33383
R3753 avdd.n144 avdd.n143 5.29504
R3754 avdd.n145 avdd.n132 5.29504
R3755 avdd.n4045 avdd.n4044 5.2295
R3756 avdd.n4302 avdd.n4299 5.20888
R3757 avdd.n4312 avdd.n4290 5.20888
R3758 avdd.n4335 avdd.n4332 5.20888
R3759 avdd.n4345 avdd.n4323 5.20888
R3760 avdd.n4217 avdd.n4214 5.20888
R3761 avdd.n4227 avdd.n4205 5.20888
R3762 avdd.n4250 avdd.n4247 5.20888
R3763 avdd.n4260 avdd.n4238 5.20888
R3764 avdd.n2368 avdd.n2367 5.20011
R3765 avdd.n2371 avdd.n2368 5.20011
R3766 avdd.n2384 avdd.n2350 5.20011
R3767 avdd.n2426 avdd.n2425 5.20011
R3768 avdd.n2427 avdd.n2426 5.20011
R3769 avdd.n2412 avdd.n2403 5.20011
R3770 avdd.n472 avdd.n471 5.20011
R3771 avdd.n475 avdd.n472 5.20011
R3772 avdd.n488 avdd.n454 5.20011
R3773 avdd.n530 avdd.n529 5.20011
R3774 avdd.n531 avdd.n530 5.20011
R3775 avdd.n516 avdd.n507 5.20011
R3776 avdd.n847 avdd.n846 5.20011
R3777 avdd.n850 avdd.n847 5.20011
R3778 avdd.n863 avdd.n829 5.20011
R3779 avdd.n905 avdd.n904 5.20011
R3780 avdd.n906 avdd.n905 5.20011
R3781 avdd.n891 avdd.n882 5.20011
R3782 avdd.n2748 avdd.n2747 5.20011
R3783 avdd.n2751 avdd.n2748 5.20011
R3784 avdd.n2764 avdd.n2730 5.20011
R3785 avdd.n2806 avdd.n2805 5.20011
R3786 avdd.n2807 avdd.n2806 5.20011
R3787 avdd.n2792 avdd.n2783 5.20011
R3788 avdd.n3123 avdd.n3122 5.20011
R3789 avdd.n3126 avdd.n3123 5.20011
R3790 avdd.n3139 avdd.n3105 5.20011
R3791 avdd.n3181 avdd.n3180 5.20011
R3792 avdd.n3182 avdd.n3181 5.20011
R3793 avdd.n3167 avdd.n3158 5.20011
R3794 avdd.n3499 avdd.n3498 5.20011
R3795 avdd.n3502 avdd.n3499 5.20011
R3796 avdd.n3515 avdd.n3481 5.20011
R3797 avdd.n3557 avdd.n3556 5.20011
R3798 avdd.n3558 avdd.n3557 5.20011
R3799 avdd.n3543 avdd.n3534 5.20011
R3800 avdd.n1695 avdd.n1694 5.20011
R3801 avdd.n1698 avdd.n1695 5.20011
R3802 avdd.n1711 avdd.n1677 5.20011
R3803 avdd.n1753 avdd.n1752 5.20011
R3804 avdd.n1754 avdd.n1753 5.20011
R3805 avdd.n1739 avdd.n1730 5.20011
R3806 avdd.n1320 avdd.n1319 5.20011
R3807 avdd.n1323 avdd.n1320 5.20011
R3808 avdd.n1336 avdd.n1302 5.20011
R3809 avdd.n1378 avdd.n1377 5.20011
R3810 avdd.n1379 avdd.n1378 5.20011
R3811 avdd.n1364 avdd.n1355 5.20011
R3812 avdd.n2275 avdd.n2267 5.19741
R3813 avdd.n2476 avdd.n2466 5.19741
R3814 avdd.n2494 avdd.n2447 5.19741
R3815 avdd.n379 avdd.n371 5.19741
R3816 avdd.n580 avdd.n570 5.19741
R3817 avdd.n598 avdd.n551 5.19741
R3818 avdd.n754 avdd.n746 5.19741
R3819 avdd.n955 avdd.n945 5.19741
R3820 avdd.n973 avdd.n926 5.19741
R3821 avdd.n2655 avdd.n2647 5.19741
R3822 avdd.n2856 avdd.n2846 5.19741
R3823 avdd.n2874 avdd.n2827 5.19741
R3824 avdd.n3030 avdd.n3022 5.19741
R3825 avdd.n3231 avdd.n3221 5.19741
R3826 avdd.n3249 avdd.n3202 5.19741
R3827 avdd.n3406 avdd.n3398 5.19741
R3828 avdd.n3607 avdd.n3597 5.19741
R3829 avdd.n3625 avdd.n3578 5.19741
R3830 avdd.n1602 avdd.n1594 5.19741
R3831 avdd.n1803 avdd.n1793 5.19741
R3832 avdd.n1821 avdd.n1774 5.19741
R3833 avdd.n1227 avdd.n1219 5.19741
R3834 avdd.n1428 avdd.n1418 5.19741
R3835 avdd.n1446 avdd.n1399 5.19741
R3836 avdd.n3869 avdd.n3863 5.19561
R3837 avdd.n3871 avdd.n3870 5.19561
R3838 avdd.n3887 avdd.n3881 5.19561
R3839 avdd.n3889 avdd.n3888 5.19561
R3840 avdd.n3906 avdd.n3900 5.19561
R3841 avdd.n3908 avdd.n3907 5.19561
R3842 avdd.n3763 avdd.n3757 5.19561
R3843 avdd.n3765 avdd.n3764 5.19561
R3844 avdd.n3781 avdd.n3775 5.19561
R3845 avdd.n3783 avdd.n3782 5.19561
R3846 avdd.n3800 avdd.n3794 5.19561
R3847 avdd.n3802 avdd.n3801 5.19561
R3848 avdd.n4060 avdd.n4054 5.19561
R3849 avdd.n4062 avdd.n4061 5.19561
R3850 avdd.n4078 avdd.n4072 5.19561
R3851 avdd.n4080 avdd.n4079 5.19561
R3852 avdd.n4097 avdd.n4091 5.19561
R3853 avdd.n4099 avdd.n4098 5.19561
R3854 avdd.n72 avdd.n66 5.19561
R3855 avdd.n74 avdd.n73 5.19561
R3856 avdd.n90 avdd.n84 5.19561
R3857 avdd.n92 avdd.n91 5.19561
R3858 avdd.n109 avdd.n103 5.19561
R3859 avdd.n111 avdd.n110 5.19561
R3860 avdd.n4127 avdd.n4121 5.19561
R3861 avdd.n4129 avdd.n4128 5.19561
R3862 avdd.n4145 avdd.n4139 5.19561
R3863 avdd.n4147 avdd.n4146 5.19561
R3864 avdd.n4164 avdd.n4158 5.19561
R3865 avdd.n4166 avdd.n4165 5.19561
R3866 avdd.n15 avdd.n9 5.19561
R3867 avdd.n17 avdd.n16 5.19561
R3868 avdd.n33 avdd.n27 5.19561
R3869 avdd.n35 avdd.n34 5.19561
R3870 avdd.n52 avdd.n46 5.19561
R3871 avdd.n54 avdd.n53 5.19561
R3872 avdd.n4364 avdd.n4363 5.19561
R3873 avdd.n4365 avdd.n4356 5.19561
R3874 avdd.n1940 avdd.n1939 5.16141
R3875 avdd.n1939 avdd.n1931 5.16141
R3876 avdd.n1994 avdd.n1993 5.16141
R3877 avdd.n1993 avdd.n1985 5.16141
R3878 avdd.n2019 avdd.n1965 5.16141
R3879 avdd.n2074 avdd.n2073 5.16141
R3880 avdd.n2073 avdd.n2065 5.16141
R3881 avdd.n2128 avdd.n2127 5.16141
R3882 avdd.n2127 avdd.n2119 5.16141
R3883 avdd.n2153 avdd.n2099 5.16141
R3884 avdd.n4289 avdd.n4271 5.12897
R3885 avdd.n4204 avdd.n4187 5.12897
R3886 avdd.n176 avdd.n175 5.0718
R3887 avdd.n2277 avdd.n2276 5.0673
R3888 avdd.n2469 avdd.n2468 5.0673
R3889 avdd.n381 avdd.n380 5.0673
R3890 avdd.n573 avdd.n572 5.0673
R3891 avdd.n756 avdd.n755 5.0673
R3892 avdd.n948 avdd.n947 5.0673
R3893 avdd.n2657 avdd.n2656 5.0673
R3894 avdd.n2849 avdd.n2848 5.0673
R3895 avdd.n3032 avdd.n3031 5.0673
R3896 avdd.n3224 avdd.n3223 5.0673
R3897 avdd.n3408 avdd.n3407 5.0673
R3898 avdd.n3600 avdd.n3599 5.0673
R3899 avdd.n1604 avdd.n1603 5.0673
R3900 avdd.n1796 avdd.n1795 5.0673
R3901 avdd.n1229 avdd.n1228 5.0673
R3902 avdd.n1421 avdd.n1420 5.0673
R3903 avdd.n139 avdd.n133 5.05733
R3904 avdd.n161 avdd.n155 5.05733
R3905 avdd.n4203 avdd.n4202 5.05692
R3906 avdd.n2528 avdd.n2518 5.04833
R3907 avdd.n632 avdd.n622 5.04833
R3908 avdd.n1007 avdd.n997 5.04833
R3909 avdd.n2908 avdd.n2898 5.04833
R3910 avdd.n3283 avdd.n3273 5.04833
R3911 avdd.n3659 avdd.n3649 5.04833
R3912 avdd.n1855 avdd.n1845 5.04833
R3913 avdd.n1480 avdd.n1470 5.04833
R3914 avdd.n4321 avdd.n4290 5.02528
R3915 avdd.n4354 avdd.n4323 5.02528
R3916 avdd.n4236 avdd.n4205 5.02528
R3917 avdd.n4269 avdd.n4238 5.02528
R3918 avdd.n3879 avdd.n3863 4.98321
R3919 avdd.n3897 avdd.n3881 4.98321
R3920 avdd.n3916 avdd.n3900 4.98321
R3921 avdd.n3773 avdd.n3757 4.98321
R3922 avdd.n3791 avdd.n3775 4.98321
R3923 avdd.n3810 avdd.n3794 4.98321
R3924 avdd.n4070 avdd.n4054 4.98321
R3925 avdd.n4088 avdd.n4072 4.98321
R3926 avdd.n4107 avdd.n4091 4.98321
R3927 avdd.n82 avdd.n66 4.98321
R3928 avdd.n100 avdd.n84 4.98321
R3929 avdd.n119 avdd.n103 4.98321
R3930 avdd.n4137 avdd.n4121 4.98321
R3931 avdd.n4155 avdd.n4139 4.98321
R3932 avdd.n4174 avdd.n4158 4.98321
R3933 avdd.n25 avdd.n9 4.98321
R3934 avdd.n43 avdd.n27 4.98321
R3935 avdd.n62 avdd.n46 4.98321
R3936 avdd.n4373 avdd.n4356 4.98321
R3937 avdd.n2379 avdd.n2378 4.94098
R3938 avdd.n2388 avdd.n2387 4.94098
R3939 avdd.n2374 avdd.n2361 4.94098
R3940 avdd.n2376 avdd.n2375 4.94098
R3941 avdd.n2432 avdd.n2431 4.94098
R3942 avdd.n2430 avdd.n2417 4.94098
R3943 avdd.n2409 avdd.n2408 4.94098
R3944 avdd.n2440 avdd.n2439 4.94098
R3945 avdd.n483 avdd.n482 4.94098
R3946 avdd.n492 avdd.n491 4.94098
R3947 avdd.n478 avdd.n465 4.94098
R3948 avdd.n480 avdd.n479 4.94098
R3949 avdd.n536 avdd.n535 4.94098
R3950 avdd.n534 avdd.n521 4.94098
R3951 avdd.n513 avdd.n512 4.94098
R3952 avdd.n544 avdd.n543 4.94098
R3953 avdd.n858 avdd.n857 4.94098
R3954 avdd.n867 avdd.n866 4.94098
R3955 avdd.n853 avdd.n840 4.94098
R3956 avdd.n855 avdd.n854 4.94098
R3957 avdd.n911 avdd.n910 4.94098
R3958 avdd.n909 avdd.n896 4.94098
R3959 avdd.n888 avdd.n887 4.94098
R3960 avdd.n919 avdd.n918 4.94098
R3961 avdd.n2759 avdd.n2758 4.94098
R3962 avdd.n2768 avdd.n2767 4.94098
R3963 avdd.n2754 avdd.n2741 4.94098
R3964 avdd.n2756 avdd.n2755 4.94098
R3965 avdd.n2812 avdd.n2811 4.94098
R3966 avdd.n2810 avdd.n2797 4.94098
R3967 avdd.n2789 avdd.n2788 4.94098
R3968 avdd.n2820 avdd.n2819 4.94098
R3969 avdd.n3134 avdd.n3133 4.94098
R3970 avdd.n3143 avdd.n3142 4.94098
R3971 avdd.n3129 avdd.n3116 4.94098
R3972 avdd.n3131 avdd.n3130 4.94098
R3973 avdd.n3187 avdd.n3186 4.94098
R3974 avdd.n3185 avdd.n3172 4.94098
R3975 avdd.n3164 avdd.n3163 4.94098
R3976 avdd.n3195 avdd.n3194 4.94098
R3977 avdd.n3510 avdd.n3509 4.94098
R3978 avdd.n3519 avdd.n3518 4.94098
R3979 avdd.n3505 avdd.n3492 4.94098
R3980 avdd.n3507 avdd.n3506 4.94098
R3981 avdd.n3563 avdd.n3562 4.94098
R3982 avdd.n3561 avdd.n3548 4.94098
R3983 avdd.n3540 avdd.n3539 4.94098
R3984 avdd.n3571 avdd.n3570 4.94098
R3985 avdd.n1706 avdd.n1705 4.94098
R3986 avdd.n1715 avdd.n1714 4.94098
R3987 avdd.n1701 avdd.n1688 4.94098
R3988 avdd.n1703 avdd.n1702 4.94098
R3989 avdd.n1759 avdd.n1758 4.94098
R3990 avdd.n1757 avdd.n1744 4.94098
R3991 avdd.n1736 avdd.n1735 4.94098
R3992 avdd.n1767 avdd.n1766 4.94098
R3993 avdd.n1331 avdd.n1330 4.94098
R3994 avdd.n1340 avdd.n1339 4.94098
R3995 avdd.n1326 avdd.n1313 4.94098
R3996 avdd.n1328 avdd.n1327 4.94098
R3997 avdd.n1384 avdd.n1383 4.94098
R3998 avdd.n1382 avdd.n1369 4.94098
R3999 avdd.n1361 avdd.n1360 4.94098
R4000 avdd.n1392 avdd.n1391 4.94098
R4001 avdd.n2273 avdd.n2270 4.9335
R4002 avdd.n2398 avdd.n2397 4.9335
R4003 avdd.n2473 avdd.n2472 4.9335
R4004 avdd.n2498 avdd.n2497 4.9335
R4005 avdd.n377 avdd.n374 4.9335
R4006 avdd.n502 avdd.n501 4.9335
R4007 avdd.n577 avdd.n576 4.9335
R4008 avdd.n602 avdd.n601 4.9335
R4009 avdd.n752 avdd.n749 4.9335
R4010 avdd.n877 avdd.n876 4.9335
R4011 avdd.n952 avdd.n951 4.9335
R4012 avdd.n977 avdd.n976 4.9335
R4013 avdd.n2653 avdd.n2650 4.9335
R4014 avdd.n2778 avdd.n2777 4.9335
R4015 avdd.n2853 avdd.n2852 4.9335
R4016 avdd.n2878 avdd.n2877 4.9335
R4017 avdd.n3028 avdd.n3025 4.9335
R4018 avdd.n3153 avdd.n3152 4.9335
R4019 avdd.n3228 avdd.n3227 4.9335
R4020 avdd.n3253 avdd.n3252 4.9335
R4021 avdd.n3404 avdd.n3401 4.9335
R4022 avdd.n3529 avdd.n3528 4.9335
R4023 avdd.n3604 avdd.n3603 4.9335
R4024 avdd.n3629 avdd.n3628 4.9335
R4025 avdd.n1600 avdd.n1597 4.9335
R4026 avdd.n1725 avdd.n1724 4.9335
R4027 avdd.n1800 avdd.n1799 4.9335
R4028 avdd.n1825 avdd.n1824 4.9335
R4029 avdd.n1225 avdd.n1222 4.9335
R4030 avdd.n1350 avdd.n1349 4.9335
R4031 avdd.n1425 avdd.n1424 4.9335
R4032 avdd.n1450 avdd.n1449 4.9335
R4033 avdd.n3875 avdd.n3874 4.92843
R4034 avdd.n3877 avdd.n3876 4.92843
R4035 avdd.n3893 avdd.n3892 4.92843
R4036 avdd.n3895 avdd.n3894 4.92843
R4037 avdd.n3912 avdd.n3911 4.92843
R4038 avdd.n3914 avdd.n3913 4.92843
R4039 avdd.n3769 avdd.n3768 4.92843
R4040 avdd.n3771 avdd.n3770 4.92843
R4041 avdd.n3787 avdd.n3786 4.92843
R4042 avdd.n3789 avdd.n3788 4.92843
R4043 avdd.n3806 avdd.n3805 4.92843
R4044 avdd.n3808 avdd.n3807 4.92843
R4045 avdd.n4066 avdd.n4065 4.92843
R4046 avdd.n4068 avdd.n4067 4.92843
R4047 avdd.n4084 avdd.n4083 4.92843
R4048 avdd.n4086 avdd.n4085 4.92843
R4049 avdd.n4103 avdd.n4102 4.92843
R4050 avdd.n4105 avdd.n4104 4.92843
R4051 avdd.n78 avdd.n77 4.92843
R4052 avdd.n80 avdd.n79 4.92843
R4053 avdd.n96 avdd.n95 4.92843
R4054 avdd.n98 avdd.n97 4.92843
R4055 avdd.n115 avdd.n114 4.92843
R4056 avdd.n117 avdd.n116 4.92843
R4057 avdd.n4133 avdd.n4132 4.92843
R4058 avdd.n4135 avdd.n4134 4.92843
R4059 avdd.n4151 avdd.n4150 4.92843
R4060 avdd.n4153 avdd.n4152 4.92843
R4061 avdd.n4170 avdd.n4169 4.92843
R4062 avdd.n4172 avdd.n4171 4.92843
R4063 avdd.n21 avdd.n20 4.92843
R4064 avdd.n23 avdd.n22 4.92843
R4065 avdd.n39 avdd.n38 4.92843
R4066 avdd.n41 avdd.n40 4.92843
R4067 avdd.n58 avdd.n57 4.92843
R4068 avdd.n60 avdd.n59 4.92843
R4069 avdd.n4369 avdd.n4368 4.92843
R4070 avdd.n4371 avdd.n4370 4.92843
R4071 avdd.n3879 avdd.n3862 4.8531
R4072 avdd.n3897 avdd.n3880 4.8531
R4073 avdd.n3916 avdd.n3899 4.8531
R4074 avdd.n3773 avdd.n3756 4.8531
R4075 avdd.n3791 avdd.n3774 4.8531
R4076 avdd.n3810 avdd.n3793 4.8531
R4077 avdd.n4070 avdd.n4053 4.8531
R4078 avdd.n4088 avdd.n4071 4.8531
R4079 avdd.n4107 avdd.n4090 4.8531
R4080 avdd.n82 avdd.n65 4.8531
R4081 avdd.n100 avdd.n83 4.8531
R4082 avdd.n119 avdd.n102 4.8531
R4083 avdd.n4137 avdd.n4120 4.8531
R4084 avdd.n4155 avdd.n4138 4.8531
R4085 avdd.n4174 avdd.n4157 4.8531
R4086 avdd.n25 avdd.n8 4.8531
R4087 avdd.n43 avdd.n26 4.8531
R4088 avdd.n62 avdd.n45 4.8531
R4089 avdd.n4373 avdd.n4357 4.8531
R4090 avdd.n4289 avdd.n4272 4.85213
R4091 avdd.n4321 avdd.n4291 4.85213
R4092 avdd.n4354 avdd.n4324 4.85213
R4093 avdd.n4204 avdd.n4188 4.85213
R4094 avdd.n4236 avdd.n4206 4.85213
R4095 avdd.n4269 avdd.n4239 4.85213
R4096 avdd.n1937 avdd.n1934 4.81843
R4097 avdd.n2033 avdd.n2032 4.81843
R4098 avdd.n1991 avdd.n1988 4.81843
R4099 avdd.n2023 avdd.n2022 4.81843
R4100 avdd.n2071 avdd.n2068 4.81843
R4101 avdd.n2167 avdd.n2166 4.81843
R4102 avdd.n2125 avdd.n2122 4.81843
R4103 avdd.n2157 avdd.n2156 4.81843
R4104 avdd.n2382 avdd.n2357 4.75136
R4105 avdd.n2370 avdd.n2369 4.75136
R4106 avdd.n2435 avdd.n2413 4.75136
R4107 avdd.n2420 avdd.n2404 4.75136
R4108 avdd.n486 avdd.n461 4.75136
R4109 avdd.n474 avdd.n473 4.75136
R4110 avdd.n539 avdd.n517 4.75136
R4111 avdd.n524 avdd.n508 4.75136
R4112 avdd.n861 avdd.n836 4.75136
R4113 avdd.n849 avdd.n848 4.75136
R4114 avdd.n914 avdd.n892 4.75136
R4115 avdd.n899 avdd.n883 4.75136
R4116 avdd.n2762 avdd.n2737 4.75136
R4117 avdd.n2750 avdd.n2749 4.75136
R4118 avdd.n2815 avdd.n2793 4.75136
R4119 avdd.n2800 avdd.n2784 4.75136
R4120 avdd.n3137 avdd.n3112 4.75136
R4121 avdd.n3125 avdd.n3124 4.75136
R4122 avdd.n3190 avdd.n3168 4.75136
R4123 avdd.n3175 avdd.n3159 4.75136
R4124 avdd.n3513 avdd.n3488 4.75136
R4125 avdd.n3501 avdd.n3500 4.75136
R4126 avdd.n3566 avdd.n3544 4.75136
R4127 avdd.n3551 avdd.n3535 4.75136
R4128 avdd.n1709 avdd.n1684 4.75136
R4129 avdd.n1697 avdd.n1696 4.75136
R4130 avdd.n1762 avdd.n1740 4.75136
R4131 avdd.n1747 avdd.n1731 4.75136
R4132 avdd.n1334 avdd.n1309 4.75136
R4133 avdd.n1322 avdd.n1321 4.75136
R4134 avdd.n1387 avdd.n1365 4.75136
R4135 avdd.n1372 avdd.n1356 4.75136
R4136 avdd.n2369 avdd.n2351 4.75135
R4137 avdd.n2383 avdd.n2382 4.75135
R4138 avdd.n2421 avdd.n2420 4.75135
R4139 avdd.n2436 avdd.n2435 4.75135
R4140 avdd.n473 avdd.n455 4.75135
R4141 avdd.n487 avdd.n486 4.75135
R4142 avdd.n525 avdd.n524 4.75135
R4143 avdd.n540 avdd.n539 4.75135
R4144 avdd.n848 avdd.n830 4.75135
R4145 avdd.n862 avdd.n861 4.75135
R4146 avdd.n900 avdd.n899 4.75135
R4147 avdd.n915 avdd.n914 4.75135
R4148 avdd.n2749 avdd.n2731 4.75135
R4149 avdd.n2763 avdd.n2762 4.75135
R4150 avdd.n2801 avdd.n2800 4.75135
R4151 avdd.n2816 avdd.n2815 4.75135
R4152 avdd.n3124 avdd.n3106 4.75135
R4153 avdd.n3138 avdd.n3137 4.75135
R4154 avdd.n3176 avdd.n3175 4.75135
R4155 avdd.n3191 avdd.n3190 4.75135
R4156 avdd.n3500 avdd.n3482 4.75135
R4157 avdd.n3514 avdd.n3513 4.75135
R4158 avdd.n3552 avdd.n3551 4.75135
R4159 avdd.n3567 avdd.n3566 4.75135
R4160 avdd.n1696 avdd.n1678 4.75135
R4161 avdd.n1710 avdd.n1709 4.75135
R4162 avdd.n1748 avdd.n1747 4.75135
R4163 avdd.n1763 avdd.n1762 4.75135
R4164 avdd.n1321 avdd.n1303 4.75135
R4165 avdd.n1335 avdd.n1334 4.75135
R4166 avdd.n1373 avdd.n1372 4.75135
R4167 avdd.n1388 avdd.n1387 4.75135
R4168 avdd.n2392 avdd.n2391 4.7462
R4169 avdd.n2445 avdd.n2444 4.7462
R4170 avdd.n496 avdd.n495 4.7462
R4171 avdd.n549 avdd.n548 4.7462
R4172 avdd.n871 avdd.n870 4.7462
R4173 avdd.n924 avdd.n923 4.7462
R4174 avdd.n2772 avdd.n2771 4.7462
R4175 avdd.n2825 avdd.n2824 4.7462
R4176 avdd.n3147 avdd.n3146 4.7462
R4177 avdd.n3200 avdd.n3199 4.7462
R4178 avdd.n3523 avdd.n3522 4.7462
R4179 avdd.n3576 avdd.n3575 4.7462
R4180 avdd.n1719 avdd.n1718 4.7462
R4181 avdd.n1772 avdd.n1771 4.7462
R4182 avdd.n1344 avdd.n1343 4.7462
R4183 avdd.n1397 avdd.n1396 4.7462
R4184 avdd.n2402 avdd.n2401 4.7435
R4185 avdd.n2394 avdd.n2393 4.7435
R4186 avdd.n2502 avdd.n2501 4.7435
R4187 avdd.n506 avdd.n505 4.7435
R4188 avdd.n498 avdd.n497 4.7435
R4189 avdd.n606 avdd.n605 4.7435
R4190 avdd.n881 avdd.n880 4.7435
R4191 avdd.n873 avdd.n872 4.7435
R4192 avdd.n981 avdd.n980 4.7435
R4193 avdd.n2782 avdd.n2781 4.7435
R4194 avdd.n2774 avdd.n2773 4.7435
R4195 avdd.n2882 avdd.n2881 4.7435
R4196 avdd.n3157 avdd.n3156 4.7435
R4197 avdd.n3149 avdd.n3148 4.7435
R4198 avdd.n3257 avdd.n3256 4.7435
R4199 avdd.n3533 avdd.n3532 4.7435
R4200 avdd.n3525 avdd.n3524 4.7435
R4201 avdd.n3633 avdd.n3632 4.7435
R4202 avdd.n1729 avdd.n1728 4.7435
R4203 avdd.n1721 avdd.n1720 4.7435
R4204 avdd.n1829 avdd.n1828 4.7435
R4205 avdd.n1354 avdd.n1353 4.7435
R4206 avdd.n1346 avdd.n1345 4.7435
R4207 avdd.n1454 avdd.n1453 4.7435
R4208 avdd.n153 avdd.n152 4.7345
R4209 avdd.n175 avdd.n174 4.7345
R4210 avdd.n2545 avdd.n2544 4.7255
R4211 avdd.n649 avdd.n648 4.7255
R4212 avdd.n1024 avdd.n1023 4.7255
R4213 avdd.n2925 avdd.n2924 4.7255
R4214 avdd.n3300 avdd.n3299 4.7255
R4215 avdd.n3676 avdd.n3675 4.7255
R4216 avdd.n1872 avdd.n1871 4.7255
R4217 avdd.n1497 avdd.n1496 4.7255
R4218 avdd.n4044 avdd.n4043 4.7255
R4219 avdd.n4047 avdd.n4046 4.7255
R4220 avdd.n4185 avdd.n2 4.7255
R4221 avdd.n1055 avdd.n1054 4.7255
R4222 avdd.n2037 avdd.n2036 4.7075
R4223 avdd.n2029 avdd.n2028 4.7075
R4224 avdd.n2027 avdd.n2026 4.7075
R4225 avdd.n2171 avdd.n2170 4.7075
R4226 avdd.n2163 avdd.n2162 4.7075
R4227 avdd.n2161 avdd.n2160 4.7075
R4228 avdd.n4316 avdd.n4315 4.68616
R4229 avdd.n4306 avdd.n4305 4.68616
R4230 avdd.n4349 avdd.n4348 4.68616
R4231 avdd.n4339 avdd.n4338 4.68616
R4232 avdd.n4231 avdd.n4230 4.68616
R4233 avdd.n4221 avdd.n4220 4.68616
R4234 avdd.n4264 avdd.n4263 4.68616
R4235 avdd.n4254 avdd.n4253 4.68616
R4236 avdd.n3878 avdd.n3877 4.58217
R4237 avdd.n3896 avdd.n3895 4.58217
R4238 avdd.n3915 avdd.n3914 4.58217
R4239 avdd.n3772 avdd.n3771 4.58217
R4240 avdd.n3790 avdd.n3789 4.58217
R4241 avdd.n3809 avdd.n3808 4.58217
R4242 avdd.n4069 avdd.n4068 4.58217
R4243 avdd.n4087 avdd.n4086 4.58217
R4244 avdd.n4106 avdd.n4105 4.58217
R4245 avdd.n81 avdd.n80 4.58217
R4246 avdd.n99 avdd.n98 4.58217
R4247 avdd.n118 avdd.n117 4.58217
R4248 avdd.n4136 avdd.n4135 4.58217
R4249 avdd.n4154 avdd.n4153 4.58217
R4250 avdd.n4173 avdd.n4172 4.58217
R4251 avdd.n24 avdd.n23 4.58217
R4252 avdd.n42 avdd.n41 4.58217
R4253 avdd.n61 avdd.n60 4.58217
R4254 avdd.n4372 avdd.n4371 4.58217
R4255 avdd.n141 avdd.n140 4.54139
R4256 avdd.n149 avdd.n148 4.54139
R4257 avdd.n1942 avdd.n1941 4.5005
R4258 avdd.n1926 avdd.n1925 4.5005
R4259 avdd.n1955 avdd.n1954 4.5005
R4260 avdd.n1956 avdd.n1924 4.5005
R4261 avdd.n1958 avdd.n1957 4.5005
R4262 avdd.n1913 avdd.n1912 4.5005
R4263 avdd.n2036 avdd.n2035 4.5005
R4264 avdd.n1940 avdd.n1936 4.5005
R4265 avdd.n1947 avdd.n1946 4.5005
R4266 avdd.n1948 avdd.n1930 4.5005
R4267 avdd.n1950 avdd.n1949 4.5005
R4268 avdd.n1920 avdd.n1919 4.5005
R4269 avdd.n1963 avdd.n1962 4.5005
R4270 avdd.n1964 avdd.n1918 4.5005
R4271 avdd.n2030 avdd.n2029 4.5005
R4272 avdd.n1932 avdd.n1931 4.5005
R4273 avdd.n1996 avdd.n1995 4.5005
R4274 avdd.n1980 avdd.n1979 4.5005
R4275 avdd.n2009 avdd.n2008 4.5005
R4276 avdd.n2010 avdd.n1978 4.5005
R4277 avdd.n2012 avdd.n2011 4.5005
R4278 avdd.n1967 avdd.n1966 4.5005
R4279 avdd.n2026 avdd.n2025 4.5005
R4280 avdd.n1994 avdd.n1990 4.5005
R4281 avdd.n2001 avdd.n2000 4.5005
R4282 avdd.n2002 avdd.n1984 4.5005
R4283 avdd.n2004 avdd.n2003 4.5005
R4284 avdd.n1974 avdd.n1973 4.5005
R4285 avdd.n2017 avdd.n2016 4.5005
R4286 avdd.n2018 avdd.n1972 4.5005
R4287 avdd.n2020 avdd.n2019 4.5005
R4288 avdd.n1986 avdd.n1985 4.5005
R4289 avdd.n2076 avdd.n2075 4.5005
R4290 avdd.n2060 avdd.n2059 4.5005
R4291 avdd.n2089 avdd.n2088 4.5005
R4292 avdd.n2090 avdd.n2058 4.5005
R4293 avdd.n2092 avdd.n2091 4.5005
R4294 avdd.n2047 avdd.n2046 4.5005
R4295 avdd.n2170 avdd.n2169 4.5005
R4296 avdd.n2074 avdd.n2070 4.5005
R4297 avdd.n2081 avdd.n2080 4.5005
R4298 avdd.n2082 avdd.n2064 4.5005
R4299 avdd.n2084 avdd.n2083 4.5005
R4300 avdd.n2054 avdd.n2053 4.5005
R4301 avdd.n2097 avdd.n2096 4.5005
R4302 avdd.n2098 avdd.n2052 4.5005
R4303 avdd.n2164 avdd.n2163 4.5005
R4304 avdd.n2066 avdd.n2065 4.5005
R4305 avdd.n2130 avdd.n2129 4.5005
R4306 avdd.n2114 avdd.n2113 4.5005
R4307 avdd.n2143 avdd.n2142 4.5005
R4308 avdd.n2144 avdd.n2112 4.5005
R4309 avdd.n2146 avdd.n2145 4.5005
R4310 avdd.n2101 avdd.n2100 4.5005
R4311 avdd.n2160 avdd.n2159 4.5005
R4312 avdd.n2128 avdd.n2124 4.5005
R4313 avdd.n2135 avdd.n2134 4.5005
R4314 avdd.n2136 avdd.n2118 4.5005
R4315 avdd.n2138 avdd.n2137 4.5005
R4316 avdd.n2108 avdd.n2107 4.5005
R4317 avdd.n2151 avdd.n2150 4.5005
R4318 avdd.n2152 avdd.n2106 4.5005
R4319 avdd.n2154 avdd.n2153 4.5005
R4320 avdd.n2120 avdd.n2119 4.5005
R4321 avdd.n2203 avdd.n2189 4.5005
R4322 avdd.n2203 avdd.n2202 4.5005
R4323 avdd.n2202 avdd.n2192 4.5005
R4324 avdd.n2195 avdd.n2189 4.5005
R4325 avdd.t154 avdd.n2195 4.5005
R4326 avdd.n2202 avdd.n2195 4.5005
R4327 avdd.n2191 avdd.n2189 4.5005
R4328 avdd.t154 avdd.n2191 4.5005
R4329 avdd.n2202 avdd.n2191 4.5005
R4330 avdd.n2201 avdd.t154 4.5005
R4331 avdd.n2202 avdd.n2201 4.5005
R4332 avdd.n2210 avdd.n2180 4.5005
R4333 avdd.n2210 avdd.n2209 4.5005
R4334 avdd.n2209 avdd.n2183 4.5005
R4335 avdd.n2186 avdd.n2180 4.5005
R4336 avdd.t155 avdd.n2186 4.5005
R4337 avdd.n2209 avdd.n2186 4.5005
R4338 avdd.n2182 avdd.n2180 4.5005
R4339 avdd.t155 avdd.n2182 4.5005
R4340 avdd.n2209 avdd.n2182 4.5005
R4341 avdd.n2208 avdd.t155 4.5005
R4342 avdd.n2209 avdd.n2208 4.5005
R4343 avdd.n2279 avdd.n2278 4.5005
R4344 avdd.n2262 avdd.n2261 4.5005
R4345 avdd.n2292 avdd.n2291 4.5005
R4346 avdd.n2293 avdd.n2260 4.5005
R4347 avdd.n2295 avdd.n2294 4.5005
R4348 avdd.n2250 avdd.n2249 4.5005
R4349 avdd.n2308 avdd.n2307 4.5005
R4350 avdd.n2309 avdd.n2248 4.5005
R4351 avdd.n2311 avdd.n2310 4.5005
R4352 avdd.n2238 avdd.n2237 4.5005
R4353 avdd.n2324 avdd.n2323 4.5005
R4354 avdd.n2325 avdd.n2236 4.5005
R4355 avdd.n2327 avdd.n2326 4.5005
R4356 avdd.n2226 avdd.n2225 4.5005
R4357 avdd.n2340 avdd.n2339 4.5005
R4358 avdd.n2341 avdd.n2224 4.5005
R4359 avdd.n2343 avdd.n2342 4.5005
R4360 avdd.n2213 avdd.n2212 4.5005
R4361 avdd.n2401 avdd.n2400 4.5005
R4362 avdd.n2277 avdd.n2272 4.5005
R4363 avdd.n2284 avdd.n2283 4.5005
R4364 avdd.n2285 avdd.n2266 4.5005
R4365 avdd.n2287 avdd.n2286 4.5005
R4366 avdd.n2256 avdd.n2255 4.5005
R4367 avdd.n2300 avdd.n2299 4.5005
R4368 avdd.n2301 avdd.n2254 4.5005
R4369 avdd.n2303 avdd.n2302 4.5005
R4370 avdd.n2244 avdd.n2243 4.5005
R4371 avdd.n2316 avdd.n2315 4.5005
R4372 avdd.n2317 avdd.n2242 4.5005
R4373 avdd.n2319 avdd.n2318 4.5005
R4374 avdd.n2232 avdd.n2231 4.5005
R4375 avdd.n2332 avdd.n2331 4.5005
R4376 avdd.n2333 avdd.n2230 4.5005
R4377 avdd.n2335 avdd.n2334 4.5005
R4378 avdd.n2220 avdd.n2219 4.5005
R4379 avdd.n2348 avdd.n2347 4.5005
R4380 avdd.n2349 avdd.n2218 4.5005
R4381 avdd.n2395 avdd.n2394 4.5005
R4382 avdd.n2268 avdd.n2267 4.5005
R4383 avdd.n2391 avdd.n2390 4.5005
R4384 avdd.n2352 avdd.n2351 4.5005
R4385 avdd.n2365 avdd.n2357 4.5005
R4386 avdd.n2367 avdd.n2366 4.5005
R4387 avdd.n2370 avdd.n2363 4.5005
R4388 avdd.n2372 avdd.n2371 4.5005
R4389 avdd.n2385 avdd.n2384 4.5005
R4390 avdd.n2383 avdd.n2356 4.5005
R4391 avdd.n2425 avdd.n2424 4.5005
R4392 avdd.n2422 avdd.n2413 4.5005
R4393 avdd.n2428 avdd.n2427 4.5005
R4394 avdd.n2421 avdd.n2419 4.5005
R4395 avdd.n2442 avdd.n2404 4.5005
R4396 avdd.n2444 avdd.n2443 4.5005
R4397 avdd.n2437 avdd.n2436 4.5005
R4398 avdd.n2412 avdd.n2411 4.5005
R4399 avdd.n2461 avdd.n2460 4.5005
R4400 avdd.n2484 avdd.n2483 4.5005
R4401 avdd.n2485 avdd.n2459 4.5005
R4402 avdd.n2487 avdd.n2486 4.5005
R4403 avdd.n2449 avdd.n2448 4.5005
R4404 avdd.n2501 avdd.n2500 4.5005
R4405 avdd.n2470 avdd.n2469 4.5005
R4406 avdd.n2477 avdd.n2465 4.5005
R4407 avdd.n2479 avdd.n2478 4.5005
R4408 avdd.n2456 avdd.n2455 4.5005
R4409 avdd.n2492 avdd.n2491 4.5005
R4410 avdd.n2493 avdd.n2454 4.5005
R4411 avdd.n2495 avdd.n2494 4.5005
R4412 avdd.n2476 avdd.n2475 4.5005
R4413 avdd.n2529 avdd.n2517 4.5005
R4414 avdd.n2531 avdd.n2530 4.5005
R4415 avdd.n2506 avdd.n2505 4.5005
R4416 avdd.n2544 avdd.n2543 4.5005
R4417 avdd.n2528 avdd.n2527 4.5005
R4418 avdd.n2513 avdd.n2512 4.5005
R4419 avdd.n2535 avdd.n2534 4.5005
R4420 avdd.n2536 avdd.n2511 4.5005
R4421 avdd.n2538 avdd.n2537 4.5005
R4422 avdd.n2522 avdd.n2521 4.5005
R4423 avdd.n307 avdd.n293 4.5005
R4424 avdd.n307 avdd.n306 4.5005
R4425 avdd.n306 avdd.n296 4.5005
R4426 avdd.n299 avdd.n293 4.5005
R4427 avdd.t156 avdd.n299 4.5005
R4428 avdd.n306 avdd.n299 4.5005
R4429 avdd.n295 avdd.n293 4.5005
R4430 avdd.t156 avdd.n295 4.5005
R4431 avdd.n306 avdd.n295 4.5005
R4432 avdd.n305 avdd.t156 4.5005
R4433 avdd.n306 avdd.n305 4.5005
R4434 avdd.n314 avdd.n284 4.5005
R4435 avdd.n314 avdd.n313 4.5005
R4436 avdd.n313 avdd.n287 4.5005
R4437 avdd.n290 avdd.n284 4.5005
R4438 avdd.t157 avdd.n290 4.5005
R4439 avdd.n313 avdd.n290 4.5005
R4440 avdd.n286 avdd.n284 4.5005
R4441 avdd.t157 avdd.n286 4.5005
R4442 avdd.n313 avdd.n286 4.5005
R4443 avdd.n312 avdd.t157 4.5005
R4444 avdd.n313 avdd.n312 4.5005
R4445 avdd.n383 avdd.n382 4.5005
R4446 avdd.n366 avdd.n365 4.5005
R4447 avdd.n396 avdd.n395 4.5005
R4448 avdd.n397 avdd.n364 4.5005
R4449 avdd.n399 avdd.n398 4.5005
R4450 avdd.n354 avdd.n353 4.5005
R4451 avdd.n412 avdd.n411 4.5005
R4452 avdd.n413 avdd.n352 4.5005
R4453 avdd.n415 avdd.n414 4.5005
R4454 avdd.n342 avdd.n341 4.5005
R4455 avdd.n428 avdd.n427 4.5005
R4456 avdd.n429 avdd.n340 4.5005
R4457 avdd.n431 avdd.n430 4.5005
R4458 avdd.n330 avdd.n329 4.5005
R4459 avdd.n444 avdd.n443 4.5005
R4460 avdd.n445 avdd.n328 4.5005
R4461 avdd.n447 avdd.n446 4.5005
R4462 avdd.n317 avdd.n316 4.5005
R4463 avdd.n505 avdd.n504 4.5005
R4464 avdd.n381 avdd.n376 4.5005
R4465 avdd.n388 avdd.n387 4.5005
R4466 avdd.n389 avdd.n370 4.5005
R4467 avdd.n391 avdd.n390 4.5005
R4468 avdd.n360 avdd.n359 4.5005
R4469 avdd.n404 avdd.n403 4.5005
R4470 avdd.n405 avdd.n358 4.5005
R4471 avdd.n407 avdd.n406 4.5005
R4472 avdd.n348 avdd.n347 4.5005
R4473 avdd.n420 avdd.n419 4.5005
R4474 avdd.n421 avdd.n346 4.5005
R4475 avdd.n423 avdd.n422 4.5005
R4476 avdd.n336 avdd.n335 4.5005
R4477 avdd.n436 avdd.n435 4.5005
R4478 avdd.n437 avdd.n334 4.5005
R4479 avdd.n439 avdd.n438 4.5005
R4480 avdd.n324 avdd.n323 4.5005
R4481 avdd.n452 avdd.n451 4.5005
R4482 avdd.n453 avdd.n322 4.5005
R4483 avdd.n499 avdd.n498 4.5005
R4484 avdd.n372 avdd.n371 4.5005
R4485 avdd.n495 avdd.n494 4.5005
R4486 avdd.n456 avdd.n455 4.5005
R4487 avdd.n469 avdd.n461 4.5005
R4488 avdd.n471 avdd.n470 4.5005
R4489 avdd.n474 avdd.n467 4.5005
R4490 avdd.n476 avdd.n475 4.5005
R4491 avdd.n489 avdd.n488 4.5005
R4492 avdd.n487 avdd.n460 4.5005
R4493 avdd.n529 avdd.n528 4.5005
R4494 avdd.n526 avdd.n517 4.5005
R4495 avdd.n532 avdd.n531 4.5005
R4496 avdd.n525 avdd.n523 4.5005
R4497 avdd.n546 avdd.n508 4.5005
R4498 avdd.n548 avdd.n547 4.5005
R4499 avdd.n541 avdd.n540 4.5005
R4500 avdd.n516 avdd.n515 4.5005
R4501 avdd.n565 avdd.n564 4.5005
R4502 avdd.n588 avdd.n587 4.5005
R4503 avdd.n589 avdd.n563 4.5005
R4504 avdd.n591 avdd.n590 4.5005
R4505 avdd.n553 avdd.n552 4.5005
R4506 avdd.n605 avdd.n604 4.5005
R4507 avdd.n574 avdd.n573 4.5005
R4508 avdd.n581 avdd.n569 4.5005
R4509 avdd.n583 avdd.n582 4.5005
R4510 avdd.n560 avdd.n559 4.5005
R4511 avdd.n596 avdd.n595 4.5005
R4512 avdd.n597 avdd.n558 4.5005
R4513 avdd.n599 avdd.n598 4.5005
R4514 avdd.n580 avdd.n579 4.5005
R4515 avdd.n633 avdd.n621 4.5005
R4516 avdd.n635 avdd.n634 4.5005
R4517 avdd.n610 avdd.n609 4.5005
R4518 avdd.n648 avdd.n647 4.5005
R4519 avdd.n632 avdd.n631 4.5005
R4520 avdd.n617 avdd.n616 4.5005
R4521 avdd.n639 avdd.n638 4.5005
R4522 avdd.n640 avdd.n615 4.5005
R4523 avdd.n642 avdd.n641 4.5005
R4524 avdd.n626 avdd.n625 4.5005
R4525 avdd.n682 avdd.n668 4.5005
R4526 avdd.n682 avdd.n681 4.5005
R4527 avdd.n681 avdd.n671 4.5005
R4528 avdd.n674 avdd.n668 4.5005
R4529 avdd.t162 avdd.n674 4.5005
R4530 avdd.n681 avdd.n674 4.5005
R4531 avdd.n670 avdd.n668 4.5005
R4532 avdd.t162 avdd.n670 4.5005
R4533 avdd.n681 avdd.n670 4.5005
R4534 avdd.n680 avdd.t162 4.5005
R4535 avdd.n681 avdd.n680 4.5005
R4536 avdd.n689 avdd.n659 4.5005
R4537 avdd.n689 avdd.n688 4.5005
R4538 avdd.n688 avdd.n662 4.5005
R4539 avdd.n665 avdd.n659 4.5005
R4540 avdd.t163 avdd.n665 4.5005
R4541 avdd.n688 avdd.n665 4.5005
R4542 avdd.n661 avdd.n659 4.5005
R4543 avdd.t163 avdd.n661 4.5005
R4544 avdd.n688 avdd.n661 4.5005
R4545 avdd.n687 avdd.t163 4.5005
R4546 avdd.n688 avdd.n687 4.5005
R4547 avdd.n758 avdd.n757 4.5005
R4548 avdd.n741 avdd.n740 4.5005
R4549 avdd.n771 avdd.n770 4.5005
R4550 avdd.n772 avdd.n739 4.5005
R4551 avdd.n774 avdd.n773 4.5005
R4552 avdd.n729 avdd.n728 4.5005
R4553 avdd.n787 avdd.n786 4.5005
R4554 avdd.n788 avdd.n727 4.5005
R4555 avdd.n790 avdd.n789 4.5005
R4556 avdd.n717 avdd.n716 4.5005
R4557 avdd.n803 avdd.n802 4.5005
R4558 avdd.n804 avdd.n715 4.5005
R4559 avdd.n806 avdd.n805 4.5005
R4560 avdd.n705 avdd.n704 4.5005
R4561 avdd.n819 avdd.n818 4.5005
R4562 avdd.n820 avdd.n703 4.5005
R4563 avdd.n822 avdd.n821 4.5005
R4564 avdd.n692 avdd.n691 4.5005
R4565 avdd.n880 avdd.n879 4.5005
R4566 avdd.n756 avdd.n751 4.5005
R4567 avdd.n763 avdd.n762 4.5005
R4568 avdd.n764 avdd.n745 4.5005
R4569 avdd.n766 avdd.n765 4.5005
R4570 avdd.n735 avdd.n734 4.5005
R4571 avdd.n779 avdd.n778 4.5005
R4572 avdd.n780 avdd.n733 4.5005
R4573 avdd.n782 avdd.n781 4.5005
R4574 avdd.n723 avdd.n722 4.5005
R4575 avdd.n795 avdd.n794 4.5005
R4576 avdd.n796 avdd.n721 4.5005
R4577 avdd.n798 avdd.n797 4.5005
R4578 avdd.n711 avdd.n710 4.5005
R4579 avdd.n811 avdd.n810 4.5005
R4580 avdd.n812 avdd.n709 4.5005
R4581 avdd.n814 avdd.n813 4.5005
R4582 avdd.n699 avdd.n698 4.5005
R4583 avdd.n827 avdd.n826 4.5005
R4584 avdd.n828 avdd.n697 4.5005
R4585 avdd.n874 avdd.n873 4.5005
R4586 avdd.n747 avdd.n746 4.5005
R4587 avdd.n870 avdd.n869 4.5005
R4588 avdd.n831 avdd.n830 4.5005
R4589 avdd.n844 avdd.n836 4.5005
R4590 avdd.n846 avdd.n845 4.5005
R4591 avdd.n849 avdd.n842 4.5005
R4592 avdd.n851 avdd.n850 4.5005
R4593 avdd.n864 avdd.n863 4.5005
R4594 avdd.n862 avdd.n835 4.5005
R4595 avdd.n904 avdd.n903 4.5005
R4596 avdd.n901 avdd.n892 4.5005
R4597 avdd.n907 avdd.n906 4.5005
R4598 avdd.n900 avdd.n898 4.5005
R4599 avdd.n921 avdd.n883 4.5005
R4600 avdd.n923 avdd.n922 4.5005
R4601 avdd.n916 avdd.n915 4.5005
R4602 avdd.n891 avdd.n890 4.5005
R4603 avdd.n940 avdd.n939 4.5005
R4604 avdd.n963 avdd.n962 4.5005
R4605 avdd.n964 avdd.n938 4.5005
R4606 avdd.n966 avdd.n965 4.5005
R4607 avdd.n928 avdd.n927 4.5005
R4608 avdd.n980 avdd.n979 4.5005
R4609 avdd.n949 avdd.n948 4.5005
R4610 avdd.n956 avdd.n944 4.5005
R4611 avdd.n958 avdd.n957 4.5005
R4612 avdd.n935 avdd.n934 4.5005
R4613 avdd.n971 avdd.n970 4.5005
R4614 avdd.n972 avdd.n933 4.5005
R4615 avdd.n974 avdd.n973 4.5005
R4616 avdd.n955 avdd.n954 4.5005
R4617 avdd.n1008 avdd.n996 4.5005
R4618 avdd.n1010 avdd.n1009 4.5005
R4619 avdd.n985 avdd.n984 4.5005
R4620 avdd.n1023 avdd.n1022 4.5005
R4621 avdd.n1007 avdd.n1006 4.5005
R4622 avdd.n992 avdd.n991 4.5005
R4623 avdd.n1014 avdd.n1013 4.5005
R4624 avdd.n1015 avdd.n990 4.5005
R4625 avdd.n1017 avdd.n1016 4.5005
R4626 avdd.n1001 avdd.n1000 4.5005
R4627 avdd.n3708 avdd.n3707 4.5005
R4628 avdd.n3711 avdd.n242 4.5005
R4629 avdd.n3703 avdd.n249 4.5005
R4630 avdd.n3704 avdd.n247 4.5005
R4631 avdd.n3704 avdd.n3703 4.5005
R4632 avdd.n2583 avdd.n2569 4.5005
R4633 avdd.n2583 avdd.n2582 4.5005
R4634 avdd.n2582 avdd.n2572 4.5005
R4635 avdd.n2575 avdd.n2569 4.5005
R4636 avdd.t164 avdd.n2575 4.5005
R4637 avdd.n2582 avdd.n2575 4.5005
R4638 avdd.n2571 avdd.n2569 4.5005
R4639 avdd.t164 avdd.n2571 4.5005
R4640 avdd.n2582 avdd.n2571 4.5005
R4641 avdd.n2581 avdd.t164 4.5005
R4642 avdd.n2582 avdd.n2581 4.5005
R4643 avdd.n2590 avdd.n2560 4.5005
R4644 avdd.n2590 avdd.n2589 4.5005
R4645 avdd.n2589 avdd.n2563 4.5005
R4646 avdd.n2566 avdd.n2560 4.5005
R4647 avdd.t165 avdd.n2566 4.5005
R4648 avdd.n2589 avdd.n2566 4.5005
R4649 avdd.n2562 avdd.n2560 4.5005
R4650 avdd.t165 avdd.n2562 4.5005
R4651 avdd.n2589 avdd.n2562 4.5005
R4652 avdd.n2588 avdd.t165 4.5005
R4653 avdd.n2589 avdd.n2588 4.5005
R4654 avdd.n2659 avdd.n2658 4.5005
R4655 avdd.n2642 avdd.n2641 4.5005
R4656 avdd.n2672 avdd.n2671 4.5005
R4657 avdd.n2673 avdd.n2640 4.5005
R4658 avdd.n2675 avdd.n2674 4.5005
R4659 avdd.n2630 avdd.n2629 4.5005
R4660 avdd.n2688 avdd.n2687 4.5005
R4661 avdd.n2689 avdd.n2628 4.5005
R4662 avdd.n2691 avdd.n2690 4.5005
R4663 avdd.n2618 avdd.n2617 4.5005
R4664 avdd.n2704 avdd.n2703 4.5005
R4665 avdd.n2705 avdd.n2616 4.5005
R4666 avdd.n2707 avdd.n2706 4.5005
R4667 avdd.n2606 avdd.n2605 4.5005
R4668 avdd.n2720 avdd.n2719 4.5005
R4669 avdd.n2721 avdd.n2604 4.5005
R4670 avdd.n2723 avdd.n2722 4.5005
R4671 avdd.n2593 avdd.n2592 4.5005
R4672 avdd.n2781 avdd.n2780 4.5005
R4673 avdd.n2657 avdd.n2652 4.5005
R4674 avdd.n2664 avdd.n2663 4.5005
R4675 avdd.n2665 avdd.n2646 4.5005
R4676 avdd.n2667 avdd.n2666 4.5005
R4677 avdd.n2636 avdd.n2635 4.5005
R4678 avdd.n2680 avdd.n2679 4.5005
R4679 avdd.n2681 avdd.n2634 4.5005
R4680 avdd.n2683 avdd.n2682 4.5005
R4681 avdd.n2624 avdd.n2623 4.5005
R4682 avdd.n2696 avdd.n2695 4.5005
R4683 avdd.n2697 avdd.n2622 4.5005
R4684 avdd.n2699 avdd.n2698 4.5005
R4685 avdd.n2612 avdd.n2611 4.5005
R4686 avdd.n2712 avdd.n2711 4.5005
R4687 avdd.n2713 avdd.n2610 4.5005
R4688 avdd.n2715 avdd.n2714 4.5005
R4689 avdd.n2600 avdd.n2599 4.5005
R4690 avdd.n2728 avdd.n2727 4.5005
R4691 avdd.n2729 avdd.n2598 4.5005
R4692 avdd.n2775 avdd.n2774 4.5005
R4693 avdd.n2648 avdd.n2647 4.5005
R4694 avdd.n2771 avdd.n2770 4.5005
R4695 avdd.n2732 avdd.n2731 4.5005
R4696 avdd.n2745 avdd.n2737 4.5005
R4697 avdd.n2747 avdd.n2746 4.5005
R4698 avdd.n2750 avdd.n2743 4.5005
R4699 avdd.n2752 avdd.n2751 4.5005
R4700 avdd.n2765 avdd.n2764 4.5005
R4701 avdd.n2763 avdd.n2736 4.5005
R4702 avdd.n2805 avdd.n2804 4.5005
R4703 avdd.n2802 avdd.n2793 4.5005
R4704 avdd.n2808 avdd.n2807 4.5005
R4705 avdd.n2801 avdd.n2799 4.5005
R4706 avdd.n2822 avdd.n2784 4.5005
R4707 avdd.n2824 avdd.n2823 4.5005
R4708 avdd.n2817 avdd.n2816 4.5005
R4709 avdd.n2792 avdd.n2791 4.5005
R4710 avdd.n2841 avdd.n2840 4.5005
R4711 avdd.n2864 avdd.n2863 4.5005
R4712 avdd.n2865 avdd.n2839 4.5005
R4713 avdd.n2867 avdd.n2866 4.5005
R4714 avdd.n2829 avdd.n2828 4.5005
R4715 avdd.n2881 avdd.n2880 4.5005
R4716 avdd.n2850 avdd.n2849 4.5005
R4717 avdd.n2857 avdd.n2845 4.5005
R4718 avdd.n2859 avdd.n2858 4.5005
R4719 avdd.n2836 avdd.n2835 4.5005
R4720 avdd.n2872 avdd.n2871 4.5005
R4721 avdd.n2873 avdd.n2834 4.5005
R4722 avdd.n2875 avdd.n2874 4.5005
R4723 avdd.n2856 avdd.n2855 4.5005
R4724 avdd.n2909 avdd.n2897 4.5005
R4725 avdd.n2911 avdd.n2910 4.5005
R4726 avdd.n2886 avdd.n2885 4.5005
R4727 avdd.n2924 avdd.n2923 4.5005
R4728 avdd.n2908 avdd.n2907 4.5005
R4729 avdd.n2893 avdd.n2892 4.5005
R4730 avdd.n2915 avdd.n2914 4.5005
R4731 avdd.n2916 avdd.n2891 4.5005
R4732 avdd.n2918 avdd.n2917 4.5005
R4733 avdd.n2902 avdd.n2901 4.5005
R4734 avdd.n2958 avdd.n2944 4.5005
R4735 avdd.n2958 avdd.n2957 4.5005
R4736 avdd.n2957 avdd.n2947 4.5005
R4737 avdd.n2950 avdd.n2944 4.5005
R4738 avdd.t166 avdd.n2950 4.5005
R4739 avdd.n2957 avdd.n2950 4.5005
R4740 avdd.n2946 avdd.n2944 4.5005
R4741 avdd.t166 avdd.n2946 4.5005
R4742 avdd.n2957 avdd.n2946 4.5005
R4743 avdd.n2956 avdd.t166 4.5005
R4744 avdd.n2957 avdd.n2956 4.5005
R4745 avdd.n2965 avdd.n2935 4.5005
R4746 avdd.n2965 avdd.n2964 4.5005
R4747 avdd.n2964 avdd.n2938 4.5005
R4748 avdd.n2941 avdd.n2935 4.5005
R4749 avdd.t167 avdd.n2941 4.5005
R4750 avdd.n2964 avdd.n2941 4.5005
R4751 avdd.n2937 avdd.n2935 4.5005
R4752 avdd.t167 avdd.n2937 4.5005
R4753 avdd.n2964 avdd.n2937 4.5005
R4754 avdd.n2963 avdd.t167 4.5005
R4755 avdd.n2964 avdd.n2963 4.5005
R4756 avdd.n3034 avdd.n3033 4.5005
R4757 avdd.n3017 avdd.n3016 4.5005
R4758 avdd.n3047 avdd.n3046 4.5005
R4759 avdd.n3048 avdd.n3015 4.5005
R4760 avdd.n3050 avdd.n3049 4.5005
R4761 avdd.n3005 avdd.n3004 4.5005
R4762 avdd.n3063 avdd.n3062 4.5005
R4763 avdd.n3064 avdd.n3003 4.5005
R4764 avdd.n3066 avdd.n3065 4.5005
R4765 avdd.n2993 avdd.n2992 4.5005
R4766 avdd.n3079 avdd.n3078 4.5005
R4767 avdd.n3080 avdd.n2991 4.5005
R4768 avdd.n3082 avdd.n3081 4.5005
R4769 avdd.n2981 avdd.n2980 4.5005
R4770 avdd.n3095 avdd.n3094 4.5005
R4771 avdd.n3096 avdd.n2979 4.5005
R4772 avdd.n3098 avdd.n3097 4.5005
R4773 avdd.n2968 avdd.n2967 4.5005
R4774 avdd.n3156 avdd.n3155 4.5005
R4775 avdd.n3032 avdd.n3027 4.5005
R4776 avdd.n3039 avdd.n3038 4.5005
R4777 avdd.n3040 avdd.n3021 4.5005
R4778 avdd.n3042 avdd.n3041 4.5005
R4779 avdd.n3011 avdd.n3010 4.5005
R4780 avdd.n3055 avdd.n3054 4.5005
R4781 avdd.n3056 avdd.n3009 4.5005
R4782 avdd.n3058 avdd.n3057 4.5005
R4783 avdd.n2999 avdd.n2998 4.5005
R4784 avdd.n3071 avdd.n3070 4.5005
R4785 avdd.n3072 avdd.n2997 4.5005
R4786 avdd.n3074 avdd.n3073 4.5005
R4787 avdd.n2987 avdd.n2986 4.5005
R4788 avdd.n3087 avdd.n3086 4.5005
R4789 avdd.n3088 avdd.n2985 4.5005
R4790 avdd.n3090 avdd.n3089 4.5005
R4791 avdd.n2975 avdd.n2974 4.5005
R4792 avdd.n3103 avdd.n3102 4.5005
R4793 avdd.n3104 avdd.n2973 4.5005
R4794 avdd.n3150 avdd.n3149 4.5005
R4795 avdd.n3023 avdd.n3022 4.5005
R4796 avdd.n3146 avdd.n3145 4.5005
R4797 avdd.n3107 avdd.n3106 4.5005
R4798 avdd.n3120 avdd.n3112 4.5005
R4799 avdd.n3122 avdd.n3121 4.5005
R4800 avdd.n3125 avdd.n3118 4.5005
R4801 avdd.n3127 avdd.n3126 4.5005
R4802 avdd.n3140 avdd.n3139 4.5005
R4803 avdd.n3138 avdd.n3111 4.5005
R4804 avdd.n3180 avdd.n3179 4.5005
R4805 avdd.n3177 avdd.n3168 4.5005
R4806 avdd.n3183 avdd.n3182 4.5005
R4807 avdd.n3176 avdd.n3174 4.5005
R4808 avdd.n3197 avdd.n3159 4.5005
R4809 avdd.n3199 avdd.n3198 4.5005
R4810 avdd.n3192 avdd.n3191 4.5005
R4811 avdd.n3167 avdd.n3166 4.5005
R4812 avdd.n3216 avdd.n3215 4.5005
R4813 avdd.n3239 avdd.n3238 4.5005
R4814 avdd.n3240 avdd.n3214 4.5005
R4815 avdd.n3242 avdd.n3241 4.5005
R4816 avdd.n3204 avdd.n3203 4.5005
R4817 avdd.n3256 avdd.n3255 4.5005
R4818 avdd.n3225 avdd.n3224 4.5005
R4819 avdd.n3232 avdd.n3220 4.5005
R4820 avdd.n3234 avdd.n3233 4.5005
R4821 avdd.n3211 avdd.n3210 4.5005
R4822 avdd.n3247 avdd.n3246 4.5005
R4823 avdd.n3248 avdd.n3209 4.5005
R4824 avdd.n3250 avdd.n3249 4.5005
R4825 avdd.n3231 avdd.n3230 4.5005
R4826 avdd.n3284 avdd.n3272 4.5005
R4827 avdd.n3286 avdd.n3285 4.5005
R4828 avdd.n3261 avdd.n3260 4.5005
R4829 avdd.n3299 avdd.n3298 4.5005
R4830 avdd.n3283 avdd.n3282 4.5005
R4831 avdd.n3268 avdd.n3267 4.5005
R4832 avdd.n3290 avdd.n3289 4.5005
R4833 avdd.n3291 avdd.n3266 4.5005
R4834 avdd.n3293 avdd.n3292 4.5005
R4835 avdd.n3277 avdd.n3276 4.5005
R4836 avdd.n3334 avdd.n3320 4.5005
R4837 avdd.n3334 avdd.n3333 4.5005
R4838 avdd.n3333 avdd.n3323 4.5005
R4839 avdd.n3326 avdd.n3320 4.5005
R4840 avdd.t168 avdd.n3326 4.5005
R4841 avdd.n3333 avdd.n3326 4.5005
R4842 avdd.n3322 avdd.n3320 4.5005
R4843 avdd.t168 avdd.n3322 4.5005
R4844 avdd.n3333 avdd.n3322 4.5005
R4845 avdd.n3332 avdd.t168 4.5005
R4846 avdd.n3333 avdd.n3332 4.5005
R4847 avdd.n3341 avdd.n3311 4.5005
R4848 avdd.n3341 avdd.n3340 4.5005
R4849 avdd.n3340 avdd.n3314 4.5005
R4850 avdd.n3317 avdd.n3311 4.5005
R4851 avdd.t169 avdd.n3317 4.5005
R4852 avdd.n3340 avdd.n3317 4.5005
R4853 avdd.n3313 avdd.n3311 4.5005
R4854 avdd.t169 avdd.n3313 4.5005
R4855 avdd.n3340 avdd.n3313 4.5005
R4856 avdd.n3339 avdd.t169 4.5005
R4857 avdd.n3340 avdd.n3339 4.5005
R4858 avdd.n3410 avdd.n3409 4.5005
R4859 avdd.n3393 avdd.n3392 4.5005
R4860 avdd.n3423 avdd.n3422 4.5005
R4861 avdd.n3424 avdd.n3391 4.5005
R4862 avdd.n3426 avdd.n3425 4.5005
R4863 avdd.n3381 avdd.n3380 4.5005
R4864 avdd.n3439 avdd.n3438 4.5005
R4865 avdd.n3440 avdd.n3379 4.5005
R4866 avdd.n3442 avdd.n3441 4.5005
R4867 avdd.n3369 avdd.n3368 4.5005
R4868 avdd.n3455 avdd.n3454 4.5005
R4869 avdd.n3456 avdd.n3367 4.5005
R4870 avdd.n3458 avdd.n3457 4.5005
R4871 avdd.n3357 avdd.n3356 4.5005
R4872 avdd.n3471 avdd.n3470 4.5005
R4873 avdd.n3472 avdd.n3355 4.5005
R4874 avdd.n3474 avdd.n3473 4.5005
R4875 avdd.n3344 avdd.n3343 4.5005
R4876 avdd.n3532 avdd.n3531 4.5005
R4877 avdd.n3408 avdd.n3403 4.5005
R4878 avdd.n3415 avdd.n3414 4.5005
R4879 avdd.n3416 avdd.n3397 4.5005
R4880 avdd.n3418 avdd.n3417 4.5005
R4881 avdd.n3387 avdd.n3386 4.5005
R4882 avdd.n3431 avdd.n3430 4.5005
R4883 avdd.n3432 avdd.n3385 4.5005
R4884 avdd.n3434 avdd.n3433 4.5005
R4885 avdd.n3375 avdd.n3374 4.5005
R4886 avdd.n3447 avdd.n3446 4.5005
R4887 avdd.n3448 avdd.n3373 4.5005
R4888 avdd.n3450 avdd.n3449 4.5005
R4889 avdd.n3363 avdd.n3362 4.5005
R4890 avdd.n3463 avdd.n3462 4.5005
R4891 avdd.n3464 avdd.n3361 4.5005
R4892 avdd.n3466 avdd.n3465 4.5005
R4893 avdd.n3351 avdd.n3350 4.5005
R4894 avdd.n3479 avdd.n3478 4.5005
R4895 avdd.n3480 avdd.n3349 4.5005
R4896 avdd.n3526 avdd.n3525 4.5005
R4897 avdd.n3399 avdd.n3398 4.5005
R4898 avdd.n3522 avdd.n3521 4.5005
R4899 avdd.n3483 avdd.n3482 4.5005
R4900 avdd.n3496 avdd.n3488 4.5005
R4901 avdd.n3498 avdd.n3497 4.5005
R4902 avdd.n3501 avdd.n3494 4.5005
R4903 avdd.n3503 avdd.n3502 4.5005
R4904 avdd.n3516 avdd.n3515 4.5005
R4905 avdd.n3514 avdd.n3487 4.5005
R4906 avdd.n3556 avdd.n3555 4.5005
R4907 avdd.n3553 avdd.n3544 4.5005
R4908 avdd.n3559 avdd.n3558 4.5005
R4909 avdd.n3552 avdd.n3550 4.5005
R4910 avdd.n3573 avdd.n3535 4.5005
R4911 avdd.n3575 avdd.n3574 4.5005
R4912 avdd.n3568 avdd.n3567 4.5005
R4913 avdd.n3543 avdd.n3542 4.5005
R4914 avdd.n3592 avdd.n3591 4.5005
R4915 avdd.n3615 avdd.n3614 4.5005
R4916 avdd.n3616 avdd.n3590 4.5005
R4917 avdd.n3618 avdd.n3617 4.5005
R4918 avdd.n3580 avdd.n3579 4.5005
R4919 avdd.n3632 avdd.n3631 4.5005
R4920 avdd.n3601 avdd.n3600 4.5005
R4921 avdd.n3608 avdd.n3596 4.5005
R4922 avdd.n3610 avdd.n3609 4.5005
R4923 avdd.n3587 avdd.n3586 4.5005
R4924 avdd.n3623 avdd.n3622 4.5005
R4925 avdd.n3624 avdd.n3585 4.5005
R4926 avdd.n3626 avdd.n3625 4.5005
R4927 avdd.n3607 avdd.n3606 4.5005
R4928 avdd.n3660 avdd.n3648 4.5005
R4929 avdd.n3662 avdd.n3661 4.5005
R4930 avdd.n3637 avdd.n3636 4.5005
R4931 avdd.n3675 avdd.n3674 4.5005
R4932 avdd.n3659 avdd.n3658 4.5005
R4933 avdd.n3644 avdd.n3643 4.5005
R4934 avdd.n3666 avdd.n3665 4.5005
R4935 avdd.n3667 avdd.n3642 4.5005
R4936 avdd.n3669 avdd.n3668 4.5005
R4937 avdd.n3653 avdd.n3652 4.5005
R4938 avdd.n2556 avdd.n278 4.5005
R4939 avdd.n1032 avdd.n1028 4.5005
R4940 avdd.n1035 avdd.n1028 4.5005
R4941 avdd.n1035 avdd.n657 4.5005
R4942 avdd.n3719 avdd.n238 4.5005
R4943 avdd.n3722 avdd.n238 4.5005
R4944 avdd.n3722 avdd.n237 4.5005
R4945 avdd.n2931 avdd.n2930 4.5005
R4946 avdd.n2929 avdd.n255 4.5005
R4947 avdd.n2930 avdd.n2929 4.5005
R4948 avdd.n3695 avdd.n252 4.5005
R4949 avdd.n3696 avdd.n3695 4.5005
R4950 avdd.n3697 avdd.n3696 4.5005
R4951 avdd.n1530 avdd.n1516 4.5005
R4952 avdd.n1530 avdd.n1529 4.5005
R4953 avdd.n1529 avdd.n1519 4.5005
R4954 avdd.n1522 avdd.n1516 4.5005
R4955 avdd.t158 avdd.n1522 4.5005
R4956 avdd.n1529 avdd.n1522 4.5005
R4957 avdd.n1518 avdd.n1516 4.5005
R4958 avdd.t158 avdd.n1518 4.5005
R4959 avdd.n1529 avdd.n1518 4.5005
R4960 avdd.n1528 avdd.t158 4.5005
R4961 avdd.n1529 avdd.n1528 4.5005
R4962 avdd.n1537 avdd.n1507 4.5005
R4963 avdd.n1537 avdd.n1536 4.5005
R4964 avdd.n1536 avdd.n1510 4.5005
R4965 avdd.n1513 avdd.n1507 4.5005
R4966 avdd.t159 avdd.n1513 4.5005
R4967 avdd.n1536 avdd.n1513 4.5005
R4968 avdd.n1509 avdd.n1507 4.5005
R4969 avdd.t159 avdd.n1509 4.5005
R4970 avdd.n1536 avdd.n1509 4.5005
R4971 avdd.n1535 avdd.t159 4.5005
R4972 avdd.n1536 avdd.n1535 4.5005
R4973 avdd.n1606 avdd.n1605 4.5005
R4974 avdd.n1589 avdd.n1588 4.5005
R4975 avdd.n1619 avdd.n1618 4.5005
R4976 avdd.n1620 avdd.n1587 4.5005
R4977 avdd.n1622 avdd.n1621 4.5005
R4978 avdd.n1577 avdd.n1576 4.5005
R4979 avdd.n1635 avdd.n1634 4.5005
R4980 avdd.n1636 avdd.n1575 4.5005
R4981 avdd.n1638 avdd.n1637 4.5005
R4982 avdd.n1565 avdd.n1564 4.5005
R4983 avdd.n1651 avdd.n1650 4.5005
R4984 avdd.n1652 avdd.n1563 4.5005
R4985 avdd.n1654 avdd.n1653 4.5005
R4986 avdd.n1553 avdd.n1552 4.5005
R4987 avdd.n1667 avdd.n1666 4.5005
R4988 avdd.n1668 avdd.n1551 4.5005
R4989 avdd.n1670 avdd.n1669 4.5005
R4990 avdd.n1540 avdd.n1539 4.5005
R4991 avdd.n1728 avdd.n1727 4.5005
R4992 avdd.n1604 avdd.n1599 4.5005
R4993 avdd.n1611 avdd.n1610 4.5005
R4994 avdd.n1612 avdd.n1593 4.5005
R4995 avdd.n1614 avdd.n1613 4.5005
R4996 avdd.n1583 avdd.n1582 4.5005
R4997 avdd.n1627 avdd.n1626 4.5005
R4998 avdd.n1628 avdd.n1581 4.5005
R4999 avdd.n1630 avdd.n1629 4.5005
R5000 avdd.n1571 avdd.n1570 4.5005
R5001 avdd.n1643 avdd.n1642 4.5005
R5002 avdd.n1644 avdd.n1569 4.5005
R5003 avdd.n1646 avdd.n1645 4.5005
R5004 avdd.n1559 avdd.n1558 4.5005
R5005 avdd.n1659 avdd.n1658 4.5005
R5006 avdd.n1660 avdd.n1557 4.5005
R5007 avdd.n1662 avdd.n1661 4.5005
R5008 avdd.n1547 avdd.n1546 4.5005
R5009 avdd.n1675 avdd.n1674 4.5005
R5010 avdd.n1676 avdd.n1545 4.5005
R5011 avdd.n1722 avdd.n1721 4.5005
R5012 avdd.n1595 avdd.n1594 4.5005
R5013 avdd.n1718 avdd.n1717 4.5005
R5014 avdd.n1679 avdd.n1678 4.5005
R5015 avdd.n1692 avdd.n1684 4.5005
R5016 avdd.n1694 avdd.n1693 4.5005
R5017 avdd.n1697 avdd.n1690 4.5005
R5018 avdd.n1699 avdd.n1698 4.5005
R5019 avdd.n1712 avdd.n1711 4.5005
R5020 avdd.n1710 avdd.n1683 4.5005
R5021 avdd.n1752 avdd.n1751 4.5005
R5022 avdd.n1749 avdd.n1740 4.5005
R5023 avdd.n1755 avdd.n1754 4.5005
R5024 avdd.n1748 avdd.n1746 4.5005
R5025 avdd.n1769 avdd.n1731 4.5005
R5026 avdd.n1771 avdd.n1770 4.5005
R5027 avdd.n1764 avdd.n1763 4.5005
R5028 avdd.n1739 avdd.n1738 4.5005
R5029 avdd.n1788 avdd.n1787 4.5005
R5030 avdd.n1811 avdd.n1810 4.5005
R5031 avdd.n1812 avdd.n1786 4.5005
R5032 avdd.n1814 avdd.n1813 4.5005
R5033 avdd.n1776 avdd.n1775 4.5005
R5034 avdd.n1828 avdd.n1827 4.5005
R5035 avdd.n1797 avdd.n1796 4.5005
R5036 avdd.n1804 avdd.n1792 4.5005
R5037 avdd.n1806 avdd.n1805 4.5005
R5038 avdd.n1783 avdd.n1782 4.5005
R5039 avdd.n1819 avdd.n1818 4.5005
R5040 avdd.n1820 avdd.n1781 4.5005
R5041 avdd.n1822 avdd.n1821 4.5005
R5042 avdd.n1803 avdd.n1802 4.5005
R5043 avdd.n1856 avdd.n1844 4.5005
R5044 avdd.n1858 avdd.n1857 4.5005
R5045 avdd.n1833 avdd.n1832 4.5005
R5046 avdd.n1871 avdd.n1870 4.5005
R5047 avdd.n1855 avdd.n1854 4.5005
R5048 avdd.n1840 avdd.n1839 4.5005
R5049 avdd.n1862 avdd.n1861 4.5005
R5050 avdd.n1863 avdd.n1838 4.5005
R5051 avdd.n1865 avdd.n1864 4.5005
R5052 avdd.n1849 avdd.n1848 4.5005
R5053 avdd.n1155 avdd.n1141 4.5005
R5054 avdd.n1155 avdd.n1154 4.5005
R5055 avdd.n1154 avdd.n1144 4.5005
R5056 avdd.n1147 avdd.n1141 4.5005
R5057 avdd.t160 avdd.n1147 4.5005
R5058 avdd.n1154 avdd.n1147 4.5005
R5059 avdd.n1143 avdd.n1141 4.5005
R5060 avdd.t160 avdd.n1143 4.5005
R5061 avdd.n1154 avdd.n1143 4.5005
R5062 avdd.n1153 avdd.t160 4.5005
R5063 avdd.n1154 avdd.n1153 4.5005
R5064 avdd.n1162 avdd.n1132 4.5005
R5065 avdd.n1162 avdd.n1161 4.5005
R5066 avdd.n1161 avdd.n1135 4.5005
R5067 avdd.n1138 avdd.n1132 4.5005
R5068 avdd.t161 avdd.n1138 4.5005
R5069 avdd.n1161 avdd.n1138 4.5005
R5070 avdd.n1134 avdd.n1132 4.5005
R5071 avdd.t161 avdd.n1134 4.5005
R5072 avdd.n1161 avdd.n1134 4.5005
R5073 avdd.n1160 avdd.t161 4.5005
R5074 avdd.n1161 avdd.n1160 4.5005
R5075 avdd.n1231 avdd.n1230 4.5005
R5076 avdd.n1214 avdd.n1213 4.5005
R5077 avdd.n1244 avdd.n1243 4.5005
R5078 avdd.n1245 avdd.n1212 4.5005
R5079 avdd.n1247 avdd.n1246 4.5005
R5080 avdd.n1202 avdd.n1201 4.5005
R5081 avdd.n1260 avdd.n1259 4.5005
R5082 avdd.n1261 avdd.n1200 4.5005
R5083 avdd.n1263 avdd.n1262 4.5005
R5084 avdd.n1190 avdd.n1189 4.5005
R5085 avdd.n1276 avdd.n1275 4.5005
R5086 avdd.n1277 avdd.n1188 4.5005
R5087 avdd.n1279 avdd.n1278 4.5005
R5088 avdd.n1178 avdd.n1177 4.5005
R5089 avdd.n1292 avdd.n1291 4.5005
R5090 avdd.n1293 avdd.n1176 4.5005
R5091 avdd.n1295 avdd.n1294 4.5005
R5092 avdd.n1165 avdd.n1164 4.5005
R5093 avdd.n1353 avdd.n1352 4.5005
R5094 avdd.n1229 avdd.n1224 4.5005
R5095 avdd.n1236 avdd.n1235 4.5005
R5096 avdd.n1237 avdd.n1218 4.5005
R5097 avdd.n1239 avdd.n1238 4.5005
R5098 avdd.n1208 avdd.n1207 4.5005
R5099 avdd.n1252 avdd.n1251 4.5005
R5100 avdd.n1253 avdd.n1206 4.5005
R5101 avdd.n1255 avdd.n1254 4.5005
R5102 avdd.n1196 avdd.n1195 4.5005
R5103 avdd.n1268 avdd.n1267 4.5005
R5104 avdd.n1269 avdd.n1194 4.5005
R5105 avdd.n1271 avdd.n1270 4.5005
R5106 avdd.n1184 avdd.n1183 4.5005
R5107 avdd.n1284 avdd.n1283 4.5005
R5108 avdd.n1285 avdd.n1182 4.5005
R5109 avdd.n1287 avdd.n1286 4.5005
R5110 avdd.n1172 avdd.n1171 4.5005
R5111 avdd.n1300 avdd.n1299 4.5005
R5112 avdd.n1301 avdd.n1170 4.5005
R5113 avdd.n1347 avdd.n1346 4.5005
R5114 avdd.n1220 avdd.n1219 4.5005
R5115 avdd.n1343 avdd.n1342 4.5005
R5116 avdd.n1304 avdd.n1303 4.5005
R5117 avdd.n1317 avdd.n1309 4.5005
R5118 avdd.n1319 avdd.n1318 4.5005
R5119 avdd.n1322 avdd.n1315 4.5005
R5120 avdd.n1324 avdd.n1323 4.5005
R5121 avdd.n1337 avdd.n1336 4.5005
R5122 avdd.n1335 avdd.n1308 4.5005
R5123 avdd.n1377 avdd.n1376 4.5005
R5124 avdd.n1374 avdd.n1365 4.5005
R5125 avdd.n1380 avdd.n1379 4.5005
R5126 avdd.n1373 avdd.n1371 4.5005
R5127 avdd.n1394 avdd.n1356 4.5005
R5128 avdd.n1396 avdd.n1395 4.5005
R5129 avdd.n1389 avdd.n1388 4.5005
R5130 avdd.n1364 avdd.n1363 4.5005
R5131 avdd.n1413 avdd.n1412 4.5005
R5132 avdd.n1436 avdd.n1435 4.5005
R5133 avdd.n1437 avdd.n1411 4.5005
R5134 avdd.n1439 avdd.n1438 4.5005
R5135 avdd.n1401 avdd.n1400 4.5005
R5136 avdd.n1453 avdd.n1452 4.5005
R5137 avdd.n1422 avdd.n1421 4.5005
R5138 avdd.n1429 avdd.n1417 4.5005
R5139 avdd.n1431 avdd.n1430 4.5005
R5140 avdd.n1408 avdd.n1407 4.5005
R5141 avdd.n1444 avdd.n1443 4.5005
R5142 avdd.n1445 avdd.n1406 4.5005
R5143 avdd.n1447 avdd.n1446 4.5005
R5144 avdd.n1428 avdd.n1427 4.5005
R5145 avdd.n1481 avdd.n1469 4.5005
R5146 avdd.n1483 avdd.n1482 4.5005
R5147 avdd.n1458 avdd.n1457 4.5005
R5148 avdd.n1496 avdd.n1495 4.5005
R5149 avdd.n1480 avdd.n1479 4.5005
R5150 avdd.n1465 avdd.n1464 4.5005
R5151 avdd.n1487 avdd.n1486 4.5005
R5152 avdd.n1488 avdd.n1463 4.5005
R5153 avdd.n1490 avdd.n1489 4.5005
R5154 avdd.n1474 avdd.n1473 4.5005
R5155 avdd.n1876 avdd.n1084 4.5005
R5156 avdd.n2553 avdd.n2552 4.5005
R5157 avdd.n2552 avdd.n2551 4.5005
R5158 avdd.n2551 avdd.n655 4.5005
R5159 avdd.n2178 avdd.n1036 4.5005
R5160 avdd.n2178 avdd.n2177 4.5005
R5161 avdd.n2177 avdd.n2044 4.5005
R5162 avdd.n3723 avdd.n234 4.5005
R5163 avdd.n3726 avdd.n234 4.5005
R5164 avdd.n3726 avdd.n233 4.5005
R5165 avdd.n1504 avdd.n1087 4.5005
R5166 avdd.n1505 avdd.n271 4.5005
R5167 avdd.n1505 avdd.n1504 4.5005
R5168 avdd.n3309 avdd.n260 4.5005
R5169 avdd.n3309 avdd.n3308 4.5005
R5170 avdd.n3308 avdd.n272 4.5005
R5171 avdd.n3690 avdd.n257 4.5005
R5172 avdd.n3691 avdd.n3690 4.5005
R5173 avdd.n3692 avdd.n3691 4.5005
R5174 avdd.n1105 avdd.n1102 4.5005
R5175 avdd.n1881 avdd.n1070 4.5005
R5176 avdd.n1884 avdd.n1070 4.5005
R5177 avdd.n1884 avdd.n1069 4.5005
R5178 avdd.n1077 avdd.n654 4.5005
R5179 avdd.n1077 avdd.n1076 4.5005
R5180 avdd.n1076 avdd.n1073 4.5005
R5181 avdd.n2043 avdd.n2042 4.5005
R5182 avdd.n2042 avdd.n2041 4.5005
R5183 avdd.n2041 avdd.n1910 4.5005
R5184 avdd.n3727 avdd.n230 4.5005
R5185 avdd.n3730 avdd.n230 4.5005
R5186 avdd.n3730 avdd.n229 4.5005
R5187 avdd.n1123 avdd.n1121 4.5005
R5188 avdd.n1125 avdd.n1124 4.5005
R5189 avdd.n1124 avdd.n1123 4.5005
R5190 avdd.n1126 avdd.n268 4.5005
R5191 avdd.n1127 avdd.n1126 4.5005
R5192 avdd.n1128 avdd.n1127 4.5005
R5193 avdd.n3684 avdd.n3683 4.5005
R5194 avdd.n3683 avdd.n3682 4.5005
R5195 avdd.n3682 avdd.n269 4.5005
R5196 avdd.n3685 avdd.n262 4.5005
R5197 avdd.n3686 avdd.n3685 4.5005
R5198 avdd.n3687 avdd.n3686 4.5005
R5199 avdd.n1098 avdd.n1097 4.5005
R5200 avdd.n1114 avdd.n1108 4.5005
R5201 avdd.n1114 avdd.n1113 4.5005
R5202 avdd.n1113 avdd.n1110 4.5005
R5203 avdd.n1892 avdd.n1885 4.5005
R5204 avdd.n1892 avdd.n1891 4.5005
R5205 avdd.n1891 avdd.n1886 4.5005
R5206 avdd.n1898 avdd.n1044 4.5005
R5207 avdd.n1899 avdd.n1898 4.5005
R5208 avdd.n1900 avdd.n1899 4.5005
R5209 avdd.n1909 avdd.n1908 4.5005
R5210 avdd.n1908 avdd.n1907 4.5005
R5211 avdd.n1907 avdd.n1905 4.5005
R5212 avdd.n3737 avdd.n3731 4.5005
R5213 avdd.n3737 avdd.n3736 4.5005
R5214 avdd.n3736 avdd.n3732 4.5005
R5215 avdd.n152 avdd.n151 4.5005
R5216 avdd.n134 avdd.n133 4.5005
R5217 avdd.n146 avdd.n145 4.5005
R5218 avdd.n144 avdd.n138 4.5005
R5219 avdd.n174 avdd.n173 4.5005
R5220 avdd.n156 avdd.n155 4.5005
R5221 avdd.n168 avdd.n167 4.5005
R5222 avdd.n166 avdd.n160 4.5005
R5223 avdd.n3872 avdd.n3871 4.5005
R5224 avdd.n3869 avdd.n3868 4.5005
R5225 avdd.n3890 avdd.n3889 4.5005
R5226 avdd.n3887 avdd.n3886 4.5005
R5227 avdd.n3909 avdd.n3908 4.5005
R5228 avdd.n3906 avdd.n3905 4.5005
R5229 avdd.n3921 avdd.n3852 4.5005
R5230 avdd.n3923 avdd.n3922 4.5005
R5231 avdd.n3922 avdd.n3921 4.5005
R5232 avdd.n3766 avdd.n3765 4.5005
R5233 avdd.n3763 avdd.n3762 4.5005
R5234 avdd.n3784 avdd.n3783 4.5005
R5235 avdd.n3781 avdd.n3780 4.5005
R5236 avdd.n3803 avdd.n3802 4.5005
R5237 avdd.n3800 avdd.n3799 4.5005
R5238 avdd.n3835 avdd.n3834 4.5005
R5239 avdd.n3968 avdd.n3753 4.5005
R5240 avdd.n3967 avdd.n3966 4.5005
R5241 avdd.n3968 avdd.n3967 4.5005
R5242 avdd.n3857 avdd.n3826 4.5005
R5243 avdd.n3857 avdd.n3814 4.5005
R5244 avdd.n3859 avdd.n3814 4.5005
R5245 avdd.n3751 avdd.n3750 4.5005
R5246 avdd.n3845 avdd.n3844 4.5005
R5247 avdd.n3844 avdd.n3843 4.5005
R5248 avdd.n3843 avdd.n3841 4.5005
R5249 avdd.n3954 avdd.n3953 4.5005
R5250 avdd.n3957 avdd.n3748 4.5005
R5251 avdd.n3954 avdd.n3748 4.5005
R5252 avdd.n3958 avdd.n3948 4.5005
R5253 avdd.n3959 avdd.n3958 4.5005
R5254 avdd.n3960 avdd.n3959 4.5005
R5255 avdd.n3944 avdd.n3817 4.5005
R5256 avdd.n3947 avdd.n3817 4.5005
R5257 avdd.n3947 avdd.n3816 4.5005
R5258 avdd.n3823 avdd.n3822 4.5005
R5259 avdd.n3937 avdd.n3825 4.5005
R5260 avdd.n3937 avdd.n3936 4.5005
R5261 avdd.n3936 avdd.n3827 4.5005
R5262 avdd.n3930 avdd.n3829 4.5005
R5263 avdd.n3930 avdd.n3929 4.5005
R5264 avdd.n3929 avdd.n3924 4.5005
R5265 avdd.n4063 avdd.n4062 4.5005
R5266 avdd.n4060 avdd.n4059 4.5005
R5267 avdd.n4081 avdd.n4080 4.5005
R5268 avdd.n4078 avdd.n4077 4.5005
R5269 avdd.n4100 avdd.n4099 4.5005
R5270 avdd.n4097 avdd.n4096 4.5005
R5271 avdd.n75 avdd.n74 4.5005
R5272 avdd.n72 avdd.n71 4.5005
R5273 avdd.n93 avdd.n92 4.5005
R5274 avdd.n90 avdd.n89 4.5005
R5275 avdd.n112 avdd.n111 4.5005
R5276 avdd.n109 avdd.n108 4.5005
R5277 avdd.n4130 avdd.n4129 4.5005
R5278 avdd.n4127 avdd.n4126 4.5005
R5279 avdd.n4148 avdd.n4147 4.5005
R5280 avdd.n4145 avdd.n4144 4.5005
R5281 avdd.n4167 avdd.n4166 4.5005
R5282 avdd.n4164 avdd.n4163 4.5005
R5283 avdd.n18 avdd.n17 4.5005
R5284 avdd.n15 avdd.n14 4.5005
R5285 avdd.n36 avdd.n35 4.5005
R5286 avdd.n33 avdd.n32 4.5005
R5287 avdd.n55 avdd.n54 4.5005
R5288 avdd.n52 avdd.n51 4.5005
R5289 avdd.n4283 avdd.n4282 4.5005
R5290 avdd.n4281 avdd.n4276 4.5005
R5291 avdd.n4310 avdd.n4309 4.5005
R5292 avdd.n4311 avdd.n4298 4.5005
R5293 avdd.n4313 avdd.n4312 4.5005
R5294 avdd.n4300 avdd.n4299 4.5005
R5295 avdd.n4343 avdd.n4342 4.5005
R5296 avdd.n4344 avdd.n4331 4.5005
R5297 avdd.n4346 avdd.n4345 4.5005
R5298 avdd.n4333 avdd.n4332 4.5005
R5299 avdd.n4197 avdd.n4196 4.5005
R5300 avdd.n4195 avdd.n4193 4.5005
R5301 avdd.n4225 avdd.n4224 4.5005
R5302 avdd.n4226 avdd.n4213 4.5005
R5303 avdd.n4228 avdd.n4227 4.5005
R5304 avdd.n4215 avdd.n4214 4.5005
R5305 avdd.n4258 avdd.n4257 4.5005
R5306 avdd.n4259 avdd.n4246 4.5005
R5307 avdd.n4261 avdd.n4260 4.5005
R5308 avdd.n4248 avdd.n4247 4.5005
R5309 avdd.n4366 avdd.n4365 4.5005
R5310 avdd.n4364 avdd.n4362 4.5005
R5311 avdd.n4278 avdd.n4277 4.43586
R5312 avdd.n4286 avdd.n4285 4.43586
R5313 avdd.n4200 avdd.n4199 4.43586
R5314 avdd.n4202 avdd.n4201 4.43586
R5315 avdd.n1059 avdd.n5 4.2199
R5316 avdd.n2542 avdd.n2541 3.89317
R5317 avdd.n2524 avdd.n2523 3.89317
R5318 avdd.n646 avdd.n645 3.89317
R5319 avdd.n628 avdd.n627 3.89317
R5320 avdd.n1021 avdd.n1020 3.89317
R5321 avdd.n1003 avdd.n1002 3.89317
R5322 avdd.n2922 avdd.n2921 3.89317
R5323 avdd.n2904 avdd.n2903 3.89317
R5324 avdd.n3297 avdd.n3296 3.89317
R5325 avdd.n3279 avdd.n3278 3.89317
R5326 avdd.n3673 avdd.n3672 3.89317
R5327 avdd.n3655 avdd.n3654 3.89317
R5328 avdd.n1869 avdd.n1868 3.89317
R5329 avdd.n1851 avdd.n1850 3.89317
R5330 avdd.n1494 avdd.n1493 3.89317
R5331 avdd.n1476 avdd.n1475 3.89317
R5332 avdd.n3879 avdd.n3878 3.73402
R5333 avdd.n3897 avdd.n3896 3.73402
R5334 avdd.n3916 avdd.n3915 3.73402
R5335 avdd.n3773 avdd.n3772 3.73402
R5336 avdd.n3791 avdd.n3790 3.73402
R5337 avdd.n3810 avdd.n3809 3.73402
R5338 avdd.n4070 avdd.n4069 3.73402
R5339 avdd.n4088 avdd.n4087 3.73402
R5340 avdd.n4107 avdd.n4106 3.73402
R5341 avdd.n82 avdd.n81 3.73402
R5342 avdd.n100 avdd.n99 3.73402
R5343 avdd.n119 avdd.n118 3.73402
R5344 avdd.n4137 avdd.n4136 3.73402
R5345 avdd.n4155 avdd.n4154 3.73402
R5346 avdd.n4174 avdd.n4173 3.73402
R5347 avdd.n25 avdd.n24 3.73402
R5348 avdd.n43 avdd.n42 3.73402
R5349 avdd.n62 avdd.n61 3.73402
R5350 avdd.n4289 avdd.n4288 3.73402
R5351 avdd.n4204 avdd.n4203 3.73402
R5352 avdd.n4373 avdd.n4372 3.73402
R5353 avdd.n4110 avdd.n125 3.6919
R5354 avdd.n4110 avdd.n4109 3.635
R5355 avdd.n1062 avdd.n1061 3.6005
R5356 avdd.n1061 avdd.n127 3.6005
R5357 avdd.n4047 avdd.n127 3.6005
R5358 avdd.n1064 avdd.n1053 3.6005
R5359 avdd.n1053 avdd.n1052 3.6005
R5360 avdd.n1052 avdd.n126 3.6005
R5361 avdd.n4045 avdd.n126 3.6005
R5362 avdd.n2547 avdd.n2546 3.44939
R5363 avdd.n651 avdd.n650 3.44939
R5364 avdd.n1026 avdd.n1025 3.44939
R5365 avdd.n2927 avdd.n2926 3.44939
R5366 avdd.n3302 avdd.n3301 3.44939
R5367 avdd.n3678 avdd.n3677 3.44939
R5368 avdd.n1874 avdd.n1873 3.44939
R5369 avdd.n1499 avdd.n1498 3.44939
R5370 avdd.n4040 avdd.n177 3.4205
R5371 avdd.n172 avdd.n171 3.40724
R5372 avdd.n163 avdd.n159 3.40724
R5373 avdd.n3878 avdd.n3864 3.33645
R5374 avdd.n3896 avdd.n3882 3.33645
R5375 avdd.n3915 avdd.n3901 3.33645
R5376 avdd.n3772 avdd.n3758 3.33645
R5377 avdd.n3790 avdd.n3776 3.33645
R5378 avdd.n3809 avdd.n3795 3.33645
R5379 avdd.n4069 avdd.n4055 3.33645
R5380 avdd.n4087 avdd.n4073 3.33645
R5381 avdd.n4106 avdd.n4092 3.33645
R5382 avdd.n81 avdd.n67 3.33645
R5383 avdd.n99 avdd.n85 3.33645
R5384 avdd.n118 avdd.n104 3.33645
R5385 avdd.n4136 avdd.n4122 3.33645
R5386 avdd.n4154 avdd.n4140 3.33645
R5387 avdd.n4173 avdd.n4159 3.33645
R5388 avdd.n24 avdd.n10 3.33645
R5389 avdd.n42 avdd.n28 3.33645
R5390 avdd.n61 avdd.n47 3.33645
R5391 avdd.n4288 avdd.n4287 3.33645
R5392 avdd.n4288 avdd.n4273 3.33645
R5393 avdd.n4203 avdd.n4189 3.33645
R5394 avdd.n4372 avdd.n4358 3.33645
R5395 avdd.n219 avdd.n218 3.32497
R5396 avdd.n4051 avdd.n4050 3.1835
R5397 avdd.n4118 avdd.n122 3.1835
R5398 avdd.n4178 avdd.n7 3.1835
R5399 avdd.n4180 avdd.n5 2.98683
R5400 avdd.n1027 avdd 2.7578
R5401 avdd.n2928 avdd 2.7578
R5402 avdd.n3303 avdd 2.7578
R5403 avdd.n3679 avdd 2.7578
R5404 avdd.n1057 avdd.n3 2.7255
R5405 avdd.n3994 avdd.n216 2.7255
R5406 avdd.n163 avdd.n162 2.72503
R5407 avdd.n171 avdd.n170 2.72503
R5408 avdd.n2548 avdd 2.7178
R5409 avdd.n652 avdd 2.7178
R5410 avdd.n1875 avdd 2.7178
R5411 avdd.n1500 avdd 2.7178
R5412 avdd.n3690 avdd.n3689 2.6726
R5413 avdd.n1124 avdd.n1095 2.6726
R5414 avdd.n4177 avdd.n64 2.60375
R5415 avdd.n4176 avdd.n4119 2.60375
R5416 avdd.n4052 avdd.n121 2.60375
R5417 avdd.n3855 avdd.n3747 2.6005
R5418 avdd.n1058 avdd.n1056 2.5079
R5419 avdd.n3695 avdd.n3694 2.4197
R5420 avdd.n3701 avdd.n3699 2.4197
R5421 avdd.n3705 avdd.n3704 2.4197
R5422 avdd.n1103 avdd.n1070 2.4197
R5423 avdd.n1078 avdd.n1077 2.4197
R5424 avdd.n2042 avdd.n1039 2.4197
R5425 avdd.n4183 avdd.n4182 2.4005
R5426 avdd.n4182 avdd.n4181 2.4005
R5427 avdd.n4181 avdd.n4 2.4005
R5428 avdd.n4115 avdd.n4 2.4005
R5429 avdd.n4115 avdd.n4114 2.4005
R5430 avdd.n4114 avdd.n124 2.4005
R5431 avdd.n203 avdd.n124 2.4005
R5432 avdd.n204 avdd.n203 2.4005
R5433 avdd.n1894 avdd.n1066 2.4005
R5434 avdd.n1895 avdd.n1894 2.4005
R5435 avdd.n1896 avdd.n1895 2.4005
R5436 avdd.n1896 avdd.n226 2.4005
R5437 avdd.n3739 avdd.n226 2.4005
R5438 avdd.n3740 avdd.n3739 2.4005
R5439 avdd.n3740 avdd.n219 2.4005
R5440 avdd.n3973 avdd.n3747 2.3429
R5441 avdd.n4114 avdd.n4113 2.3005
R5442 avdd.n4116 avdd.n4115 2.3005
R5443 avdd.n6 avdd.n4 2.3005
R5444 avdd.n4181 avdd.n4180 2.3005
R5445 avdd.n3679 avdd.n3309 2.29077
R5446 avdd.n1502 avdd.n1500 2.29077
R5447 avdd.n3931 avdd.n185 2.283
R5448 avdd.n3721 avdd.n239 2.26231
R5449 avdd.n3725 avdd.n235 2.26231
R5450 avdd.n3729 avdd.n231 2.26231
R5451 avdd.n1122 avdd.n1093 2.26231
R5452 avdd.n1119 avdd.n1118 2.26231
R5453 avdd.n3735 avdd.n3733 2.26231
R5454 avdd.n3846 avdd.n3833 2.26231
R5455 avdd.n3842 avdd.n3837 2.26231
R5456 avdd.n3956 avdd.n3955 2.26231
R5457 avdd.n3942 avdd.n3941 2.26231
R5458 avdd.n245 avdd.n243 2.25074
R5459 avdd.n1118 avdd.n1117 2.25074
R5460 avdd.n3838 avdd.n3749 2.25074
R5461 avdd.n3941 avdd.n3940 2.25074
R5462 avdd.n2198 avdd.n2190 2.24986
R5463 avdd.n2194 avdd.n2193 2.24986
R5464 avdd.n2198 avdd.n2197 2.24986
R5465 avdd.n2196 avdd.n2193 2.24986
R5466 avdd.n2205 avdd.n2181 2.24986
R5467 avdd.n2185 avdd.n2184 2.24986
R5468 avdd.n2205 avdd.n2204 2.24986
R5469 avdd.n2187 avdd.n2184 2.24986
R5470 avdd.n302 avdd.n294 2.24986
R5471 avdd.n298 avdd.n297 2.24986
R5472 avdd.n302 avdd.n301 2.24986
R5473 avdd.n300 avdd.n297 2.24986
R5474 avdd.n309 avdd.n285 2.24986
R5475 avdd.n289 avdd.n288 2.24986
R5476 avdd.n309 avdd.n308 2.24986
R5477 avdd.n291 avdd.n288 2.24986
R5478 avdd.n677 avdd.n669 2.24986
R5479 avdd.n673 avdd.n672 2.24986
R5480 avdd.n677 avdd.n676 2.24986
R5481 avdd.n675 avdd.n672 2.24986
R5482 avdd.n684 avdd.n660 2.24986
R5483 avdd.n664 avdd.n663 2.24986
R5484 avdd.n684 avdd.n683 2.24986
R5485 avdd.n666 avdd.n663 2.24986
R5486 avdd.n2578 avdd.n2570 2.24986
R5487 avdd.n2574 avdd.n2573 2.24986
R5488 avdd.n2578 avdd.n2577 2.24986
R5489 avdd.n2576 avdd.n2573 2.24986
R5490 avdd.n2585 avdd.n2561 2.24986
R5491 avdd.n2565 avdd.n2564 2.24986
R5492 avdd.n2585 avdd.n2584 2.24986
R5493 avdd.n2567 avdd.n2564 2.24986
R5494 avdd.n2953 avdd.n2945 2.24986
R5495 avdd.n2949 avdd.n2948 2.24986
R5496 avdd.n2953 avdd.n2952 2.24986
R5497 avdd.n2951 avdd.n2948 2.24986
R5498 avdd.n2960 avdd.n2936 2.24986
R5499 avdd.n2940 avdd.n2939 2.24986
R5500 avdd.n2960 avdd.n2959 2.24986
R5501 avdd.n2942 avdd.n2939 2.24986
R5502 avdd.n3329 avdd.n3321 2.24986
R5503 avdd.n3325 avdd.n3324 2.24986
R5504 avdd.n3329 avdd.n3328 2.24986
R5505 avdd.n3327 avdd.n3324 2.24986
R5506 avdd.n3336 avdd.n3312 2.24986
R5507 avdd.n3316 avdd.n3315 2.24986
R5508 avdd.n3336 avdd.n3335 2.24986
R5509 avdd.n3318 avdd.n3315 2.24986
R5510 avdd.n1525 avdd.n1517 2.24986
R5511 avdd.n1521 avdd.n1520 2.24986
R5512 avdd.n1525 avdd.n1524 2.24986
R5513 avdd.n1523 avdd.n1520 2.24986
R5514 avdd.n1532 avdd.n1508 2.24986
R5515 avdd.n1512 avdd.n1511 2.24986
R5516 avdd.n1532 avdd.n1531 2.24986
R5517 avdd.n1514 avdd.n1511 2.24986
R5518 avdd.n1150 avdd.n1142 2.24986
R5519 avdd.n1146 avdd.n1145 2.24986
R5520 avdd.n1150 avdd.n1149 2.24986
R5521 avdd.n1148 avdd.n1145 2.24986
R5522 avdd.n1157 avdd.n1133 2.24986
R5523 avdd.n1137 avdd.n1136 2.24986
R5524 avdd.n1157 avdd.n1156 2.24986
R5525 avdd.n1139 avdd.n1136 2.24986
R5526 avdd.n3706 avdd.n3705 2.2479
R5527 avdd.n3710 avdd.n243 2.2479
R5528 avdd.n3717 avdd.n3716 2.2479
R5529 avdd.n3713 avdd.n3712 2.2479
R5530 avdd.n3702 avdd.n3701 2.2479
R5531 avdd.n2558 avdd.n277 2.2479
R5532 avdd.n280 avdd.n279 2.2479
R5533 avdd.n1034 avdd.n1029 2.2479
R5534 avdd.n2933 avdd.n273 2.2479
R5535 avdd.n3699 avdd.n251 2.2479
R5536 avdd.n1879 avdd.n1878 2.2479
R5537 avdd.n1083 avdd.n1082 2.2479
R5538 avdd.n2550 avdd.n2549 2.2479
R5539 avdd.n2176 avdd.n2174 2.2479
R5540 avdd.n1503 avdd.n1502 2.2479
R5541 avdd.n3307 avdd.n3305 2.2479
R5542 avdd.n3694 avdd.n256 2.2479
R5543 avdd.n1106 avdd.n1095 2.2479
R5544 avdd.n1104 avdd.n1103 2.2479
R5545 avdd.n1883 avdd.n1078 2.2479
R5546 avdd.n1075 avdd.n1039 2.2479
R5547 avdd.n2040 avdd.n2039 2.2479
R5548 avdd.n1130 avdd.n1089 2.2479
R5549 avdd.n3681 avdd.n3680 2.2479
R5550 avdd.n3689 avdd.n261 2.2479
R5551 avdd.n1116 avdd.n1096 2.2479
R5552 avdd.n1112 avdd.n1067 2.2479
R5553 avdd.n1890 avdd.n1888 2.2479
R5554 avdd.n1902 avdd.n1043 2.2479
R5555 avdd.n1906 avdd.n227 2.2479
R5556 avdd.n3920 avdd.n3919 2.2479
R5557 avdd.n3849 avdd.n3848 2.2479
R5558 avdd.n3964 avdd.n3754 2.2479
R5559 avdd.n3861 avdd.n3853 2.2479
R5560 avdd.n3971 avdd.n3749 2.2479
R5561 avdd.n3839 avdd.n3752 2.2479
R5562 avdd.n3962 avdd.n3815 2.2479
R5563 avdd.n3946 avdd.n3818 2.2479
R5564 avdd.n3940 avdd.n3939 2.2479
R5565 avdd.n3935 avdd.n3933 2.2479
R5566 avdd.n3928 avdd.n3926 2.2479
R5567 avdd.n2203 avdd.n2188 2.24741
R5568 avdd.n2200 avdd.n2192 2.24741
R5569 avdd.n2201 avdd.n2199 2.24741
R5570 avdd.n2210 avdd.n2179 2.24741
R5571 avdd.n2207 avdd.n2183 2.24741
R5572 avdd.n2208 avdd.n2206 2.24741
R5573 avdd.n307 avdd.n292 2.24741
R5574 avdd.n304 avdd.n296 2.24741
R5575 avdd.n305 avdd.n303 2.24741
R5576 avdd.n314 avdd.n283 2.24741
R5577 avdd.n311 avdd.n287 2.24741
R5578 avdd.n312 avdd.n310 2.24741
R5579 avdd.n682 avdd.n667 2.24741
R5580 avdd.n679 avdd.n671 2.24741
R5581 avdd.n680 avdd.n678 2.24741
R5582 avdd.n689 avdd.n658 2.24741
R5583 avdd.n686 avdd.n662 2.24741
R5584 avdd.n687 avdd.n685 2.24741
R5585 avdd.n2583 avdd.n2568 2.24741
R5586 avdd.n2580 avdd.n2572 2.24741
R5587 avdd.n2581 avdd.n2579 2.24741
R5588 avdd.n2590 avdd.n2559 2.24741
R5589 avdd.n2587 avdd.n2563 2.24741
R5590 avdd.n2588 avdd.n2586 2.24741
R5591 avdd.n2958 avdd.n2943 2.24741
R5592 avdd.n2955 avdd.n2947 2.24741
R5593 avdd.n2956 avdd.n2954 2.24741
R5594 avdd.n2965 avdd.n2934 2.24741
R5595 avdd.n2962 avdd.n2938 2.24741
R5596 avdd.n2963 avdd.n2961 2.24741
R5597 avdd.n3334 avdd.n3319 2.24741
R5598 avdd.n3331 avdd.n3323 2.24741
R5599 avdd.n3332 avdd.n3330 2.24741
R5600 avdd.n3341 avdd.n3310 2.24741
R5601 avdd.n3338 avdd.n3314 2.24741
R5602 avdd.n3339 avdd.n3337 2.24741
R5603 avdd.n1530 avdd.n1515 2.24741
R5604 avdd.n1527 avdd.n1519 2.24741
R5605 avdd.n1528 avdd.n1526 2.24741
R5606 avdd.n1537 avdd.n1506 2.24741
R5607 avdd.n1534 avdd.n1510 2.24741
R5608 avdd.n1535 avdd.n1533 2.24741
R5609 avdd.n1155 avdd.n1140 2.24741
R5610 avdd.n1152 avdd.n1144 2.24741
R5611 avdd.n1153 avdd.n1151 2.24741
R5612 avdd.n1162 avdd.n1131 2.24741
R5613 avdd.n1159 avdd.n1135 2.24741
R5614 avdd.n1160 avdd.n1158 2.24741
R5615 avdd.n3303 avdd.n2933 2.24578
R5616 avdd.n2928 avdd.n2558 2.24578
R5617 avdd.n1028 avdd.n1027 2.24578
R5618 avdd.n1878 avdd.n1875 2.24578
R5619 avdd.n2552 avdd.n652 2.24578
R5620 avdd.n2548 avdd.n2178 2.24578
R5621 avdd.n3709 avdd.n244 2.24405
R5622 avdd.n3715 avdd.n3714 2.24405
R5623 avdd.n3718 avdd.n241 2.24405
R5624 avdd.n3700 avdd.n247 2.24405
R5625 avdd.n250 avdd.n246 2.24405
R5626 avdd.n2557 avdd.n248 2.24405
R5627 avdd.n2555 avdd.n2554 2.24405
R5628 avdd.n1032 avdd.n1031 2.24405
R5629 avdd.n1033 avdd.n1030 2.24405
R5630 avdd.n3719 avdd.n239 2.24405
R5631 avdd.n3720 avdd.n240 2.24405
R5632 avdd.n2932 avdd.n255 2.24405
R5633 avdd.n275 avdd.n274 2.24405
R5634 avdd.n3698 avdd.n252 2.24405
R5635 avdd.n254 avdd.n253 2.24405
R5636 avdd.n1877 avdd.n276 2.24405
R5637 avdd.n1880 avdd.n1081 2.24405
R5638 avdd.n2553 avdd.n282 2.24405
R5639 avdd.n653 avdd.n281 2.24405
R5640 avdd.n2173 avdd.n1036 2.24405
R5641 avdd.n2175 avdd.n656 2.24405
R5642 avdd.n3723 avdd.n235 2.24405
R5643 avdd.n3724 avdd.n236 2.24405
R5644 avdd.n1501 avdd.n271 2.24405
R5645 avdd.n1088 avdd.n1085 2.24405
R5646 avdd.n3304 avdd.n260 2.24405
R5647 avdd.n3306 avdd.n270 2.24405
R5648 avdd.n3693 avdd.n257 2.24405
R5649 avdd.n259 avdd.n258 2.24405
R5650 avdd.n1101 avdd.n1086 2.24405
R5651 avdd.n1107 avdd.n1100 2.24405
R5652 avdd.n1881 avdd.n1080 2.24405
R5653 avdd.n1882 avdd.n1079 2.24405
R5654 avdd.n1072 avdd.n654 2.24405
R5655 avdd.n1074 avdd.n1071 2.24405
R5656 avdd.n2043 avdd.n1038 2.24405
R5657 avdd.n1040 avdd.n1037 2.24405
R5658 avdd.n3727 avdd.n231 2.24405
R5659 avdd.n3728 avdd.n232 2.24405
R5660 avdd.n1125 avdd.n1093 2.24405
R5661 avdd.n1094 avdd.n1092 2.24405
R5662 avdd.n1129 avdd.n268 2.24405
R5663 avdd.n1091 avdd.n1090 2.24405
R5664 avdd.n3684 avdd.n266 2.24405
R5665 avdd.n267 avdd.n265 2.24405
R5666 avdd.n3688 avdd.n262 2.24405
R5667 avdd.n264 avdd.n263 2.24405
R5668 avdd.n1120 avdd.n1119 2.24405
R5669 avdd.n1109 avdd.n1108 2.24405
R5670 avdd.n1111 avdd.n1099 2.24405
R5671 avdd.n1887 avdd.n1885 2.24405
R5672 avdd.n1889 avdd.n1068 2.24405
R5673 avdd.n1901 avdd.n1044 2.24405
R5674 avdd.n1046 avdd.n1045 2.24405
R5675 avdd.n1909 avdd.n1042 2.24405
R5676 avdd.n1904 avdd.n1041 2.24405
R5677 avdd.n3733 avdd.n3731 2.24405
R5678 avdd.n3734 avdd.n228 2.24405
R5679 avdd.n3923 avdd.n3831 2.24405
R5680 avdd.n3832 avdd.n3830 2.24405
R5681 avdd.n3851 avdd.n3850 2.24405
R5682 avdd.n3847 avdd.n3846 2.24405
R5683 avdd.n3966 avdd.n3965 2.24405
R5684 avdd.n3813 avdd.n3755 2.24405
R5685 avdd.n3860 avdd.n3826 2.24405
R5686 avdd.n3858 avdd.n3854 2.24405
R5687 avdd.n3970 avdd.n3969 2.24405
R5688 avdd.n3845 avdd.n3837 2.24405
R5689 avdd.n3840 avdd.n3836 2.24405
R5690 avdd.n3957 avdd.n3956 2.24405
R5691 avdd.n3952 avdd.n3951 2.24405
R5692 avdd.n3961 avdd.n3948 2.24405
R5693 avdd.n3950 avdd.n3949 2.24405
R5694 avdd.n3944 avdd.n3820 2.24405
R5695 avdd.n3945 avdd.n3819 2.24405
R5696 avdd.n3943 avdd.n3821 2.24405
R5697 avdd.n3932 avdd.n3825 2.24405
R5698 avdd.n3934 avdd.n3824 2.24405
R5699 avdd.n3925 avdd.n3829 2.24405
R5700 avdd.n3927 avdd.n3828 2.24405
R5701 avdd.n2525 avdd.n2524 2.2395
R5702 avdd.n2541 avdd.n2540 2.2395
R5703 avdd.n629 avdd.n628 2.2395
R5704 avdd.n645 avdd.n644 2.2395
R5705 avdd.n1004 avdd.n1003 2.2395
R5706 avdd.n1020 avdd.n1019 2.2395
R5707 avdd.n2905 avdd.n2904 2.2395
R5708 avdd.n2921 avdd.n2920 2.2395
R5709 avdd.n3280 avdd.n3279 2.2395
R5710 avdd.n3296 avdd.n3295 2.2395
R5711 avdd.n3656 avdd.n3655 2.2395
R5712 avdd.n3672 avdd.n3671 2.2395
R5713 avdd.n1852 avdd.n1851 2.2395
R5714 avdd.n1868 avdd.n1867 2.2395
R5715 avdd.n1477 avdd.n1476 2.2395
R5716 avdd.n1493 avdd.n1492 2.2395
R5717 avdd.n1058 avdd.n1057 2.2181
R5718 avdd.n4321 avdd.n4292 2.21557
R5719 avdd.n4321 avdd.n4320 2.21557
R5720 avdd.n4354 avdd.n4325 2.21557
R5721 avdd.n4354 avdd.n4353 2.21557
R5722 avdd.n4236 avdd.n4207 2.21557
R5723 avdd.n4236 avdd.n4235 2.21557
R5724 avdd.n4269 avdd.n4240 2.21557
R5725 avdd.n4269 avdd.n4268 2.21557
R5726 avdd.n208 avdd.n204 2.2055
R5727 avdd.n3844 avdd.n3839 2.0597
R5728 avdd.n4183 avdd.n1 2.02203
R5729 avdd.n4109 avdd 2.0139
R5730 avdd.n121 avdd 2.0139
R5731 avdd.n4176 avdd 2.0139
R5732 avdd.n64 avdd 2.0139
R5733 avdd.n3727 avdd.n3726 1.9957
R5734 avdd.n3723 avdd.n3722 1.9957
R5735 avdd.n2177 avdd.n2043 1.9957
R5736 avdd.n1036 avdd.n1035 1.9957
R5737 avdd.n2551 avdd.n654 1.9957
R5738 avdd.n2554 avdd.n2553 1.9957
R5739 avdd.n1881 avdd.n1880 1.9957
R5740 avdd.n2930 avdd.n276 1.9957
R5741 avdd.n1504 avdd.n1086 1.9957
R5742 avdd.n3308 avdd.n271 1.9957
R5743 avdd.n1127 avdd.n1125 1.9957
R5744 avdd.n3682 avdd.n268 1.9957
R5745 avdd.n1057 avdd.n1049 1.9628
R5746 avdd.n2546 avdd.n2503 1.9373
R5747 avdd.n650 avdd.n607 1.9373
R5748 avdd.n1025 avdd.n982 1.9373
R5749 avdd.n2926 avdd.n2883 1.9373
R5750 avdd.n3301 avdd.n3258 1.9373
R5751 avdd.n3677 avdd.n3634 1.9373
R5752 avdd.n1873 avdd.n1830 1.9373
R5753 avdd.n1498 avdd.n1455 1.9373
R5754 avdd avdd.n0 1.9343
R5755 avdd avdd.n4186 1.9167
R5756 avdd.n4024 avdd.n204 1.8205
R5757 avdd.n188 avdd.n124 1.8205
R5758 avdd.n4184 avdd.n4183 1.8205
R5759 avdd.n4182 avdd.n2 1.8205
R5760 avdd.n203 avdd.n202 1.8205
R5761 avdd.n1897 avdd.n1047 1.8005
R5762 avdd.n4186 avdd.n1 1.77785
R5763 avdd.n1048 avdd.n0 1.77785
R5764 avdd.n4285 avdd.n4284 1.72097
R5765 avdd.n4278 avdd.n4275 1.72097
R5766 avdd.n4199 avdd.n4198 1.72097
R5767 avdd.n4009 avdd.n207 1.7108
R5768 avdd.n4011 avdd.n4010 1.7108
R5769 avdd.n4013 avdd.n210 1.7108
R5770 avdd.n4008 avdd.n4007 1.7108
R5771 avdd.n4005 avdd.n211 1.7108
R5772 avdd.n218 avdd.n213 1.7108
R5773 avdd.n1116 avdd.n1115 1.6952
R5774 avdd.n3739 avdd.n3738 1.687
R5775 avdd.n1903 avdd.n226 1.687
R5776 avdd.n1897 avdd.n1896 1.687
R5777 avdd.n1895 avdd.n1047 1.687
R5778 avdd.n1894 avdd.n1893 1.687
R5779 avdd.n1115 avdd.n1066 1.687
R5780 avdd.n3993 avdd.n219 1.6797
R5781 avdd.n3746 avdd.n3740 1.6797
R5782 avdd.n1893 avdd.n1892 1.6529
R5783 avdd.n4046 avdd.n4045 1.6519
R5784 avdd.n4048 avdd.n126 1.6519
R5785 avdd.n1052 avdd.n1051 1.6519
R5786 avdd.n1060 avdd.n1053 1.6519
R5787 avdd.n1064 avdd.n1063 1.6519
R5788 avdd.n4051 avdd.n123 1.64217
R5789 avdd.n4118 avdd.n4117 1.64217
R5790 avdd.n4179 avdd.n4178 1.64217
R5791 avdd.n64 avdd.n5 1.6385
R5792 avdd.n150 avdd.n149 1.61615
R5793 avdd.n141 avdd.n137 1.61615
R5794 avdd.n4025 avdd.n185 1.6005
R5795 avdd.n4025 avdd.n4024 1.6005
R5796 avdd.n189 avdd.n128 1.6005
R5797 avdd.n189 avdd.n188 1.6005
R5798 avdd.n4184 avdd.n3 1.6005
R5799 avdd.n1056 avdd.n1055 1.6005
R5800 avdd.n1055 avdd.n2 1.6005
R5801 avdd.n3994 avdd.n3993 1.6005
R5802 avdd.n3975 avdd.n3746 1.6005
R5803 avdd.n3975 avdd.n3974 1.6005
R5804 avdd.n4041 avdd.n131 1.6005
R5805 avdd.n202 avdd.n131 1.6005
R5806 avdd.n3918 avdd 1.5714
R5807 avdd.n190 avdd.n189 1.4999
R5808 avdd.n191 avdd.n188 1.4999
R5809 avdd.n3919 avdd.n3918 1.48955
R5810 avdd.n3849 avdd.n3812 1.48955
R5811 avdd.n4315 avdd.n4314 1.4681
R5812 avdd.n4305 avdd.n4304 1.4681
R5813 avdd.n4348 avdd.n4347 1.4681
R5814 avdd.n4338 avdd.n4337 1.4681
R5815 avdd.n4230 avdd.n4229 1.4681
R5816 avdd.n4220 avdd.n4219 1.4681
R5817 avdd.n4263 avdd.n4262 1.4681
R5818 avdd.n4253 avdd.n4252 1.4681
R5819 avdd.n3812 avdd 1.4514
R5820 avdd.n2545 avdd.n2504 1.40235
R5821 avdd.n649 avdd.n608 1.40235
R5822 avdd.n1024 avdd.n983 1.40235
R5823 avdd.n2925 avdd.n2884 1.40235
R5824 avdd.n3300 avdd.n3259 1.40235
R5825 avdd.n3676 avdd.n3635 1.40235
R5826 avdd.n1872 avdd.n1831 1.40235
R5827 avdd.n1497 avdd.n1456 1.40235
R5828 avdd.n1050 avdd.n7 1.3805
R5829 avdd.n4049 avdd.n122 1.3805
R5830 avdd.n4050 avdd.n125 1.3805
R5831 avdd.n4179 avdd.n6 1.3805
R5832 avdd.n4117 avdd.n4116 1.3805
R5833 avdd.n4113 avdd.n123 1.3805
R5834 avdd.n177 avdd 1.3487
R5835 avdd.n2034 avdd.n2033 1.33893
R5836 avdd.n1937 avdd.n1933 1.33893
R5837 avdd.n2024 avdd.n2023 1.33893
R5838 avdd.n1991 avdd.n1987 1.33893
R5839 avdd.n2168 avdd.n2167 1.33893
R5840 avdd.n2071 avdd.n2067 1.33893
R5841 avdd.n2158 avdd.n2157 1.33893
R5842 avdd.n2125 avdd.n2121 1.33893
R5843 avdd.n3933 avdd.n3931 1.3226
R5844 avdd.n177 avdd.n128 1.3055
R5845 avdd.n4046 avdd.n125 1.3045
R5846 avdd.n4049 avdd.n4048 1.3045
R5847 avdd.n1051 avdd.n1050 1.3045
R5848 avdd.n1060 avdd.n1059 1.3045
R5849 avdd.n3921 avdd.n3851 1.2757
R5850 avdd.n3966 avdd.n3814 1.2757
R5851 avdd.n3948 avdd.n3947 1.2757
R5852 avdd.n3874 avdd.n3873 1.24621
R5853 avdd.n3892 avdd.n3891 1.24621
R5854 avdd.n3911 avdd.n3910 1.24621
R5855 avdd.n3768 avdd.n3767 1.24621
R5856 avdd.n3786 avdd.n3785 1.24621
R5857 avdd.n3805 avdd.n3804 1.24621
R5858 avdd.n4065 avdd.n4064 1.24621
R5859 avdd.n4083 avdd.n4082 1.24621
R5860 avdd.n4102 avdd.n4101 1.24621
R5861 avdd.n77 avdd.n76 1.24621
R5862 avdd.n95 avdd.n94 1.24621
R5863 avdd.n114 avdd.n113 1.24621
R5864 avdd.n4132 avdd.n4131 1.24621
R5865 avdd.n4150 avdd.n4149 1.24621
R5866 avdd.n4169 avdd.n4168 1.24621
R5867 avdd.n20 avdd.n19 1.24621
R5868 avdd.n38 avdd.n37 1.24621
R5869 avdd.n57 avdd.n56 1.24621
R5870 avdd.n4368 avdd.n4367 1.24621
R5871 avdd.n4113 avdd.n4112 1.2455
R5872 avdd.n2399 avdd.n2398 1.24194
R5873 avdd.n2273 avdd.n2269 1.24194
R5874 avdd.n2499 avdd.n2498 1.24194
R5875 avdd.n2474 avdd.n2473 1.24194
R5876 avdd.n503 avdd.n502 1.24194
R5877 avdd.n377 avdd.n373 1.24194
R5878 avdd.n603 avdd.n602 1.24194
R5879 avdd.n578 avdd.n577 1.24194
R5880 avdd.n878 avdd.n877 1.24194
R5881 avdd.n752 avdd.n748 1.24194
R5882 avdd.n978 avdd.n977 1.24194
R5883 avdd.n953 avdd.n952 1.24194
R5884 avdd.n2779 avdd.n2778 1.24194
R5885 avdd.n2653 avdd.n2649 1.24194
R5886 avdd.n2879 avdd.n2878 1.24194
R5887 avdd.n2854 avdd.n2853 1.24194
R5888 avdd.n3154 avdd.n3153 1.24194
R5889 avdd.n3028 avdd.n3024 1.24194
R5890 avdd.n3254 avdd.n3253 1.24194
R5891 avdd.n3229 avdd.n3228 1.24194
R5892 avdd.n3530 avdd.n3529 1.24194
R5893 avdd.n3404 avdd.n3400 1.24194
R5894 avdd.n3630 avdd.n3629 1.24194
R5895 avdd.n3605 avdd.n3604 1.24194
R5896 avdd.n1726 avdd.n1725 1.24194
R5897 avdd.n1600 avdd.n1596 1.24194
R5898 avdd.n1826 avdd.n1825 1.24194
R5899 avdd.n1801 avdd.n1800 1.24194
R5900 avdd.n1351 avdd.n1350 1.24194
R5901 avdd.n1225 avdd.n1221 1.24194
R5902 avdd.n1451 avdd.n1450 1.24194
R5903 avdd.n1426 avdd.n1425 1.24194
R5904 avdd.n2389 avdd.n2388 1.23564
R5905 avdd.n2379 avdd.n2355 1.23564
R5906 avdd.n2376 avdd.n2360 1.23564
R5907 avdd.n2364 avdd.n2361 1.23564
R5908 avdd.n2423 avdd.n2417 1.23564
R5909 avdd.n2432 avdd.n2416 1.23564
R5910 avdd.n2441 avdd.n2440 1.23564
R5911 avdd.n2410 avdd.n2409 1.23564
R5912 avdd.n493 avdd.n492 1.23564
R5913 avdd.n483 avdd.n459 1.23564
R5914 avdd.n480 avdd.n464 1.23564
R5915 avdd.n468 avdd.n465 1.23564
R5916 avdd.n527 avdd.n521 1.23564
R5917 avdd.n536 avdd.n520 1.23564
R5918 avdd.n545 avdd.n544 1.23564
R5919 avdd.n514 avdd.n513 1.23564
R5920 avdd.n868 avdd.n867 1.23564
R5921 avdd.n858 avdd.n834 1.23564
R5922 avdd.n855 avdd.n839 1.23564
R5923 avdd.n843 avdd.n840 1.23564
R5924 avdd.n902 avdd.n896 1.23564
R5925 avdd.n911 avdd.n895 1.23564
R5926 avdd.n920 avdd.n919 1.23564
R5927 avdd.n889 avdd.n888 1.23564
R5928 avdd.n2769 avdd.n2768 1.23564
R5929 avdd.n2759 avdd.n2735 1.23564
R5930 avdd.n2756 avdd.n2740 1.23564
R5931 avdd.n2744 avdd.n2741 1.23564
R5932 avdd.n2803 avdd.n2797 1.23564
R5933 avdd.n2812 avdd.n2796 1.23564
R5934 avdd.n2821 avdd.n2820 1.23564
R5935 avdd.n2790 avdd.n2789 1.23564
R5936 avdd.n3144 avdd.n3143 1.23564
R5937 avdd.n3134 avdd.n3110 1.23564
R5938 avdd.n3131 avdd.n3115 1.23564
R5939 avdd.n3119 avdd.n3116 1.23564
R5940 avdd.n3178 avdd.n3172 1.23564
R5941 avdd.n3187 avdd.n3171 1.23564
R5942 avdd.n3196 avdd.n3195 1.23564
R5943 avdd.n3165 avdd.n3164 1.23564
R5944 avdd.n3520 avdd.n3519 1.23564
R5945 avdd.n3510 avdd.n3486 1.23564
R5946 avdd.n3507 avdd.n3491 1.23564
R5947 avdd.n3495 avdd.n3492 1.23564
R5948 avdd.n3554 avdd.n3548 1.23564
R5949 avdd.n3563 avdd.n3547 1.23564
R5950 avdd.n3572 avdd.n3571 1.23564
R5951 avdd.n3541 avdd.n3540 1.23564
R5952 avdd.n1716 avdd.n1715 1.23564
R5953 avdd.n1706 avdd.n1682 1.23564
R5954 avdd.n1703 avdd.n1687 1.23564
R5955 avdd.n1691 avdd.n1688 1.23564
R5956 avdd.n1750 avdd.n1744 1.23564
R5957 avdd.n1759 avdd.n1743 1.23564
R5958 avdd.n1768 avdd.n1767 1.23564
R5959 avdd.n1737 avdd.n1736 1.23564
R5960 avdd.n1341 avdd.n1340 1.23564
R5961 avdd.n1331 avdd.n1307 1.23564
R5962 avdd.n1328 avdd.n1312 1.23564
R5963 avdd.n1316 avdd.n1313 1.23564
R5964 avdd.n1375 avdd.n1369 1.23564
R5965 avdd.n1384 avdd.n1368 1.23564
R5966 avdd.n1393 avdd.n1392 1.23564
R5967 avdd.n1362 avdd.n1361 1.23564
R5968 avdd.n1903 avdd.n1902 1.2173
R5969 avdd.n1908 avdd.n1903 1.2029
R5970 avdd.n175 avdd.n154 1.18713
R5971 avdd.n3716 avdd.n3710 1.1822
R5972 avdd.n1029 avdd.n238 1.1822
R5973 avdd.n3847 avdd.n3845 1.1469
R5974 avdd.n3969 avdd.n3968 1.1469
R5975 avdd.n3959 avdd.n3957 1.1469
R5976 avdd.n185 avdd.n183 1.1255
R5977 avdd.n4026 avdd.n4025 1.1255
R5978 avdd.n4024 avdd.n4023 1.1255
R5979 avdd.n4119 avdd.n4118 1.1255
R5980 avdd.n4052 avdd.n4051 1.1255
R5981 avdd.n4178 avdd.n4177 1.1255
R5982 avdd.n1051 avdd.n127 1.1255
R5983 avdd.n4048 avdd.n4047 1.1255
R5984 avdd.n1061 avdd.n1060 1.1255
R5985 avdd.n1054 avdd.n3 1.1255
R5986 avdd.n4185 avdd.n4184 1.1255
R5987 avdd.n1063 avdd.n1062 1.1255
R5988 avdd.n3995 avdd.n3994 1.1255
R5989 avdd.n3976 avdd.n3975 1.1255
R5990 avdd.n3974 avdd.n224 1.1255
R5991 avdd.n4043 avdd.n4042 1.1255
R5992 avdd.n4041 avdd.n4040 1.1255
R5993 avdd.n196 avdd.n131 1.1255
R5994 avdd.n202 avdd.n201 1.1255
R5995 avdd.n3746 avdd.n3745 1.1255
R5996 avdd.n3993 avdd.n3992 1.1255
R5997 avdd.n4044 avdd.n128 1.0965
R5998 avdd.n4042 avdd.n4041 1.0965
R5999 avdd.n1063 avdd.n1056 1.0741
R6000 avdd.n2520 avdd.n2518 1.0717
R6001 avdd.n624 avdd.n622 1.0717
R6002 avdd.n999 avdd.n997 1.0717
R6003 avdd.n2900 avdd.n2898 1.0717
R6004 avdd.n3275 avdd.n3273 1.0717
R6005 avdd.n3651 avdd.n3649 1.0717
R6006 avdd.n1847 avdd.n1845 1.0717
R6007 avdd.n1472 avdd.n1470 1.0717
R6008 avdd.n1065 avdd.n1049 1.06717
R6009 avdd.n1049 avdd.n1048 1.06717
R6010 avdd.n1048 avdd.n1 1.06717
R6011 avdd.n218 avdd.n211 1.06717
R6012 avdd.n4008 avdd.n211 1.06717
R6013 avdd.n4010 avdd.n4009 1.06717
R6014 avdd.n4009 avdd.n210 1.06717
R6015 avdd.n1059 avdd.n7 1.0205
R6016 avdd.n1050 avdd.n122 1.0205
R6017 avdd.n4050 avdd.n4049 1.0205
R6018 avdd.n4180 avdd.n4179 1.0205
R6019 avdd.n4117 avdd.n6 1.0205
R6020 avdd.n4116 avdd.n123 1.0205
R6021 avdd.n2172 avdd.n234 1.0058
R6022 avdd.n2038 avdd.n230 1.0058
R6023 avdd.n1115 avdd.n1114 0.9779
R6024 avdd.n2038 avdd 0.921
R6025 avdd.n2172 avdd 0.921
R6026 avdd.n1939 avdd.n1938 0.9005
R6027 avdd.n1993 avdd.n1992 0.9005
R6028 avdd.n1969 avdd.n1965 0.9005
R6029 avdd.n1915 avdd.n1911 0.9005
R6030 avdd.n2073 avdd.n2072 0.9005
R6031 avdd.n2127 avdd.n2126 0.9005
R6032 avdd.n2103 avdd.n2099 0.9005
R6033 avdd.n2049 avdd.n2045 0.9005
R6034 avdd.n2275 avdd.n2274 0.9005
R6035 avdd.n2368 avdd.n2362 0.9005
R6036 avdd.n2381 avdd.n2377 0.9005
R6037 avdd.n2381 avdd.n2380 0.9005
R6038 avdd.n2354 avdd.n2350 0.9005
R6039 avdd.n2215 avdd.n2211 0.9005
R6040 avdd.n2426 avdd.n2418 0.9005
R6041 avdd.n2434 avdd.n2406 0.9005
R6042 avdd.n2434 avdd.n2433 0.9005
R6043 avdd.n2407 avdd.n2403 0.9005
R6044 avdd.n2467 avdd.n2466 0.9005
R6045 avdd.n2451 avdd.n2447 0.9005
R6046 avdd.n379 avdd.n378 0.9005
R6047 avdd.n472 avdd.n466 0.9005
R6048 avdd.n485 avdd.n481 0.9005
R6049 avdd.n485 avdd.n484 0.9005
R6050 avdd.n458 avdd.n454 0.9005
R6051 avdd.n319 avdd.n315 0.9005
R6052 avdd.n530 avdd.n522 0.9005
R6053 avdd.n538 avdd.n510 0.9005
R6054 avdd.n538 avdd.n537 0.9005
R6055 avdd.n511 avdd.n507 0.9005
R6056 avdd.n571 avdd.n570 0.9005
R6057 avdd.n555 avdd.n551 0.9005
R6058 avdd.n754 avdd.n753 0.9005
R6059 avdd.n847 avdd.n841 0.9005
R6060 avdd.n860 avdd.n856 0.9005
R6061 avdd.n860 avdd.n859 0.9005
R6062 avdd.n833 avdd.n829 0.9005
R6063 avdd.n694 avdd.n690 0.9005
R6064 avdd.n905 avdd.n897 0.9005
R6065 avdd.n913 avdd.n885 0.9005
R6066 avdd.n913 avdd.n912 0.9005
R6067 avdd.n886 avdd.n882 0.9005
R6068 avdd.n946 avdd.n945 0.9005
R6069 avdd.n930 avdd.n926 0.9005
R6070 avdd.n2655 avdd.n2654 0.9005
R6071 avdd.n2748 avdd.n2742 0.9005
R6072 avdd.n2761 avdd.n2757 0.9005
R6073 avdd.n2761 avdd.n2760 0.9005
R6074 avdd.n2734 avdd.n2730 0.9005
R6075 avdd.n2595 avdd.n2591 0.9005
R6076 avdd.n2806 avdd.n2798 0.9005
R6077 avdd.n2814 avdd.n2786 0.9005
R6078 avdd.n2814 avdd.n2813 0.9005
R6079 avdd.n2787 avdd.n2783 0.9005
R6080 avdd.n2847 avdd.n2846 0.9005
R6081 avdd.n2831 avdd.n2827 0.9005
R6082 avdd.n3030 avdd.n3029 0.9005
R6083 avdd.n3123 avdd.n3117 0.9005
R6084 avdd.n3136 avdd.n3132 0.9005
R6085 avdd.n3136 avdd.n3135 0.9005
R6086 avdd.n3109 avdd.n3105 0.9005
R6087 avdd.n2970 avdd.n2966 0.9005
R6088 avdd.n3181 avdd.n3173 0.9005
R6089 avdd.n3189 avdd.n3161 0.9005
R6090 avdd.n3189 avdd.n3188 0.9005
R6091 avdd.n3162 avdd.n3158 0.9005
R6092 avdd.n3222 avdd.n3221 0.9005
R6093 avdd.n3206 avdd.n3202 0.9005
R6094 avdd.n3406 avdd.n3405 0.9005
R6095 avdd.n3499 avdd.n3493 0.9005
R6096 avdd.n3512 avdd.n3508 0.9005
R6097 avdd.n3512 avdd.n3511 0.9005
R6098 avdd.n3485 avdd.n3481 0.9005
R6099 avdd.n3346 avdd.n3342 0.9005
R6100 avdd.n3557 avdd.n3549 0.9005
R6101 avdd.n3565 avdd.n3537 0.9005
R6102 avdd.n3565 avdd.n3564 0.9005
R6103 avdd.n3538 avdd.n3534 0.9005
R6104 avdd.n3598 avdd.n3597 0.9005
R6105 avdd.n3582 avdd.n3578 0.9005
R6106 avdd.n1602 avdd.n1601 0.9005
R6107 avdd.n1695 avdd.n1689 0.9005
R6108 avdd.n1708 avdd.n1704 0.9005
R6109 avdd.n1708 avdd.n1707 0.9005
R6110 avdd.n1681 avdd.n1677 0.9005
R6111 avdd.n1542 avdd.n1538 0.9005
R6112 avdd.n1753 avdd.n1745 0.9005
R6113 avdd.n1761 avdd.n1733 0.9005
R6114 avdd.n1761 avdd.n1760 0.9005
R6115 avdd.n1734 avdd.n1730 0.9005
R6116 avdd.n1794 avdd.n1793 0.9005
R6117 avdd.n1778 avdd.n1774 0.9005
R6118 avdd.n1227 avdd.n1226 0.9005
R6119 avdd.n1320 avdd.n1314 0.9005
R6120 avdd.n1333 avdd.n1329 0.9005
R6121 avdd.n1333 avdd.n1332 0.9005
R6122 avdd.n1306 avdd.n1302 0.9005
R6123 avdd.n1167 avdd.n1163 0.9005
R6124 avdd.n1378 avdd.n1370 0.9005
R6125 avdd.n1386 avdd.n1358 0.9005
R6126 avdd.n1386 avdd.n1385 0.9005
R6127 avdd.n1359 avdd.n1355 0.9005
R6128 avdd.n1419 avdd.n1418 0.9005
R6129 avdd.n1403 avdd.n1399 0.9005
R6130 avdd.n3870 avdd.n3867 0.9005
R6131 avdd.n3865 avdd.n3863 0.9005
R6132 avdd.n3888 avdd.n3885 0.9005
R6133 avdd.n3883 avdd.n3881 0.9005
R6134 avdd.n3907 avdd.n3904 0.9005
R6135 avdd.n3902 avdd.n3900 0.9005
R6136 avdd.n3764 avdd.n3761 0.9005
R6137 avdd.n3759 avdd.n3757 0.9005
R6138 avdd.n3782 avdd.n3779 0.9005
R6139 avdd.n3777 avdd.n3775 0.9005
R6140 avdd.n3801 avdd.n3798 0.9005
R6141 avdd.n3796 avdd.n3794 0.9005
R6142 avdd.n4061 avdd.n4058 0.9005
R6143 avdd.n4056 avdd.n4054 0.9005
R6144 avdd.n4079 avdd.n4076 0.9005
R6145 avdd.n4074 avdd.n4072 0.9005
R6146 avdd.n4098 avdd.n4095 0.9005
R6147 avdd.n4093 avdd.n4091 0.9005
R6148 avdd.n73 avdd.n70 0.9005
R6149 avdd.n68 avdd.n66 0.9005
R6150 avdd.n91 avdd.n88 0.9005
R6151 avdd.n86 avdd.n84 0.9005
R6152 avdd.n110 avdd.n107 0.9005
R6153 avdd.n105 avdd.n103 0.9005
R6154 avdd.n4128 avdd.n4125 0.9005
R6155 avdd.n4123 avdd.n4121 0.9005
R6156 avdd.n4146 avdd.n4143 0.9005
R6157 avdd.n4141 avdd.n4139 0.9005
R6158 avdd.n4165 avdd.n4162 0.9005
R6159 avdd.n4160 avdd.n4158 0.9005
R6160 avdd.n16 avdd.n13 0.9005
R6161 avdd.n11 avdd.n9 0.9005
R6162 avdd.n34 avdd.n31 0.9005
R6163 avdd.n29 avdd.n27 0.9005
R6164 avdd.n53 avdd.n50 0.9005
R6165 avdd.n48 avdd.n46 0.9005
R6166 avdd.n4361 avdd.n4356 0.9005
R6167 avdd.n4363 avdd.n4359 0.9005
R6168 avdd.n165 avdd.n161 0.856478
R6169 avdd.n2028 avdd.n2027 0.818326
R6170 avdd.n2162 avdd.n2161 0.818326
R6171 avdd.n4297 avdd.n4290 0.788
R6172 avdd.n4303 avdd.n4302 0.788
R6173 avdd.n4330 avdd.n4323 0.788
R6174 avdd.n4336 avdd.n4335 0.788
R6175 avdd.n4212 avdd.n4205 0.788
R6176 avdd.n4218 avdd.n4217 0.788
R6177 avdd.n4245 avdd.n4238 0.788
R6178 avdd.n4251 avdd.n4250 0.788
R6179 avdd.n1893 avdd.n1067 0.7673
R6180 avdd.n3931 avdd.n3930 0.7376
R6181 avdd.n3731 avdd.n3730 0.7253
R6182 avdd.n2041 avdd.n1909 0.7253
R6183 avdd.n1076 avdd.n1044 0.7253
R6184 avdd.n1885 avdd.n1884 0.7253
R6185 avdd.n1108 avdd.n1107 0.7253
R6186 avdd.n1123 avdd.n1120 0.7253
R6187 avdd.n4111 avdd.n4110 0.713833
R6188 avdd.n210 avdd.n209 0.713833
R6189 avdd.n190 avdd.n187 0.7061
R6190 avdd.n194 avdd.n187 0.7061
R6191 avdd.n195 avdd.n194 0.7061
R6192 avdd.n197 avdd.n195 0.7061
R6193 avdd.n4036 avdd.n180 0.7061
R6194 avdd.n4036 avdd.n4035 0.7061
R6195 avdd.n4035 avdd.n181 0.7061
R6196 avdd.n4027 avdd.n181 0.7061
R6197 avdd.n4017 avdd.n184 0.7061
R6198 avdd.n4017 avdd.n4016 0.7061
R6199 avdd.n4016 avdd.n207 0.7061
R6200 avdd.n4039 avdd.n4038 0.7061
R6201 avdd.n4038 avdd.n178 0.7061
R6202 avdd.n4030 avdd.n178 0.7061
R6203 avdd.n4030 avdd.n4029 0.7061
R6204 avdd.n4020 avdd.n4019 0.7061
R6205 avdd.n4019 avdd.n206 0.7061
R6206 avdd.n4011 avdd.n206 0.7061
R6207 avdd.n192 avdd.n191 0.7061
R6208 avdd.n193 avdd.n192 0.7061
R6209 avdd.n193 avdd.n186 0.7061
R6210 avdd.n198 avdd.n186 0.7061
R6211 avdd.n200 avdd.n179 0.7061
R6212 avdd.n4033 avdd.n179 0.7061
R6213 avdd.n4033 avdd.n4032 0.7061
R6214 avdd.n4032 avdd.n182 0.7061
R6215 avdd.n4022 avdd.n205 0.7061
R6216 avdd.n4014 avdd.n205 0.7061
R6217 avdd.n4014 avdd.n4013 0.7061
R6218 avdd.n3980 avdd.n3979 0.7061
R6219 avdd.n3980 avdd.n221 0.7061
R6220 avdd.n3988 avdd.n221 0.7061
R6221 avdd.n3989 avdd.n3988 0.7061
R6222 avdd.n3999 avdd.n3998 0.7061
R6223 avdd.n3999 avdd.n212 0.7061
R6224 avdd.n4007 avdd.n212 0.7061
R6225 avdd.n3977 avdd.n222 0.7061
R6226 avdd.n3985 avdd.n222 0.7061
R6227 avdd.n3986 avdd.n3985 0.7061
R6228 avdd.n3986 avdd.n217 0.7061
R6229 avdd.n3996 avdd.n214 0.7061
R6230 avdd.n4004 avdd.n214 0.7061
R6231 avdd.n4005 avdd.n4004 0.7061
R6232 avdd.n3982 avdd.n223 0.7061
R6233 avdd.n3983 avdd.n3982 0.7061
R6234 avdd.n3983 avdd.n220 0.7061
R6235 avdd.n3991 avdd.n220 0.7061
R6236 avdd.n4001 avdd.n215 0.7061
R6237 avdd.n4002 avdd.n4001 0.7061
R6238 avdd.n4002 avdd.n213 0.7061
R6239 avdd.n143 avdd.n142 0.7005
R6240 avdd.n136 avdd.n132 0.7005
R6241 avdd.n3855 avdd.n130 0.6805
R6242 avdd.n4322 avdd.n4289 0.667685
R6243 avdd.n4237 avdd.n4204 0.667685
R6244 avdd.n3974 avdd.n3973 0.6581
R6245 avdd.n3738 avdd.n3737 0.6404
R6246 avdd.n4274 avdd.n4271 0.6305
R6247 avdd.n4280 avdd.n4279 0.6305
R6248 avdd.n4192 avdd.n4187 0.6305
R6249 avdd.n4194 avdd.n4190 0.6305
R6250 avdd.n4042 avdd.n130 0.6245
R6251 avdd.n2393 avdd.n2392 0.622674
R6252 avdd.n497 avdd.n496 0.622674
R6253 avdd.n872 avdd.n871 0.622674
R6254 avdd.n2773 avdd.n2772 0.622674
R6255 avdd.n3148 avdd.n3147 0.622674
R6256 avdd.n3524 avdd.n3523 0.622674
R6257 avdd.n1720 avdd.n1719 0.622674
R6258 avdd.n1345 avdd.n1344 0.622674
R6259 avdd.n3898 avdd.n3879 0.613685
R6260 avdd.n3792 avdd.n3773 0.613685
R6261 avdd.n4089 avdd.n4070 0.613685
R6262 avdd.n101 avdd.n82 0.613685
R6263 avdd.n4156 avdd.n4137 0.613685
R6264 avdd.n44 avdd.n25 0.613685
R6265 avdd.n2503 avdd.n2446 0.5801
R6266 avdd.n607 avdd.n550 0.5801
R6267 avdd.n982 avdd.n925 0.5801
R6268 avdd.n2883 avdd.n2826 0.5801
R6269 avdd.n3258 avdd.n3201 0.5801
R6270 avdd.n3634 avdd.n3577 0.5801
R6271 avdd.n1830 avdd.n1773 0.5801
R6272 avdd.n1455 avdd.n1398 0.5801
R6273 avdd.n3918 avdd.n3861 0.57065
R6274 avdd.n3967 avdd.n3812 0.57065
R6275 avdd.n3973 avdd.n3972 0.563
R6276 avdd.n3963 avdd.n3747 0.563
R6277 avdd.n3856 avdd.n3855 0.563
R6278 avdd.n3938 avdd.n130 0.563
R6279 avdd.n153 avdd.n132 0.561043
R6280 avdd.n4355 avdd.n4322 0.5549
R6281 avdd.n4270 avdd.n4237 0.5549
R6282 avdd.n4374 avdd.n4270 0.5549
R6283 avdd.n4374 avdd.n4355 0.5549
R6284 avdd.n3738 avdd.n227 0.5423
R6285 avdd.n1898 avdd.n1897 0.5279
R6286 avdd.n3917 avdd.n3898 0.5009
R6287 avdd.n3811 avdd.n3792 0.5009
R6288 avdd.n4108 avdd.n4089 0.5009
R6289 avdd.n120 avdd.n101 0.5009
R6290 avdd.n4175 avdd.n4156 0.5009
R6291 avdd.n63 avdd.n44 0.5009
R6292 avdd.n4112 avdd.n4111 0.5005
R6293 avdd.n209 avdd.n208 0.5005
R6294 avdd.n4027 avdd.n4026 0.4757
R6295 avdd.n4029 avdd.n183 0.4757
R6296 avdd.n4023 avdd.n182 0.4757
R6297 avdd.n3989 avdd.n216 0.4757
R6298 avdd.n3995 avdd.n217 0.4757
R6299 avdd.n3992 avdd.n3991 0.4757
R6300 avdd.n2027 avdd.n1965 0.454413
R6301 avdd.n2028 avdd.n1911 0.454413
R6302 avdd.n2037 avdd.n1911 0.454413
R6303 avdd.n2161 avdd.n2099 0.454413
R6304 avdd.n2162 avdd.n2045 0.454413
R6305 avdd.n2171 avdd.n2045 0.454413
R6306 avdd.n2392 avdd.n2350 0.454413
R6307 avdd.n2393 avdd.n2211 0.454413
R6308 avdd.n2402 avdd.n2211 0.454413
R6309 avdd.n2445 avdd.n2403 0.454413
R6310 avdd.n2502 avdd.n2447 0.454413
R6311 avdd.n496 avdd.n454 0.454413
R6312 avdd.n497 avdd.n315 0.454413
R6313 avdd.n506 avdd.n315 0.454413
R6314 avdd.n549 avdd.n507 0.454413
R6315 avdd.n606 avdd.n551 0.454413
R6316 avdd.n871 avdd.n829 0.454413
R6317 avdd.n872 avdd.n690 0.454413
R6318 avdd.n881 avdd.n690 0.454413
R6319 avdd.n924 avdd.n882 0.454413
R6320 avdd.n981 avdd.n926 0.454413
R6321 avdd.n2772 avdd.n2730 0.454413
R6322 avdd.n2773 avdd.n2591 0.454413
R6323 avdd.n2782 avdd.n2591 0.454413
R6324 avdd.n2825 avdd.n2783 0.454413
R6325 avdd.n2882 avdd.n2827 0.454413
R6326 avdd.n3147 avdd.n3105 0.454413
R6327 avdd.n3148 avdd.n2966 0.454413
R6328 avdd.n3157 avdd.n2966 0.454413
R6329 avdd.n3200 avdd.n3158 0.454413
R6330 avdd.n3257 avdd.n3202 0.454413
R6331 avdd.n3523 avdd.n3481 0.454413
R6332 avdd.n3524 avdd.n3342 0.454413
R6333 avdd.n3533 avdd.n3342 0.454413
R6334 avdd.n3576 avdd.n3534 0.454413
R6335 avdd.n3633 avdd.n3578 0.454413
R6336 avdd.n1719 avdd.n1677 0.454413
R6337 avdd.n1720 avdd.n1538 0.454413
R6338 avdd.n1729 avdd.n1538 0.454413
R6339 avdd.n1772 avdd.n1730 0.454413
R6340 avdd.n1829 avdd.n1774 0.454413
R6341 avdd.n1344 avdd.n1302 0.454413
R6342 avdd.n1345 avdd.n1163 0.454413
R6343 avdd.n1354 avdd.n1163 0.454413
R6344 avdd.n1397 avdd.n1355 0.454413
R6345 avdd.n1454 avdd.n1399 0.454413
R6346 avdd.n3857 avdd.n3856 0.4226
R6347 avdd.n3964 avdd.n3963 0.4226
R6348 avdd.n3972 avdd.n3971 0.4226
R6349 avdd.n3938 avdd.n3937 0.4226
R6350 avdd.n197 avdd.n196 0.4037
R6351 avdd.n201 avdd.n198 0.4037
R6352 avdd.n3742 avdd.n224 0.4037
R6353 avdd.n3976 avdd.n225 0.4037
R6354 avdd.n3745 avdd.n3744 0.4037
R6355 avdd.n4177 avdd.n4176 0.39725
R6356 avdd.n4119 avdd.n121 0.39725
R6357 avdd.n4109 avdd.n4052 0.39725
R6358 avdd.n3680 avdd.n3679 0.382325
R6359 avdd.n1500 avdd.n1130 0.382325
R6360 avdd.n3719 avdd.n3718 0.3157
R6361 avdd.n1032 avdd.n244 0.3157
R6362 avdd.n3703 avdd.n248 0.3157
R6363 avdd.n3696 avdd.n255 0.3157
R6364 avdd.n3691 avdd.n260 0.3157
R6365 avdd.n3686 avdd.n3684 0.3157
R6366 avdd.n3929 avdd.n3923 0.3157
R6367 avdd.n3936 avdd.n3826 0.3157
R6368 avdd.n3944 avdd.n3943 0.3157
R6369 avdd.n196 avdd.n180 0.3029
R6370 avdd.n4040 avdd.n4039 0.3029
R6371 avdd.n201 avdd.n200 0.3029
R6372 avdd.n3979 avdd.n224 0.3029
R6373 avdd.n3977 avdd.n3976 0.3029
R6374 avdd.n3745 avdd.n223 0.3029
R6375 avdd.n165 avdd.n164 0.274413
R6376 avdd.n158 avdd.n154 0.274413
R6377 avdd.n4280 avdd.n4272 0.269522
R6378 avdd.n4194 avdd.n4188 0.269522
R6379 avdd.n4026 avdd.n184 0.2309
R6380 avdd.n4020 avdd.n183 0.2309
R6381 avdd.n4023 avdd.n4022 0.2309
R6382 avdd.n3998 avdd.n216 0.2309
R6383 avdd.n3996 avdd.n3995 0.2309
R6384 avdd.n3992 avdd.n215 0.2309
R6385 avdd.n143 avdd.n139 0.230391
R6386 avdd.n2520 avdd.n2519 0.2255
R6387 avdd.n2508 avdd.n2504 0.2255
R6388 avdd.n624 avdd.n623 0.2255
R6389 avdd.n612 avdd.n608 0.2255
R6390 avdd.n999 avdd.n998 0.2255
R6391 avdd.n987 avdd.n983 0.2255
R6392 avdd.n2900 avdd.n2899 0.2255
R6393 avdd.n2888 avdd.n2884 0.2255
R6394 avdd.n3275 avdd.n3274 0.2255
R6395 avdd.n3263 avdd.n3259 0.2255
R6396 avdd.n3651 avdd.n3650 0.2255
R6397 avdd.n3639 avdd.n3635 0.2255
R6398 avdd.n1847 avdd.n1846 0.2255
R6399 avdd.n1835 avdd.n1831 0.2255
R6400 avdd.n1472 avdd.n1471 0.2255
R6401 avdd.n1460 avdd.n1456 0.2255
R6402 avdd avdd.n2547 0.214324
R6403 avdd avdd.n651 0.214324
R6404 avdd avdd.n1026 0.214324
R6405 avdd avdd.n2927 0.214324
R6406 avdd avdd.n3302 0.214324
R6407 avdd avdd.n3678 0.214324
R6408 avdd avdd.n1874 0.214324
R6409 avdd avdd.n1499 0.214324
R6410 avdd.n4186 avdd.n4185 0.18545
R6411 avdd.n1054 avdd.n0 0.18545
R6412 avdd.n2174 avdd.n2172 0.1769
R6413 avdd.n2039 avdd.n2038 0.1769
R6414 avdd.n3305 avdd.n3303 0.174425
R6415 avdd.n2929 avdd.n2928 0.174425
R6416 avdd.n1027 avdd.n280 0.174425
R6417 avdd.n1875 avdd.n1505 0.174425
R6418 avdd.n1082 avdd.n652 0.174425
R6419 avdd.n2549 avdd.n2548 0.174425
R6420 avdd.n4302 avdd.n4291 0.165826
R6421 avdd.n4335 avdd.n4324 0.165826
R6422 avdd.n4217 avdd.n4206 0.165826
R6423 avdd.n4250 avdd.n4239 0.165826
R6424 avdd.n4374 avdd.n4373 0.155722
R6425 avdd.n3856 avdd.n3818 0.1544
R6426 avdd.n3963 avdd.n3962 0.1544
R6427 avdd.n3972 avdd.n3748 0.1544
R6428 avdd.n3939 avdd.n3938 0.1544
R6429 avdd.n1946 avdd.n1932 0.1445
R6430 avdd.n1946 avdd.n1930 0.1445
R6431 avdd.n1950 avdd.n1930 0.1445
R6432 avdd.n1950 avdd.n1920 0.1445
R6433 avdd.n1962 avdd.n1920 0.1445
R6434 avdd.n1962 avdd.n1918 0.1445
R6435 avdd.n2030 avdd.n1918 0.1445
R6436 avdd.n1942 avdd.n1936 0.1445
R6437 avdd.n1942 avdd.n1926 0.1445
R6438 avdd.n1954 avdd.n1926 0.1445
R6439 avdd.n1954 avdd.n1924 0.1445
R6440 avdd.n1958 avdd.n1924 0.1445
R6441 avdd.n1958 avdd.n1913 0.1445
R6442 avdd.n2035 avdd.n1913 0.1445
R6443 avdd.n1941 avdd.n1940 0.1445
R6444 avdd.n1941 avdd.n1925 0.1445
R6445 avdd.n1955 avdd.n1925 0.1445
R6446 avdd.n1956 avdd.n1955 0.1445
R6447 avdd.n1957 avdd.n1956 0.1445
R6448 avdd.n1957 avdd.n1912 0.1445
R6449 avdd.n2036 avdd.n1912 0.1445
R6450 avdd.n1947 avdd.n1931 0.1445
R6451 avdd.n1948 avdd.n1947 0.1445
R6452 avdd.n1949 avdd.n1948 0.1445
R6453 avdd.n1949 avdd.n1919 0.1445
R6454 avdd.n1963 avdd.n1919 0.1445
R6455 avdd.n1964 avdd.n1963 0.1445
R6456 avdd.n2029 avdd.n1964 0.1445
R6457 avdd.n2000 avdd.n1986 0.1445
R6458 avdd.n2000 avdd.n1984 0.1445
R6459 avdd.n2004 avdd.n1984 0.1445
R6460 avdd.n2004 avdd.n1974 0.1445
R6461 avdd.n2016 avdd.n1974 0.1445
R6462 avdd.n2016 avdd.n1972 0.1445
R6463 avdd.n2020 avdd.n1972 0.1445
R6464 avdd.n1996 avdd.n1990 0.1445
R6465 avdd.n1996 avdd.n1980 0.1445
R6466 avdd.n2008 avdd.n1980 0.1445
R6467 avdd.n2008 avdd.n1978 0.1445
R6468 avdd.n2012 avdd.n1978 0.1445
R6469 avdd.n2012 avdd.n1967 0.1445
R6470 avdd.n2025 avdd.n1967 0.1445
R6471 avdd.n1995 avdd.n1994 0.1445
R6472 avdd.n1995 avdd.n1979 0.1445
R6473 avdd.n2009 avdd.n1979 0.1445
R6474 avdd.n2010 avdd.n2009 0.1445
R6475 avdd.n2011 avdd.n2010 0.1445
R6476 avdd.n2011 avdd.n1966 0.1445
R6477 avdd.n2026 avdd.n1966 0.1445
R6478 avdd.n2001 avdd.n1985 0.1445
R6479 avdd.n2002 avdd.n2001 0.1445
R6480 avdd.n2003 avdd.n2002 0.1445
R6481 avdd.n2003 avdd.n1973 0.1445
R6482 avdd.n2017 avdd.n1973 0.1445
R6483 avdd.n2018 avdd.n2017 0.1445
R6484 avdd.n2019 avdd.n2018 0.1445
R6485 avdd.n2080 avdd.n2066 0.1445
R6486 avdd.n2080 avdd.n2064 0.1445
R6487 avdd.n2084 avdd.n2064 0.1445
R6488 avdd.n2084 avdd.n2054 0.1445
R6489 avdd.n2096 avdd.n2054 0.1445
R6490 avdd.n2096 avdd.n2052 0.1445
R6491 avdd.n2164 avdd.n2052 0.1445
R6492 avdd.n2076 avdd.n2070 0.1445
R6493 avdd.n2076 avdd.n2060 0.1445
R6494 avdd.n2088 avdd.n2060 0.1445
R6495 avdd.n2088 avdd.n2058 0.1445
R6496 avdd.n2092 avdd.n2058 0.1445
R6497 avdd.n2092 avdd.n2047 0.1445
R6498 avdd.n2169 avdd.n2047 0.1445
R6499 avdd.n2075 avdd.n2074 0.1445
R6500 avdd.n2075 avdd.n2059 0.1445
R6501 avdd.n2089 avdd.n2059 0.1445
R6502 avdd.n2090 avdd.n2089 0.1445
R6503 avdd.n2091 avdd.n2090 0.1445
R6504 avdd.n2091 avdd.n2046 0.1445
R6505 avdd.n2170 avdd.n2046 0.1445
R6506 avdd.n2081 avdd.n2065 0.1445
R6507 avdd.n2082 avdd.n2081 0.1445
R6508 avdd.n2083 avdd.n2082 0.1445
R6509 avdd.n2083 avdd.n2053 0.1445
R6510 avdd.n2097 avdd.n2053 0.1445
R6511 avdd.n2098 avdd.n2097 0.1445
R6512 avdd.n2163 avdd.n2098 0.1445
R6513 avdd.n2134 avdd.n2120 0.1445
R6514 avdd.n2134 avdd.n2118 0.1445
R6515 avdd.n2138 avdd.n2118 0.1445
R6516 avdd.n2138 avdd.n2108 0.1445
R6517 avdd.n2150 avdd.n2108 0.1445
R6518 avdd.n2150 avdd.n2106 0.1445
R6519 avdd.n2154 avdd.n2106 0.1445
R6520 avdd.n2130 avdd.n2124 0.1445
R6521 avdd.n2130 avdd.n2114 0.1445
R6522 avdd.n2142 avdd.n2114 0.1445
R6523 avdd.n2142 avdd.n2112 0.1445
R6524 avdd.n2146 avdd.n2112 0.1445
R6525 avdd.n2146 avdd.n2101 0.1445
R6526 avdd.n2159 avdd.n2101 0.1445
R6527 avdd.n2129 avdd.n2128 0.1445
R6528 avdd.n2129 avdd.n2113 0.1445
R6529 avdd.n2143 avdd.n2113 0.1445
R6530 avdd.n2144 avdd.n2143 0.1445
R6531 avdd.n2145 avdd.n2144 0.1445
R6532 avdd.n2145 avdd.n2100 0.1445
R6533 avdd.n2160 avdd.n2100 0.1445
R6534 avdd.n2135 avdd.n2119 0.1445
R6535 avdd.n2136 avdd.n2135 0.1445
R6536 avdd.n2137 avdd.n2136 0.1445
R6537 avdd.n2137 avdd.n2107 0.1445
R6538 avdd.n2151 avdd.n2107 0.1445
R6539 avdd.n2152 avdd.n2151 0.1445
R6540 avdd.n2153 avdd.n2152 0.1445
R6541 avdd.n2283 avdd.n2268 0.1445
R6542 avdd.n2283 avdd.n2266 0.1445
R6543 avdd.n2287 avdd.n2266 0.1445
R6544 avdd.n2287 avdd.n2256 0.1445
R6545 avdd.n2299 avdd.n2256 0.1445
R6546 avdd.n2299 avdd.n2254 0.1445
R6547 avdd.n2303 avdd.n2254 0.1445
R6548 avdd.n2303 avdd.n2244 0.1445
R6549 avdd.n2315 avdd.n2244 0.1445
R6550 avdd.n2315 avdd.n2242 0.1445
R6551 avdd.n2319 avdd.n2242 0.1445
R6552 avdd.n2319 avdd.n2232 0.1445
R6553 avdd.n2331 avdd.n2232 0.1445
R6554 avdd.n2331 avdd.n2230 0.1445
R6555 avdd.n2335 avdd.n2230 0.1445
R6556 avdd.n2335 avdd.n2220 0.1445
R6557 avdd.n2347 avdd.n2220 0.1445
R6558 avdd.n2347 avdd.n2218 0.1445
R6559 avdd.n2395 avdd.n2218 0.1445
R6560 avdd.n2279 avdd.n2272 0.1445
R6561 avdd.n2279 avdd.n2262 0.1445
R6562 avdd.n2291 avdd.n2262 0.1445
R6563 avdd.n2291 avdd.n2260 0.1445
R6564 avdd.n2295 avdd.n2260 0.1445
R6565 avdd.n2295 avdd.n2250 0.1445
R6566 avdd.n2307 avdd.n2250 0.1445
R6567 avdd.n2307 avdd.n2248 0.1445
R6568 avdd.n2311 avdd.n2248 0.1445
R6569 avdd.n2311 avdd.n2238 0.1445
R6570 avdd.n2323 avdd.n2238 0.1445
R6571 avdd.n2323 avdd.n2236 0.1445
R6572 avdd.n2327 avdd.n2236 0.1445
R6573 avdd.n2327 avdd.n2226 0.1445
R6574 avdd.n2339 avdd.n2226 0.1445
R6575 avdd.n2339 avdd.n2224 0.1445
R6576 avdd.n2343 avdd.n2224 0.1445
R6577 avdd.n2343 avdd.n2213 0.1445
R6578 avdd.n2400 avdd.n2213 0.1445
R6579 avdd.n2278 avdd.n2277 0.1445
R6580 avdd.n2278 avdd.n2261 0.1445
R6581 avdd.n2292 avdd.n2261 0.1445
R6582 avdd.n2293 avdd.n2292 0.1445
R6583 avdd.n2294 avdd.n2293 0.1445
R6584 avdd.n2294 avdd.n2249 0.1445
R6585 avdd.n2308 avdd.n2249 0.1445
R6586 avdd.n2309 avdd.n2308 0.1445
R6587 avdd.n2310 avdd.n2309 0.1445
R6588 avdd.n2310 avdd.n2237 0.1445
R6589 avdd.n2324 avdd.n2237 0.1445
R6590 avdd.n2325 avdd.n2324 0.1445
R6591 avdd.n2326 avdd.n2325 0.1445
R6592 avdd.n2326 avdd.n2225 0.1445
R6593 avdd.n2340 avdd.n2225 0.1445
R6594 avdd.n2341 avdd.n2340 0.1445
R6595 avdd.n2342 avdd.n2341 0.1445
R6596 avdd.n2342 avdd.n2212 0.1445
R6597 avdd.n2401 avdd.n2212 0.1445
R6598 avdd.n2284 avdd.n2267 0.1445
R6599 avdd.n2285 avdd.n2284 0.1445
R6600 avdd.n2286 avdd.n2285 0.1445
R6601 avdd.n2286 avdd.n2255 0.1445
R6602 avdd.n2300 avdd.n2255 0.1445
R6603 avdd.n2301 avdd.n2300 0.1445
R6604 avdd.n2302 avdd.n2301 0.1445
R6605 avdd.n2302 avdd.n2243 0.1445
R6606 avdd.n2316 avdd.n2243 0.1445
R6607 avdd.n2317 avdd.n2316 0.1445
R6608 avdd.n2318 avdd.n2317 0.1445
R6609 avdd.n2318 avdd.n2231 0.1445
R6610 avdd.n2332 avdd.n2231 0.1445
R6611 avdd.n2333 avdd.n2332 0.1445
R6612 avdd.n2334 avdd.n2333 0.1445
R6613 avdd.n2334 avdd.n2219 0.1445
R6614 avdd.n2348 avdd.n2219 0.1445
R6615 avdd.n2349 avdd.n2348 0.1445
R6616 avdd.n2394 avdd.n2349 0.1445
R6617 avdd.n2385 avdd.n2356 0.1445
R6618 avdd.n2390 avdd.n2352 0.1445
R6619 avdd.n2391 avdd.n2351 0.1445
R6620 avdd.n2372 avdd.n2363 0.1445
R6621 avdd.n2366 avdd.n2365 0.1445
R6622 avdd.n2367 avdd.n2357 0.1445
R6623 avdd.n2371 avdd.n2370 0.1445
R6624 avdd.n2384 avdd.n2383 0.1445
R6625 avdd.n2428 avdd.n2419 0.1445
R6626 avdd.n2424 avdd.n2422 0.1445
R6627 avdd.n2425 avdd.n2413 0.1445
R6628 avdd.n2427 avdd.n2421 0.1445
R6629 avdd.n2437 avdd.n2411 0.1445
R6630 avdd.n2443 avdd.n2442 0.1445
R6631 avdd.n2444 avdd.n2404 0.1445
R6632 avdd.n2436 avdd.n2412 0.1445
R6633 avdd.n2475 avdd.n2465 0.1445
R6634 avdd.n2479 avdd.n2465 0.1445
R6635 avdd.n2479 avdd.n2456 0.1445
R6636 avdd.n2491 avdd.n2456 0.1445
R6637 avdd.n2491 avdd.n2454 0.1445
R6638 avdd.n2495 avdd.n2454 0.1445
R6639 avdd.n2470 avdd.n2461 0.1445
R6640 avdd.n2483 avdd.n2461 0.1445
R6641 avdd.n2483 avdd.n2459 0.1445
R6642 avdd.n2487 avdd.n2459 0.1445
R6643 avdd.n2487 avdd.n2449 0.1445
R6644 avdd.n2500 avdd.n2449 0.1445
R6645 avdd.n2469 avdd.n2460 0.1445
R6646 avdd.n2484 avdd.n2460 0.1445
R6647 avdd.n2485 avdd.n2484 0.1445
R6648 avdd.n2486 avdd.n2485 0.1445
R6649 avdd.n2486 avdd.n2448 0.1445
R6650 avdd.n2501 avdd.n2448 0.1445
R6651 avdd.n2477 avdd.n2476 0.1445
R6652 avdd.n2478 avdd.n2477 0.1445
R6653 avdd.n2478 avdd.n2455 0.1445
R6654 avdd.n2492 avdd.n2455 0.1445
R6655 avdd.n2493 avdd.n2492 0.1445
R6656 avdd.n2494 avdd.n2493 0.1445
R6657 avdd.n2522 avdd.n2513 0.1445
R6658 avdd.n2534 avdd.n2513 0.1445
R6659 avdd.n2534 avdd.n2511 0.1445
R6660 avdd.n2538 avdd.n2511 0.1445
R6661 avdd.n2527 avdd.n2517 0.1445
R6662 avdd.n2531 avdd.n2517 0.1445
R6663 avdd.n2531 avdd.n2506 0.1445
R6664 avdd.n2543 avdd.n2506 0.1445
R6665 avdd.n2529 avdd.n2528 0.1445
R6666 avdd.n2530 avdd.n2529 0.1445
R6667 avdd.n2530 avdd.n2505 0.1445
R6668 avdd.n2544 avdd.n2505 0.1445
R6669 avdd.n2521 avdd.n2512 0.1445
R6670 avdd.n2535 avdd.n2512 0.1445
R6671 avdd.n2536 avdd.n2535 0.1445
R6672 avdd.n2537 avdd.n2536 0.1445
R6673 avdd.n387 avdd.n372 0.1445
R6674 avdd.n387 avdd.n370 0.1445
R6675 avdd.n391 avdd.n370 0.1445
R6676 avdd.n391 avdd.n360 0.1445
R6677 avdd.n403 avdd.n360 0.1445
R6678 avdd.n403 avdd.n358 0.1445
R6679 avdd.n407 avdd.n358 0.1445
R6680 avdd.n407 avdd.n348 0.1445
R6681 avdd.n419 avdd.n348 0.1445
R6682 avdd.n419 avdd.n346 0.1445
R6683 avdd.n423 avdd.n346 0.1445
R6684 avdd.n423 avdd.n336 0.1445
R6685 avdd.n435 avdd.n336 0.1445
R6686 avdd.n435 avdd.n334 0.1445
R6687 avdd.n439 avdd.n334 0.1445
R6688 avdd.n439 avdd.n324 0.1445
R6689 avdd.n451 avdd.n324 0.1445
R6690 avdd.n451 avdd.n322 0.1445
R6691 avdd.n499 avdd.n322 0.1445
R6692 avdd.n383 avdd.n376 0.1445
R6693 avdd.n383 avdd.n366 0.1445
R6694 avdd.n395 avdd.n366 0.1445
R6695 avdd.n395 avdd.n364 0.1445
R6696 avdd.n399 avdd.n364 0.1445
R6697 avdd.n399 avdd.n354 0.1445
R6698 avdd.n411 avdd.n354 0.1445
R6699 avdd.n411 avdd.n352 0.1445
R6700 avdd.n415 avdd.n352 0.1445
R6701 avdd.n415 avdd.n342 0.1445
R6702 avdd.n427 avdd.n342 0.1445
R6703 avdd.n427 avdd.n340 0.1445
R6704 avdd.n431 avdd.n340 0.1445
R6705 avdd.n431 avdd.n330 0.1445
R6706 avdd.n443 avdd.n330 0.1445
R6707 avdd.n443 avdd.n328 0.1445
R6708 avdd.n447 avdd.n328 0.1445
R6709 avdd.n447 avdd.n317 0.1445
R6710 avdd.n504 avdd.n317 0.1445
R6711 avdd.n382 avdd.n381 0.1445
R6712 avdd.n382 avdd.n365 0.1445
R6713 avdd.n396 avdd.n365 0.1445
R6714 avdd.n397 avdd.n396 0.1445
R6715 avdd.n398 avdd.n397 0.1445
R6716 avdd.n398 avdd.n353 0.1445
R6717 avdd.n412 avdd.n353 0.1445
R6718 avdd.n413 avdd.n412 0.1445
R6719 avdd.n414 avdd.n413 0.1445
R6720 avdd.n414 avdd.n341 0.1445
R6721 avdd.n428 avdd.n341 0.1445
R6722 avdd.n429 avdd.n428 0.1445
R6723 avdd.n430 avdd.n429 0.1445
R6724 avdd.n430 avdd.n329 0.1445
R6725 avdd.n444 avdd.n329 0.1445
R6726 avdd.n445 avdd.n444 0.1445
R6727 avdd.n446 avdd.n445 0.1445
R6728 avdd.n446 avdd.n316 0.1445
R6729 avdd.n505 avdd.n316 0.1445
R6730 avdd.n388 avdd.n371 0.1445
R6731 avdd.n389 avdd.n388 0.1445
R6732 avdd.n390 avdd.n389 0.1445
R6733 avdd.n390 avdd.n359 0.1445
R6734 avdd.n404 avdd.n359 0.1445
R6735 avdd.n405 avdd.n404 0.1445
R6736 avdd.n406 avdd.n405 0.1445
R6737 avdd.n406 avdd.n347 0.1445
R6738 avdd.n420 avdd.n347 0.1445
R6739 avdd.n421 avdd.n420 0.1445
R6740 avdd.n422 avdd.n421 0.1445
R6741 avdd.n422 avdd.n335 0.1445
R6742 avdd.n436 avdd.n335 0.1445
R6743 avdd.n437 avdd.n436 0.1445
R6744 avdd.n438 avdd.n437 0.1445
R6745 avdd.n438 avdd.n323 0.1445
R6746 avdd.n452 avdd.n323 0.1445
R6747 avdd.n453 avdd.n452 0.1445
R6748 avdd.n498 avdd.n453 0.1445
R6749 avdd.n489 avdd.n460 0.1445
R6750 avdd.n494 avdd.n456 0.1445
R6751 avdd.n495 avdd.n455 0.1445
R6752 avdd.n476 avdd.n467 0.1445
R6753 avdd.n470 avdd.n469 0.1445
R6754 avdd.n471 avdd.n461 0.1445
R6755 avdd.n475 avdd.n474 0.1445
R6756 avdd.n488 avdd.n487 0.1445
R6757 avdd.n532 avdd.n523 0.1445
R6758 avdd.n528 avdd.n526 0.1445
R6759 avdd.n529 avdd.n517 0.1445
R6760 avdd.n531 avdd.n525 0.1445
R6761 avdd.n541 avdd.n515 0.1445
R6762 avdd.n547 avdd.n546 0.1445
R6763 avdd.n548 avdd.n508 0.1445
R6764 avdd.n540 avdd.n516 0.1445
R6765 avdd.n579 avdd.n569 0.1445
R6766 avdd.n583 avdd.n569 0.1445
R6767 avdd.n583 avdd.n560 0.1445
R6768 avdd.n595 avdd.n560 0.1445
R6769 avdd.n595 avdd.n558 0.1445
R6770 avdd.n599 avdd.n558 0.1445
R6771 avdd.n574 avdd.n565 0.1445
R6772 avdd.n587 avdd.n565 0.1445
R6773 avdd.n587 avdd.n563 0.1445
R6774 avdd.n591 avdd.n563 0.1445
R6775 avdd.n591 avdd.n553 0.1445
R6776 avdd.n604 avdd.n553 0.1445
R6777 avdd.n573 avdd.n564 0.1445
R6778 avdd.n588 avdd.n564 0.1445
R6779 avdd.n589 avdd.n588 0.1445
R6780 avdd.n590 avdd.n589 0.1445
R6781 avdd.n590 avdd.n552 0.1445
R6782 avdd.n605 avdd.n552 0.1445
R6783 avdd.n581 avdd.n580 0.1445
R6784 avdd.n582 avdd.n581 0.1445
R6785 avdd.n582 avdd.n559 0.1445
R6786 avdd.n596 avdd.n559 0.1445
R6787 avdd.n597 avdd.n596 0.1445
R6788 avdd.n598 avdd.n597 0.1445
R6789 avdd.n626 avdd.n617 0.1445
R6790 avdd.n638 avdd.n617 0.1445
R6791 avdd.n638 avdd.n615 0.1445
R6792 avdd.n642 avdd.n615 0.1445
R6793 avdd.n631 avdd.n621 0.1445
R6794 avdd.n635 avdd.n621 0.1445
R6795 avdd.n635 avdd.n610 0.1445
R6796 avdd.n647 avdd.n610 0.1445
R6797 avdd.n633 avdd.n632 0.1445
R6798 avdd.n634 avdd.n633 0.1445
R6799 avdd.n634 avdd.n609 0.1445
R6800 avdd.n648 avdd.n609 0.1445
R6801 avdd.n625 avdd.n616 0.1445
R6802 avdd.n639 avdd.n616 0.1445
R6803 avdd.n640 avdd.n639 0.1445
R6804 avdd.n641 avdd.n640 0.1445
R6805 avdd.n762 avdd.n747 0.1445
R6806 avdd.n762 avdd.n745 0.1445
R6807 avdd.n766 avdd.n745 0.1445
R6808 avdd.n766 avdd.n735 0.1445
R6809 avdd.n778 avdd.n735 0.1445
R6810 avdd.n778 avdd.n733 0.1445
R6811 avdd.n782 avdd.n733 0.1445
R6812 avdd.n782 avdd.n723 0.1445
R6813 avdd.n794 avdd.n723 0.1445
R6814 avdd.n794 avdd.n721 0.1445
R6815 avdd.n798 avdd.n721 0.1445
R6816 avdd.n798 avdd.n711 0.1445
R6817 avdd.n810 avdd.n711 0.1445
R6818 avdd.n810 avdd.n709 0.1445
R6819 avdd.n814 avdd.n709 0.1445
R6820 avdd.n814 avdd.n699 0.1445
R6821 avdd.n826 avdd.n699 0.1445
R6822 avdd.n826 avdd.n697 0.1445
R6823 avdd.n874 avdd.n697 0.1445
R6824 avdd.n758 avdd.n751 0.1445
R6825 avdd.n758 avdd.n741 0.1445
R6826 avdd.n770 avdd.n741 0.1445
R6827 avdd.n770 avdd.n739 0.1445
R6828 avdd.n774 avdd.n739 0.1445
R6829 avdd.n774 avdd.n729 0.1445
R6830 avdd.n786 avdd.n729 0.1445
R6831 avdd.n786 avdd.n727 0.1445
R6832 avdd.n790 avdd.n727 0.1445
R6833 avdd.n790 avdd.n717 0.1445
R6834 avdd.n802 avdd.n717 0.1445
R6835 avdd.n802 avdd.n715 0.1445
R6836 avdd.n806 avdd.n715 0.1445
R6837 avdd.n806 avdd.n705 0.1445
R6838 avdd.n818 avdd.n705 0.1445
R6839 avdd.n818 avdd.n703 0.1445
R6840 avdd.n822 avdd.n703 0.1445
R6841 avdd.n822 avdd.n692 0.1445
R6842 avdd.n879 avdd.n692 0.1445
R6843 avdd.n757 avdd.n756 0.1445
R6844 avdd.n757 avdd.n740 0.1445
R6845 avdd.n771 avdd.n740 0.1445
R6846 avdd.n772 avdd.n771 0.1445
R6847 avdd.n773 avdd.n772 0.1445
R6848 avdd.n773 avdd.n728 0.1445
R6849 avdd.n787 avdd.n728 0.1445
R6850 avdd.n788 avdd.n787 0.1445
R6851 avdd.n789 avdd.n788 0.1445
R6852 avdd.n789 avdd.n716 0.1445
R6853 avdd.n803 avdd.n716 0.1445
R6854 avdd.n804 avdd.n803 0.1445
R6855 avdd.n805 avdd.n804 0.1445
R6856 avdd.n805 avdd.n704 0.1445
R6857 avdd.n819 avdd.n704 0.1445
R6858 avdd.n820 avdd.n819 0.1445
R6859 avdd.n821 avdd.n820 0.1445
R6860 avdd.n821 avdd.n691 0.1445
R6861 avdd.n880 avdd.n691 0.1445
R6862 avdd.n763 avdd.n746 0.1445
R6863 avdd.n764 avdd.n763 0.1445
R6864 avdd.n765 avdd.n764 0.1445
R6865 avdd.n765 avdd.n734 0.1445
R6866 avdd.n779 avdd.n734 0.1445
R6867 avdd.n780 avdd.n779 0.1445
R6868 avdd.n781 avdd.n780 0.1445
R6869 avdd.n781 avdd.n722 0.1445
R6870 avdd.n795 avdd.n722 0.1445
R6871 avdd.n796 avdd.n795 0.1445
R6872 avdd.n797 avdd.n796 0.1445
R6873 avdd.n797 avdd.n710 0.1445
R6874 avdd.n811 avdd.n710 0.1445
R6875 avdd.n812 avdd.n811 0.1445
R6876 avdd.n813 avdd.n812 0.1445
R6877 avdd.n813 avdd.n698 0.1445
R6878 avdd.n827 avdd.n698 0.1445
R6879 avdd.n828 avdd.n827 0.1445
R6880 avdd.n873 avdd.n828 0.1445
R6881 avdd.n864 avdd.n835 0.1445
R6882 avdd.n869 avdd.n831 0.1445
R6883 avdd.n870 avdd.n830 0.1445
R6884 avdd.n851 avdd.n842 0.1445
R6885 avdd.n845 avdd.n844 0.1445
R6886 avdd.n846 avdd.n836 0.1445
R6887 avdd.n850 avdd.n849 0.1445
R6888 avdd.n863 avdd.n862 0.1445
R6889 avdd.n907 avdd.n898 0.1445
R6890 avdd.n903 avdd.n901 0.1445
R6891 avdd.n904 avdd.n892 0.1445
R6892 avdd.n906 avdd.n900 0.1445
R6893 avdd.n916 avdd.n890 0.1445
R6894 avdd.n922 avdd.n921 0.1445
R6895 avdd.n923 avdd.n883 0.1445
R6896 avdd.n915 avdd.n891 0.1445
R6897 avdd.n954 avdd.n944 0.1445
R6898 avdd.n958 avdd.n944 0.1445
R6899 avdd.n958 avdd.n935 0.1445
R6900 avdd.n970 avdd.n935 0.1445
R6901 avdd.n970 avdd.n933 0.1445
R6902 avdd.n974 avdd.n933 0.1445
R6903 avdd.n949 avdd.n940 0.1445
R6904 avdd.n962 avdd.n940 0.1445
R6905 avdd.n962 avdd.n938 0.1445
R6906 avdd.n966 avdd.n938 0.1445
R6907 avdd.n966 avdd.n928 0.1445
R6908 avdd.n979 avdd.n928 0.1445
R6909 avdd.n948 avdd.n939 0.1445
R6910 avdd.n963 avdd.n939 0.1445
R6911 avdd.n964 avdd.n963 0.1445
R6912 avdd.n965 avdd.n964 0.1445
R6913 avdd.n965 avdd.n927 0.1445
R6914 avdd.n980 avdd.n927 0.1445
R6915 avdd.n956 avdd.n955 0.1445
R6916 avdd.n957 avdd.n956 0.1445
R6917 avdd.n957 avdd.n934 0.1445
R6918 avdd.n971 avdd.n934 0.1445
R6919 avdd.n972 avdd.n971 0.1445
R6920 avdd.n973 avdd.n972 0.1445
R6921 avdd.n1001 avdd.n992 0.1445
R6922 avdd.n1013 avdd.n992 0.1445
R6923 avdd.n1013 avdd.n990 0.1445
R6924 avdd.n1017 avdd.n990 0.1445
R6925 avdd.n1006 avdd.n996 0.1445
R6926 avdd.n1010 avdd.n996 0.1445
R6927 avdd.n1010 avdd.n985 0.1445
R6928 avdd.n1022 avdd.n985 0.1445
R6929 avdd.n1008 avdd.n1007 0.1445
R6930 avdd.n1009 avdd.n1008 0.1445
R6931 avdd.n1009 avdd.n984 0.1445
R6932 avdd.n1023 avdd.n984 0.1445
R6933 avdd.n1000 avdd.n991 0.1445
R6934 avdd.n1014 avdd.n991 0.1445
R6935 avdd.n1015 avdd.n1014 0.1445
R6936 avdd.n1016 avdd.n1015 0.1445
R6937 avdd.n2663 avdd.n2648 0.1445
R6938 avdd.n2663 avdd.n2646 0.1445
R6939 avdd.n2667 avdd.n2646 0.1445
R6940 avdd.n2667 avdd.n2636 0.1445
R6941 avdd.n2679 avdd.n2636 0.1445
R6942 avdd.n2679 avdd.n2634 0.1445
R6943 avdd.n2683 avdd.n2634 0.1445
R6944 avdd.n2683 avdd.n2624 0.1445
R6945 avdd.n2695 avdd.n2624 0.1445
R6946 avdd.n2695 avdd.n2622 0.1445
R6947 avdd.n2699 avdd.n2622 0.1445
R6948 avdd.n2699 avdd.n2612 0.1445
R6949 avdd.n2711 avdd.n2612 0.1445
R6950 avdd.n2711 avdd.n2610 0.1445
R6951 avdd.n2715 avdd.n2610 0.1445
R6952 avdd.n2715 avdd.n2600 0.1445
R6953 avdd.n2727 avdd.n2600 0.1445
R6954 avdd.n2727 avdd.n2598 0.1445
R6955 avdd.n2775 avdd.n2598 0.1445
R6956 avdd.n2659 avdd.n2652 0.1445
R6957 avdd.n2659 avdd.n2642 0.1445
R6958 avdd.n2671 avdd.n2642 0.1445
R6959 avdd.n2671 avdd.n2640 0.1445
R6960 avdd.n2675 avdd.n2640 0.1445
R6961 avdd.n2675 avdd.n2630 0.1445
R6962 avdd.n2687 avdd.n2630 0.1445
R6963 avdd.n2687 avdd.n2628 0.1445
R6964 avdd.n2691 avdd.n2628 0.1445
R6965 avdd.n2691 avdd.n2618 0.1445
R6966 avdd.n2703 avdd.n2618 0.1445
R6967 avdd.n2703 avdd.n2616 0.1445
R6968 avdd.n2707 avdd.n2616 0.1445
R6969 avdd.n2707 avdd.n2606 0.1445
R6970 avdd.n2719 avdd.n2606 0.1445
R6971 avdd.n2719 avdd.n2604 0.1445
R6972 avdd.n2723 avdd.n2604 0.1445
R6973 avdd.n2723 avdd.n2593 0.1445
R6974 avdd.n2780 avdd.n2593 0.1445
R6975 avdd.n2658 avdd.n2657 0.1445
R6976 avdd.n2658 avdd.n2641 0.1445
R6977 avdd.n2672 avdd.n2641 0.1445
R6978 avdd.n2673 avdd.n2672 0.1445
R6979 avdd.n2674 avdd.n2673 0.1445
R6980 avdd.n2674 avdd.n2629 0.1445
R6981 avdd.n2688 avdd.n2629 0.1445
R6982 avdd.n2689 avdd.n2688 0.1445
R6983 avdd.n2690 avdd.n2689 0.1445
R6984 avdd.n2690 avdd.n2617 0.1445
R6985 avdd.n2704 avdd.n2617 0.1445
R6986 avdd.n2705 avdd.n2704 0.1445
R6987 avdd.n2706 avdd.n2705 0.1445
R6988 avdd.n2706 avdd.n2605 0.1445
R6989 avdd.n2720 avdd.n2605 0.1445
R6990 avdd.n2721 avdd.n2720 0.1445
R6991 avdd.n2722 avdd.n2721 0.1445
R6992 avdd.n2722 avdd.n2592 0.1445
R6993 avdd.n2781 avdd.n2592 0.1445
R6994 avdd.n2664 avdd.n2647 0.1445
R6995 avdd.n2665 avdd.n2664 0.1445
R6996 avdd.n2666 avdd.n2665 0.1445
R6997 avdd.n2666 avdd.n2635 0.1445
R6998 avdd.n2680 avdd.n2635 0.1445
R6999 avdd.n2681 avdd.n2680 0.1445
R7000 avdd.n2682 avdd.n2681 0.1445
R7001 avdd.n2682 avdd.n2623 0.1445
R7002 avdd.n2696 avdd.n2623 0.1445
R7003 avdd.n2697 avdd.n2696 0.1445
R7004 avdd.n2698 avdd.n2697 0.1445
R7005 avdd.n2698 avdd.n2611 0.1445
R7006 avdd.n2712 avdd.n2611 0.1445
R7007 avdd.n2713 avdd.n2712 0.1445
R7008 avdd.n2714 avdd.n2713 0.1445
R7009 avdd.n2714 avdd.n2599 0.1445
R7010 avdd.n2728 avdd.n2599 0.1445
R7011 avdd.n2729 avdd.n2728 0.1445
R7012 avdd.n2774 avdd.n2729 0.1445
R7013 avdd.n2765 avdd.n2736 0.1445
R7014 avdd.n2770 avdd.n2732 0.1445
R7015 avdd.n2771 avdd.n2731 0.1445
R7016 avdd.n2752 avdd.n2743 0.1445
R7017 avdd.n2746 avdd.n2745 0.1445
R7018 avdd.n2747 avdd.n2737 0.1445
R7019 avdd.n2751 avdd.n2750 0.1445
R7020 avdd.n2764 avdd.n2763 0.1445
R7021 avdd.n2808 avdd.n2799 0.1445
R7022 avdd.n2804 avdd.n2802 0.1445
R7023 avdd.n2805 avdd.n2793 0.1445
R7024 avdd.n2807 avdd.n2801 0.1445
R7025 avdd.n2817 avdd.n2791 0.1445
R7026 avdd.n2823 avdd.n2822 0.1445
R7027 avdd.n2824 avdd.n2784 0.1445
R7028 avdd.n2816 avdd.n2792 0.1445
R7029 avdd.n2855 avdd.n2845 0.1445
R7030 avdd.n2859 avdd.n2845 0.1445
R7031 avdd.n2859 avdd.n2836 0.1445
R7032 avdd.n2871 avdd.n2836 0.1445
R7033 avdd.n2871 avdd.n2834 0.1445
R7034 avdd.n2875 avdd.n2834 0.1445
R7035 avdd.n2850 avdd.n2841 0.1445
R7036 avdd.n2863 avdd.n2841 0.1445
R7037 avdd.n2863 avdd.n2839 0.1445
R7038 avdd.n2867 avdd.n2839 0.1445
R7039 avdd.n2867 avdd.n2829 0.1445
R7040 avdd.n2880 avdd.n2829 0.1445
R7041 avdd.n2849 avdd.n2840 0.1445
R7042 avdd.n2864 avdd.n2840 0.1445
R7043 avdd.n2865 avdd.n2864 0.1445
R7044 avdd.n2866 avdd.n2865 0.1445
R7045 avdd.n2866 avdd.n2828 0.1445
R7046 avdd.n2881 avdd.n2828 0.1445
R7047 avdd.n2857 avdd.n2856 0.1445
R7048 avdd.n2858 avdd.n2857 0.1445
R7049 avdd.n2858 avdd.n2835 0.1445
R7050 avdd.n2872 avdd.n2835 0.1445
R7051 avdd.n2873 avdd.n2872 0.1445
R7052 avdd.n2874 avdd.n2873 0.1445
R7053 avdd.n2902 avdd.n2893 0.1445
R7054 avdd.n2914 avdd.n2893 0.1445
R7055 avdd.n2914 avdd.n2891 0.1445
R7056 avdd.n2918 avdd.n2891 0.1445
R7057 avdd.n2907 avdd.n2897 0.1445
R7058 avdd.n2911 avdd.n2897 0.1445
R7059 avdd.n2911 avdd.n2886 0.1445
R7060 avdd.n2923 avdd.n2886 0.1445
R7061 avdd.n2909 avdd.n2908 0.1445
R7062 avdd.n2910 avdd.n2909 0.1445
R7063 avdd.n2910 avdd.n2885 0.1445
R7064 avdd.n2924 avdd.n2885 0.1445
R7065 avdd.n2901 avdd.n2892 0.1445
R7066 avdd.n2915 avdd.n2892 0.1445
R7067 avdd.n2916 avdd.n2915 0.1445
R7068 avdd.n2917 avdd.n2916 0.1445
R7069 avdd.n3038 avdd.n3023 0.1445
R7070 avdd.n3038 avdd.n3021 0.1445
R7071 avdd.n3042 avdd.n3021 0.1445
R7072 avdd.n3042 avdd.n3011 0.1445
R7073 avdd.n3054 avdd.n3011 0.1445
R7074 avdd.n3054 avdd.n3009 0.1445
R7075 avdd.n3058 avdd.n3009 0.1445
R7076 avdd.n3058 avdd.n2999 0.1445
R7077 avdd.n3070 avdd.n2999 0.1445
R7078 avdd.n3070 avdd.n2997 0.1445
R7079 avdd.n3074 avdd.n2997 0.1445
R7080 avdd.n3074 avdd.n2987 0.1445
R7081 avdd.n3086 avdd.n2987 0.1445
R7082 avdd.n3086 avdd.n2985 0.1445
R7083 avdd.n3090 avdd.n2985 0.1445
R7084 avdd.n3090 avdd.n2975 0.1445
R7085 avdd.n3102 avdd.n2975 0.1445
R7086 avdd.n3102 avdd.n2973 0.1445
R7087 avdd.n3150 avdd.n2973 0.1445
R7088 avdd.n3034 avdd.n3027 0.1445
R7089 avdd.n3034 avdd.n3017 0.1445
R7090 avdd.n3046 avdd.n3017 0.1445
R7091 avdd.n3046 avdd.n3015 0.1445
R7092 avdd.n3050 avdd.n3015 0.1445
R7093 avdd.n3050 avdd.n3005 0.1445
R7094 avdd.n3062 avdd.n3005 0.1445
R7095 avdd.n3062 avdd.n3003 0.1445
R7096 avdd.n3066 avdd.n3003 0.1445
R7097 avdd.n3066 avdd.n2993 0.1445
R7098 avdd.n3078 avdd.n2993 0.1445
R7099 avdd.n3078 avdd.n2991 0.1445
R7100 avdd.n3082 avdd.n2991 0.1445
R7101 avdd.n3082 avdd.n2981 0.1445
R7102 avdd.n3094 avdd.n2981 0.1445
R7103 avdd.n3094 avdd.n2979 0.1445
R7104 avdd.n3098 avdd.n2979 0.1445
R7105 avdd.n3098 avdd.n2968 0.1445
R7106 avdd.n3155 avdd.n2968 0.1445
R7107 avdd.n3033 avdd.n3032 0.1445
R7108 avdd.n3033 avdd.n3016 0.1445
R7109 avdd.n3047 avdd.n3016 0.1445
R7110 avdd.n3048 avdd.n3047 0.1445
R7111 avdd.n3049 avdd.n3048 0.1445
R7112 avdd.n3049 avdd.n3004 0.1445
R7113 avdd.n3063 avdd.n3004 0.1445
R7114 avdd.n3064 avdd.n3063 0.1445
R7115 avdd.n3065 avdd.n3064 0.1445
R7116 avdd.n3065 avdd.n2992 0.1445
R7117 avdd.n3079 avdd.n2992 0.1445
R7118 avdd.n3080 avdd.n3079 0.1445
R7119 avdd.n3081 avdd.n3080 0.1445
R7120 avdd.n3081 avdd.n2980 0.1445
R7121 avdd.n3095 avdd.n2980 0.1445
R7122 avdd.n3096 avdd.n3095 0.1445
R7123 avdd.n3097 avdd.n3096 0.1445
R7124 avdd.n3097 avdd.n2967 0.1445
R7125 avdd.n3156 avdd.n2967 0.1445
R7126 avdd.n3039 avdd.n3022 0.1445
R7127 avdd.n3040 avdd.n3039 0.1445
R7128 avdd.n3041 avdd.n3040 0.1445
R7129 avdd.n3041 avdd.n3010 0.1445
R7130 avdd.n3055 avdd.n3010 0.1445
R7131 avdd.n3056 avdd.n3055 0.1445
R7132 avdd.n3057 avdd.n3056 0.1445
R7133 avdd.n3057 avdd.n2998 0.1445
R7134 avdd.n3071 avdd.n2998 0.1445
R7135 avdd.n3072 avdd.n3071 0.1445
R7136 avdd.n3073 avdd.n3072 0.1445
R7137 avdd.n3073 avdd.n2986 0.1445
R7138 avdd.n3087 avdd.n2986 0.1445
R7139 avdd.n3088 avdd.n3087 0.1445
R7140 avdd.n3089 avdd.n3088 0.1445
R7141 avdd.n3089 avdd.n2974 0.1445
R7142 avdd.n3103 avdd.n2974 0.1445
R7143 avdd.n3104 avdd.n3103 0.1445
R7144 avdd.n3149 avdd.n3104 0.1445
R7145 avdd.n3140 avdd.n3111 0.1445
R7146 avdd.n3145 avdd.n3107 0.1445
R7147 avdd.n3146 avdd.n3106 0.1445
R7148 avdd.n3127 avdd.n3118 0.1445
R7149 avdd.n3121 avdd.n3120 0.1445
R7150 avdd.n3122 avdd.n3112 0.1445
R7151 avdd.n3126 avdd.n3125 0.1445
R7152 avdd.n3139 avdd.n3138 0.1445
R7153 avdd.n3183 avdd.n3174 0.1445
R7154 avdd.n3179 avdd.n3177 0.1445
R7155 avdd.n3180 avdd.n3168 0.1445
R7156 avdd.n3182 avdd.n3176 0.1445
R7157 avdd.n3192 avdd.n3166 0.1445
R7158 avdd.n3198 avdd.n3197 0.1445
R7159 avdd.n3199 avdd.n3159 0.1445
R7160 avdd.n3191 avdd.n3167 0.1445
R7161 avdd.n3230 avdd.n3220 0.1445
R7162 avdd.n3234 avdd.n3220 0.1445
R7163 avdd.n3234 avdd.n3211 0.1445
R7164 avdd.n3246 avdd.n3211 0.1445
R7165 avdd.n3246 avdd.n3209 0.1445
R7166 avdd.n3250 avdd.n3209 0.1445
R7167 avdd.n3225 avdd.n3216 0.1445
R7168 avdd.n3238 avdd.n3216 0.1445
R7169 avdd.n3238 avdd.n3214 0.1445
R7170 avdd.n3242 avdd.n3214 0.1445
R7171 avdd.n3242 avdd.n3204 0.1445
R7172 avdd.n3255 avdd.n3204 0.1445
R7173 avdd.n3224 avdd.n3215 0.1445
R7174 avdd.n3239 avdd.n3215 0.1445
R7175 avdd.n3240 avdd.n3239 0.1445
R7176 avdd.n3241 avdd.n3240 0.1445
R7177 avdd.n3241 avdd.n3203 0.1445
R7178 avdd.n3256 avdd.n3203 0.1445
R7179 avdd.n3232 avdd.n3231 0.1445
R7180 avdd.n3233 avdd.n3232 0.1445
R7181 avdd.n3233 avdd.n3210 0.1445
R7182 avdd.n3247 avdd.n3210 0.1445
R7183 avdd.n3248 avdd.n3247 0.1445
R7184 avdd.n3249 avdd.n3248 0.1445
R7185 avdd.n3277 avdd.n3268 0.1445
R7186 avdd.n3289 avdd.n3268 0.1445
R7187 avdd.n3289 avdd.n3266 0.1445
R7188 avdd.n3293 avdd.n3266 0.1445
R7189 avdd.n3282 avdd.n3272 0.1445
R7190 avdd.n3286 avdd.n3272 0.1445
R7191 avdd.n3286 avdd.n3261 0.1445
R7192 avdd.n3298 avdd.n3261 0.1445
R7193 avdd.n3284 avdd.n3283 0.1445
R7194 avdd.n3285 avdd.n3284 0.1445
R7195 avdd.n3285 avdd.n3260 0.1445
R7196 avdd.n3299 avdd.n3260 0.1445
R7197 avdd.n3276 avdd.n3267 0.1445
R7198 avdd.n3290 avdd.n3267 0.1445
R7199 avdd.n3291 avdd.n3290 0.1445
R7200 avdd.n3292 avdd.n3291 0.1445
R7201 avdd.n3414 avdd.n3399 0.1445
R7202 avdd.n3414 avdd.n3397 0.1445
R7203 avdd.n3418 avdd.n3397 0.1445
R7204 avdd.n3418 avdd.n3387 0.1445
R7205 avdd.n3430 avdd.n3387 0.1445
R7206 avdd.n3430 avdd.n3385 0.1445
R7207 avdd.n3434 avdd.n3385 0.1445
R7208 avdd.n3434 avdd.n3375 0.1445
R7209 avdd.n3446 avdd.n3375 0.1445
R7210 avdd.n3446 avdd.n3373 0.1445
R7211 avdd.n3450 avdd.n3373 0.1445
R7212 avdd.n3450 avdd.n3363 0.1445
R7213 avdd.n3462 avdd.n3363 0.1445
R7214 avdd.n3462 avdd.n3361 0.1445
R7215 avdd.n3466 avdd.n3361 0.1445
R7216 avdd.n3466 avdd.n3351 0.1445
R7217 avdd.n3478 avdd.n3351 0.1445
R7218 avdd.n3478 avdd.n3349 0.1445
R7219 avdd.n3526 avdd.n3349 0.1445
R7220 avdd.n3410 avdd.n3403 0.1445
R7221 avdd.n3410 avdd.n3393 0.1445
R7222 avdd.n3422 avdd.n3393 0.1445
R7223 avdd.n3422 avdd.n3391 0.1445
R7224 avdd.n3426 avdd.n3391 0.1445
R7225 avdd.n3426 avdd.n3381 0.1445
R7226 avdd.n3438 avdd.n3381 0.1445
R7227 avdd.n3438 avdd.n3379 0.1445
R7228 avdd.n3442 avdd.n3379 0.1445
R7229 avdd.n3442 avdd.n3369 0.1445
R7230 avdd.n3454 avdd.n3369 0.1445
R7231 avdd.n3454 avdd.n3367 0.1445
R7232 avdd.n3458 avdd.n3367 0.1445
R7233 avdd.n3458 avdd.n3357 0.1445
R7234 avdd.n3470 avdd.n3357 0.1445
R7235 avdd.n3470 avdd.n3355 0.1445
R7236 avdd.n3474 avdd.n3355 0.1445
R7237 avdd.n3474 avdd.n3344 0.1445
R7238 avdd.n3531 avdd.n3344 0.1445
R7239 avdd.n3409 avdd.n3408 0.1445
R7240 avdd.n3409 avdd.n3392 0.1445
R7241 avdd.n3423 avdd.n3392 0.1445
R7242 avdd.n3424 avdd.n3423 0.1445
R7243 avdd.n3425 avdd.n3424 0.1445
R7244 avdd.n3425 avdd.n3380 0.1445
R7245 avdd.n3439 avdd.n3380 0.1445
R7246 avdd.n3440 avdd.n3439 0.1445
R7247 avdd.n3441 avdd.n3440 0.1445
R7248 avdd.n3441 avdd.n3368 0.1445
R7249 avdd.n3455 avdd.n3368 0.1445
R7250 avdd.n3456 avdd.n3455 0.1445
R7251 avdd.n3457 avdd.n3456 0.1445
R7252 avdd.n3457 avdd.n3356 0.1445
R7253 avdd.n3471 avdd.n3356 0.1445
R7254 avdd.n3472 avdd.n3471 0.1445
R7255 avdd.n3473 avdd.n3472 0.1445
R7256 avdd.n3473 avdd.n3343 0.1445
R7257 avdd.n3532 avdd.n3343 0.1445
R7258 avdd.n3415 avdd.n3398 0.1445
R7259 avdd.n3416 avdd.n3415 0.1445
R7260 avdd.n3417 avdd.n3416 0.1445
R7261 avdd.n3417 avdd.n3386 0.1445
R7262 avdd.n3431 avdd.n3386 0.1445
R7263 avdd.n3432 avdd.n3431 0.1445
R7264 avdd.n3433 avdd.n3432 0.1445
R7265 avdd.n3433 avdd.n3374 0.1445
R7266 avdd.n3447 avdd.n3374 0.1445
R7267 avdd.n3448 avdd.n3447 0.1445
R7268 avdd.n3449 avdd.n3448 0.1445
R7269 avdd.n3449 avdd.n3362 0.1445
R7270 avdd.n3463 avdd.n3362 0.1445
R7271 avdd.n3464 avdd.n3463 0.1445
R7272 avdd.n3465 avdd.n3464 0.1445
R7273 avdd.n3465 avdd.n3350 0.1445
R7274 avdd.n3479 avdd.n3350 0.1445
R7275 avdd.n3480 avdd.n3479 0.1445
R7276 avdd.n3525 avdd.n3480 0.1445
R7277 avdd.n3516 avdd.n3487 0.1445
R7278 avdd.n3521 avdd.n3483 0.1445
R7279 avdd.n3522 avdd.n3482 0.1445
R7280 avdd.n3503 avdd.n3494 0.1445
R7281 avdd.n3497 avdd.n3496 0.1445
R7282 avdd.n3498 avdd.n3488 0.1445
R7283 avdd.n3502 avdd.n3501 0.1445
R7284 avdd.n3515 avdd.n3514 0.1445
R7285 avdd.n3559 avdd.n3550 0.1445
R7286 avdd.n3555 avdd.n3553 0.1445
R7287 avdd.n3556 avdd.n3544 0.1445
R7288 avdd.n3558 avdd.n3552 0.1445
R7289 avdd.n3568 avdd.n3542 0.1445
R7290 avdd.n3574 avdd.n3573 0.1445
R7291 avdd.n3575 avdd.n3535 0.1445
R7292 avdd.n3567 avdd.n3543 0.1445
R7293 avdd.n3606 avdd.n3596 0.1445
R7294 avdd.n3610 avdd.n3596 0.1445
R7295 avdd.n3610 avdd.n3587 0.1445
R7296 avdd.n3622 avdd.n3587 0.1445
R7297 avdd.n3622 avdd.n3585 0.1445
R7298 avdd.n3626 avdd.n3585 0.1445
R7299 avdd.n3601 avdd.n3592 0.1445
R7300 avdd.n3614 avdd.n3592 0.1445
R7301 avdd.n3614 avdd.n3590 0.1445
R7302 avdd.n3618 avdd.n3590 0.1445
R7303 avdd.n3618 avdd.n3580 0.1445
R7304 avdd.n3631 avdd.n3580 0.1445
R7305 avdd.n3600 avdd.n3591 0.1445
R7306 avdd.n3615 avdd.n3591 0.1445
R7307 avdd.n3616 avdd.n3615 0.1445
R7308 avdd.n3617 avdd.n3616 0.1445
R7309 avdd.n3617 avdd.n3579 0.1445
R7310 avdd.n3632 avdd.n3579 0.1445
R7311 avdd.n3608 avdd.n3607 0.1445
R7312 avdd.n3609 avdd.n3608 0.1445
R7313 avdd.n3609 avdd.n3586 0.1445
R7314 avdd.n3623 avdd.n3586 0.1445
R7315 avdd.n3624 avdd.n3623 0.1445
R7316 avdd.n3625 avdd.n3624 0.1445
R7317 avdd.n3653 avdd.n3644 0.1445
R7318 avdd.n3665 avdd.n3644 0.1445
R7319 avdd.n3665 avdd.n3642 0.1445
R7320 avdd.n3669 avdd.n3642 0.1445
R7321 avdd.n3658 avdd.n3648 0.1445
R7322 avdd.n3662 avdd.n3648 0.1445
R7323 avdd.n3662 avdd.n3637 0.1445
R7324 avdd.n3674 avdd.n3637 0.1445
R7325 avdd.n3660 avdd.n3659 0.1445
R7326 avdd.n3661 avdd.n3660 0.1445
R7327 avdd.n3661 avdd.n3636 0.1445
R7328 avdd.n3675 avdd.n3636 0.1445
R7329 avdd.n3652 avdd.n3643 0.1445
R7330 avdd.n3666 avdd.n3643 0.1445
R7331 avdd.n3667 avdd.n3666 0.1445
R7332 avdd.n3668 avdd.n3667 0.1445
R7333 avdd.n1610 avdd.n1595 0.1445
R7334 avdd.n1610 avdd.n1593 0.1445
R7335 avdd.n1614 avdd.n1593 0.1445
R7336 avdd.n1614 avdd.n1583 0.1445
R7337 avdd.n1626 avdd.n1583 0.1445
R7338 avdd.n1626 avdd.n1581 0.1445
R7339 avdd.n1630 avdd.n1581 0.1445
R7340 avdd.n1630 avdd.n1571 0.1445
R7341 avdd.n1642 avdd.n1571 0.1445
R7342 avdd.n1642 avdd.n1569 0.1445
R7343 avdd.n1646 avdd.n1569 0.1445
R7344 avdd.n1646 avdd.n1559 0.1445
R7345 avdd.n1658 avdd.n1559 0.1445
R7346 avdd.n1658 avdd.n1557 0.1445
R7347 avdd.n1662 avdd.n1557 0.1445
R7348 avdd.n1662 avdd.n1547 0.1445
R7349 avdd.n1674 avdd.n1547 0.1445
R7350 avdd.n1674 avdd.n1545 0.1445
R7351 avdd.n1722 avdd.n1545 0.1445
R7352 avdd.n1606 avdd.n1599 0.1445
R7353 avdd.n1606 avdd.n1589 0.1445
R7354 avdd.n1618 avdd.n1589 0.1445
R7355 avdd.n1618 avdd.n1587 0.1445
R7356 avdd.n1622 avdd.n1587 0.1445
R7357 avdd.n1622 avdd.n1577 0.1445
R7358 avdd.n1634 avdd.n1577 0.1445
R7359 avdd.n1634 avdd.n1575 0.1445
R7360 avdd.n1638 avdd.n1575 0.1445
R7361 avdd.n1638 avdd.n1565 0.1445
R7362 avdd.n1650 avdd.n1565 0.1445
R7363 avdd.n1650 avdd.n1563 0.1445
R7364 avdd.n1654 avdd.n1563 0.1445
R7365 avdd.n1654 avdd.n1553 0.1445
R7366 avdd.n1666 avdd.n1553 0.1445
R7367 avdd.n1666 avdd.n1551 0.1445
R7368 avdd.n1670 avdd.n1551 0.1445
R7369 avdd.n1670 avdd.n1540 0.1445
R7370 avdd.n1727 avdd.n1540 0.1445
R7371 avdd.n1605 avdd.n1604 0.1445
R7372 avdd.n1605 avdd.n1588 0.1445
R7373 avdd.n1619 avdd.n1588 0.1445
R7374 avdd.n1620 avdd.n1619 0.1445
R7375 avdd.n1621 avdd.n1620 0.1445
R7376 avdd.n1621 avdd.n1576 0.1445
R7377 avdd.n1635 avdd.n1576 0.1445
R7378 avdd.n1636 avdd.n1635 0.1445
R7379 avdd.n1637 avdd.n1636 0.1445
R7380 avdd.n1637 avdd.n1564 0.1445
R7381 avdd.n1651 avdd.n1564 0.1445
R7382 avdd.n1652 avdd.n1651 0.1445
R7383 avdd.n1653 avdd.n1652 0.1445
R7384 avdd.n1653 avdd.n1552 0.1445
R7385 avdd.n1667 avdd.n1552 0.1445
R7386 avdd.n1668 avdd.n1667 0.1445
R7387 avdd.n1669 avdd.n1668 0.1445
R7388 avdd.n1669 avdd.n1539 0.1445
R7389 avdd.n1728 avdd.n1539 0.1445
R7390 avdd.n1611 avdd.n1594 0.1445
R7391 avdd.n1612 avdd.n1611 0.1445
R7392 avdd.n1613 avdd.n1612 0.1445
R7393 avdd.n1613 avdd.n1582 0.1445
R7394 avdd.n1627 avdd.n1582 0.1445
R7395 avdd.n1628 avdd.n1627 0.1445
R7396 avdd.n1629 avdd.n1628 0.1445
R7397 avdd.n1629 avdd.n1570 0.1445
R7398 avdd.n1643 avdd.n1570 0.1445
R7399 avdd.n1644 avdd.n1643 0.1445
R7400 avdd.n1645 avdd.n1644 0.1445
R7401 avdd.n1645 avdd.n1558 0.1445
R7402 avdd.n1659 avdd.n1558 0.1445
R7403 avdd.n1660 avdd.n1659 0.1445
R7404 avdd.n1661 avdd.n1660 0.1445
R7405 avdd.n1661 avdd.n1546 0.1445
R7406 avdd.n1675 avdd.n1546 0.1445
R7407 avdd.n1676 avdd.n1675 0.1445
R7408 avdd.n1721 avdd.n1676 0.1445
R7409 avdd.n1712 avdd.n1683 0.1445
R7410 avdd.n1717 avdd.n1679 0.1445
R7411 avdd.n1718 avdd.n1678 0.1445
R7412 avdd.n1699 avdd.n1690 0.1445
R7413 avdd.n1693 avdd.n1692 0.1445
R7414 avdd.n1694 avdd.n1684 0.1445
R7415 avdd.n1698 avdd.n1697 0.1445
R7416 avdd.n1711 avdd.n1710 0.1445
R7417 avdd.n1755 avdd.n1746 0.1445
R7418 avdd.n1751 avdd.n1749 0.1445
R7419 avdd.n1752 avdd.n1740 0.1445
R7420 avdd.n1754 avdd.n1748 0.1445
R7421 avdd.n1764 avdd.n1738 0.1445
R7422 avdd.n1770 avdd.n1769 0.1445
R7423 avdd.n1771 avdd.n1731 0.1445
R7424 avdd.n1763 avdd.n1739 0.1445
R7425 avdd.n1802 avdd.n1792 0.1445
R7426 avdd.n1806 avdd.n1792 0.1445
R7427 avdd.n1806 avdd.n1783 0.1445
R7428 avdd.n1818 avdd.n1783 0.1445
R7429 avdd.n1818 avdd.n1781 0.1445
R7430 avdd.n1822 avdd.n1781 0.1445
R7431 avdd.n1797 avdd.n1788 0.1445
R7432 avdd.n1810 avdd.n1788 0.1445
R7433 avdd.n1810 avdd.n1786 0.1445
R7434 avdd.n1814 avdd.n1786 0.1445
R7435 avdd.n1814 avdd.n1776 0.1445
R7436 avdd.n1827 avdd.n1776 0.1445
R7437 avdd.n1796 avdd.n1787 0.1445
R7438 avdd.n1811 avdd.n1787 0.1445
R7439 avdd.n1812 avdd.n1811 0.1445
R7440 avdd.n1813 avdd.n1812 0.1445
R7441 avdd.n1813 avdd.n1775 0.1445
R7442 avdd.n1828 avdd.n1775 0.1445
R7443 avdd.n1804 avdd.n1803 0.1445
R7444 avdd.n1805 avdd.n1804 0.1445
R7445 avdd.n1805 avdd.n1782 0.1445
R7446 avdd.n1819 avdd.n1782 0.1445
R7447 avdd.n1820 avdd.n1819 0.1445
R7448 avdd.n1821 avdd.n1820 0.1445
R7449 avdd.n1849 avdd.n1840 0.1445
R7450 avdd.n1861 avdd.n1840 0.1445
R7451 avdd.n1861 avdd.n1838 0.1445
R7452 avdd.n1865 avdd.n1838 0.1445
R7453 avdd.n1854 avdd.n1844 0.1445
R7454 avdd.n1858 avdd.n1844 0.1445
R7455 avdd.n1858 avdd.n1833 0.1445
R7456 avdd.n1870 avdd.n1833 0.1445
R7457 avdd.n1856 avdd.n1855 0.1445
R7458 avdd.n1857 avdd.n1856 0.1445
R7459 avdd.n1857 avdd.n1832 0.1445
R7460 avdd.n1871 avdd.n1832 0.1445
R7461 avdd.n1848 avdd.n1839 0.1445
R7462 avdd.n1862 avdd.n1839 0.1445
R7463 avdd.n1863 avdd.n1862 0.1445
R7464 avdd.n1864 avdd.n1863 0.1445
R7465 avdd.n1235 avdd.n1220 0.1445
R7466 avdd.n1235 avdd.n1218 0.1445
R7467 avdd.n1239 avdd.n1218 0.1445
R7468 avdd.n1239 avdd.n1208 0.1445
R7469 avdd.n1251 avdd.n1208 0.1445
R7470 avdd.n1251 avdd.n1206 0.1445
R7471 avdd.n1255 avdd.n1206 0.1445
R7472 avdd.n1255 avdd.n1196 0.1445
R7473 avdd.n1267 avdd.n1196 0.1445
R7474 avdd.n1267 avdd.n1194 0.1445
R7475 avdd.n1271 avdd.n1194 0.1445
R7476 avdd.n1271 avdd.n1184 0.1445
R7477 avdd.n1283 avdd.n1184 0.1445
R7478 avdd.n1283 avdd.n1182 0.1445
R7479 avdd.n1287 avdd.n1182 0.1445
R7480 avdd.n1287 avdd.n1172 0.1445
R7481 avdd.n1299 avdd.n1172 0.1445
R7482 avdd.n1299 avdd.n1170 0.1445
R7483 avdd.n1347 avdd.n1170 0.1445
R7484 avdd.n1231 avdd.n1224 0.1445
R7485 avdd.n1231 avdd.n1214 0.1445
R7486 avdd.n1243 avdd.n1214 0.1445
R7487 avdd.n1243 avdd.n1212 0.1445
R7488 avdd.n1247 avdd.n1212 0.1445
R7489 avdd.n1247 avdd.n1202 0.1445
R7490 avdd.n1259 avdd.n1202 0.1445
R7491 avdd.n1259 avdd.n1200 0.1445
R7492 avdd.n1263 avdd.n1200 0.1445
R7493 avdd.n1263 avdd.n1190 0.1445
R7494 avdd.n1275 avdd.n1190 0.1445
R7495 avdd.n1275 avdd.n1188 0.1445
R7496 avdd.n1279 avdd.n1188 0.1445
R7497 avdd.n1279 avdd.n1178 0.1445
R7498 avdd.n1291 avdd.n1178 0.1445
R7499 avdd.n1291 avdd.n1176 0.1445
R7500 avdd.n1295 avdd.n1176 0.1445
R7501 avdd.n1295 avdd.n1165 0.1445
R7502 avdd.n1352 avdd.n1165 0.1445
R7503 avdd.n1230 avdd.n1229 0.1445
R7504 avdd.n1230 avdd.n1213 0.1445
R7505 avdd.n1244 avdd.n1213 0.1445
R7506 avdd.n1245 avdd.n1244 0.1445
R7507 avdd.n1246 avdd.n1245 0.1445
R7508 avdd.n1246 avdd.n1201 0.1445
R7509 avdd.n1260 avdd.n1201 0.1445
R7510 avdd.n1261 avdd.n1260 0.1445
R7511 avdd.n1262 avdd.n1261 0.1445
R7512 avdd.n1262 avdd.n1189 0.1445
R7513 avdd.n1276 avdd.n1189 0.1445
R7514 avdd.n1277 avdd.n1276 0.1445
R7515 avdd.n1278 avdd.n1277 0.1445
R7516 avdd.n1278 avdd.n1177 0.1445
R7517 avdd.n1292 avdd.n1177 0.1445
R7518 avdd.n1293 avdd.n1292 0.1445
R7519 avdd.n1294 avdd.n1293 0.1445
R7520 avdd.n1294 avdd.n1164 0.1445
R7521 avdd.n1353 avdd.n1164 0.1445
R7522 avdd.n1236 avdd.n1219 0.1445
R7523 avdd.n1237 avdd.n1236 0.1445
R7524 avdd.n1238 avdd.n1237 0.1445
R7525 avdd.n1238 avdd.n1207 0.1445
R7526 avdd.n1252 avdd.n1207 0.1445
R7527 avdd.n1253 avdd.n1252 0.1445
R7528 avdd.n1254 avdd.n1253 0.1445
R7529 avdd.n1254 avdd.n1195 0.1445
R7530 avdd.n1268 avdd.n1195 0.1445
R7531 avdd.n1269 avdd.n1268 0.1445
R7532 avdd.n1270 avdd.n1269 0.1445
R7533 avdd.n1270 avdd.n1183 0.1445
R7534 avdd.n1284 avdd.n1183 0.1445
R7535 avdd.n1285 avdd.n1284 0.1445
R7536 avdd.n1286 avdd.n1285 0.1445
R7537 avdd.n1286 avdd.n1171 0.1445
R7538 avdd.n1300 avdd.n1171 0.1445
R7539 avdd.n1301 avdd.n1300 0.1445
R7540 avdd.n1346 avdd.n1301 0.1445
R7541 avdd.n1337 avdd.n1308 0.1445
R7542 avdd.n1342 avdd.n1304 0.1445
R7543 avdd.n1343 avdd.n1303 0.1445
R7544 avdd.n1324 avdd.n1315 0.1445
R7545 avdd.n1318 avdd.n1317 0.1445
R7546 avdd.n1319 avdd.n1309 0.1445
R7547 avdd.n1323 avdd.n1322 0.1445
R7548 avdd.n1336 avdd.n1335 0.1445
R7549 avdd.n1380 avdd.n1371 0.1445
R7550 avdd.n1376 avdd.n1374 0.1445
R7551 avdd.n1377 avdd.n1365 0.1445
R7552 avdd.n1379 avdd.n1373 0.1445
R7553 avdd.n1389 avdd.n1363 0.1445
R7554 avdd.n1395 avdd.n1394 0.1445
R7555 avdd.n1396 avdd.n1356 0.1445
R7556 avdd.n1388 avdd.n1364 0.1445
R7557 avdd.n1427 avdd.n1417 0.1445
R7558 avdd.n1431 avdd.n1417 0.1445
R7559 avdd.n1431 avdd.n1408 0.1445
R7560 avdd.n1443 avdd.n1408 0.1445
R7561 avdd.n1443 avdd.n1406 0.1445
R7562 avdd.n1447 avdd.n1406 0.1445
R7563 avdd.n1422 avdd.n1413 0.1445
R7564 avdd.n1435 avdd.n1413 0.1445
R7565 avdd.n1435 avdd.n1411 0.1445
R7566 avdd.n1439 avdd.n1411 0.1445
R7567 avdd.n1439 avdd.n1401 0.1445
R7568 avdd.n1452 avdd.n1401 0.1445
R7569 avdd.n1421 avdd.n1412 0.1445
R7570 avdd.n1436 avdd.n1412 0.1445
R7571 avdd.n1437 avdd.n1436 0.1445
R7572 avdd.n1438 avdd.n1437 0.1445
R7573 avdd.n1438 avdd.n1400 0.1445
R7574 avdd.n1453 avdd.n1400 0.1445
R7575 avdd.n1429 avdd.n1428 0.1445
R7576 avdd.n1430 avdd.n1429 0.1445
R7577 avdd.n1430 avdd.n1407 0.1445
R7578 avdd.n1444 avdd.n1407 0.1445
R7579 avdd.n1445 avdd.n1444 0.1445
R7580 avdd.n1446 avdd.n1445 0.1445
R7581 avdd.n1474 avdd.n1465 0.1445
R7582 avdd.n1486 avdd.n1465 0.1445
R7583 avdd.n1486 avdd.n1463 0.1445
R7584 avdd.n1490 avdd.n1463 0.1445
R7585 avdd.n1479 avdd.n1469 0.1445
R7586 avdd.n1483 avdd.n1469 0.1445
R7587 avdd.n1483 avdd.n1458 0.1445
R7588 avdd.n1495 avdd.n1458 0.1445
R7589 avdd.n1481 avdd.n1480 0.1445
R7590 avdd.n1482 avdd.n1481 0.1445
R7591 avdd.n1482 avdd.n1457 0.1445
R7592 avdd.n1496 avdd.n1457 0.1445
R7593 avdd.n1473 avdd.n1464 0.1445
R7594 avdd.n1487 avdd.n1464 0.1445
R7595 avdd.n1488 avdd.n1487 0.1445
R7596 avdd.n1489 avdd.n1488 0.1445
R7597 avdd.n146 avdd.n138 0.1445
R7598 avdd.n151 avdd.n134 0.1445
R7599 avdd.n152 avdd.n133 0.1445
R7600 avdd.n145 avdd.n144 0.1445
R7601 avdd.n168 avdd.n160 0.1445
R7602 avdd.n173 avdd.n156 0.1445
R7603 avdd.n174 avdd.n155 0.1445
R7604 avdd.n167 avdd.n166 0.1445
R7605 avdd.n3872 avdd.n3868 0.1445
R7606 avdd.n3871 avdd.n3869 0.1445
R7607 avdd.n3890 avdd.n3886 0.1445
R7608 avdd.n3889 avdd.n3887 0.1445
R7609 avdd.n3909 avdd.n3905 0.1445
R7610 avdd.n3908 avdd.n3906 0.1445
R7611 avdd.n3766 avdd.n3762 0.1445
R7612 avdd.n3765 avdd.n3763 0.1445
R7613 avdd.n3784 avdd.n3780 0.1445
R7614 avdd.n3783 avdd.n3781 0.1445
R7615 avdd.n3803 avdd.n3799 0.1445
R7616 avdd.n3802 avdd.n3800 0.1445
R7617 avdd.n4063 avdd.n4059 0.1445
R7618 avdd.n4062 avdd.n4060 0.1445
R7619 avdd.n4081 avdd.n4077 0.1445
R7620 avdd.n4080 avdd.n4078 0.1445
R7621 avdd.n4100 avdd.n4096 0.1445
R7622 avdd.n4099 avdd.n4097 0.1445
R7623 avdd.n75 avdd.n71 0.1445
R7624 avdd.n74 avdd.n72 0.1445
R7625 avdd.n93 avdd.n89 0.1445
R7626 avdd.n92 avdd.n90 0.1445
R7627 avdd.n112 avdd.n108 0.1445
R7628 avdd.n111 avdd.n109 0.1445
R7629 avdd.n4130 avdd.n4126 0.1445
R7630 avdd.n4129 avdd.n4127 0.1445
R7631 avdd.n4148 avdd.n4144 0.1445
R7632 avdd.n4147 avdd.n4145 0.1445
R7633 avdd.n4167 avdd.n4163 0.1445
R7634 avdd.n4166 avdd.n4164 0.1445
R7635 avdd.n18 avdd.n14 0.1445
R7636 avdd.n17 avdd.n15 0.1445
R7637 avdd.n36 avdd.n32 0.1445
R7638 avdd.n35 avdd.n33 0.1445
R7639 avdd.n55 avdd.n51 0.1445
R7640 avdd.n54 avdd.n52 0.1445
R7641 avdd.n4283 avdd.n4276 0.1445
R7642 avdd.n4282 avdd.n4281 0.1445
R7643 avdd.n4309 avdd.n4300 0.1445
R7644 avdd.n4309 avdd.n4298 0.1445
R7645 avdd.n4313 avdd.n4298 0.1445
R7646 avdd.n4310 avdd.n4299 0.1445
R7647 avdd.n4311 avdd.n4310 0.1445
R7648 avdd.n4312 avdd.n4311 0.1445
R7649 avdd.n4319 avdd.n4294 0.1445
R7650 avdd.n4342 avdd.n4333 0.1445
R7651 avdd.n4342 avdd.n4331 0.1445
R7652 avdd.n4346 avdd.n4331 0.1445
R7653 avdd.n4343 avdd.n4332 0.1445
R7654 avdd.n4344 avdd.n4343 0.1445
R7655 avdd.n4345 avdd.n4344 0.1445
R7656 avdd.n4352 avdd.n4327 0.1445
R7657 avdd.n4197 avdd.n4193 0.1445
R7658 avdd.n4196 avdd.n4195 0.1445
R7659 avdd.n4224 avdd.n4215 0.1445
R7660 avdd.n4224 avdd.n4213 0.1445
R7661 avdd.n4228 avdd.n4213 0.1445
R7662 avdd.n4225 avdd.n4214 0.1445
R7663 avdd.n4226 avdd.n4225 0.1445
R7664 avdd.n4227 avdd.n4226 0.1445
R7665 avdd.n4234 avdd.n4209 0.1445
R7666 avdd.n4257 avdd.n4248 0.1445
R7667 avdd.n4257 avdd.n4246 0.1445
R7668 avdd.n4261 avdd.n4246 0.1445
R7669 avdd.n4258 avdd.n4247 0.1445
R7670 avdd.n4259 avdd.n4258 0.1445
R7671 avdd.n4260 avdd.n4259 0.1445
R7672 avdd.n4267 avdd.n4242 0.1445
R7673 avdd.n4366 avdd.n4362 0.1445
R7674 avdd.n4365 avdd.n4364 0.1445
R7675 avdd.n2276 avdd.n2275 0.122783
R7676 avdd.n2468 avdd.n2466 0.122783
R7677 avdd.n380 avdd.n379 0.122783
R7678 avdd.n572 avdd.n570 0.122783
R7679 avdd.n755 avdd.n754 0.122783
R7680 avdd.n947 avdd.n945 0.122783
R7681 avdd.n2656 avdd.n2655 0.122783
R7682 avdd.n2848 avdd.n2846 0.122783
R7683 avdd.n3031 avdd.n3030 0.122783
R7684 avdd.n3223 avdd.n3221 0.122783
R7685 avdd.n3407 avdd.n3406 0.122783
R7686 avdd.n3599 avdd.n3597 0.122783
R7687 avdd.n1603 avdd.n1602 0.122783
R7688 avdd.n1795 avdd.n1793 0.122783
R7689 avdd.n1228 avdd.n1227 0.122783
R7690 avdd.n1420 avdd.n1418 0.122783
R7691 avdd.n3870 avdd.n3862 0.122783
R7692 avdd.n3888 avdd.n3880 0.122783
R7693 avdd.n3907 avdd.n3899 0.122783
R7694 avdd.n3764 avdd.n3756 0.122783
R7695 avdd.n3782 avdd.n3774 0.122783
R7696 avdd.n3801 avdd.n3793 0.122783
R7697 avdd.n4061 avdd.n4053 0.122783
R7698 avdd.n4079 avdd.n4071 0.122783
R7699 avdd.n4098 avdd.n4090 0.122783
R7700 avdd.n73 avdd.n65 0.122783
R7701 avdd.n91 avdd.n83 0.122783
R7702 avdd.n110 avdd.n102 0.122783
R7703 avdd.n4128 avdd.n4120 0.122783
R7704 avdd.n4146 avdd.n4138 0.122783
R7705 avdd.n4165 avdd.n4157 0.122783
R7706 avdd.n16 avdd.n8 0.122783
R7707 avdd.n34 avdd.n26 0.122783
R7708 avdd.n53 avdd.n45 0.122783
R7709 avdd.n4363 avdd.n4357 0.122783
R7710 avdd.n3898 avdd.n3897 0.113285
R7711 avdd.n3917 avdd.n3916 0.113285
R7712 avdd.n3792 avdd.n3791 0.113285
R7713 avdd.n3811 avdd.n3810 0.113285
R7714 avdd.n4089 avdd.n4088 0.113285
R7715 avdd.n4108 avdd.n4107 0.113285
R7716 avdd.n101 avdd.n100 0.113285
R7717 avdd.n120 avdd.n119 0.113285
R7718 avdd.n4156 avdd.n4155 0.113285
R7719 avdd.n4175 avdd.n4174 0.113285
R7720 avdd.n44 avdd.n43 0.113285
R7721 avdd.n63 avdd.n62 0.113285
R7722 avdd.n4322 avdd.n4321 0.102257
R7723 avdd.n4355 avdd.n4354 0.102257
R7724 avdd.n4237 avdd.n4236 0.102257
R7725 avdd.n4270 avdd.n4269 0.102257
R7726 avdd.n1888 avdd.n1047 0.0923
R7727 avdd.n2547 avdd.n2210 0.0846229
R7728 avdd.n651 avdd.n314 0.0846229
R7729 avdd.n1026 avdd.n689 0.0846229
R7730 avdd.n2927 avdd.n2590 0.0846229
R7731 avdd.n3302 avdd.n2965 0.0846229
R7732 avdd.n3678 avdd.n3341 0.0846229
R7733 avdd.n1874 avdd.n1537 0.0846229
R7734 avdd.n1499 avdd.n1162 0.0846229
R7735 avdd.n4294 avdd.n4292 0.0718661
R7736 avdd.n4320 avdd.n4319 0.0718661
R7737 avdd.n4327 avdd.n4325 0.0718661
R7738 avdd.n4353 avdd.n4352 0.0718661
R7739 avdd.n4209 avdd.n4207 0.0718661
R7740 avdd.n4235 avdd.n4234 0.0718661
R7741 avdd.n4242 avdd.n4240 0.0718661
R7742 avdd.n4268 avdd.n4267 0.0718661
R7743 avdd.n2382 avdd.n2381 0.0543057
R7744 avdd.n2435 avdd.n2434 0.0543057
R7745 avdd.n486 avdd.n485 0.0543057
R7746 avdd.n539 avdd.n538 0.0543057
R7747 avdd.n861 avdd.n860 0.0543057
R7748 avdd.n914 avdd.n913 0.0543057
R7749 avdd.n2762 avdd.n2761 0.0543057
R7750 avdd.n2815 avdd.n2814 0.0543057
R7751 avdd.n3137 avdd.n3136 0.0543057
R7752 avdd.n3190 avdd.n3189 0.0543057
R7753 avdd.n3513 avdd.n3512 0.0543057
R7754 avdd.n3566 avdd.n3565 0.0543057
R7755 avdd.n1709 avdd.n1708 0.0543057
R7756 avdd.n1762 avdd.n1761 0.0543057
R7757 avdd.n1334 avdd.n1333 0.0543057
R7758 avdd.n1387 avdd.n1386 0.0543057
R7759 avdd.n4112 avdd 0.0455
R7760 avdd.n208 avdd 0.0455
R7761 avdd.n2369 avdd.n2358 0.0385313
R7762 avdd.n2420 avdd.n2414 0.0385313
R7763 avdd.n473 avdd.n462 0.0385313
R7764 avdd.n524 avdd.n518 0.0385313
R7765 avdd.n848 avdd.n837 0.0385313
R7766 avdd.n899 avdd.n893 0.0385313
R7767 avdd.n2749 avdd.n2738 0.0385313
R7768 avdd.n2800 avdd.n2794 0.0385313
R7769 avdd.n3124 avdd.n3113 0.0385313
R7770 avdd.n3175 avdd.n3169 0.0385313
R7771 avdd.n3500 avdd.n3489 0.0385313
R7772 avdd.n3551 avdd.n3545 0.0385313
R7773 avdd.n1696 avdd.n1685 0.0385313
R7774 avdd.n1747 avdd.n1741 0.0385313
R7775 avdd.n1321 avdd.n1310 0.0385313
R7776 avdd.n1372 avdd.n1366 0.0385313
R7777 avdd.n2208 avdd.n2203 0.0245
R7778 avdd.n312 avdd.n307 0.0245
R7779 avdd.n687 avdd.n682 0.0245
R7780 avdd.n2588 avdd.n2583 0.0245
R7781 avdd.n2963 avdd.n2958 0.0245
R7782 avdd.n3339 avdd.n3334 0.0245
R7783 avdd.n1535 avdd.n1530 0.0245
R7784 avdd.n1160 avdd.n1155 0.0245
R7785 avdd.n4111 avdd 0.0205
R7786 avdd.n209 avdd 0.0205
R7787 avdd.n3712 avdd 0.0176
R7788 avdd.n3926 avdd 0.0176
R7789 avdd.n2381 avdd.n2358 0.0162745
R7790 avdd.n2434 avdd.n2414 0.0162745
R7791 avdd.n485 avdd.n462 0.0162745
R7792 avdd.n538 avdd.n518 0.0162745
R7793 avdd.n860 avdd.n837 0.0162745
R7794 avdd.n913 avdd.n893 0.0162745
R7795 avdd.n2761 avdd.n2738 0.0162745
R7796 avdd.n2814 avdd.n2794 0.0162745
R7797 avdd.n3136 avdd.n3113 0.0162745
R7798 avdd.n3189 avdd.n3169 0.0162745
R7799 avdd.n3512 avdd.n3489 0.0162745
R7800 avdd.n3565 avdd.n3545 0.0162745
R7801 avdd.n1708 avdd.n1685 0.0162745
R7802 avdd.n1761 avdd.n1741 0.0162745
R7803 avdd.n1333 avdd.n1310 0.0162745
R7804 avdd.n1386 avdd.n1366 0.0162745
R7805 avdd.n3687 avdd.n264 0.0149069
R7806 avdd.n3688 avdd.n3687 0.0149069
R7807 avdd.n3692 avdd.n259 0.0149069
R7808 avdd.n3693 avdd.n3692 0.0149069
R7809 avdd.n3697 avdd.n254 0.0149069
R7810 avdd.n3698 avdd.n3697 0.0149069
R7811 avdd.n3701 avdd.n3700 0.0149069
R7812 avdd.n3704 avdd.n246 0.0149069
R7813 avdd.n3708 avdd.n245 0.0149069
R7814 avdd.n3709 avdd.n3708 0.0149069
R7815 avdd.n3715 avdd.n3711 0.0149069
R7816 avdd.n3711 avdd.n241 0.0149069
R7817 avdd.n3705 avdd.n245 0.0149069
R7818 avdd.n3710 avdd.n3709 0.0149069
R7819 avdd.n3716 avdd.n3715 0.0149069
R7820 avdd.n3712 avdd.n241 0.0149069
R7821 avdd.n3700 avdd.n249 0.0149069
R7822 avdd.n249 avdd.n246 0.0149069
R7823 avdd.n269 avdd.n267 0.0149069
R7824 avdd.n269 avdd.n266 0.0149069
R7825 avdd.n272 avdd.n270 0.0149069
R7826 avdd.n3304 avdd.n272 0.0149069
R7827 avdd.n2933 avdd.n2932 0.0149069
R7828 avdd.n2929 avdd.n275 0.0149069
R7829 avdd.n2557 avdd.n2556 0.0149069
R7830 avdd.n2556 avdd.n2555 0.0149069
R7831 avdd.n1030 avdd.n657 0.0149069
R7832 avdd.n1031 avdd.n657 0.0149069
R7833 avdd.n240 avdd.n237 0.0149069
R7834 avdd.n239 avdd.n237 0.0149069
R7835 avdd.n2558 avdd.n2557 0.0149069
R7836 avdd.n2555 avdd.n280 0.0149069
R7837 avdd.n1030 avdd.n1028 0.0149069
R7838 avdd.n1031 avdd.n1029 0.0149069
R7839 avdd.n240 avdd.n238 0.0149069
R7840 avdd.n2932 avdd.n2931 0.0149069
R7841 avdd.n2931 avdd.n275 0.0149069
R7842 avdd.n3695 avdd.n254 0.0149069
R7843 avdd.n3699 avdd.n3698 0.0149069
R7844 avdd.n1128 avdd.n1091 0.0149069
R7845 avdd.n1129 avdd.n1128 0.0149069
R7846 avdd.n1502 avdd.n1501 0.0149069
R7847 avdd.n1505 avdd.n1085 0.0149069
R7848 avdd.n1877 avdd.n1876 0.0149069
R7849 avdd.n1876 avdd.n1081 0.0149069
R7850 avdd.n655 avdd.n653 0.0149069
R7851 avdd.n655 avdd.n282 0.0149069
R7852 avdd.n2044 avdd.n656 0.0149069
R7853 avdd.n2173 avdd.n2044 0.0149069
R7854 avdd.n236 avdd.n233 0.0149069
R7855 avdd.n235 avdd.n233 0.0149069
R7856 avdd.n1878 avdd.n1877 0.0149069
R7857 avdd.n1082 avdd.n1081 0.0149069
R7858 avdd.n2552 avdd.n653 0.0149069
R7859 avdd.n2549 avdd.n282 0.0149069
R7860 avdd.n2178 avdd.n656 0.0149069
R7861 avdd.n2174 avdd.n2173 0.0149069
R7862 avdd.n236 avdd.n234 0.0149069
R7863 avdd.n1501 avdd.n1087 0.0149069
R7864 avdd.n1087 avdd.n1085 0.0149069
R7865 avdd.n3309 avdd.n270 0.0149069
R7866 avdd.n3305 avdd.n3304 0.0149069
R7867 avdd.n3690 avdd.n259 0.0149069
R7868 avdd.n3694 avdd.n3693 0.0149069
R7869 avdd.n1124 avdd.n1094 0.0149069
R7870 avdd.n1102 avdd.n1101 0.0149069
R7871 avdd.n1102 avdd.n1100 0.0149069
R7872 avdd.n1079 avdd.n1069 0.0149069
R7873 avdd.n1080 avdd.n1069 0.0149069
R7874 avdd.n1073 avdd.n1071 0.0149069
R7875 avdd.n1073 avdd.n1072 0.0149069
R7876 avdd.n1910 avdd.n1040 0.0149069
R7877 avdd.n1910 avdd.n1038 0.0149069
R7878 avdd.n232 avdd.n229 0.0149069
R7879 avdd.n231 avdd.n229 0.0149069
R7880 avdd.n1101 avdd.n1095 0.0149069
R7881 avdd.n1103 avdd.n1100 0.0149069
R7882 avdd.n1079 avdd.n1070 0.0149069
R7883 avdd.n1080 avdd.n1078 0.0149069
R7884 avdd.n1077 avdd.n1071 0.0149069
R7885 avdd.n1072 avdd.n1039 0.0149069
R7886 avdd.n2042 avdd.n1040 0.0149069
R7887 avdd.n2039 avdd.n1038 0.0149069
R7888 avdd.n232 avdd.n230 0.0149069
R7889 avdd.n1121 avdd.n1093 0.0149069
R7890 avdd.n1121 avdd.n1094 0.0149069
R7891 avdd.n1126 avdd.n1091 0.0149069
R7892 avdd.n1130 avdd.n1129 0.0149069
R7893 avdd.n3683 avdd.n267 0.0149069
R7894 avdd.n3680 avdd.n266 0.0149069
R7895 avdd.n3685 avdd.n264 0.0149069
R7896 avdd.n3689 avdd.n3688 0.0149069
R7897 avdd.n1119 avdd.n1097 0.0149069
R7898 avdd.n1117 avdd.n1097 0.0149069
R7899 avdd.n1110 avdd.n1099 0.0149069
R7900 avdd.n1110 avdd.n1109 0.0149069
R7901 avdd.n1886 avdd.n1068 0.0149069
R7902 avdd.n1887 avdd.n1886 0.0149069
R7903 avdd.n1900 avdd.n1046 0.0149069
R7904 avdd.n1901 avdd.n1900 0.0149069
R7905 avdd.n1905 avdd.n1904 0.0149069
R7906 avdd.n1905 avdd.n1042 0.0149069
R7907 avdd.n3732 avdd.n228 0.0149069
R7908 avdd.n3733 avdd.n3732 0.0149069
R7909 avdd.n1117 avdd.n1116 0.0149069
R7910 avdd.n1114 avdd.n1099 0.0149069
R7911 avdd.n1109 avdd.n1067 0.0149069
R7912 avdd.n1892 avdd.n1068 0.0149069
R7913 avdd.n1888 avdd.n1887 0.0149069
R7914 avdd.n1898 avdd.n1046 0.0149069
R7915 avdd.n1902 avdd.n1901 0.0149069
R7916 avdd.n1908 avdd.n1904 0.0149069
R7917 avdd.n1042 avdd.n227 0.0149069
R7918 avdd.n3737 avdd.n228 0.0149069
R7919 avdd.n3819 avdd.n3816 0.0149069
R7920 avdd.n3820 avdd.n3816 0.0149069
R7921 avdd.n3859 avdd.n3858 0.0149069
R7922 avdd.n3860 avdd.n3859 0.0149069
R7923 avdd.n3919 avdd.n3831 0.0149069
R7924 avdd.n3922 avdd.n3832 0.0149069
R7925 avdd.n3852 avdd.n3831 0.0149069
R7926 avdd.n3852 avdd.n3832 0.0149069
R7927 avdd.n3960 avdd.n3950 0.0149069
R7928 avdd.n3961 avdd.n3960 0.0149069
R7929 avdd.n3965 avdd.n3964 0.0149069
R7930 avdd.n3967 avdd.n3755 0.0149069
R7931 avdd.n3850 avdd.n3834 0.0149069
R7932 avdd.n3846 avdd.n3834 0.0149069
R7933 avdd.n3850 avdd.n3849 0.0149069
R7934 avdd.n3965 avdd.n3753 0.0149069
R7935 avdd.n3755 avdd.n3753 0.0149069
R7936 avdd.n3858 avdd.n3857 0.0149069
R7937 avdd.n3861 avdd.n3860 0.0149069
R7938 avdd.n3952 avdd.n3748 0.0149069
R7939 avdd.n3970 avdd.n3750 0.0149069
R7940 avdd.n3838 avdd.n3750 0.0149069
R7941 avdd.n3841 avdd.n3840 0.0149069
R7942 avdd.n3841 avdd.n3837 0.0149069
R7943 avdd.n3971 avdd.n3970 0.0149069
R7944 avdd.n3839 avdd.n3838 0.0149069
R7945 avdd.n3844 avdd.n3840 0.0149069
R7946 avdd.n3956 avdd.n3953 0.0149069
R7947 avdd.n3953 avdd.n3952 0.0149069
R7948 avdd.n3958 avdd.n3950 0.0149069
R7949 avdd.n3962 avdd.n3961 0.0149069
R7950 avdd.n3819 avdd.n3817 0.0149069
R7951 avdd.n3820 avdd.n3818 0.0149069
R7952 avdd.n3941 avdd.n3823 0.0149069
R7953 avdd.n3823 avdd.n3821 0.0149069
R7954 avdd.n3827 avdd.n3824 0.0149069
R7955 avdd.n3932 avdd.n3827 0.0149069
R7956 avdd.n3924 avdd.n3828 0.0149069
R7957 avdd.n3925 avdd.n3924 0.0149069
R7958 avdd.n3939 avdd.n3821 0.0149069
R7959 avdd.n3937 avdd.n3824 0.0149069
R7960 avdd.n3933 avdd.n3932 0.0149069
R7961 avdd.n3930 avdd.n3828 0.0149069
R7962 avdd.n3926 avdd.n3925 0.0149069
R7963 avdd.n2209 avdd.n2184 0.0149
R7964 avdd.n2202 avdd.n2193 0.0149
R7965 avdd.n313 avdd.n288 0.0149
R7966 avdd.n306 avdd.n297 0.0149
R7967 avdd.n688 avdd.n663 0.0149
R7968 avdd.n681 avdd.n672 0.0149
R7969 avdd.n2589 avdd.n2564 0.0149
R7970 avdd.n2582 avdd.n2573 0.0149
R7971 avdd.n2964 avdd.n2939 0.0149
R7972 avdd.n2957 avdd.n2948 0.0149
R7973 avdd.n3340 avdd.n3315 0.0149
R7974 avdd.n3333 avdd.n3324 0.0149
R7975 avdd.n1536 avdd.n1511 0.0149
R7976 avdd.n1529 avdd.n1520 0.0149
R7977 avdd.n1161 avdd.n1136 0.0149
R7978 avdd.n1154 avdd.n1145 0.0149
R7979 avdd.n3734 avdd.n3731 0.0129
R7980 avdd.n3728 avdd.n3727 0.0129
R7981 avdd.n3724 avdd.n3723 0.0129
R7982 avdd.n3720 avdd.n3719 0.0129
R7983 avdd.n1909 avdd.n1041 0.0129
R7984 avdd.n2043 avdd.n1037 0.0129
R7985 avdd.n2175 avdd.n1036 0.0129
R7986 avdd.n1033 avdd.n1032 0.0129
R7987 avdd.n1045 avdd.n1044 0.0129
R7988 avdd.n1074 avdd.n654 0.0129
R7989 avdd.n2553 avdd.n281 0.0129
R7990 avdd.n250 avdd.n247 0.0129
R7991 avdd.n1889 avdd.n1885 0.0129
R7992 avdd.n1882 avdd.n1881 0.0129
R7993 avdd.n274 avdd.n255 0.0129
R7994 avdd.n253 avdd.n252 0.0129
R7995 avdd.n1111 avdd.n1108 0.0129
R7996 avdd.n1088 avdd.n271 0.0129
R7997 avdd.n3306 avdd.n260 0.0129
R7998 avdd.n258 avdd.n257 0.0129
R7999 avdd.n1125 avdd.n1092 0.0129
R8000 avdd.n1090 avdd.n268 0.0129
R8001 avdd.n3684 avdd.n265 0.0129
R8002 avdd.n263 avdd.n262 0.0129
R8003 avdd.n3845 avdd.n3836 0.0129
R8004 avdd.n3923 avdd.n3830 0.0129
R8005 avdd.n3927 avdd.n3829 0.0129
R8006 avdd.n3966 avdd.n3813 0.0129
R8007 avdd.n3854 avdd.n3826 0.0129
R8008 avdd.n3934 avdd.n3825 0.0129
R8009 avdd.n3957 avdd.n3951 0.0129
R8010 avdd.n3949 avdd.n3948 0.0129
R8011 avdd.n3945 avdd.n3944 0.0129
R8012 avdd.n2184 avdd.n2179 0.0081885
R8013 avdd.n2207 avdd.n2180 0.0081885
R8014 avdd.n2206 avdd.n2205 0.0081885
R8015 avdd.n2193 avdd.n2188 0.0081885
R8016 avdd.n2200 avdd.n2189 0.0081885
R8017 avdd.n2199 avdd.n2198 0.0081885
R8018 avdd.t154 avdd.n2188 0.0081885
R8019 avdd.t154 avdd.n2200 0.0081885
R8020 avdd.n2199 avdd.n2189 0.0081885
R8021 avdd.t155 avdd.n2179 0.0081885
R8022 avdd.t155 avdd.n2207 0.0081885
R8023 avdd.n2206 avdd.n2180 0.0081885
R8024 avdd.n288 avdd.n283 0.0081885
R8025 avdd.n311 avdd.n284 0.0081885
R8026 avdd.n310 avdd.n309 0.0081885
R8027 avdd.n297 avdd.n292 0.0081885
R8028 avdd.n304 avdd.n293 0.0081885
R8029 avdd.n303 avdd.n302 0.0081885
R8030 avdd.t156 avdd.n292 0.0081885
R8031 avdd.t156 avdd.n304 0.0081885
R8032 avdd.n303 avdd.n293 0.0081885
R8033 avdd.t157 avdd.n283 0.0081885
R8034 avdd.t157 avdd.n311 0.0081885
R8035 avdd.n310 avdd.n284 0.0081885
R8036 avdd.n663 avdd.n658 0.0081885
R8037 avdd.n686 avdd.n659 0.0081885
R8038 avdd.n685 avdd.n684 0.0081885
R8039 avdd.n672 avdd.n667 0.0081885
R8040 avdd.n679 avdd.n668 0.0081885
R8041 avdd.n678 avdd.n677 0.0081885
R8042 avdd.t162 avdd.n667 0.0081885
R8043 avdd.t162 avdd.n679 0.0081885
R8044 avdd.n678 avdd.n668 0.0081885
R8045 avdd.t163 avdd.n658 0.0081885
R8046 avdd.t163 avdd.n686 0.0081885
R8047 avdd.n685 avdd.n659 0.0081885
R8048 avdd.n2564 avdd.n2559 0.0081885
R8049 avdd.n2587 avdd.n2560 0.0081885
R8050 avdd.n2586 avdd.n2585 0.0081885
R8051 avdd.n2573 avdd.n2568 0.0081885
R8052 avdd.n2580 avdd.n2569 0.0081885
R8053 avdd.n2579 avdd.n2578 0.0081885
R8054 avdd.t164 avdd.n2568 0.0081885
R8055 avdd.t164 avdd.n2580 0.0081885
R8056 avdd.n2579 avdd.n2569 0.0081885
R8057 avdd.t165 avdd.n2559 0.0081885
R8058 avdd.t165 avdd.n2587 0.0081885
R8059 avdd.n2586 avdd.n2560 0.0081885
R8060 avdd.n2939 avdd.n2934 0.0081885
R8061 avdd.n2962 avdd.n2935 0.0081885
R8062 avdd.n2961 avdd.n2960 0.0081885
R8063 avdd.n2948 avdd.n2943 0.0081885
R8064 avdd.n2955 avdd.n2944 0.0081885
R8065 avdd.n2954 avdd.n2953 0.0081885
R8066 avdd.t166 avdd.n2943 0.0081885
R8067 avdd.t166 avdd.n2955 0.0081885
R8068 avdd.n2954 avdd.n2944 0.0081885
R8069 avdd.t167 avdd.n2934 0.0081885
R8070 avdd.t167 avdd.n2962 0.0081885
R8071 avdd.n2961 avdd.n2935 0.0081885
R8072 avdd.n3315 avdd.n3310 0.0081885
R8073 avdd.n3338 avdd.n3311 0.0081885
R8074 avdd.n3337 avdd.n3336 0.0081885
R8075 avdd.n3324 avdd.n3319 0.0081885
R8076 avdd.n3331 avdd.n3320 0.0081885
R8077 avdd.n3330 avdd.n3329 0.0081885
R8078 avdd.t168 avdd.n3319 0.0081885
R8079 avdd.t168 avdd.n3331 0.0081885
R8080 avdd.n3330 avdd.n3320 0.0081885
R8081 avdd.t169 avdd.n3310 0.0081885
R8082 avdd.t169 avdd.n3338 0.0081885
R8083 avdd.n3337 avdd.n3311 0.0081885
R8084 avdd.n1511 avdd.n1506 0.0081885
R8085 avdd.n1534 avdd.n1507 0.0081885
R8086 avdd.n1533 avdd.n1532 0.0081885
R8087 avdd.n1520 avdd.n1515 0.0081885
R8088 avdd.n1527 avdd.n1516 0.0081885
R8089 avdd.n1526 avdd.n1525 0.0081885
R8090 avdd.t158 avdd.n1515 0.0081885
R8091 avdd.t158 avdd.n1527 0.0081885
R8092 avdd.n1526 avdd.n1516 0.0081885
R8093 avdd.t159 avdd.n1506 0.0081885
R8094 avdd.t159 avdd.n1534 0.0081885
R8095 avdd.n1533 avdd.n1507 0.0081885
R8096 avdd.n1136 avdd.n1131 0.0081885
R8097 avdd.n1159 avdd.n1132 0.0081885
R8098 avdd.n1158 avdd.n1157 0.0081885
R8099 avdd.n1145 avdd.n1140 0.0081885
R8100 avdd.n1152 avdd.n1141 0.0081885
R8101 avdd.n1151 avdd.n1150 0.0081885
R8102 avdd.t160 avdd.n1140 0.0081885
R8103 avdd.t160 avdd.n1152 0.0081885
R8104 avdd.n1151 avdd.n1141 0.0081885
R8105 avdd.t161 avdd.n1131 0.0081885
R8106 avdd.t161 avdd.n1159 0.0081885
R8107 avdd.n1158 avdd.n1132 0.0081885
R8108 avdd.n3714 avdd 0.0081
R8109 avdd.n3829 avdd 0.0081
R8110 avdd.n3735 avdd.n3734 0.00719147
R8111 avdd.n3729 avdd.n3728 0.00719147
R8112 avdd.n3725 avdd.n3724 0.00719147
R8113 avdd.n3721 avdd.n3720 0.00719147
R8114 avdd.n3717 avdd.n242 0.00719147
R8115 avdd.n3714 avdd.n3713 0.00719147
R8116 avdd.n1906 avdd.n1041 0.00719147
R8117 avdd.n2040 avdd.n1037 0.00719147
R8118 avdd.n2176 avdd.n2175 0.00719147
R8119 avdd.n1034 avdd.n1033 0.00719147
R8120 avdd.n3707 avdd.n3706 0.00719147
R8121 avdd.n3706 avdd.n244 0.00719147
R8122 avdd.n3707 avdd.n243 0.00719147
R8123 avdd.n3718 avdd.n3717 0.00719147
R8124 avdd.n3713 avdd.n242 0.00719147
R8125 avdd.n1045 avdd.n1043 0.00719147
R8126 avdd.n1075 avdd.n1074 0.00719147
R8127 avdd.n2550 avdd.n281 0.00719147
R8128 avdd.n278 avdd.n277 0.00719147
R8129 avdd.n279 avdd.n248 0.00719147
R8130 avdd.n3703 avdd.n3702 0.00719147
R8131 avdd.n3702 avdd.n250 0.00719147
R8132 avdd.n2554 avdd.n277 0.00719147
R8133 avdd.n279 avdd.n278 0.00719147
R8134 avdd.n1035 avdd.n1034 0.00719147
R8135 avdd.n3722 avdd.n3721 0.00719147
R8136 avdd.n1890 avdd.n1889 0.00719147
R8137 avdd.n1883 avdd.n1882 0.00719147
R8138 avdd.n1879 avdd.n1084 0.00719147
R8139 avdd.n1083 avdd.n276 0.00719147
R8140 avdd.n2930 avdd.n273 0.00719147
R8141 avdd.n253 avdd.n251 0.00719147
R8142 avdd.n274 avdd.n273 0.00719147
R8143 avdd.n3696 avdd.n251 0.00719147
R8144 avdd.n1880 avdd.n1879 0.00719147
R8145 avdd.n1084 avdd.n1083 0.00719147
R8146 avdd.n2551 avdd.n2550 0.00719147
R8147 avdd.n2177 avdd.n2176 0.00719147
R8148 avdd.n3726 avdd.n3725 0.00719147
R8149 avdd.n1112 avdd.n1111 0.00719147
R8150 avdd.n1106 avdd.n1105 0.00719147
R8151 avdd.n1104 avdd.n1086 0.00719147
R8152 avdd.n1504 avdd.n1503 0.00719147
R8153 avdd.n3307 avdd.n3306 0.00719147
R8154 avdd.n258 avdd.n256 0.00719147
R8155 avdd.n1503 avdd.n1088 0.00719147
R8156 avdd.n3308 avdd.n3307 0.00719147
R8157 avdd.n3691 avdd.n256 0.00719147
R8158 avdd.n1107 avdd.n1106 0.00719147
R8159 avdd.n1105 avdd.n1104 0.00719147
R8160 avdd.n1884 avdd.n1883 0.00719147
R8161 avdd.n1076 avdd.n1075 0.00719147
R8162 avdd.n2041 avdd.n2040 0.00719147
R8163 avdd.n3730 avdd.n3729 0.00719147
R8164 avdd.n1118 avdd.n1098 0.00719147
R8165 avdd.n1120 avdd.n1096 0.00719147
R8166 avdd.n1123 avdd.n1122 0.00719147
R8167 avdd.n1090 avdd.n1089 0.00719147
R8168 avdd.n3681 avdd.n265 0.00719147
R8169 avdd.n263 avdd.n261 0.00719147
R8170 avdd.n1122 avdd.n1092 0.00719147
R8171 avdd.n1127 avdd.n1089 0.00719147
R8172 avdd.n3682 avdd.n3681 0.00719147
R8173 avdd.n3686 avdd.n261 0.00719147
R8174 avdd.n1098 avdd.n1096 0.00719147
R8175 avdd.n1113 avdd.n1112 0.00719147
R8176 avdd.n1891 avdd.n1890 0.00719147
R8177 avdd.n1899 avdd.n1043 0.00719147
R8178 avdd.n1907 avdd.n1906 0.00719147
R8179 avdd.n3736 avdd.n3735 0.00719147
R8180 avdd.n3842 avdd.n3836 0.00719147
R8181 avdd.n3848 avdd.n3835 0.00719147
R8182 avdd.n3851 avdd.n3833 0.00719147
R8183 avdd.n3921 avdd.n3920 0.00719147
R8184 avdd.n3928 avdd.n3927 0.00719147
R8185 avdd.n3920 avdd.n3830 0.00719147
R8186 avdd.n3848 avdd.n3847 0.00719147
R8187 avdd.n3835 avdd.n3833 0.00719147
R8188 avdd.n3751 avdd.n3749 0.00719147
R8189 avdd.n3969 avdd.n3752 0.00719147
R8190 avdd.n3968 avdd.n3754 0.00719147
R8191 avdd.n3854 avdd.n3853 0.00719147
R8192 avdd.n3935 avdd.n3934 0.00719147
R8193 avdd.n3813 avdd.n3754 0.00719147
R8194 avdd.n3853 avdd.n3814 0.00719147
R8195 avdd.n3752 avdd.n3751 0.00719147
R8196 avdd.n3843 avdd.n3842 0.00719147
R8197 avdd.n3955 avdd.n3954 0.00719147
R8198 avdd.n3949 avdd.n3815 0.00719147
R8199 avdd.n3946 avdd.n3945 0.00719147
R8200 avdd.n3942 avdd.n3822 0.00719147
R8201 avdd.n3955 avdd.n3951 0.00719147
R8202 avdd.n3959 avdd.n3815 0.00719147
R8203 avdd.n3947 avdd.n3946 0.00719147
R8204 avdd.n3943 avdd.n3942 0.00719147
R8205 avdd.n3940 avdd.n3822 0.00719147
R8206 avdd.n3936 avdd.n3935 0.00719147
R8207 avdd.n3929 avdd.n3928 0.00719147
R8208 avdd.n2183 avdd.n2181 0.00328455
R8209 avdd.n2186 avdd.n2185 0.00328455
R8210 avdd.n2204 avdd.n2182 0.00328455
R8211 avdd.n2208 avdd.n2187 0.00328455
R8212 avdd.n2192 avdd.n2190 0.00328455
R8213 avdd.n2195 avdd.n2194 0.00328455
R8214 avdd.n2197 avdd.n2191 0.00328455
R8215 avdd.n2201 avdd.n2196 0.00328455
R8216 avdd.n2203 avdd.n2190 0.00328455
R8217 avdd.n2194 avdd.n2192 0.00328455
R8218 avdd.n2197 avdd.n2195 0.00328455
R8219 avdd.n2196 avdd.n2191 0.00328455
R8220 avdd.n2210 avdd.n2181 0.00328455
R8221 avdd.n2185 avdd.n2183 0.00328455
R8222 avdd.n2204 avdd.n2186 0.00328455
R8223 avdd.n2187 avdd.n2182 0.00328455
R8224 avdd.n287 avdd.n285 0.00328455
R8225 avdd.n290 avdd.n289 0.00328455
R8226 avdd.n308 avdd.n286 0.00328455
R8227 avdd.n312 avdd.n291 0.00328455
R8228 avdd.n296 avdd.n294 0.00328455
R8229 avdd.n299 avdd.n298 0.00328455
R8230 avdd.n301 avdd.n295 0.00328455
R8231 avdd.n305 avdd.n300 0.00328455
R8232 avdd.n307 avdd.n294 0.00328455
R8233 avdd.n298 avdd.n296 0.00328455
R8234 avdd.n301 avdd.n299 0.00328455
R8235 avdd.n300 avdd.n295 0.00328455
R8236 avdd.n314 avdd.n285 0.00328455
R8237 avdd.n289 avdd.n287 0.00328455
R8238 avdd.n308 avdd.n290 0.00328455
R8239 avdd.n291 avdd.n286 0.00328455
R8240 avdd.n662 avdd.n660 0.00328455
R8241 avdd.n665 avdd.n664 0.00328455
R8242 avdd.n683 avdd.n661 0.00328455
R8243 avdd.n687 avdd.n666 0.00328455
R8244 avdd.n671 avdd.n669 0.00328455
R8245 avdd.n674 avdd.n673 0.00328455
R8246 avdd.n676 avdd.n670 0.00328455
R8247 avdd.n680 avdd.n675 0.00328455
R8248 avdd.n682 avdd.n669 0.00328455
R8249 avdd.n673 avdd.n671 0.00328455
R8250 avdd.n676 avdd.n674 0.00328455
R8251 avdd.n675 avdd.n670 0.00328455
R8252 avdd.n689 avdd.n660 0.00328455
R8253 avdd.n664 avdd.n662 0.00328455
R8254 avdd.n683 avdd.n665 0.00328455
R8255 avdd.n666 avdd.n661 0.00328455
R8256 avdd.n2563 avdd.n2561 0.00328455
R8257 avdd.n2566 avdd.n2565 0.00328455
R8258 avdd.n2584 avdd.n2562 0.00328455
R8259 avdd.n2588 avdd.n2567 0.00328455
R8260 avdd.n2572 avdd.n2570 0.00328455
R8261 avdd.n2575 avdd.n2574 0.00328455
R8262 avdd.n2577 avdd.n2571 0.00328455
R8263 avdd.n2581 avdd.n2576 0.00328455
R8264 avdd.n2583 avdd.n2570 0.00328455
R8265 avdd.n2574 avdd.n2572 0.00328455
R8266 avdd.n2577 avdd.n2575 0.00328455
R8267 avdd.n2576 avdd.n2571 0.00328455
R8268 avdd.n2590 avdd.n2561 0.00328455
R8269 avdd.n2565 avdd.n2563 0.00328455
R8270 avdd.n2584 avdd.n2566 0.00328455
R8271 avdd.n2567 avdd.n2562 0.00328455
R8272 avdd.n2938 avdd.n2936 0.00328455
R8273 avdd.n2941 avdd.n2940 0.00328455
R8274 avdd.n2959 avdd.n2937 0.00328455
R8275 avdd.n2963 avdd.n2942 0.00328455
R8276 avdd.n2947 avdd.n2945 0.00328455
R8277 avdd.n2950 avdd.n2949 0.00328455
R8278 avdd.n2952 avdd.n2946 0.00328455
R8279 avdd.n2956 avdd.n2951 0.00328455
R8280 avdd.n2958 avdd.n2945 0.00328455
R8281 avdd.n2949 avdd.n2947 0.00328455
R8282 avdd.n2952 avdd.n2950 0.00328455
R8283 avdd.n2951 avdd.n2946 0.00328455
R8284 avdd.n2965 avdd.n2936 0.00328455
R8285 avdd.n2940 avdd.n2938 0.00328455
R8286 avdd.n2959 avdd.n2941 0.00328455
R8287 avdd.n2942 avdd.n2937 0.00328455
R8288 avdd.n3314 avdd.n3312 0.00328455
R8289 avdd.n3317 avdd.n3316 0.00328455
R8290 avdd.n3335 avdd.n3313 0.00328455
R8291 avdd.n3339 avdd.n3318 0.00328455
R8292 avdd.n3323 avdd.n3321 0.00328455
R8293 avdd.n3326 avdd.n3325 0.00328455
R8294 avdd.n3328 avdd.n3322 0.00328455
R8295 avdd.n3332 avdd.n3327 0.00328455
R8296 avdd.n3334 avdd.n3321 0.00328455
R8297 avdd.n3325 avdd.n3323 0.00328455
R8298 avdd.n3328 avdd.n3326 0.00328455
R8299 avdd.n3327 avdd.n3322 0.00328455
R8300 avdd.n3341 avdd.n3312 0.00328455
R8301 avdd.n3316 avdd.n3314 0.00328455
R8302 avdd.n3335 avdd.n3317 0.00328455
R8303 avdd.n3318 avdd.n3313 0.00328455
R8304 avdd.n1510 avdd.n1508 0.00328455
R8305 avdd.n1513 avdd.n1512 0.00328455
R8306 avdd.n1531 avdd.n1509 0.00328455
R8307 avdd.n1535 avdd.n1514 0.00328455
R8308 avdd.n1519 avdd.n1517 0.00328455
R8309 avdd.n1522 avdd.n1521 0.00328455
R8310 avdd.n1524 avdd.n1518 0.00328455
R8311 avdd.n1528 avdd.n1523 0.00328455
R8312 avdd.n1530 avdd.n1517 0.00328455
R8313 avdd.n1521 avdd.n1519 0.00328455
R8314 avdd.n1524 avdd.n1522 0.00328455
R8315 avdd.n1523 avdd.n1518 0.00328455
R8316 avdd.n1537 avdd.n1508 0.00328455
R8317 avdd.n1512 avdd.n1510 0.00328455
R8318 avdd.n1531 avdd.n1513 0.00328455
R8319 avdd.n1514 avdd.n1509 0.00328455
R8320 avdd.n1135 avdd.n1133 0.00328455
R8321 avdd.n1138 avdd.n1137 0.00328455
R8322 avdd.n1156 avdd.n1134 0.00328455
R8323 avdd.n1160 avdd.n1139 0.00328455
R8324 avdd.n1144 avdd.n1142 0.00328455
R8325 avdd.n1147 avdd.n1146 0.00328455
R8326 avdd.n1149 avdd.n1143 0.00328455
R8327 avdd.n1153 avdd.n1148 0.00328455
R8328 avdd.n1155 avdd.n1142 0.00328455
R8329 avdd.n1146 avdd.n1144 0.00328455
R8330 avdd.n1149 avdd.n1147 0.00328455
R8331 avdd.n1148 avdd.n1143 0.00328455
R8332 avdd.n1162 avdd.n1133 0.00328455
R8333 avdd.n1137 avdd.n1135 0.00328455
R8334 avdd.n1156 avdd.n1138 0.00328455
R8335 avdd.n1139 avdd.n1134 0.00328455
R8336 avss.n9400 avss.n8 33692.5
R8337 avss.n7999 avss.n8 33692.5
R8338 avss.n6892 avss.n6891 19754.3
R8339 avss.n1203 avss.n377 14677.4
R8340 avss.n6700 avss.n1203 14677.4
R8341 avss.n6717 avss.n1176 13255.4
R8342 avss.n1227 avss.n1226 12133.3
R8343 avss.n5720 avss.n1176 12133.3
R8344 avss.n5848 avss.n1176 12133.3
R8345 avss.n8692 avss.n196 12133.3
R8346 avss.n7790 avss.n110 12133.3
R8347 avss.n8615 avss.n7790 12133.3
R8348 avss.n8615 avss.n175 12133.3
R8349 avss.n9151 avss.n196 12133.3
R8350 avss.n7996 avss.n110 12133.3
R8351 avss.n8005 avss.n90 12133.3
R8352 avss.n8692 avss.n90 12133.3
R8353 avss.n534 avss.n371 12011.6
R8354 avss.n831 avss.n686 12011.6
R8355 avss.n2356 avss.n2355 11519
R8356 avss.n2355 avss.n2266 11519
R8357 avss.n3071 avss.n2106 11519
R8358 avss.n3206 avss.n2106 11519
R8359 avss.n7395 avss.n7394 11519
R8360 avss.n3915 avss.n722 11519
R8361 avss.n3915 avss.n3838 11519
R8362 avss.n4374 avss.n3835 11519
R8363 avss.n3835 avss.n3764 11519
R8364 avss.n909 avss.n713 11519
R8365 avss.n7060 avss.n834 11272.6
R8366 avss.n9359 avss.n50 10887.5
R8367 avss.n49 avss.n15 10887.5
R8368 avss.n7984 avss.n7982 10887.5
R8369 avss.n7981 avss.n7720 10887.5
R8370 avss.n1203 avss.n378 10340.9
R8371 avss.n1631 avss.n1203 10340.9
R8372 avss.n3072 avss.n373 9594.57
R8373 avss.n2357 avss.n375 9594.57
R8374 avss.n6890 avss.n6889 9594.57
R8375 avss.n6889 avss.n6888 9594.57
R8376 avss.n6888 avss.n376 9594.57
R8377 avss.n7481 avss.n380 9594.57
R8378 avss.n4375 avss.n835 9594.57
R8379 avss.n3907 avss.n836 9594.57
R8380 avss.n913 avss.n912 9594.57
R8381 avss.n7393 avss.n380 9106.02
R8382 avss.n912 avss.n911 9106.02
R8383 avss.n7034 avss.n951 8725.76
R8384 avss.n6210 avss.n6209 8725.76
R8385 avss.n3683 avss.n834 8698.98
R8386 avss.n3072 avss.n3071 8527.72
R8387 avss.n2357 avss.n2356 8527.72
R8388 avss.n4375 avss.n4374 8527.72
R8389 avss.n3907 avss.n722 8527.72
R8390 avss.n7482 avss.n373 7969.56
R8391 avss.n7482 avss.n375 7969.56
R8392 avss.n7482 avss.n376 7969.56
R8393 avss.n7482 avss.n7481 7969.56
R8394 avss.n7060 avss.n835 7969.56
R8395 avss.n7060 avss.n836 7969.56
R8396 avss.n7060 avss.n913 7969.56
R8397 avss.n7392 avss.n7391 7913.04
R8398 avss.n2368 avss.n2357 7913.04
R8399 avss.n2344 avss.n375 7913.04
R8400 avss.n3073 avss.n3072 7913.04
R8401 avss.n3030 avss.n373 7913.04
R8402 avss.n2133 avss.n534 7913.04
R8403 avss.n2751 avss.n2133 7913.04
R8404 avss.n7391 avss.n494 7913.04
R8405 avss.n2474 avss.n494 7913.04
R8406 avss.n6888 avss.n6887 7913.04
R8407 avss.n6889 avss.n1090 7913.04
R8408 avss.n6890 avss.n996 7913.04
R8409 avss.n1138 avss.n376 7913.04
R8410 avss.n432 avss.n380 7913.04
R8411 avss.n7481 avss.n7480 7913.04
R8412 avss.n4376 avss.n4375 7913.04
R8413 avss.n4409 avss.n835 7913.04
R8414 avss.n4265 avss.n3907 7913.04
R8415 avss.n4298 avss.n836 7913.04
R8416 avss.n912 avss.n908 7913.04
R8417 avss.n913 avss.n837 7913.04
R8418 avss.n910 avss.n674 7913.04
R8419 avss.n4028 avss.n686 7913.04
R8420 avss.n4028 avss.n3428 7913.04
R8421 avss.n3975 avss.n674 7913.04
R8422 avss.n3975 avss.n3666 7913.04
R8423 avss.n2355 avss.n2096 6026.49
R8424 avss.n2355 avss.n2273 6026.49
R8425 avss.n7394 avss.n482 6026.49
R8426 avss.n2106 avss.n482 6026.49
R8427 avss.n2106 avss.n2096 6026.49
R8428 avss.n3916 avss.n3835 6026.49
R8429 avss.n3835 avss.n3834 6026.49
R8430 avss.n909 avss.n720 6026.49
R8431 avss.n3915 avss.n720 6026.49
R8432 avss.n3916 avss.n3915 6026.49
R8433 avss.n7981 avss.n7484 5961.29
R8434 avss.n9129 avss.n9128 4931.97
R8435 avss.n9130 avss.n9129 4261.27
R8436 avss.n1595 avss.n224 3778.76
R8437 avss.n7394 avss.n7393 3757.89
R8438 avss.n911 avss.n909 3757.89
R8439 avss.n9322 avss.n50 3754.29
R8440 avss.n5686 avss.n1176 3714.29
R8441 avss.n6125 avss.n5686 3714.29
R8442 avss.n9130 avss.n223 3503.8
R8443 avss.n7393 avss.n7392 3430.28
R8444 avss.n911 avss.n910 3430.28
R8445 avss.n6891 avss.n6890 3363.04
R8446 avss.n6258 avss.n952 3333.68
R8447 avss.n952 avss.n951 3165.61
R8448 avss.n6209 avss.n4672 2912.54
R8449 avss.n7034 avss.n7033 2903.57
R8450 avss.n1176 avss.n952 2903.57
R8451 avss.n9321 avss.n63 2839.67
R8452 avss.n223 avss.n63 2839.67
R8453 avss.n5354 avss.n5353 2771.64
R8454 avss.n7483 avss.n371 2455.38
R8455 avss.n7060 avss.n831 2132.95
R8456 avss.n9129 avss.n224 1962.62
R8457 avss.n5353 avss.n5352 1926.17
R8458 avss.n6576 avss.n370 1776.27
R8459 avss.n8899 avss.n370 1766.66
R8460 avss.n9322 avss.n9321 1618.61
R8461 avss.n7059 avss.n915 1612.69
R8462 avss.n1226 avss.n370 1595.94
R8463 avss.n2972 avss.n2139 1571.32
R8464 avss.n2774 avss.n2773 1571.32
R8465 avss.n2925 avss.n2924 1571.32
R8466 avss.n3554 avss.n3553 1571.32
R8467 avss.n4123 avss.n4118 1571.32
R8468 avss.n4587 avss.n4533 1571.32
R8469 avss.n7482 avss.n370 1471.34
R8470 avss.t118 avss.n1200 1341.11
R8471 avss.t132 avss.n2021 1339.53
R8472 avss.n2972 avss.t148 1339.53
R8473 avss.t132 avss.n2227 1339.53
R8474 avss.n2773 avss.t161 1339.53
R8475 avss.t132 avss.n2805 1339.53
R8476 avss.n2924 avss.t136 1339.53
R8477 avss.t133 avss.n636 1339.53
R8478 avss.n3553 avss.t141 1339.53
R8479 avss.n4016 avss.t133 1339.53
R8480 avss.n4123 avss.t152 1339.53
R8481 avss.n3644 avss.t133 1339.53
R8482 avss.n4587 avss.t164 1339.53
R8483 avss.n8900 avss.n8899 1331.58
R8484 avss.n7982 avss.n8 1289.1
R8485 avss.n49 avss.n8 1289.1
R8486 avss.n2926 avss.n371 1193.14
R8487 avss.n831 avss.n627 1193.14
R8488 avss.n5053 avss.n834 1190.72
R8489 avss.n7392 avss.n371 1164.03
R8490 avss.n910 avss.n831 1164.03
R8491 avss.n4998 avss.n915 1055.71
R8492 avss.n7059 avss.n7058 986.083
R8493 avss.t118 avss.n6701 971.524
R8494 avss.t132 avss.n2139 944.258
R8495 avss.t132 avss.n2774 944.258
R8496 avss.t132 avss.n2925 944.258
R8497 avss.t133 avss.n3554 944.258
R8498 avss.n4118 avss.t133 944.258
R8499 avss.n4533 avss.t133 944.258
R8500 avss.n7982 avss.n7981 911.091
R8501 avss.n50 avss.n49 911.091
R8502 avss.n6209 avss.n6208 882.588
R8503 avss.n6208 avss.n6207 772.841
R8504 avss.n7035 avss.n7034 739.797
R8505 avss.n7033 avss.n952 739.797
R8506 avss.n6279 avss.n915 723.153
R8507 avss.n2892 avss.n2151 660.169
R8508 avss.n3491 avss.n3490 660.169
R8509 avss.n2950 avss.n2927 638.021
R8510 avss.n4158 avss.n4046 638.021
R8511 avss.n2715 avss.n2150 637.165
R8512 avss.n4565 avss.n4542 637.165
R8513 avss.n7484 avss.n7483 588.952
R8514 avss.n3071 avss.n491 558.153
R8515 avss.n2356 avss.n2084 558.153
R8516 avss.n4374 avss.n4373 558.153
R8517 avss.n7123 avss.n722 558.153
R8518 avss.t53 avss.n951 550.481
R8519 avss.n6091 avss.n1176 426.909
R8520 avss.n5353 avss.n5344 421.913
R8521 avss.n7060 avss.n7059 399.563
R8522 avss.t53 avss.n5616 391.334
R8523 avss.n5686 avss.n5616 388.646
R8524 avss.n8899 avss.n8898 386.755
R8525 avss.n6127 avss.n5683 373.884
R8526 avss.n1226 avss.n377 363.313
R8527 avss.n7759 avss.t7 334.134
R8528 avss.n2668 avss.t160 331.265
R8529 avss.t147 avss.n2084 331.265
R8530 avss.n4373 avss.t151 331.265
R8531 avss.t163 avss.n3767 331.265
R8532 avss.t135 avss.n491 323.471
R8533 avss.n7123 avss.t140 323.471
R8534 avss.n7483 avss.n7482 270.923
R8535 avss.n6002 avss.n5683 219.632
R8536 avss.n6561 avss.n6560 212.703
R8537 avss.n5686 avss.n951 194.591
R8538 avss.n9349 avss.n9322 190.159
R8539 avss.n6279 avss.n6276 177.936
R8540 avss.n6310 avss.n6258 177.936
R8541 avss.n9390 avss.n9389 154.398
R8542 avss.n7059 avss.n914 150.107
R8543 avss.n5026 avss.n4868 131.195
R8544 avss.n6546 avss.n224 129.472
R8545 avss.n1383 avss.n1176 125.633
R8546 avss.n6286 avss.n6276 121.666
R8547 avss.n6294 avss.n6270 121.666
R8548 avss.n6302 avss.n6264 121.666
R8549 avss.n6302 avss.n6257 121.666
R8550 avss.n6310 avss.n6257 121.666
R8551 avss.n5359 avss.n5354 120.3
R8552 avss.n4939 avss.n4931 120.3
R8553 avss.n4999 avss.n4998 120.3
R8554 avss.n7058 avss.n916 120.3
R8555 avss.n8711 avss.n7803 119.986
R8556 avss.n8587 avss.n7893 119.986
R8557 avss.n9320 avss.n64 119.986
R8558 avss.n8033 avss.n7999 112.392
R8559 avss.n9401 avss.n9400 112.392
R8560 avss.n2366 avss.n2358 108.465
R8561 avss.n3093 avss.n3082 108.465
R8562 avss.n4263 avss.n4262 108.465
R8563 avss.n4471 avss.n4470 108.465
R8564 avss.n7412 avss.n473 105.912
R8565 avss.n7107 avss.n783 105.912
R8566 avss.n6599 avss.n6538 104.514
R8567 avss.n6601 avss.n6538 104.514
R8568 avss.n6577 avss.n6571 104.514
R8569 avss.n6577 avss.n6574 104.514
R8570 avss.n6552 avss.n6545 102.376
R8571 avss.n6554 avss.n6545 102.376
R8572 avss.n6559 avss.n6542 102.376
R8573 avss.n6559 avss.n6541 102.376
R8574 avss.n2420 avss.n372 99.4583
R8575 avss.n3165 avss.n374 99.4583
R8576 avss.n4329 avss.n832 99.4583
R8577 avss.n4440 avss.n833 99.4583
R8578 avss.n7463 avss.n379 97.1181
R8579 avss.n7074 avss.n830 97.1181
R8580 avss.n6576 avss.n6572 97.1042
R8581 avss.n6600 avss.n6561 97.1042
R8582 avss.n8899 avss.n7484 94.9118
R8583 avss.n4867 avss.n4821 93.7778
R8584 avss.n6560 avss.n6540 89.8379
R8585 avss.n6553 avss.n6546 89.8379
R8586 avss.n1596 avss.n1583 84.0977
R8587 avss.n1596 avss.n1581 84.0977
R8588 avss.n1384 avss.n1381 84.0977
R8589 avss.n1384 avss.n1379 84.0977
R8590 avss.n6092 avss.n5822 84.0977
R8591 avss.n6092 avss.n5823 84.0977
R8592 avss.n6206 avss.n5598 84.0977
R8593 avss.n6206 avss.n5597 84.0977
R8594 avss.n9319 avss.n66 84.0977
R8595 avss.n9319 avss.n67 84.0977
R8596 avss.n8897 avss.n7489 84.0977
R8597 avss.n8897 avss.n7488 84.0977
R8598 avss.n9132 avss.n206 84.0977
R8599 avss.n9132 avss.n222 84.0977
R8600 avss.n8905 avss.n369 84.0977
R8601 avss.n8903 avss.n369 84.0977
R8602 avss.n8588 avss.n7898 84.0977
R8603 avss.n8588 avss.n8586 84.0977
R8604 avss.n8179 avss.n7487 84.0977
R8605 avss.n8185 avss.n7487 84.0977
R8606 avss.n8712 avss.n7808 84.0977
R8607 avss.n8712 avss.n8710 84.0977
R8608 avss.n8410 avss.n7485 84.0977
R8609 avss.n8418 avss.n7485 84.0977
R8610 avss.n6286 avss.n951 79.8437
R8611 avss.n8904 avss.n8900 77.7166
R8612 avss.n9131 avss.n210 77.7166
R8613 avss.n2286 avss.n2267 77.5306
R8614 avss.n3204 avss.n3203 77.5306
R8615 avss.n4365 avss.n3846 77.5306
R8616 avss.n3826 avss.n3697 77.5306
R8617 avss.n6091 avss.n5824 77.4541
R8618 avss.n1383 avss.n1380 77.4541
R8619 avss.n1595 avss.n1586 77.4541
R8620 avss.n9401 avss.n7 77.199
R8621 avss.n9399 avss.n9 77.199
R8622 avss.n9391 avss.n9390 77.199
R8623 avss.n2368 avss.n2367 75.9644
R8624 avss.n3081 avss.n3073 75.9644
R8625 avss.n4265 avss.n4264 75.9644
R8626 avss.n4376 avss.n3700 75.9644
R8627 avss.n5359 avss.n5106 75.7802
R8628 avss.n5367 avss.n5106 75.7802
R8629 avss.n5367 avss.n5100 75.7802
R8630 avss.n5375 avss.n5100 75.7802
R8631 avss.n5375 avss.n5094 75.7802
R8632 avss.n5383 avss.n5094 75.7802
R8633 avss.n5391 avss.n5088 75.7802
R8634 avss.n5391 avss.n5082 75.7802
R8635 avss.n5400 avss.n5082 75.7802
R8636 avss.n5400 avss.n5075 75.7802
R8637 avss.n5409 avss.n5075 75.7802
R8638 avss.n5409 avss.n5076 75.7802
R8639 avss.n5421 avss.n4803 75.7802
R8640 avss.n5456 avss.n4803 75.7802
R8641 avss.n5456 avss.n4794 75.7802
R8642 avss.n5543 avss.n4692 75.7802
R8643 avss.n5595 avss.n4694 75.7802
R8644 avss.n5587 avss.n4703 75.7802
R8645 avss.t154 avss.n4703 75.7802
R8646 avss.n5578 avss.t154 75.7802
R8647 avss.n5569 avss.n4722 75.7802
R8648 avss.n5569 avss.n4723 75.7802
R8649 avss.n5563 avss.n4723 75.7802
R8650 avss.n4842 avss.n4735 75.7802
R8651 avss.n5045 avss.n4833 75.7802
R8652 avss.n5054 avss.n4827 75.7802
R8653 avss.n5062 avss.n4820 75.7802
R8654 avss.n4939 avss.n4938 75.7802
R8655 avss.n4948 avss.n4876 75.7802
R8656 avss.n5011 avss.n4888 75.7802
R8657 avss.n4964 avss.n4963 75.7802
R8658 avss.n4973 avss.n4964 75.7802
R8659 avss.n4973 avss.n4904 75.7802
R8660 avss.n925 avss.n916 75.7802
R8661 avss.n7050 avss.n925 75.7802
R8662 avss.n7050 avss.n926 75.7802
R8663 avss.n7044 avss.n926 75.7802
R8664 avss.n7044 avss.n7043 75.7802
R8665 avss.n7043 avss.n7042 75.7802
R8666 avss.n7036 avss.n948 75.7802
R8667 avss.n6360 avss.n950 75.7802
R8668 avss.n6382 avss.n6360 75.7802
R8669 avss.n6382 avss.n6330 75.7802
R8670 avss.n6390 avss.n6330 75.7802
R8671 avss.n6341 avss.n6336 75.7802
R8672 avss.n6341 avss.n1062 75.7802
R8673 avss.n6913 avss.n1062 75.7802
R8674 avss.n7331 avss.n7329 75.7064
R8675 avss.n782 avss.n714 75.7064
R8676 avss.n8758 avss.n8757 75.5819
R8677 avss.n8747 avss.n7781 75.5819
R8678 avss.n8674 avss.n7792 75.5819
R8679 avss.n8682 avss.n7836 75.5819
R8680 avss.n8702 avss.n7815 75.5819
R8681 avss.n8533 avss.n7859 75.5819
R8682 avss.n8616 avss.n7879 75.5819
R8683 avss.n8551 avss.n7882 75.5819
R8684 avss.n8559 avss.n7926 75.5819
R8685 avss.n8578 avss.n7905 75.5819
R8686 avss.n8376 avss.n8369 75.5819
R8687 avss.n9230 avss.n117 75.5819
R8688 avss.n9262 avss.n102 75.5819
R8689 avss.n9271 avss.n9270 75.5819
R8690 avss.n9293 avss.n82 75.5819
R8691 avss.n472 avss.n432 74.177
R8692 avss.n908 avss.n838 74.177
R8693 avss.n8651 avss.n7779 72.7476
R8694 avss.n8628 avss.n8622 72.7476
R8695 avss.n9221 avss.n125 72.7476
R8696 avss.n8034 avss.n8033 72.0903
R8697 avss.n9350 avss.n9349 72.0903
R8698 avss.n4997 avss.n4983 68.9311
R8699 avss.n4997 avss.n4984 68.9311
R8700 avss.n5007 avss.n4903 68.9311
R8701 avss.n5007 avss.n4902 68.9311
R8702 avss.n5009 avss.n4875 68.9311
R8703 avss.n5009 avss.n4890 68.9311
R8704 avss.n4877 avss.n4874 68.9311
R8705 avss.n5019 avss.n4874 68.9311
R8706 avss.n5025 avss.n4869 68.9311
R8707 avss.n4869 avss.n4865 68.9311
R8708 avss.n5029 avss.n5028 68.9311
R8709 avss.n5029 avss.n4864 68.9311
R8710 avss.n5035 avss.n4856 68.9311
R8711 avss.n4856 avss.n4855 68.9311
R8712 avss.n5561 avss.n4737 68.9311
R8713 avss.n5561 avss.n4736 68.9311
R8714 avss.n7404 avss.n478 68.9311
R8715 avss.n7404 avss.n479 68.9311
R8716 avss.n511 avss.n509 68.9311
R8717 avss.n7381 avss.n511 68.9311
R8718 avss.n7466 avss.n397 68.9311
R8719 avss.n7466 avss.n7465 68.9311
R8720 avss.n396 avss.n394 68.9311
R8721 avss.n7471 avss.n396 68.9311
R8722 avss.n7432 avss.n418 68.9311
R8723 avss.n7432 avss.n419 68.9311
R8724 avss.n7426 avss.n425 68.9311
R8725 avss.n7424 avss.n425 68.9311
R8726 avss.n7411 avss.n428 68.9311
R8727 avss.n7413 avss.n428 68.9311
R8728 avss.n476 avss.n431 68.9311
R8729 avss.n476 avss.n474 68.9311
R8730 avss.n6859 avss.n1126 68.9311
R8731 avss.n6859 avss.n1127 68.9311
R8732 avss.n6869 avss.n1113 68.9311
R8733 avss.n6869 avss.n1112 68.9311
R8734 avss.n1110 avss.n1107 68.9311
R8735 avss.n6813 avss.n1110 68.9311
R8736 avss.n1106 avss.n1104 68.9311
R8737 avss.n6875 avss.n1106 68.9311
R8738 avss.n6807 avss.n1164 68.9311
R8739 avss.n6807 avss.n1165 68.9311
R8740 avss.n1168 avss.n1167 68.9311
R8741 avss.n6803 avss.n1168 68.9311
R8742 avss.n6789 avss.n1170 68.9311
R8743 avss.n6791 avss.n1170 68.9311
R8744 avss.n6990 avss.n1011 68.9311
R8745 avss.n6990 avss.n1010 68.9311
R8746 avss.n2658 avss.n2279 68.9311
R8747 avss.n2658 avss.n2453 68.9311
R8748 avss.n2278 avss.n2276 68.9311
R8749 avss.n2665 avss.n2278 68.9311
R8750 avss.n3215 avss.n2088 68.9311
R8751 avss.n3215 avss.n2093 68.9311
R8752 avss.n2087 avss.n2085 68.9311
R8753 avss.n3222 avss.n2087 68.9311
R8754 avss.n2336 avss.n2323 68.9311
R8755 avss.n2323 avss.n2322 68.9311
R8756 avss.n2428 avss.n2311 68.9311
R8757 avss.n2428 avss.n2310 68.9311
R8758 avss.n2430 avss.n2292 68.9311
R8759 avss.n2430 avss.n2307 68.9311
R8760 avss.n2294 avss.n2291 68.9311
R8761 avss.n2440 avss.n2291 68.9311
R8762 avss.n2365 avss.n2287 68.9311
R8763 avss.n2365 avss.n2285 68.9311
R8764 avss.n2449 avss.n2282 68.9311
R8765 avss.n2447 avss.n2282 68.9311
R8766 avss.n3156 avss.n3155 68.9311
R8767 avss.n3157 avss.n3156 68.9311
R8768 avss.n3149 avss.n3015 68.9311
R8769 avss.n3149 avss.n3016 68.9311
R8770 avss.n3085 avss.n3019 68.9311
R8771 avss.n3064 avss.n3019 68.9311
R8772 avss.n3099 avss.n3060 68.9311
R8773 avss.n3099 avss.n3059 68.9311
R8774 avss.n3092 avss.n3062 68.9311
R8775 avss.n3094 avss.n3062 68.9311
R8776 avss.n3070 avss.n2091 68.9311
R8777 avss.n3083 avss.n2091 68.9311
R8778 avss.n4428 avss.n3734 68.9311
R8779 avss.n4438 avss.n4428 68.9311
R8780 avss.n3736 avss.n3733 68.9311
R8781 avss.n4451 avss.n3733 68.9311
R8782 avss.n4457 avss.n3726 68.9311
R8783 avss.n3726 avss.n3724 68.9311
R8784 avss.n4467 avss.n3710 68.9311
R8785 avss.n4467 avss.n3709 68.9311
R8786 avss.n4469 avss.n3696 68.9311
R8787 avss.n4469 avss.n3699 68.9311
R8788 avss.n3698 avss.n3695 68.9311
R8789 avss.n4473 avss.n3695 68.9311
R8790 avss.n4317 avss.n3877 68.9311
R8791 avss.n4327 avss.n4317 68.9311
R8792 avss.n3879 avss.n3876 68.9311
R8793 avss.n4340 avss.n3876 68.9311
R8794 avss.n4346 avss.n3871 68.9311
R8795 avss.n3871 avss.n3869 68.9311
R8796 avss.n4356 avss.n3855 68.9311
R8797 avss.n4356 avss.n3854 68.9311
R8798 avss.n3852 avss.n3849 68.9311
R8799 avss.n4261 avss.n3852 68.9311
R8800 avss.n3848 avss.n3847 68.9311
R8801 avss.n4363 avss.n3848 68.9311
R8802 avss.n7073 avss.n820 68.9311
R8803 avss.n7073 avss.n7071 68.9311
R8804 avss.n822 avss.n819 68.9311
R8805 avss.n7084 avss.n819 68.9311
R8806 avss.n7090 avss.n814 68.9311
R8807 avss.n814 avss.n812 68.9311
R8808 avss.n7100 avss.n798 68.9311
R8809 avss.n7100 avss.n797 68.9311
R8810 avss.n7106 avss.n784 68.9311
R8811 avss.n784 avss.n780 68.9311
R8812 avss.n7110 avss.n7109 68.9311
R8813 avss.n7110 avss.n779 68.9311
R8814 avss.n7112 avss.n771 68.9311
R8815 avss.n7112 avss.n773 68.9311
R8816 avss.n7167 avss.n679 68.9311
R8817 avss.n7167 avss.n678 68.9311
R8818 avss.n4255 avss.n3911 68.9311
R8819 avss.n4255 avss.n3912 68.9311
R8820 avss.n4215 avss.n3940 68.9311
R8821 avss.n4215 avss.n3937 68.9311
R8822 avss.n4479 avss.n3688 68.9311
R8823 avss.n4481 avss.n3688 68.9311
R8824 avss.n4497 avss.n3681 68.9311
R8825 avss.n4497 avss.n3680 68.9311
R8826 avss.n9311 avss.n65 68.4449
R8827 avss.n9313 avss.n65 68.4449
R8828 avss.n74 avss.n73 68.4449
R8829 avss.n9305 avss.n74 68.4449
R8830 avss.n9247 avss.n9246 68.4449
R8831 avss.n9248 avss.n9247 68.4449
R8832 avss.n9252 avss.n9239 68.4449
R8833 avss.n9252 avss.n9238 68.4449
R8834 avss.n9392 avss.n13 68.4449
R8835 avss.n14 avss.n13 68.4449
R8836 avss.n9398 avss.n11 68.4449
R8837 avss.n9398 avss.n10 68.4449
R8838 avss.n9402 avss.n5 68.4449
R8839 avss.n9402 avss.n6 68.4449
R8840 avss.n8012 avss.n8003 68.4449
R8841 avss.n8010 avss.n8003 68.4449
R8842 avss.n1594 avss.n1591 68.4449
R8843 avss.n1594 avss.n1593 68.4449
R8844 avss.n6675 avss.n1240 68.4449
R8845 avss.n6675 avss.n1239 68.4449
R8846 avss.n6685 avss.n1218 68.4449
R8847 avss.n6685 avss.n1223 68.4449
R8848 avss.n1217 avss.n1216 68.4449
R8849 avss.n6691 avss.n1217 68.4449
R8850 avss.n1647 avss.n1248 68.4449
R8851 avss.n1649 avss.n1248 68.4449
R8852 avss.n1251 avss.n1247 68.4449
R8853 avss.n1641 avss.n1251 68.4449
R8854 avss.n6090 avss.n5825 68.4449
R8855 avss.n6090 avss.n5826 68.4449
R8856 avss.n5832 avss.n5829 68.4449
R8857 avss.n6084 avss.n5829 68.4449
R8858 avss.n5860 avss.n5855 68.4449
R8859 avss.n5855 avss.n5854 68.4449
R8860 avss.n6099 avss.n5724 68.4449
R8861 avss.n6099 avss.n5723 68.4449
R8862 avss.n6109 avss.n5703 68.4449
R8863 avss.n6109 avss.n5708 68.4449
R8864 avss.n5702 avss.n5701 68.4449
R8865 avss.n6115 avss.n5702 68.4449
R8866 avss.n9141 avss.n212 68.4449
R8867 avss.n212 avss.n209 68.4449
R8868 avss.n217 avss.n216 68.4449
R8869 avss.n216 avss.n211 68.4449
R8870 avss.n9163 avss.n182 68.4449
R8871 avss.n9165 avss.n182 68.4449
R8872 avss.n9169 avss.n179 68.4449
R8873 avss.n9169 avss.n178 68.4449
R8874 avss.n9184 avss.n9179 68.4449
R8875 avss.n9179 avss.n164 68.4449
R8876 avss.n9194 avss.n150 68.4449
R8877 avss.n9194 avss.n149 68.4449
R8878 avss.n8603 avss.n7892 68.4449
R8879 avss.n8605 avss.n7892 68.4449
R8880 avss.n7894 avss.n7891 68.4449
R8881 avss.n8597 avss.n7894 68.4449
R8882 avss.n7924 avss.n7919 68.4449
R8883 avss.n7919 avss.n7918 68.4449
R8884 avss.n8612 avss.n7884 68.4449
R8885 avss.n8612 avss.n7883 68.4449
R8886 avss.n8627 avss.n7867 68.4449
R8887 avss.n8629 avss.n7867 68.4449
R8888 avss.n8633 avss.n7861 68.4449
R8889 avss.n8633 avss.n7860 68.4449
R8890 avss.n8727 avss.n7802 68.4449
R8891 avss.n8729 avss.n7802 68.4449
R8892 avss.n7804 avss.n7801 68.4449
R8893 avss.n8721 avss.n7804 68.4449
R8894 avss.n7834 avss.n7829 68.4449
R8895 avss.n7829 avss.n7828 68.4449
R8896 avss.n8739 avss.n7794 68.4449
R8897 avss.n8739 avss.n7793 68.4449
R8898 avss.n8749 avss.n7773 68.4449
R8899 avss.n8749 avss.n7778 68.4449
R8900 avss.n7772 avss.n7771 68.4449
R8901 avss.n8755 avss.n7772 68.4449
R8902 avss.n8379 avss.n126 68.4449
R8903 avss.n8379 avss.n8378 68.4449
R8904 avss.n9220 avss.n127 68.4449
R8905 avss.n127 avss.n124 68.4449
R8906 avss.n4741 avss.n4711 67.7644
R8907 avss.n5556 avss.n4741 67.7644
R8908 avss.n4704 avss.n4702 67.7644
R8909 avss.n5586 avss.n4704 67.7644
R8910 avss.n7374 avss.n516 67.7644
R8911 avss.n7305 avss.n516 67.7644
R8912 avss.n7285 avss.n528 67.7644
R8913 avss.n7287 avss.n528 67.7644
R8914 avss.n1015 avss.n984 67.7644
R8915 avss.n6985 avss.n1015 67.7644
R8916 avss.n977 avss.n975 67.7644
R8917 avss.n7015 avss.n977 67.7644
R8918 avss.n2489 avss.n2486 67.7644
R8919 avss.n2596 avss.n2489 67.7644
R8920 avss.n2747 avss.n2254 67.7644
R8921 avss.n2747 avss.n2253 67.7644
R8922 avss.n3244 avss.n2048 67.7644
R8923 avss.n2050 avss.n2048 67.7644
R8924 avss.n2040 avss.n2037 67.7644
R8925 avss.n3251 avss.n2037 67.7644
R8926 avss.n7181 avss.n661 67.7644
R8927 avss.n663 avss.n661 67.7644
R8928 avss.n653 avss.n650 67.7644
R8929 avss.n7188 avss.n650 67.7644
R8930 avss.n4208 avss.n3947 67.7644
R8931 avss.n4210 avss.n3947 67.7644
R8932 avss.n4195 avss.n3995 67.7644
R8933 avss.n4193 avss.n3995 67.7644
R8934 avss.n3686 avss.n3654 67.7644
R8935 avss.n4492 avss.n3686 67.7644
R8936 avss.n4525 avss.n4524 67.7644
R8937 avss.n4525 avss.n3566 67.7644
R8938 avss.n8720 avss.n7805 67.079
R8939 avss.n8596 avss.n7895 67.079
R8940 avss.n9304 avss.n75 67.079
R8941 avss.n9388 avss.n16 66.6949
R8942 avss.n9348 avss.n60 66.6949
R8943 avss.n9348 avss.n62 66.6949
R8944 avss.n9388 avss.n17 66.6949
R8945 avss.n6389 avss.n6329 66.6949
R8946 avss.n6391 avss.n6329 66.6949
R8947 avss.n7057 avss.n918 66.6949
R8948 avss.n7057 avss.n917 66.6949
R8949 avss.n5545 avss.n4747 66.6949
R8950 avss.n5545 avss.n4748 66.6949
R8951 avss.n5422 avss.n4808 66.6949
R8952 avss.n5420 avss.n4808 66.6949
R8953 avss.n5000 avss.n4913 66.6949
R8954 avss.n4982 avss.n4913 66.6949
R8955 avss.n4937 avss.n4930 66.6949
R8956 avss.n4940 avss.n4930 66.6949
R8957 avss.n5061 avss.n4819 66.6949
R8958 avss.n5063 avss.n4819 66.6949
R8959 avss.n5576 avss.n4715 66.6949
R8960 avss.n5576 avss.n4714 66.6949
R8961 avss.n5589 avss.n4696 66.6949
R8962 avss.n5589 avss.n4700 66.6949
R8963 avss.n5468 avss.n4787 66.6949
R8964 avss.n5468 avss.n4790 66.6949
R8965 avss.n5416 avss.n4810 66.6949
R8966 avss.n5416 avss.n4811 66.6949
R8967 avss.n5360 avss.n5110 66.6949
R8968 avss.n5358 avss.n5110 66.6949
R8969 avss.n3286 avss.n1753 66.6949
R8970 avss.n3286 avss.n1750 66.6949
R8971 avss.n1944 avss.n1943 66.6949
R8972 avss.n1944 avss.n1924 66.6949
R8973 avss.n1752 avss.n1747 66.6949
R8974 avss.n3316 avss.n1747 66.6949
R8975 avss.n1889 avss.n1888 66.6949
R8976 avss.n1889 avss.n1855 66.6949
R8977 avss.n7280 avss.n532 66.6949
R8978 avss.n7280 avss.n533 66.6949
R8979 avss.n2000 avss.n1994 66.6949
R8980 avss.n3283 avss.n2000 66.6949
R8981 avss.n546 avss.n544 66.6949
R8982 avss.n7269 avss.n546 66.6949
R8983 avss.n2893 avss.n2853 66.6949
R8984 avss.n2923 avss.n2853 66.6949
R8985 avss.n7462 avss.n402 66.6949
R8986 avss.n402 avss.n401 66.6949
R8987 avss.n471 avss.n434 66.6949
R8988 avss.n471 avss.n433 66.6949
R8989 avss.n7332 avss.n490 66.6949
R8990 avss.n7333 avss.n7332 66.6949
R8991 avss.n7308 avss.n7306 66.6949
R8992 avss.n7371 avss.n7308 66.6949
R8993 avss.n8032 avss.n7995 66.6949
R8994 avss.n8032 avss.n7998 66.6949
R8995 avss.n8062 avss.n7945 66.6949
R8996 avss.n8062 avss.n7944 66.6949
R8997 avss.n6974 avss.n1021 66.6949
R8998 avss.n6974 avss.n6973 66.6949
R8999 avss.n6352 avss.n6333 66.6949
R9000 avss.n6352 avss.n6332 66.6949
R9001 avss.n6862 avss.n1123 66.6949
R9002 avss.n1125 avss.n1123 66.6949
R9003 avss.n1094 avss.n1092 66.6949
R9004 avss.n6885 avss.n1094 66.6949
R9005 avss.n6771 avss.n6760 66.6949
R9006 avss.n6773 avss.n6760 66.6949
R9007 avss.n7005 avss.n988 66.6949
R9008 avss.n7005 avss.n987 66.6949
R9009 avss.n7018 avss.n969 66.6949
R9010 avss.n7018 avss.n973 66.6949
R9011 avss.n6911 avss.n1066 66.6949
R9012 avss.n6911 avss.n1065 66.6949
R9013 avss.n2749 avss.n2249 66.6949
R9014 avss.n2749 avss.n2250 66.6949
R9015 avss.n2550 avss.n1996 66.6949
R9016 avss.n2550 avss.n1998 66.6949
R9017 avss.n2744 avss.n2257 66.6949
R9018 avss.n2744 avss.n2258 66.6949
R9019 avss.n2714 avss.n2236 66.6949
R9020 avss.n2772 avss.n2236 66.6949
R9021 avss.n2187 avss.n2031 66.6949
R9022 avss.n2187 avss.n2183 66.6949
R9023 avss.n2161 avss.n1995 66.6949
R9024 avss.n2161 avss.n1999 66.6949
R9025 avss.n2996 avss.n2118 66.6949
R9026 avss.n2998 avss.n2118 66.6949
R9027 avss.n2951 avss.n2143 66.6949
R9028 avss.n2971 avss.n2143 66.6949
R9029 avss.n2421 avss.n2321 66.6949
R9030 avss.n2419 avss.n2321 66.6949
R9031 avss.n2374 avss.n2354 66.6949
R9032 avss.n2377 avss.n2354 66.6949
R9033 avss.n2676 avss.n2265 66.6949
R9034 avss.n2678 avss.n2265 66.6949
R9035 avss.n2608 avss.n2482 66.6949
R9036 avss.n2608 avss.n2480 66.6949
R9037 avss.n3164 avss.n3007 66.6949
R9038 avss.n3166 avss.n3007 66.6949
R9039 avss.n3080 avss.n3074 66.6949
R9040 avss.n3080 avss.n3056 66.6949
R9041 avss.n3202 avss.n2104 66.6949
R9042 avss.n3202 avss.n2107 66.6949
R9043 avss.n2053 avss.n2051 66.6949
R9044 avss.n3241 avss.n2053 66.6949
R9045 avss.n4442 avss.n3739 66.6949
R9046 avss.n4442 avss.n4441 66.6949
R9047 avss.n4384 avss.n3763 66.6949
R9048 avss.n4382 avss.n3763 66.6949
R9049 avss.n4331 avss.n3882 66.6949
R9050 avss.n4331 avss.n4330 66.6949
R9051 avss.n4273 avss.n3906 66.6949
R9052 avss.n4271 avss.n3906 66.6949
R9053 avss.n7075 avss.n825 66.6949
R9054 avss.n7075 avss.n829 66.6949
R9055 avss.n840 avss.n839 66.6949
R9056 avss.n906 avss.n840 66.6949
R9057 avss.n7131 avss.n712 66.6949
R9058 avss.n7133 avss.n712 66.6949
R9059 avss.n666 avss.n664 66.6949
R9060 avss.n7178 avss.n666 66.6949
R9061 avss.n4366 avss.n3840 66.6949
R9062 avss.n4366 avss.n3844 66.6949
R9063 avss.n3957 avss.n3955 66.6949
R9064 avss.n3983 avss.n3957 66.6949
R9065 avss.n3828 avss.n3774 66.6949
R9066 avss.n3825 avss.n3774 66.6949
R9067 avss.n4512 avss.n3658 66.6949
R9068 avss.n4512 avss.n3657 66.6949
R9069 avss.n4586 avss.n4537 66.6949
R9070 avss.n4611 avss.n3413 66.6949
R9071 avss.n4613 avss.n3413 66.6949
R9072 avss.n4566 avss.n4537 66.6949
R9073 avss.n7224 avss.n573 66.6949
R9074 avss.n7224 avss.n574 66.6949
R9075 avss.n5343 avss.n5115 66.6949
R9076 avss.n5343 avss.n5114 66.6949
R9077 avss.n7153 avss.n644 66.6949
R9078 avss.n7153 avss.n685 66.6949
R9079 avss.n603 avss.n597 66.6949
R9080 avss.n7221 avss.n603 66.6949
R9081 avss.n3531 avss.n3487 66.6949
R9082 avss.n3531 avss.n3530 66.6949
R9083 avss.n698 avss.n696 66.6949
R9084 avss.n7142 avss.n698 66.6949
R9085 avss.n575 avss.n571 66.6949
R9086 avss.n7243 avss.n571 66.6949
R9087 avss.n5201 avss.n5111 66.6949
R9088 avss.n5209 avss.n5111 66.6949
R9089 avss.n4187 avss.n4026 66.6949
R9090 avss.n4187 avss.n4027 66.6949
R9091 avss.n4085 avss.n598 66.6949
R9092 avss.n4085 avss.n602 66.6949
R9093 avss.n4139 avss.n4138 66.6949
R9094 avss.n4140 avss.n4139 66.6949
R9095 avss.n4040 avss.n4038 66.6949
R9096 avss.n4176 avss.n4040 66.6949
R9097 avss.n3647 avss.n3565 66.6949
R9098 avss.n3565 avss.n3559 66.6949
R9099 avss.n3617 avss.n599 66.6949
R9100 avss.n3617 avss.n601 66.6949
R9101 avss.n5279 avss.n5113 66.6949
R9102 avss.n5247 avss.n5113 66.6949
R9103 avss.n7241 avss.n579 66.6949
R9104 avss.n579 avss.n576 66.6949
R9105 avss.n1826 avss.n1819 66.6949
R9106 avss.n1826 avss.n1821 66.6949
R9107 avss.n3314 avss.n1755 66.6949
R9108 avss.n1755 avss.n1749 66.6949
R9109 avss.n5006 avss.n5005 66.3077
R9110 avss.n5352 avss.n4690 65.4818
R9111 avss.n6235 avss.n4672 65.4818
R9112 avss.n5076 avss.n4809 65.3605
R9113 avss.n5421 avss.n5417 65.3605
R9114 avss.n4701 avss.n4694 65.3605
R9115 avss.n5588 avss.n5587 65.3605
R9116 avss.n5563 avss.n5562 65.3605
R9117 avss.n6390 avss.n6353 65.3605
R9118 avss.n6336 avss.n6331 65.3605
R9119 avss.n5005 avss.n4906 64.8868
R9120 avss.n6280 avss.n6277 64.7505
R9121 avss.n6311 avss.n6256 64.7505
R9122 avss.n6309 avss.n6256 64.7505
R9123 avss.n6280 avss.n6275 64.7505
R9124 avss.n5351 avss.n5345 64.7505
R9125 avss.n6236 avss.n4670 64.7505
R9126 avss.n6234 avss.n4670 64.7505
R9127 avss.n5351 avss.n4689 64.7505
R9128 avss.n5467 avss.n5466 63.466
R9129 avss.n5544 avss.n4749 63.466
R9130 avss.n5577 avss.n4713 63.466
R9131 avss.n4740 avss.n4739 63.466
R9132 avss.n6912 avss.n1064 63.466
R9133 avss.n8693 avss.n7822 63.2999
R9134 avss.n8569 avss.n7912 63.2999
R9135 avss.n9279 avss.n89 63.2999
R9136 avss.n2376 avss.n2375 62.6511
R9137 avss.n2385 avss.n2293 62.6511
R9138 avss.n2432 avss.n2305 62.6511
R9139 avss.n2401 avss.n2400 62.6511
R9140 avss.n2410 avss.n2312 62.6511
R9141 avss.n3101 avss.n3057 62.6511
R9142 avss.n3109 avss.n3049 62.6511
R9143 avss.n3119 avss.n3118 62.6511
R9144 avss.n3127 avss.n3037 62.6511
R9145 avss.n3139 avss.n3021 62.6511
R9146 avss.n4272 avss.n3856 62.6511
R9147 avss.n4354 avss.n3858 62.6511
R9148 avss.n4288 avss.n3870 62.6511
R9149 avss.n4299 avss.n3898 62.6511
R9150 avss.n4308 avss.n3891 62.6511
R9151 avss.n4383 avss.n3711 62.6511
R9152 avss.n4465 avss.n3713 62.6511
R9153 avss.n4399 avss.n3725 62.6511
R9154 avss.n4410 avss.n3755 62.6511
R9155 avss.n4419 avss.n3748 62.6511
R9156 avss.n2926 avss.n2150 61.9274
R9157 avss.n4542 avss.n627 61.9274
R9158 avss.n7816 avss.n7805 61.4104
R9159 avss.n7906 avss.n7895 61.4104
R9160 avss.n9292 avss.n75 61.4104
R9161 avss.n453 avss.n452 61.177
R9162 avss.n464 avss.n426 61.177
R9163 avss.n7435 avss.n7434 61.177
R9164 avss.n7444 avss.n381 61.177
R9165 avss.n7479 avss.n383 61.177
R9166 avss.n907 avss.n799 61.177
R9167 avss.n7098 avss.n801 61.177
R9168 avss.n891 avss.n813 61.177
R9169 avss.n885 avss.n857 61.177
R9170 avss.n879 avss.n872 61.177
R9171 avss.n6294 avss.t113 60.8334
R9172 avss.t113 avss.n6264 60.8334
R9173 avss.n4931 avss.n4868 60.6242
R9174 avss.n2926 avss.n2151 59.9621
R9175 avss.n3490 avss.n627 59.9621
R9176 avss.n2927 avss.n2926 59.1235
R9177 avss.n4046 avss.n627 59.1235
R9178 avss.n8741 avss.n8740 57.6313
R9179 avss.n8614 avss.n8613 57.6313
R9180 avss.n9254 avss.n9253 57.6313
R9181 avss.n5466 avss.n4796 56.8352
R9182 avss.n5475 avss.n4788 56.8352
R9183 avss.n5486 avss.n5485 56.8352
R9184 avss.n5506 avss.n4771 56.8352
R9185 avss.n5505 avss.n4774 56.8352
R9186 avss.n5514 avss.n4763 56.8352
R9187 avss.n5534 avss.n4756 56.8352
R9188 avss.n5533 avss.n4749 56.8352
R9189 avss.n4739 avss.n4713 56.8352
R9190 avss.n1064 avss.n1053 56.8352
R9191 avss.n6923 avss.n1054 56.8352
R9192 avss.n6933 avss.n1037 56.8352
R9193 avss.n6949 avss.n6948 56.8352
R9194 avss.n1040 avss.n1028 56.8352
R9195 avss.n6965 avss.n1029 56.8352
R9196 avss.n7032 avss.n954 56.8352
R9197 avss.n8741 avss.n7790 56.6865
R9198 avss.n8615 avss.n8614 56.6865
R9199 avss.n9254 avss.n110 56.6865
R9200 avss.n8748 avss.n7779 55.7418
R9201 avss.n8622 avss.n7870 55.7418
R9202 avss.n125 avss.n116 55.7418
R9203 avss.n2410 avss.n2344 55.6029
R9204 avss.n3139 avss.n3030 55.6029
R9205 avss.n4298 avss.n3891 55.6029
R9206 avss.n4409 avss.n3748 55.6029
R9207 avss.n2726 avss.n2248 55.2022
R9208 avss.n2737 avss.n2726 55.2022
R9209 avss.n2737 avss.n2255 55.2022
R9210 avss.n2591 avss.n2256 55.2022
R9211 avss.n2591 avss.t124 55.2022
R9212 avss.n2606 avss.t124 55.2022
R9213 avss.n2615 avss.n2614 55.2022
R9214 avss.n2625 avss.n2475 55.2022
R9215 avss.n2635 avss.n2275 55.2022
R9216 avss.n2646 avss.n2454 55.2022
R9217 avss.n4604 avss.n3421 55.2022
R9218 avss.n4604 avss.n3414 55.2022
R9219 avss.n4612 avss.n3414 55.2022
R9220 avss.n4523 avss.n4522 55.2022
R9221 avss.n4522 avss.t157 55.2022
R9222 avss.n4514 avss.t157 55.2022
R9223 avss.n4505 avss.n3665 55.2022
R9224 avss.n4499 avss.n3677 55.2022
R9225 avss.n3789 avss.n3679 55.2022
R9226 avss.n3814 avss.n3689 55.2022
R9227 avss.n5417 avss.n4809 54.9408
R9228 avss.n5588 avss.n4701 54.9408
R9229 avss.n6353 avss.n6331 54.9408
R9230 avss.n2427 avss.n2426 54.8198
R9231 avss.n3148 avss.n3147 54.8198
R9232 avss.n3892 avss.n3878 54.8198
R9233 avss.n3749 avss.n3735 54.8198
R9234 avss.n7480 avss.n7479 54.2946
R9235 avss.n872 avss.n837 54.2946
R9236 avss.n2426 avss.n2314 53.6451
R9237 avss.n3147 avss.n3024 53.6451
R9238 avss.n4339 avss.n3878 53.6451
R9239 avss.n4450 avss.n3735 53.6451
R9240 avss.n7473 avss.n392 53.5299
R9241 avss.n873 avss.n821 53.5299
R9242 avss.n6584 avss.n6572 52.846
R9243 avss.n6584 avss.n6573 52.846
R9244 avss.n6592 avss.n6539 52.846
R9245 avss.n6600 avss.n6539 52.846
R9246 avss.n2989 avss.n2126 52.6321
R9247 avss.n2989 avss.n2119 52.6321
R9248 avss.n2997 avss.n2119 52.6321
R9249 avss.n3250 avss.n3249 52.6321
R9250 avss.n3249 avss.t128 52.6321
R9251 avss.t128 avss.n2042 52.6321
R9252 avss.n3236 avss.n2060 52.6321
R9253 avss.n3230 avss.n2073 52.6321
R9254 avss.n3224 avss.n2082 52.6321
R9255 avss.n3187 avss.n2094 52.6321
R9256 avss.n4185 avss.n4030 52.6321
R9257 avss.n4179 avss.n4030 52.6321
R9258 avss.n4179 avss.n4178 52.6321
R9259 avss.n4194 avss.n3990 52.6321
R9260 avss.t144 avss.n3990 52.6321
R9261 avss.t144 avss.n3991 52.6321
R9262 avss.n3976 avss.n3960 52.6321
R9263 avss.n4217 avss.n3935 52.6321
R9264 avss.n4225 avss.n3929 52.6321
R9265 avss.n4244 avss.n3913 52.6321
R9266 avss.n5683 avss.t53 52.5147
R9267 avss.n7473 avss.n7472 52.3829
R9268 avss.n7083 avss.n821 52.3829
R9269 avss.n7278 avss.n536 51.5878
R9270 avss.n7272 avss.n536 51.5878
R9271 avss.n7272 avss.n7271 51.5878
R9272 avss.n7286 avss.n523 51.5878
R9273 avss.t130 avss.n523 51.5878
R9274 avss.t130 avss.n524 51.5878
R9275 avss.n7311 avss.n495 51.5878
R9276 avss.n7390 avss.n497 51.5878
R9277 avss.n7384 avss.n7383 51.5878
R9278 avss.n7351 avss.n480 51.5878
R9279 avss.n7151 avss.n688 51.5878
R9280 avss.n7145 avss.n688 51.5878
R9281 avss.n7145 avss.n7144 51.5878
R9282 avss.n7187 avss.n7186 51.5878
R9283 avss.n7186 avss.t126 51.5878
R9284 avss.t126 avss.n655 51.5878
R9285 avss.n749 avss.n748 51.5878
R9286 avss.n7170 avss.n7169 51.5878
R9287 avss.n723 avss.n677 51.5878
R9288 avss.n7114 avss.n735 51.5878
R9289 avss.n4834 avss.n4827 51.1518
R9290 avss.n8693 avss.n8692 51.0179
R9291 avss.n8569 avss.n196 51.0179
R9292 avss.n9279 avss.n90 51.0179
R9293 avss.n6208 avss.n5595 50.6781
R9294 avss.n5054 avss.n5053 50.2045
R9295 avss.n2367 avss.n2366 50.121
R9296 avss.n3082 avss.n3081 50.121
R9297 avss.n4264 avss.n4263 50.121
R9298 avss.n4470 avss.n3700 50.121
R9299 avss.n8758 avss.n7768 50.0732
R9300 avss.n8634 avss.n7859 50.0732
R9301 avss.n8380 avss.n8369 50.0732
R9302 avss.n8904 avss.n365 48.9555
R9303 avss.n8912 avss.n365 48.9555
R9304 avss.n8912 avss.n359 48.9555
R9305 avss.n8920 avss.n359 48.9555
R9306 avss.n8920 avss.n353 48.9555
R9307 avss.n8928 avss.n353 48.9555
R9308 avss.n8928 avss.n347 48.9555
R9309 avss.n8936 avss.n347 48.9555
R9310 avss.n8936 avss.n341 48.9555
R9311 avss.n8944 avss.n341 48.9555
R9312 avss.n8944 avss.n335 48.9555
R9313 avss.n8952 avss.n335 48.9555
R9314 avss.n8952 avss.n329 48.9555
R9315 avss.n8960 avss.n329 48.9555
R9316 avss.n8960 avss.n323 48.9555
R9317 avss.n8968 avss.n323 48.9555
R9318 avss.n8968 avss.n317 48.9555
R9319 avss.n8979 avss.n317 48.9555
R9320 avss.n8979 avss.n311 48.9555
R9321 avss.n8988 avss.n311 48.9555
R9322 avss.n8988 avss.n225 48.9555
R9323 avss.n9127 avss.n227 48.9555
R9324 avss.n9121 avss.n227 48.9555
R9325 avss.n9121 avss.n9120 48.9555
R9326 avss.n9120 avss.n9119 48.9555
R9327 avss.n9119 avss.n239 48.9555
R9328 avss.n9113 avss.n239 48.9555
R9329 avss.n9113 avss.n9112 48.9555
R9330 avss.n9112 avss.n9111 48.9555
R9331 avss.n9111 avss.n250 48.9555
R9332 avss.n9105 avss.n9104 48.9555
R9333 avss.n9104 avss.n9103 48.9555
R9334 avss.n9103 avss.n261 48.9555
R9335 avss.n9097 avss.n261 48.9555
R9336 avss.n9097 avss.n9096 48.9555
R9337 avss.n9096 avss.n9095 48.9555
R9338 avss.n9095 avss.n272 48.9555
R9339 avss.n9089 avss.n272 48.9555
R9340 avss.n9089 avss.n9088 48.9555
R9341 avss.n9088 avss.n9087 48.9555
R9342 avss.n9087 avss.n283 48.9555
R9343 avss.n9081 avss.n283 48.9555
R9344 avss.n9081 avss.n151 48.9555
R9345 avss.n9192 avss.n153 48.9555
R9346 avss.n9177 avss.n167 48.9555
R9347 avss.n9064 avss.n177 48.9555
R9348 avss.n9158 avss.n185 48.9555
R9349 avss.n9150 avss.n9149 48.9555
R9350 avss.n473 avss.n472 48.9417
R9351 avss.n838 avss.n783 48.9417
R9352 avss.n6127 avss.n6126 48.7901
R9353 avss.n6124 avss.n5688 48.7901
R9354 avss.n6118 avss.n6117 48.7901
R9355 avss.n6107 avss.n5711 48.7901
R9356 avss.n6041 avss.n5722 48.7901
R9357 avss.n6050 avss.n6049 48.7901
R9358 avss.n6072 avss.n5840 48.7901
R9359 avss.n1390 avss.n1380 48.7901
R9360 avss.n1390 avss.n1373 48.7901
R9361 avss.n1398 avss.n1373 48.7901
R9362 avss.n1398 avss.n1374 48.7901
R9363 avss.n1406 avss.n1362 48.7901
R9364 avss.n1414 avss.n1362 48.7901
R9365 avss.n1414 avss.n1356 48.7901
R9366 avss.n1422 avss.n1356 48.7901
R9367 avss.n1422 avss.n1350 48.7901
R9368 avss.n1430 avss.n1350 48.7901
R9369 avss.n1430 avss.n1344 48.7901
R9370 avss.n1438 avss.n1344 48.7901
R9371 avss.n1438 avss.n1338 48.7901
R9372 avss.n1446 avss.n1338 48.7901
R9373 avss.n1446 avss.n1332 48.7901
R9374 avss.n1454 avss.n1332 48.7901
R9375 avss.n1454 avss.n1326 48.7901
R9376 avss.n1462 avss.n1326 48.7901
R9377 avss.n1462 avss.n1320 48.7901
R9378 avss.n1473 avss.n1320 48.7901
R9379 avss.n1473 avss.n1314 48.7901
R9380 avss.n1482 avss.n1314 48.7901
R9381 avss.n1482 avss.n1177 48.7901
R9382 avss.n6716 avss.n1179 48.7901
R9383 avss.n6710 avss.n1179 48.7901
R9384 avss.n6710 avss.n6709 48.7901
R9385 avss.n6709 avss.n6708 48.7901
R9386 avss.n6708 avss.n1191 48.7901
R9387 avss.n6702 avss.n1191 48.7901
R9388 avss.n1503 avss.n1201 48.7901
R9389 avss.n1503 avss.n1302 48.7901
R9390 avss.n1511 avss.n1302 48.7901
R9391 avss.n1511 avss.n1296 48.7901
R9392 avss.n1519 avss.n1296 48.7901
R9393 avss.n1519 avss.n1290 48.7901
R9394 avss.n1527 avss.n1290 48.7901
R9395 avss.n1527 avss.n1284 48.7901
R9396 avss.n1535 avss.n1284 48.7901
R9397 avss.n1535 avss.n1278 48.7901
R9398 avss.n1546 avss.n1278 48.7901
R9399 avss.n1546 avss.n1271 48.7901
R9400 avss.n1555 avss.n1271 48.7901
R9401 avss.n1639 avss.n1252 48.7901
R9402 avss.n6693 avss.n1214 48.7901
R9403 avss.n1619 avss.n1224 48.7901
R9404 avss.n6677 avss.n1236 48.7901
R9405 avss.n4938 avss.n4926 48.31
R9406 avss.n1406 avss.n1200 48.1803
R9407 avss.n4888 avss.n4879 47.8364
R9408 avss.n2746 avss.n2255 47.612
R9409 avss.n2745 avss.n2256 47.612
R9410 avss.n2475 avss.n2467 47.612
R9411 avss.n4612 avss.n3415 47.612
R9412 avss.n4523 avss.n3569 47.612
R9413 avss.n4499 avss.n4498 47.612
R9414 avss.n9185 avss.n165 47.1197
R9415 avss.n6018 avss.n5709 46.9605
R9416 avss.n1648 avss.n1250 46.9605
R9417 avss.n2614 avss.n2474 46.9219
R9418 avss.n4505 avss.n3666 46.9219
R9419 avss.n2656 avss.n2273 46.5769
R9420 avss.n3834 avss.n3765 46.5769
R9421 avss.n2607 avss.n1088 46.2319
R9422 avss.n2481 avss.n1089 46.2319
R9423 avss.n4513 avss.n3656 46.2319
R9424 avss.n3685 avss.n3684 46.2319
R9425 avss.n8049 avss.n7958 45.4114
R9426 avss.n8043 avss.n8042 45.4114
R9427 avss.n8042 avss.n8041 45.4114
R9428 avss.n8041 avss.n7988 45.4114
R9429 avss.n8035 avss.n8034 45.4114
R9430 avss.n25 avss.n24 45.4114
R9431 avss.n9374 avss.n25 45.4114
R9432 avss.n9374 avss.n26 45.4114
R9433 avss.n9368 avss.n26 45.4114
R9434 avss.n9368 avss.n9367 45.4114
R9435 avss.n9367 avss.n9366 45.4114
R9436 avss.n9360 avss.n47 45.4114
R9437 avss.n9358 avss.n9357 45.4114
R9438 avss.n9357 avss.n53 45.4114
R9439 avss.n9351 avss.n53 45.4114
R9440 avss.n9351 avss.n9350 45.4114
R9441 avss.n2997 avss.n2120 45.3952
R9442 avss.n3250 avss.n2039 45.3952
R9443 avss.n3230 avss.n2074 45.3952
R9444 avss.n4178 avss.n4177 45.3952
R9445 avss.n4194 avss.n3996 45.3952
R9446 avss.n4217 avss.n4216 45.3952
R9447 avss.n2677 avss.n2266 45.0306
R9448 avss.n3206 avss.n3205 45.0306
R9449 avss.n3845 avss.n3838 45.0306
R9450 avss.n3827 avss.n3764 45.0306
R9451 avss.n6211 avss.n4690 44.7741
R9452 avss.n6219 avss.n4684 44.7741
R9453 avss.n6227 avss.n4678 44.7741
R9454 avss.n6227 avss.n4671 44.7741
R9455 avss.n6235 avss.n4671 44.7741
R9456 avss.n3236 avss.n494 44.7373
R9457 avss.n3976 avss.n3975 44.7373
R9458 avss.n7271 avss.n7270 44.4945
R9459 avss.n7286 avss.n529 44.4945
R9460 avss.n506 avss.n497 44.4945
R9461 avss.n7144 avss.n7143 44.4945
R9462 avss.n7187 avss.n652 44.4945
R9463 avss.n7169 avss.n7168 44.4945
R9464 avss.n3213 avss.n2096 44.4084
R9465 avss.n4253 avss.n3916 44.4084
R9466 avss.n3243 avss.n2049 44.0794
R9467 avss.n3242 avss.n2052 44.0794
R9468 avss.n4209 avss.n3954 44.0794
R9469 avss.n3984 avss.n3956 44.0794
R9470 avss.n7395 avss.n493 43.9711
R9471 avss.n7132 avss.n713 43.9711
R9472 avss.n7391 avss.n495 43.8497
R9473 avss.n749 avss.n674 43.8497
R9474 avss.n7402 avss.n482 43.5273
R9475 avss.n770 avss.n720 43.5273
R9476 avss.n2669 avss.n2668 43.4718
R9477 avss.n3833 avss.n3767 43.4718
R9478 avss.n8711 avss.n63 43.4598
R9479 avss.n8587 avss.n223 43.4598
R9480 avss.n9321 avss.n9320 43.4598
R9481 avss.n9047 avss.n207 43.4481
R9482 avss.n6083 avss.n5830 43.3013
R9483 avss.n1582 avss.n1238 43.3013
R9484 avss.n7373 avss.n517 43.2049
R9485 avss.n7372 avss.n7307 43.2049
R9486 avss.n7180 avss.n662 43.2049
R9487 avss.n7179 avss.n665 43.2049
R9488 avss.n1632 avss.n1631 42.0816
R9489 avss.n8004 avss.n7999 42.0056
R9490 avss.n9400 avss.n9399 42.0056
R9491 avss.n6270 avss.n951 41.8231
R9492 avss.n3194 avss.n2084 41.4479
R9493 avss.n4373 avss.n3836 41.4479
R9494 avss.n24 avss.n15 41.4379
R9495 avss.n2752 avss.n2148 41.4018
R9496 avss.n4596 avss.n3427 41.4018
R9497 avss.n6806 avss.n6805 41.3856
R9498 avss.n7035 avss.n950 41.2057
R9499 avss.n9152 avss.n194 41.0003
R9500 avss.n6058 avss.n5847 40.8618
R9501 avss.n6684 avss.n6683 40.8618
R9502 avss.n8682 avss.n7835 40.6255
R9503 avss.n8559 avss.n7925 40.6255
R9504 avss.n7336 avss.n491 40.6255
R9505 avss.n7124 avss.n7123 40.6255
R9506 avss.n9271 avss.n96 40.6255
R9507 avss.n2746 avss.n2745 40.0217
R9508 avss.n3569 avss.n3415 40.0217
R9509 avss.n2375 avss.n2350 39.9403
R9510 avss.n3101 avss.n3100 39.9403
R9511 avss.n4355 avss.n3856 39.9403
R9512 avss.n4466 avss.n3711 39.9403
R9513 avss.n9047 avss.n199 39.7764
R9514 avss.n7033 avss.t172 39.7421
R9515 avss.n6071 avss.n5830 39.6421
R9516 avss.n6676 avss.n1238 39.6421
R9517 avss.n2305 avss.n2296 39.5487
R9518 avss.n3119 avss.n3043 39.5487
R9519 avss.n4347 avss.n3870 39.5487
R9520 avss.n4458 avss.n3725 39.5487
R9521 avss.n2981 avss.n2132 39.4742
R9522 avss.n3243 avss.n3242 39.4742
R9523 avss.n4161 avss.n4160 39.4742
R9524 avss.n4209 avss.n3984 39.4742
R9525 avss.n8005 avss.n8004 39.1674
R9526 avss.n453 avss.n451 39.0005
R9527 avss.n7099 avss.n799 39.0005
R9528 avss.n2876 avss.n2149 38.691
R9529 avss.n7373 avss.n7372 38.691
R9530 avss.n3513 avss.n3512 38.691
R9531 avss.n7180 avss.n7179 38.691
R9532 avss.n7435 avss.n416 38.6181
R9533 avss.n7091 avss.n813 38.6181
R9534 avss.n2120 avss.n2039 38.1584
R9535 avss.n4177 avss.n3996 38.1584
R9536 avss.n8011 avss.n8005 38.0321
R9537 avss.n6861 avss.n6860 37.9493
R9538 avss.n5383 avss.t173 37.8903
R9539 avss.t173 avss.n5088 37.8903
R9540 avss.n4789 avss.t169 37.8903
R9541 avss.t181 avss.n4764 37.8903
R9542 avss.n4842 avss.t180 37.8903
R9543 avss.t26 avss.n5036 37.8903
R9544 avss.n5027 avss.t73 37.8903
R9545 avss.t73 avss.n5026 37.8903
R9546 avss.n5018 avss.t84 37.8903
R9547 avss.n4963 avss.t179 37.8903
R9548 avss.t95 avss.n4914 37.8903
R9549 avss.n7042 avss.t177 37.8903
R9550 avss.n948 avss.t177 37.8903
R9551 avss.n1056 avss.t168 37.8903
R9552 avss.n6898 avss.t172 37.8903
R9553 avss.n8756 avss.t29 37.7912
R9554 avss.n8673 avss.t31 37.7912
R9555 avss.n8728 avss.t1 37.7912
R9556 avss.n8527 avss.t18 37.7912
R9557 avss.n8550 avss.t16 37.7912
R9558 avss.n8604 avss.t187 37.7912
R9559 avss.n8377 avss.t106 37.7912
R9560 avss.n104 avss.t104 37.7912
R9561 avss.n9312 avss.t102 37.7912
R9562 avss.n6125 avss.n6124 37.5075
R9563 avss.n5027 avss.n4867 37.4167
R9564 avss.n7270 avss.n529 37.4013
R9565 avss.n7143 avss.n652 37.4013
R9566 avss.n9171 avss.n9170 37.3287
R9567 avss.n2657 avss.n2656 37.2616
R9568 avss.n3781 avss.n3765 37.2616
R9569 avss.n6101 avss.n6100 37.2026
R9570 avss.n6699 avss.n1205 37.2026
R9571 avss.n9171 avss.n175 36.7168
R9572 avss.n6101 avss.n5720 36.5927
R9573 avss.n9178 avss.n165 36.1048
R9574 avss.n7482 avss.n372 36.0246
R9575 avss.n7482 avss.n374 36.0246
R9576 avss.n7060 avss.n832 36.0246
R9577 avss.n7060 avss.n833 36.0246
R9578 avss.n6108 avss.n5709 35.9829
R9579 avss.n1263 avss.n1250 35.9829
R9580 avss.n3214 avss.n3213 35.5268
R9581 avss.n4254 avss.n4253 35.5268
R9582 avss.n7482 avss.n379 35.177
R9583 avss.n7074 avss.n7060 35.177
R9584 avss.n8657 avss.t29 34.9569
R9585 avss.n8674 avss.n8673 34.9569
R9586 avss.n8672 avss.n7835 34.9569
R9587 avss.t18 avss.n7868 34.9569
R9588 avss.n8551 avss.n8550 34.9569
R9589 avss.n8549 avss.n7925 34.9569
R9590 avss.n9222 avss.t106 34.9569
R9591 avss.n9262 avss.n104 34.9569
R9592 avss.n103 avss.n96 34.9569
R9593 avss.n7403 avss.n7402 34.8219
R9594 avss.n7113 avss.n770 34.8219
R9595 avss.n7036 avss.n7035 34.575
R9596 avss.n6891 avss.n1088 34.5016
R9597 avss.n3683 avss.n3656 34.5016
R9598 avss.n2752 avss.n2751 33.1215
R9599 avss.n4596 avss.n3428 33.1215
R9600 avss.n9152 avss.n9151 33.0451
R9601 avss.n6058 avss.n5848 32.9335
R9602 avss.n6683 avss.n1227 32.9335
R9603 avss.n9193 avss.n9192 32.4332
R9604 avss.n6118 avss.n5698 32.3236
R9605 avss.n1272 avss.n1252 32.3236
R9606 avss.n6207 avss.n5596 31.6774
R9607 avss.n2981 avss.n2133 31.5794
R9608 avss.n4161 avss.n4028 31.5794
R9609 avss.n2448 avss.t71 31.3258
R9610 avss.n2358 avss.t71 31.3258
R9611 avss.n2439 avss.t14 31.3258
R9612 avss.n2400 avss.t159 31.3258
R9613 avss.t48 avss.n2337 31.3258
R9614 avss.t96 avss.n2108 31.3258
R9615 avss.n3093 avss.t96 31.3258
R9616 avss.n3051 avss.t202 31.3258
R9617 avss.n3127 avss.t146 31.3258
R9618 avss.t62 avss.n3008 31.3258
R9619 avss.n4364 avss.t33 31.3258
R9620 avss.n4262 avss.t33 31.3258
R9621 avss.t5 avss.n3867 31.3258
R9622 avss.t150 avss.n3898 31.3258
R9623 avss.n4328 avss.t63 31.3258
R9624 avss.n4472 avss.t198 31.3258
R9625 avss.t198 avss.n4471 31.3258
R9626 avss.t66 avss.n3722 31.3258
R9627 avss.t162 avss.n3755 31.3258
R9628 avss.n4439 avss.t49 31.3258
R9629 avss.n2876 avss.n534 30.9529
R9630 avss.n3513 avss.n686 30.9529
R9631 avss.n2448 avss.n2286 30.9342
R9632 avss.n3203 avss.n2108 30.9342
R9633 avss.n4365 avss.n4364 30.9342
R9634 avss.n4472 avss.n3697 30.9342
R9635 avss.n5037 avss.n4841 30.786
R9636 avss.n5036 avss.n4833 30.786
R9637 avss.n9389 avss.n15 30.6528
R9638 avss.n7330 avss.t184 30.5887
R9639 avss.n7412 avss.t184 30.5887
R9640 avss.n7425 avss.t80 30.5887
R9641 avss.n7444 avss.t134 30.5887
R9642 avss.n7464 avss.t27 30.5887
R9643 avss.n7108 avss.t193 30.5887
R9644 avss.t193 avss.n7107 30.5887
R9645 avss.t110 avss.n810 30.5887
R9646 avss.n857 avss.t139 30.5887
R9647 avss.n7070 avss.t28 30.5887
R9648 avss.n5010 avss.t179 30.3124
R9649 avss.n7331 avss.n7330 30.2064
R9650 avss.n7108 avss.n782 30.2064
R9651 avss.n7984 avss.n7983 30.0852
R9652 avss.n6717 avss.n6716 29.8842
R9653 avss.n6762 avss.n1166 29.5826
R9654 avss.n6211 avss.n6210 29.3831
R9655 avss.n9128 avss.n225 29.3735
R9656 avss.n8719 avss.t1 29.2883
R9657 avss.n8595 avss.t187 29.2883
R9658 avss.n9303 avss.t102 29.2883
R9659 avss.n6887 avss.n1091 28.985
R9660 avss.n9131 avss.n9130 28.1496
R9661 avss.n5018 avss.n4876 27.9442
R9662 avss.n5017 avss.n4879 27.9442
R9663 avss.t160 avss.n2275 27.6013
R9664 avss.n2460 avss.t60 27.6013
R9665 avss.n3789 avss.t163 27.6013
R9666 avss.n4480 avss.t25 27.6013
R9667 avss.n4948 avss.n4926 27.4706
R9668 avss.t161 avss.n2150 27.2036
R9669 avss.n4542 avss.t164 27.2036
R9670 avss.n4915 avss.t95 26.997
R9671 avss.n5062 avss.n4821 26.5234
R9672 avss.n6573 avss.t182 26.4233
R9673 avss.n6592 avss.t182 26.4233
R9674 avss.t175 avss.n6540 26.4233
R9675 avss.n6553 avss.t175 26.4233
R9676 avss.n3224 avss.t147 26.3163
R9677 avss.n3181 avss.t59 26.3163
R9678 avss.n4225 avss.t151 26.3163
R9679 avss.t24 avss.n3922 26.3163
R9680 avss.n9164 avss.n9158 26.3138
R9681 avss.n6050 avss.n5861 26.2249
R9682 avss.n1620 avss.n1619 26.2249
R9683 avss.n8035 avss.n7996 26.1118
R9684 avss.n2927 avss.t148 25.9719
R9685 avss.t152 avss.n4046 25.9719
R9686 avss.n7383 avss.t135 25.7941
R9687 avss.n7342 avss.t58 25.7941
R9688 avss.t140 avss.n723 25.7941
R9689 avss.n772 avss.t23 25.7941
R9690 avss.n5053 avss.n4820 25.5761
R9691 avss.n7845 avss.n7768 25.5092
R9692 avss.n8635 avss.n8634 25.5092
R9693 avss.n8381 avss.n8380 25.5092
R9694 avss.n6208 avss.n4692 25.1025
R9695 avss.n2431 avss.t159 25.0607
R9696 avss.n3117 avss.t146 25.0607
R9697 avss.n4283 avss.t150 25.0607
R9698 avss.n4394 avss.t162 25.0607
R9699 avss.n5045 avss.n4834 24.6289
R9700 avss.n8692 avss.n7815 24.5645
R9701 avss.n7905 avss.n196 24.5645
R9702 avss.n90 avss.n82 24.5645
R9703 avss.t206 avss.n250 24.478
R9704 avss.n9105 avss.t206 24.478
R9705 avss.t40 avss.n162 24.478
R9706 avss.n9058 avss.t38 24.478
R9707 avss.t21 avss.n9142 24.478
R9708 avss.n7433 avss.t134 24.4711
R9709 avss.t139 avss.n849 24.4711
R9710 avss.n6116 avss.t191 24.3953
R9711 avss.n6036 avss.t189 24.3953
R9712 avss.t10 avss.n5834 24.3953
R9713 avss.n6702 avss.t118 24.3953
R9714 avss.t118 avss.n1201 24.3953
R9715 avss.n1640 avss.t86 24.3953
R9716 avss.n6692 avss.t88 24.3953
R9717 avss.n1592 avss.t51 24.3953
R9718 avss.n7026 avss.n7025 23.9052
R9719 avss.n7025 avss.n7024 23.9052
R9720 avss.n7024 avss.n968 23.9052
R9721 avss.n7016 avss.n976 23.9052
R9722 avss.t166 avss.n976 23.9052
R9723 avss.n7007 avss.t166 23.9052
R9724 avss.n6998 avss.n995 23.9052
R9725 avss.n6992 avss.n1007 23.9052
R9726 avss.n6746 avss.n1009 23.9052
R9727 avss.n6779 avss.n6778 23.9052
R9728 avss.n6772 avss.n6761 23.9052
R9729 avss.n6886 avss.n1093 23.9052
R9730 avss.n6877 avss.n1102 23.9052
R9731 avss.n6820 avss.n6816 23.9052
R9732 avss.n6829 avss.n6828 23.9052
R9733 avss.n6838 avss.n1114 23.9052
R9734 avss.t136 avss.n2151 23.6554
R9735 avss.n3490 avss.t141 23.6554
R9736 avss.n2376 avss.n2368 23.4945
R9737 avss.n3073 avss.n3057 23.4945
R9738 avss.n4272 avss.n4265 23.4945
R9739 avss.n4383 avss.n4376 23.4945
R9740 avss.n9359 avss.n9358 23.2736
R9741 avss.n2439 avss.n2293 23.1029
R9742 avss.n2438 avss.n2296 23.1029
R9743 avss.n3109 avss.n3051 23.1029
R9744 avss.n3050 avss.n3043 23.1029
R9745 avss.n3867 avss.n3858 23.1029
R9746 avss.n4348 avss.n4347 23.1029
R9747 avss.n3722 avss.n3713 23.1029
R9748 avss.n4459 avss.n4458 23.1029
R9749 avss.n452 avss.n432 22.9417
R9750 avss.n908 avss.n907 22.9417
R9751 avss.n2385 avss.n2350 22.7113
R9752 avss.n3100 avss.n3049 22.7113
R9753 avss.n4355 avss.n4354 22.7113
R9754 avss.n4466 avss.n4465 22.7113
R9755 avss.n8049 avss.t98 22.7059
R9756 avss.n7983 avss.t98 22.7059
R9757 avss.n8011 avss.t122 22.7059
R9758 avss.t122 avss.n7 22.7059
R9759 avss.t120 avss.n9 22.7059
R9760 avss.n9391 avss.t120 22.7059
R9761 avss.n9366 avss.t205 22.7059
R9762 avss.n47 avss.t205 22.7059
R9763 avss.n9186 avss.t40 22.6422
R9764 avss.n9064 avss.n9058 22.6422
R9765 avss.n9164 avss.n183 22.6422
R9766 avss.n8898 avss.n7486 22.573
R9767 avss.n6024 avss.t191 22.5657
R9768 avss.n6041 avss.n6036 22.5657
R9769 avss.n6035 avss.n5861 22.5657
R9770 avss.t86 avss.n1249 22.5657
R9771 avss.n6693 avss.n6692 22.5657
R9772 avss.n1621 avss.n1620 22.5657
R9773 avss.n7425 avss.n426 22.5593
R9774 avss.n448 avss.n416 22.5593
R9775 avss.n810 avss.n801 22.5593
R9776 avss.n7092 avss.n7091 22.5593
R9777 avss.n2666 avss.n2277 22.4262
R9778 avss.n2646 avss.n2460 22.4262
R9779 avss.n3805 avss.n3788 22.4262
R9780 avss.n4480 avss.n3689 22.4262
R9781 avss.n6219 avss.t116 22.3873
R9782 avss.t116 avss.n4678 22.3873
R9783 avss.n2338 avss.t48 22.3198
R9784 avss.n3023 avss.t62 22.3198
R9785 avss.n4338 avss.t63 22.3198
R9786 avss.n4449 avss.t49 22.3198
R9787 avss.t98 avss.n7759 22.2176
R9788 avss.n464 avss.n451 22.177
R9789 avss.n7099 avss.n7098 22.177
R9790 avss.n9360 avss.n9359 22.1383
R9791 avss.t133 avss.n627 22.0623
R9792 avss.n2926 avss.t132 22.0623
R9793 avss.n2677 avss.n2267 21.9282
R9794 avss.n3205 avss.n3204 21.9282
R9795 avss.n3846 avss.n3845 21.9282
R9796 avss.n3827 avss.n3826 21.9282
R9797 avss.t27 avss.n395 21.7946
R9798 avss.n7082 avss.t28 21.7946
R9799 avss.n7329 avss.n493 21.4123
R9800 avss.n7132 avss.n714 21.4123
R9801 avss.n3223 avss.n2086 21.3821
R9802 avss.n3187 avss.n3181 21.3821
R9803 avss.n3939 avss.n3938 21.3821
R9804 avss.n4244 avss.n3922 21.3821
R9805 avss.n8006 avss.t123 21.3319
R9806 avss.n9396 avss.t121 21.3319
R9807 avss.n6838 avss.n1138 21.216
R9808 avss.n5355 avss.t174 21.1375
R9809 avss.n1825 avss.t138 21.1375
R9810 avss.n919 avss.t178 21.1375
R9811 avss.n1891 avss.t156 21.1375
R9812 avss.n1946 avss.t149 21.1375
R9813 avss.n5276 avss.t165 21.1375
R9814 avss.n5116 avss.t143 21.1375
R9815 avss.n5212 avss.t153 21.1375
R9816 avss.n1588 avss.t52 21.1339
R9817 avss.n6687 avss.t89 21.1339
R9818 avss.n1644 avss.t87 21.1339
R9819 avss.n6111 avss.t192 21.1339
R9820 avss.n5857 avss.t190 21.1339
R9821 avss.n6088 avss.t11 21.1339
R9822 avss.n9243 avss.t105 21.1339
R9823 avss.n9308 avss.t103 21.1339
R9824 avss.n9181 avss.t41 21.1339
R9825 avss.n9138 avss.t22 21.1339
R9826 avss.n9160 avss.t39 21.1339
R9827 avss.n8624 avss.t19 21.1339
R9828 avss.n8600 avss.t188 21.1339
R9829 avss.n7921 avss.t17 21.1339
R9830 avss.n8751 avss.t30 21.1339
R9831 avss.n8724 avss.t2 21.1339
R9832 avss.n7831 avss.t32 21.1339
R9833 avss.n9217 avss.t107 21.1339
R9834 avss.n7382 avss.n510 20.9578
R9835 avss.n7351 avss.n7342 20.9578
R9836 avss.n7121 avss.n7120 20.9578
R9837 avss.n772 avss.n735 20.9578
R9838 avss.n6868 avss.n6867 20.9172
R9839 avss.n974 avss.n968 20.6183
R9840 avss.n7017 avss.n7016 20.6183
R9841 avss.n6992 avss.n6991 20.6183
R9842 avss.n7482 avss.n377 20.4781
R9843 avss.n6867 avss.n1116 20.4689
R9844 avss.n6998 avss.n996 20.3195
R9845 avss.n6701 avss.n1202 20.1262
R9846 avss.n7006 avss.n986 20.0207
R9847 avss.n1014 avss.n1013 20.0207
R9848 avss.n5605 avss.n5596 19.9545
R9849 avss.n6199 avss.n5605 19.9545
R9850 avss.n6199 avss.n5606 19.9545
R9851 avss.n8748 avss.n8747 19.8406
R9852 avss.n7879 avss.n7870 19.8406
R9853 avss.n9230 avss.n116 19.8406
R9854 avss.n9128 avss.n9127 19.5825
R9855 avss.n6611 avss.n6530 19.5005
R9856 avss.n6613 avss.n6612 19.5005
R9857 avss.n6614 avss.n6529 19.5005
R9858 avss.n6616 avss.n6615 19.5005
R9859 avss.n6617 avss.n6527 19.5005
R9860 avss.n6622 avss.n6525 19.5005
R9861 avss.n4871 avss.t85 19.4509
R9862 avss.n5031 avss.t74 19.4509
R9863 avss.n7418 avss.t81 19.4509
R9864 avss.n7406 avss.t185 19.4509
R9865 avss.n1163 avss.t211 19.4509
R9866 avss.n6796 avss.t100 19.4509
R9867 avss.n2288 avss.t15 19.4509
R9868 avss.n2660 avss.t72 19.4509
R9869 avss.n3061 avss.t203 19.4509
R9870 avss.n3217 avss.t97 19.4509
R9871 avss.n774 avss.t194 19.4509
R9872 avss.n7102 avss.t111 19.4509
R9873 avss.n3910 avss.t34 19.4509
R9874 avss.n4358 avss.t6 19.4509
R9875 avss.n3692 avss.t199 19.4509
R9876 avss.n3701 avss.t67 19.4509
R9877 avss.n7996 avss.n7988 19.3001
R9878 avss.n4746 avss.t155 19.2161
R9879 avss.n531 avss.t131 19.2161
R9880 avss.n1020 avss.t167 19.2161
R9881 avss.n2251 avss.t125 19.2161
R9882 avss.n2034 avss.t129 19.2161
R9883 avss.n647 avss.t127 19.2161
R9884 avss.n4189 avss.t145 19.2161
R9885 avss.n3563 avss.t158 19.2161
R9886 avss.n6806 avss.n1091 19.1243
R9887 avss.n9143 avss.t21 18.9706
R9888 avss.n4796 avss.n4788 18.9454
R9889 avss.n5475 avss.n4789 18.9454
R9890 avss.t169 avss.n4781 18.9454
R9891 avss.n5486 avss.n4781 18.9454
R9892 avss.n5485 avss.n4771 18.9454
R9893 avss.n5506 avss.n5505 18.9454
R9894 avss.n4774 avss.n4763 18.9454
R9895 avss.n5514 avss.n4765 18.9454
R9896 avss.n4765 avss.t181 18.9454
R9897 avss.n4764 avss.n4756 18.9454
R9898 avss.n5534 avss.n5533 18.9454
R9899 avss.n6923 avss.n1053 18.9454
R9900 avss.n1056 avss.n1054 18.9454
R9901 avss.n6934 avss.t168 18.9454
R9902 avss.n6934 avss.n6933 18.9454
R9903 avss.n6949 avss.n1037 18.9454
R9904 avss.n6948 avss.n1040 18.9454
R9905 avss.n6965 avss.n1028 18.9454
R9906 avss.n1031 avss.n1029 18.9454
R9907 avss.n1031 avss.t172 18.9454
R9908 avss.n6898 avss.n954 18.9454
R9909 avss.n6082 avss.t10 18.9065
R9910 avss.n6717 avss.n1177 18.9065
R9911 avss.n6701 avss.n6700 18.9065
R9912 avss.n1603 avss.t51 18.9065
R9913 avss.n7790 avss.n7781 18.8958
R9914 avss.n8616 avss.n8615 18.8958
R9915 avss.n117 avss.n110 18.8958
R9916 avss.n5344 avss.n5112 18.3132
R9917 avss.n1820 avss.n914 18.3132
R9918 avss.n5606 avss.n951 18.2085
R9919 avss.n7845 avss.n7759 17.9511
R9920 avss.n8740 avss.n7792 17.9511
R9921 avss.n8635 avss.n7759 17.9511
R9922 avss.n8613 avss.n7882 17.9511
R9923 avss.n8381 avss.n7759 17.9511
R9924 avss.n9253 avss.n102 17.9511
R9925 avss.n2657 avss.n2454 17.9411
R9926 avss.n3814 avss.n3781 17.9411
R9927 avss.n6893 avss.n953 17.9291
R9928 avss.n1013 avss.n986 17.9291
R9929 avss.n2667 avss.n2266 17.621
R9930 avss.n3207 avss.n3206 17.621
R9931 avss.n4372 avss.n3838 17.621
R9932 avss.n3775 avss.n3764 17.621
R9933 avss.n7017 avss.n974 17.3314
R9934 avss.n7396 avss.n7395 17.2064
R9935 avss.n7122 avss.n713 17.2064
R9936 avss.n3214 avss.n2094 17.1058
R9937 avss.n4254 avss.n3913 17.1058
R9938 avss.n7403 avss.n480 16.7664
R9939 avss.n7114 avss.n7113 16.7664
R9940 avss.n9193 avss.n151 16.5228
R9941 avss.n5698 avss.n5688 16.467
R9942 avss.n1555 avss.n1272 16.467
R9943 avss.n6779 avss.n6726 16.1362
R9944 avss.n9151 avss.n9150 15.9109
R9945 avss.n5848 avss.n5840 15.8571
R9946 avss.n1236 avss.n1227 15.8571
R9947 avss.n6752 avss.n6717 15.8374
R9948 avss.n6761 avss.n1090 15.8374
R9949 avss.n9311 avss.n9305 15.5561
R9950 avss.n9246 avss.n9238 15.5561
R9951 avss.n27 avss.n16 15.5561
R9952 avss.n9373 avss.n27 15.5561
R9953 avss.n9373 avss.n28 15.5561
R9954 avss.n9369 avss.n28 15.5561
R9955 avss.n9369 avss.n36 15.5561
R9956 avss.n9365 avss.n36 15.5561
R9957 avss.n9365 avss.n40 15.5561
R9958 avss.n9361 avss.n40 15.5561
R9959 avss.n9361 avss.n46 15.5561
R9960 avss.n9356 avss.n46 15.5561
R9961 avss.n9356 avss.n54 15.5561
R9962 avss.n9352 avss.n54 15.5561
R9963 avss.n9352 avss.n60 15.5561
R9964 avss.n20 avss.n17 15.5561
R9965 avss.n9375 avss.n20 15.5561
R9966 avss.n9375 avss.n23 15.5561
R9967 avss.n37 avss.n23 15.5561
R9968 avss.n38 avss.n37 15.5561
R9969 avss.n39 avss.n38 15.5561
R9970 avss.n9335 avss.n39 15.5561
R9971 avss.n9335 avss.n48 15.5561
R9972 avss.n51 avss.n48 15.5561
R9973 avss.n52 avss.n51 15.5561
R9974 avss.n9342 avss.n52 15.5561
R9975 avss.n9342 avss.n61 15.5561
R9976 avss.n62 avss.n61 15.5561
R9977 avss.n14 avss.n11 15.5561
R9978 avss.n9392 avss.n10 15.5561
R9979 avss.n8012 avss.n6 15.5561
R9980 avss.n8010 avss.n5 15.5561
R9981 avss.n1591 avss.n1239 15.5561
R9982 avss.n6691 avss.n1218 15.5561
R9983 avss.n6554 avss.n6542 15.5561
R9984 avss.n6552 avss.n6541 15.5561
R9985 avss.n6585 avss.n6571 15.5561
R9986 avss.n6585 avss.n6567 15.5561
R9987 avss.n6591 avss.n6567 15.5561
R9988 avss.n6591 avss.n6537 15.5561
R9989 avss.n6601 avss.n6537 15.5561
R9990 avss.n6583 avss.n6574 15.5561
R9991 avss.n6583 avss.n6566 15.5561
R9992 avss.n6593 avss.n6566 15.5561
R9993 avss.n6593 avss.n6562 15.5561
R9994 avss.n6599 avss.n6562 15.5561
R9995 avss.n1647 avss.n1641 15.5561
R9996 avss.n1389 avss.n1381 15.5561
R9997 avss.n1389 avss.n1372 15.5561
R9998 avss.n1399 avss.n1372 15.5561
R9999 avss.n1399 avss.n1368 15.5561
R10000 avss.n1405 avss.n1368 15.5561
R10001 avss.n1405 avss.n1361 15.5561
R10002 avss.n1415 avss.n1361 15.5561
R10003 avss.n1415 avss.n1357 15.5561
R10004 avss.n1421 avss.n1357 15.5561
R10005 avss.n1421 avss.n1349 15.5561
R10006 avss.n1431 avss.n1349 15.5561
R10007 avss.n1431 avss.n1345 15.5561
R10008 avss.n1437 avss.n1345 15.5561
R10009 avss.n1437 avss.n1337 15.5561
R10010 avss.n1447 avss.n1337 15.5561
R10011 avss.n1447 avss.n1333 15.5561
R10012 avss.n1453 avss.n1333 15.5561
R10013 avss.n1453 avss.n1325 15.5561
R10014 avss.n1463 avss.n1325 15.5561
R10015 avss.n1463 avss.n1321 15.5561
R10016 avss.n1472 avss.n1321 15.5561
R10017 avss.n1472 avss.n1313 15.5561
R10018 avss.n1483 avss.n1313 15.5561
R10019 avss.n1484 avss.n1483 15.5561
R10020 avss.n1484 avss.n1178 15.5561
R10021 avss.n1309 avss.n1178 15.5561
R10022 avss.n1309 avss.n1188 15.5561
R10023 avss.n1189 avss.n1188 15.5561
R10024 avss.n1190 avss.n1189 15.5561
R10025 avss.n1306 avss.n1190 15.5561
R10026 avss.n1306 avss.n1199 15.5561
R10027 avss.n1498 avss.n1199 15.5561
R10028 avss.n1504 avss.n1498 15.5561
R10029 avss.n1504 avss.n1303 15.5561
R10030 avss.n1510 avss.n1303 15.5561
R10031 avss.n1510 avss.n1295 15.5561
R10032 avss.n1520 avss.n1295 15.5561
R10033 avss.n1520 avss.n1291 15.5561
R10034 avss.n1526 avss.n1291 15.5561
R10035 avss.n1526 avss.n1283 15.5561
R10036 avss.n1536 avss.n1283 15.5561
R10037 avss.n1536 avss.n1279 15.5561
R10038 avss.n1545 avss.n1279 15.5561
R10039 avss.n1545 avss.n1270 15.5561
R10040 avss.n1556 avss.n1270 15.5561
R10041 avss.n1557 avss.n1556 15.5561
R10042 avss.n1557 avss.n1253 15.5561
R10043 avss.n1560 avss.n1253 15.5561
R10044 avss.n1560 avss.n1264 15.5561
R10045 avss.n1630 avss.n1264 15.5561
R10046 avss.n1630 avss.n1265 15.5561
R10047 avss.n1265 avss.n1204 15.5561
R10048 avss.n1625 avss.n1204 15.5561
R10049 avss.n1625 avss.n1215 15.5561
R10050 avss.n1622 avss.n1215 15.5561
R10051 avss.n1622 avss.n1613 15.5561
R10052 avss.n1613 avss.n1612 15.5561
R10053 avss.n1612 avss.n1225 15.5561
R10054 avss.n1608 avss.n1225 15.5561
R10055 avss.n1608 avss.n1237 15.5561
R10056 avss.n1605 avss.n1237 15.5561
R10057 avss.n1605 avss.n1604 15.5561
R10058 avss.n1604 avss.n1581 15.5561
R10059 avss.n1391 avss.n1379 15.5561
R10060 avss.n1391 avss.n1375 15.5561
R10061 avss.n1397 avss.n1375 15.5561
R10062 avss.n1397 avss.n1367 15.5561
R10063 avss.n1407 avss.n1367 15.5561
R10064 avss.n1407 avss.n1363 15.5561
R10065 avss.n1413 avss.n1363 15.5561
R10066 avss.n1413 avss.n1355 15.5561
R10067 avss.n1423 avss.n1355 15.5561
R10068 avss.n1423 avss.n1351 15.5561
R10069 avss.n1429 avss.n1351 15.5561
R10070 avss.n1429 avss.n1343 15.5561
R10071 avss.n1439 avss.n1343 15.5561
R10072 avss.n1439 avss.n1339 15.5561
R10073 avss.n1445 avss.n1339 15.5561
R10074 avss.n1445 avss.n1331 15.5561
R10075 avss.n1455 avss.n1331 15.5561
R10076 avss.n1455 avss.n1327 15.5561
R10077 avss.n1461 avss.n1327 15.5561
R10078 avss.n1461 avss.n1319 15.5561
R10079 avss.n1474 avss.n1319 15.5561
R10080 avss.n1474 avss.n1315 15.5561
R10081 avss.n1481 avss.n1315 15.5561
R10082 avss.n1481 avss.n1180 15.5561
R10083 avss.n6715 avss.n1180 15.5561
R10084 avss.n6715 avss.n1181 15.5561
R10085 avss.n6711 avss.n1181 15.5561
R10086 avss.n6711 avss.n1187 15.5561
R10087 avss.n6707 avss.n1187 15.5561
R10088 avss.n6707 avss.n1192 15.5561
R10089 avss.n6703 avss.n1192 15.5561
R10090 avss.n6703 avss.n1198 15.5561
R10091 avss.n1502 avss.n1198 15.5561
R10092 avss.n1502 avss.n1301 15.5561
R10093 avss.n1512 avss.n1301 15.5561
R10094 avss.n1512 avss.n1297 15.5561
R10095 avss.n1518 avss.n1297 15.5561
R10096 avss.n1518 avss.n1289 15.5561
R10097 avss.n1528 avss.n1289 15.5561
R10098 avss.n1528 avss.n1285 15.5561
R10099 avss.n1534 avss.n1285 15.5561
R10100 avss.n1534 avss.n1277 15.5561
R10101 avss.n1547 avss.n1277 15.5561
R10102 avss.n1547 avss.n1273 15.5561
R10103 avss.n1554 avss.n1273 15.5561
R10104 avss.n1554 avss.n1254 15.5561
R10105 avss.n1638 avss.n1254 15.5561
R10106 avss.n1638 avss.n1255 15.5561
R10107 avss.n1634 avss.n1255 15.5561
R10108 avss.n1634 avss.n1633 15.5561
R10109 avss.n1633 avss.n1206 15.5561
R10110 avss.n6698 avss.n1206 15.5561
R10111 avss.n6698 avss.n1207 15.5561
R10112 avss.n6694 avss.n1207 15.5561
R10113 avss.n6694 avss.n1213 15.5561
R10114 avss.n1618 avss.n1213 15.5561
R10115 avss.n1618 avss.n1228 15.5561
R10116 avss.n6682 avss.n1228 15.5561
R10117 avss.n6682 avss.n1229 15.5561
R10118 avss.n6678 avss.n1229 15.5561
R10119 avss.n6678 avss.n1235 15.5561
R10120 avss.n1602 avss.n1235 15.5561
R10121 avss.n1602 avss.n1583 15.5561
R10122 avss.n6084 avss.n5825 15.5561
R10123 avss.n5860 avss.n5723 15.5561
R10124 avss.n6115 avss.n5703 15.5561
R10125 avss.n921 avss.n918 15.5561
R10126 avss.n7051 avss.n921 15.5561
R10127 avss.n7051 avss.n924 15.5561
R10128 avss.n938 avss.n924 15.5561
R10129 avss.n939 avss.n938 15.5561
R10130 avss.n940 avss.n939 15.5561
R10131 avss.n6372 avss.n940 15.5561
R10132 avss.n6372 avss.n949 15.5561
R10133 avss.n6375 avss.n949 15.5561
R10134 avss.n6375 avss.n6361 15.5561
R10135 avss.n6381 avss.n6361 15.5561
R10136 avss.n6381 avss.n6328 15.5561
R10137 avss.n6391 avss.n6328 15.5561
R10138 avss.n927 avss.n917 15.5561
R10139 avss.n7049 avss.n927 15.5561
R10140 avss.n7049 avss.n928 15.5561
R10141 avss.n7045 avss.n928 15.5561
R10142 avss.n7045 avss.n937 15.5561
R10143 avss.n7041 avss.n937 15.5561
R10144 avss.n7041 avss.n941 15.5561
R10145 avss.n7037 avss.n941 15.5561
R10146 avss.n7037 avss.n947 15.5561
R10147 avss.n6359 avss.n947 15.5561
R10148 avss.n6383 avss.n6359 15.5561
R10149 avss.n6383 avss.n6354 15.5561
R10150 avss.n6389 avss.n6354 15.5561
R10151 avss.n6285 avss.n6277 15.5561
R10152 avss.n6285 avss.n6269 15.5561
R10153 avss.n6295 avss.n6269 15.5561
R10154 avss.n6295 avss.n6265 15.5561
R10155 avss.n6301 avss.n6265 15.5561
R10156 avss.n6301 avss.n6255 15.5561
R10157 avss.n6311 avss.n6255 15.5561
R10158 avss.n6287 avss.n6275 15.5561
R10159 avss.n6287 avss.n6271 15.5561
R10160 avss.n6293 avss.n6271 15.5561
R10161 avss.n6293 avss.n6263 15.5561
R10162 avss.n6303 avss.n6263 15.5561
R10163 avss.n6303 avss.n6259 15.5561
R10164 avss.n6309 avss.n6259 15.5561
R10165 avss.n5601 avss.n5598 15.5561
R10166 avss.n6200 avss.n5601 15.5561
R10167 avss.n6200 avss.n5604 15.5561
R10168 avss.n5911 avss.n5604 15.5561
R10169 avss.n5914 avss.n5913 15.5561
R10170 avss.n5921 avss.n5920 15.5561
R10171 avss.n5924 avss.n5923 15.5561
R10172 avss.n5931 avss.n5930 15.5561
R10173 avss.n5934 avss.n5933 15.5561
R10174 avss.n5941 avss.n5940 15.5561
R10175 avss.n5944 avss.n5943 15.5561
R10176 avss.n5951 avss.n5950 15.5561
R10177 avss.n5954 avss.n5953 15.5561
R10178 avss.n5961 avss.n5960 15.5561
R10179 avss.n5964 avss.n5963 15.5561
R10180 avss.n5971 avss.n5970 15.5561
R10181 avss.n5974 avss.n5973 15.5561
R10182 avss.n5981 avss.n5980 15.5561
R10183 avss.n5984 avss.n5983 15.5561
R10184 avss.n5991 avss.n5990 15.5561
R10185 avss.n5993 avss.n5891 15.5561
R10186 avss.n6000 avss.n5873 15.5561
R10187 avss.n6004 avss.n5684 15.5561
R10188 avss.n5685 avss.n5684 15.5561
R10189 avss.n5687 avss.n5685 15.5561
R10190 avss.n6011 avss.n5687 15.5561
R10191 avss.n6011 avss.n5699 15.5561
R10192 avss.n5700 avss.n5699 15.5561
R10193 avss.n6025 avss.n5700 15.5561
R10194 avss.n6026 avss.n6025 15.5561
R10195 avss.n6026 avss.n5710 15.5561
R10196 avss.n5865 avss.n5710 15.5561
R10197 avss.n5865 avss.n5721 15.5561
R10198 avss.n6034 avss.n5721 15.5561
R10199 avss.n6042 avss.n6034 15.5561
R10200 avss.n6042 avss.n5862 15.5561
R10201 avss.n6048 avss.n5862 15.5561
R10202 avss.n6048 avss.n5846 15.5561
R10203 avss.n6059 avss.n5846 15.5561
R10204 avss.n6059 avss.n5841 15.5561
R10205 avss.n6070 avss.n5841 15.5561
R10206 avss.n6070 avss.n5842 15.5561
R10207 avss.n5842 avss.n5833 15.5561
R10208 avss.n5833 avss.n5823 15.5561
R10209 avss.n5607 avss.n5597 15.5561
R10210 avss.n6198 avss.n5607 15.5561
R10211 avss.n6198 avss.n5608 15.5561
R10212 avss.n6194 avss.n5608 15.5561
R10213 avss.n6192 avss.n6191 15.5561
R10214 avss.n6189 avss.n5618 15.5561
R10215 avss.n6185 avss.n6184 15.5561
R10216 avss.n6182 avss.n5626 15.5561
R10217 avss.n6178 avss.n6177 15.5561
R10218 avss.n6175 avss.n5633 15.5561
R10219 avss.n6171 avss.n6170 15.5561
R10220 avss.n6168 avss.n5640 15.5561
R10221 avss.n6164 avss.n6163 15.5561
R10222 avss.n6161 avss.n5647 15.5561
R10223 avss.n6157 avss.n6156 15.5561
R10224 avss.n6154 avss.n5654 15.5561
R10225 avss.n6150 avss.n6149 15.5561
R10226 avss.n6147 avss.n5661 15.5561
R10227 avss.n6143 avss.n6142 15.5561
R10228 avss.n6140 avss.n5668 15.5561
R10229 avss.n6136 avss.n6135 15.5561
R10230 avss.n6133 avss.n5675 15.5561
R10231 avss.n6129 avss.n6128 15.5561
R10232 avss.n6128 avss.n5682 15.5561
R10233 avss.n6123 avss.n5682 15.5561
R10234 avss.n6123 avss.n5689 15.5561
R10235 avss.n6119 avss.n5689 15.5561
R10236 avss.n6119 avss.n5697 15.5561
R10237 avss.n6023 avss.n5697 15.5561
R10238 avss.n6023 avss.n5712 15.5561
R10239 avss.n6106 avss.n5712 15.5561
R10240 avss.n6106 avss.n5713 15.5561
R10241 avss.n6102 avss.n5713 15.5561
R10242 avss.n6102 avss.n5719 15.5561
R10243 avss.n6040 avss.n5719 15.5561
R10244 avss.n6040 avss.n5853 15.5561
R10245 avss.n6051 avss.n5853 15.5561
R10246 avss.n6051 avss.n5849 15.5561
R10247 avss.n6057 avss.n5849 15.5561
R10248 avss.n6057 avss.n5839 15.5561
R10249 avss.n6073 avss.n5839 15.5561
R10250 avss.n6073 avss.n5835 15.5561
R10251 avss.n6081 avss.n5835 15.5561
R10252 avss.n6081 avss.n5822 15.5561
R10253 avss.n4984 avss.n4903 15.5561
R10254 avss.n4983 avss.n4902 15.5561
R10255 avss.n4890 avss.n4877 15.5561
R10256 avss.n5019 avss.n4875 15.5561
R10257 avss.n5028 avss.n4865 15.5561
R10258 avss.n5025 avss.n4864 15.5561
R10259 avss.n4855 avss.n4737 15.5561
R10260 avss.n5035 avss.n4736 15.5561
R10261 avss.n5552 avss.n4702 15.5561
R10262 avss.n5553 avss.n5552 15.5561
R10263 avss.n5553 avss.n4712 15.5561
R10264 avss.n5556 avss.n4712 15.5561
R10265 avss.n5586 avss.n4705 15.5561
R10266 avss.n4710 avss.n4705 15.5561
R10267 avss.n5579 avss.n4710 15.5561
R10268 avss.n5579 avss.n4711 15.5561
R10269 avss.n5422 avss.n4804 15.5561
R10270 avss.n5455 avss.n4804 15.5561
R10271 avss.n5455 avss.n4805 15.5561
R10272 avss.n4805 avss.n4795 15.5561
R10273 avss.n5450 avss.n4795 15.5561
R10274 avss.n5450 avss.n5449 15.5561
R10275 avss.n5449 avss.n4782 15.5561
R10276 avss.n5445 avss.n4782 15.5561
R10277 avss.n5445 avss.n4773 15.5561
R10278 avss.n5442 avss.n4773 15.5561
R10279 avss.n5442 avss.n5441 15.5561
R10280 avss.n5441 avss.n5440 15.5561
R10281 avss.n5440 avss.n4748 15.5561
R10282 avss.n5420 avss.n4802 15.5561
R10283 avss.n5457 avss.n4802 15.5561
R10284 avss.n5457 avss.n4797 15.5561
R10285 avss.n5465 avss.n4797 15.5561
R10286 avss.n5465 avss.n4798 15.5561
R10287 avss.n4798 avss.n4780 15.5561
R10288 avss.n5487 avss.n4780 15.5561
R10289 avss.n5487 avss.n4775 15.5561
R10290 avss.n5504 avss.n4775 15.5561
R10291 avss.n5504 avss.n4776 15.5561
R10292 avss.n5500 avss.n4776 15.5561
R10293 avss.n5500 avss.n5499 15.5561
R10294 avss.n5499 avss.n4747 15.5561
R10295 avss.n4937 avss.n4925 15.5561
R10296 avss.n4949 avss.n4925 15.5561
R10297 avss.n4950 avss.n4949 15.5561
R10298 avss.n4950 avss.n4878 15.5561
R10299 avss.n4953 avss.n4878 15.5561
R10300 avss.n4953 avss.n4889 15.5561
R10301 avss.n4962 avss.n4889 15.5561
R10302 avss.n4962 avss.n4920 15.5561
R10303 avss.n4974 avss.n4920 15.5561
R10304 avss.n4975 avss.n4974 15.5561
R10305 avss.n4975 avss.n4905 15.5561
R10306 avss.n4916 avss.n4905 15.5561
R10307 avss.n4982 avss.n4916 15.5561
R10308 avss.n4940 avss.n4927 15.5561
R10309 avss.n4947 avss.n4927 15.5561
R10310 avss.n4947 avss.n4880 15.5561
R10311 avss.n5016 avss.n4880 15.5561
R10312 avss.n5016 avss.n4881 15.5561
R10313 avss.n5012 avss.n4881 15.5561
R10314 avss.n5012 avss.n4887 15.5561
R10315 avss.n4965 avss.n4887 15.5561
R10316 avss.n4972 avss.n4965 15.5561
R10317 avss.n4972 avss.n4907 15.5561
R10318 avss.n5004 avss.n4907 15.5561
R10319 avss.n5004 avss.n4908 15.5561
R10320 avss.n5000 avss.n4908 15.5561
R10321 avss.n4718 avss.n4715 15.5561
R10322 avss.n5570 avss.n4718 15.5561
R10323 avss.n5570 avss.n4721 15.5561
R10324 avss.n4734 avss.n4721 15.5561
R10325 avss.n4848 avss.n4734 15.5561
R10326 avss.n4848 avss.n4843 15.5561
R10327 avss.n4854 avss.n4843 15.5561
R10328 avss.n4854 avss.n4832 15.5561
R10329 avss.n5046 avss.n4832 15.5561
R10330 avss.n5046 avss.n4828 15.5561
R10331 avss.n5052 avss.n4828 15.5561
R10332 avss.n5052 avss.n4818 15.5561
R10333 avss.n5063 avss.n4818 15.5561
R10334 avss.n4724 avss.n4714 15.5561
R10335 avss.n5568 avss.n4724 15.5561
R10336 avss.n5568 avss.n4725 15.5561
R10337 avss.n5564 avss.n4725 15.5561
R10338 avss.n5564 avss.n4733 15.5561
R10339 avss.n4840 avss.n4733 15.5561
R10340 avss.n5038 avss.n4840 15.5561
R10341 avss.n5038 avss.n4835 15.5561
R10342 avss.n5044 avss.n4835 15.5561
R10343 avss.n5044 avss.n4826 15.5561
R10344 avss.n5055 avss.n4826 15.5561
R10345 avss.n5055 avss.n4822 15.5561
R10346 avss.n5061 avss.n4822 15.5561
R10347 avss.n5476 avss.n4787 15.5561
R10348 avss.n5476 avss.n4783 15.5561
R10349 avss.n5484 avss.n4783 15.5561
R10350 avss.n5484 avss.n4772 15.5561
R10351 avss.n4772 avss.n4762 15.5561
R10352 avss.n5515 avss.n4762 15.5561
R10353 avss.n5515 avss.n4757 15.5561
R10354 avss.n5532 avss.n4757 15.5561
R10355 avss.n5532 avss.n4758 15.5561
R10356 avss.n4758 avss.n4750 15.5561
R10357 avss.n5527 avss.n4750 15.5561
R10358 avss.n5527 avss.n4693 15.5561
R10359 avss.n4700 avss.n4693 15.5561
R10360 avss.n5474 avss.n4790 15.5561
R10361 avss.n5474 avss.n4791 15.5561
R10362 avss.n4791 avss.n4770 15.5561
R10363 avss.n5507 avss.n4770 15.5561
R10364 avss.n5507 avss.n4766 15.5561
R10365 avss.n5513 avss.n4766 15.5561
R10366 avss.n5513 avss.n4755 15.5561
R10367 avss.n5535 avss.n4755 15.5561
R10368 avss.n5535 avss.n4751 15.5561
R10369 avss.n5542 avss.n4751 15.5561
R10370 avss.n5542 avss.n4695 15.5561
R10371 avss.n5594 avss.n4695 15.5561
R10372 avss.n5594 avss.n4696 15.5561
R10373 avss.n5360 avss.n5107 15.5561
R10374 avss.n5366 avss.n5107 15.5561
R10375 avss.n5366 avss.n5099 15.5561
R10376 avss.n5376 avss.n5099 15.5561
R10377 avss.n5376 avss.n5095 15.5561
R10378 avss.n5382 avss.n5095 15.5561
R10379 avss.n5382 avss.n5087 15.5561
R10380 avss.n5392 avss.n5087 15.5561
R10381 avss.n5392 avss.n5083 15.5561
R10382 avss.n5399 avss.n5083 15.5561
R10383 avss.n5399 avss.n5074 15.5561
R10384 avss.n5410 avss.n5074 15.5561
R10385 avss.n5410 avss.n4811 15.5561
R10386 avss.n5358 avss.n5105 15.5561
R10387 avss.n5368 avss.n5105 15.5561
R10388 avss.n5368 avss.n5101 15.5561
R10389 avss.n5374 avss.n5101 15.5561
R10390 avss.n5374 avss.n5093 15.5561
R10391 avss.n5384 avss.n5093 15.5561
R10392 avss.n5384 avss.n5089 15.5561
R10393 avss.n5390 avss.n5089 15.5561
R10394 avss.n5390 avss.n5081 15.5561
R10395 avss.n5401 avss.n5081 15.5561
R10396 avss.n5401 avss.n5077 15.5561
R10397 avss.n5408 avss.n5077 15.5561
R10398 avss.n5408 avss.n4810 15.5561
R10399 avss.n5345 avss.n4691 15.5561
R10400 avss.n4691 avss.n4683 15.5561
R10401 avss.n6220 avss.n4683 15.5561
R10402 avss.n6220 avss.n4679 15.5561
R10403 avss.n6226 avss.n4679 15.5561
R10404 avss.n6226 avss.n4669 15.5561
R10405 avss.n6236 avss.n4669 15.5561
R10406 avss.n6212 avss.n4689 15.5561
R10407 avss.n6212 avss.n4685 15.5561
R10408 avss.n6218 avss.n4685 15.5561
R10409 avss.n6218 avss.n4677 15.5561
R10410 avss.n6228 avss.n4677 15.5561
R10411 avss.n6228 avss.n4673 15.5561
R10412 avss.n6234 avss.n4673 15.5561
R10413 avss.n1943 avss.n1853 15.5561
R10414 avss.n1927 avss.n1853 15.5561
R10415 avss.n1927 avss.n1812 15.5561
R10416 avss.n1935 avss.n1812 15.5561
R10417 avss.n1935 avss.n1800 15.5561
R10418 avss.n1800 avss.n1788 15.5561
R10419 avss.n1981 avss.n1788 15.5561
R10420 avss.n1982 avss.n1981 15.5561
R10421 avss.n1982 avss.n1773 15.5561
R10422 avss.n1784 avss.n1773 15.5561
R10423 avss.n1784 avss.n1762 15.5561
R10424 avss.n1989 avss.n1762 15.5561
R10425 avss.n1989 avss.n1750 15.5561
R10426 avss.n1950 avss.n1924 15.5561
R10427 avss.n1950 avss.n1809 15.5561
R10428 avss.n1960 avss.n1809 15.5561
R10429 avss.n1960 avss.n1804 15.5561
R10430 avss.n1971 avss.n1804 15.5561
R10431 avss.n1971 avss.n1805 15.5561
R10432 avss.n1805 avss.n1792 15.5561
R10433 avss.n1792 avss.n1776 15.5561
R10434 avss.n3295 avss.n1776 15.5561
R10435 avss.n3295 avss.n1777 15.5561
R10436 avss.n1777 avss.n1765 15.5561
R10437 avss.n3290 avss.n1765 15.5561
R10438 avss.n3290 avss.n1753 15.5561
R10439 avss.n1888 avss.n1854 15.5561
R10440 avss.n1860 avss.n1854 15.5561
R10441 avss.n1860 avss.n1813 15.5561
R10442 avss.n1880 avss.n1813 15.5561
R10443 avss.n1880 avss.n1801 15.5561
R10444 avss.n1877 avss.n1801 15.5561
R10445 avss.n1877 avss.n1790 15.5561
R10446 avss.n1874 avss.n1790 15.5561
R10447 avss.n1874 avss.n1774 15.5561
R10448 avss.n1871 avss.n1774 15.5561
R10449 avss.n1871 avss.n1763 15.5561
R10450 avss.n1763 avss.n1746 15.5561
R10451 avss.n3316 avss.n1746 15.5561
R10452 avss.n1923 avss.n1855 15.5561
R10453 avss.n1923 avss.n1856 15.5561
R10454 avss.n1856 avss.n1814 15.5561
R10455 avss.n1916 avss.n1814 15.5561
R10456 avss.n1916 avss.n1803 15.5561
R10457 avss.n1913 avss.n1803 15.5561
R10458 avss.n1913 avss.n1791 15.5561
R10459 avss.n1910 avss.n1791 15.5561
R10460 avss.n1910 avss.n1775 15.5561
R10461 avss.n1907 avss.n1775 15.5561
R10462 avss.n1907 avss.n1764 15.5561
R10463 avss.n1904 avss.n1764 15.5561
R10464 avss.n1904 avss.n1752 15.5561
R10465 avss.n509 avss.n479 15.5561
R10466 avss.n7381 avss.n478 15.5561
R10467 avss.n7285 avss.n522 15.5561
R10468 avss.n7294 avss.n522 15.5561
R10469 avss.n7294 avss.n518 15.5561
R10470 avss.n7305 avss.n518 15.5561
R10471 avss.n7287 avss.n525 15.5561
R10472 avss.n7293 avss.n525 15.5561
R10473 avss.n7293 avss.n515 15.5561
R10474 avss.n7374 avss.n515 15.5561
R10475 avss.n2820 avss.n1994 15.5561
R10476 avss.n2821 avss.n2820 15.5561
R10477 avss.n2821 avss.n2009 15.5561
R10478 avss.n2827 avss.n2009 15.5561
R10479 avss.n2828 avss.n2827 15.5561
R10480 avss.n2831 avss.n2830 15.5561
R10481 avss.n2838 avss.n2837 15.5561
R10482 avss.n2840 avss.n2809 15.5561
R10483 avss.n2847 avss.n533 15.5561
R10484 avss.n3283 avss.n2001 15.5561
R10485 avss.n2006 avss.n2001 15.5561
R10486 avss.n3276 avss.n2006 15.5561
R10487 avss.n3276 avss.n2007 15.5561
R10488 avss.n2783 avss.n2007 15.5561
R10489 avss.n2786 avss.n2785 15.5561
R10490 avss.n2793 avss.n2792 15.5561
R10491 avss.n2795 avss.n2778 15.5561
R10492 avss.n2803 avss.n532 15.5561
R10493 avss.n2893 avss.n2857 15.5561
R10494 avss.n2890 avss.n2861 15.5561
R10495 avss.n2886 avss.n2885 15.5561
R10496 avss.n2882 avss.n2881 15.5561
R10497 avss.n2878 avss.n2877 15.5561
R10498 avss.n2877 avss.n535 15.5561
R10499 avss.n2872 avss.n535 15.5561
R10500 avss.n2872 avss.n545 15.5561
R10501 avss.n7269 avss.n545 15.5561
R10502 avss.n2923 avss.n2854 15.5561
R10503 avss.n2919 avss.n2918 15.5561
R10504 avss.n2915 avss.n2914 15.5561
R10505 avss.n2911 avss.n2910 15.5561
R10506 avss.n2907 avss.n537 15.5561
R10507 avss.n7277 avss.n537 15.5561
R10508 avss.n7277 avss.n538 15.5561
R10509 avss.n7273 avss.n538 15.5561
R10510 avss.n7273 avss.n544 15.5561
R10511 avss.n7465 avss.n394 15.5561
R10512 avss.n7471 avss.n397 15.5561
R10513 avss.n7426 avss.n419 15.5561
R10514 avss.n7424 avss.n418 15.5561
R10515 avss.n7413 avss.n431 15.5561
R10516 avss.n7411 avss.n474 15.5561
R10517 avss.n437 avss.n434 15.5561
R10518 avss.n465 avss.n437 15.5561
R10519 avss.n465 avss.n450 15.5561
R10520 avss.n450 avss.n449 15.5561
R10521 avss.n449 avss.n417 15.5561
R10522 avss.n417 avss.n410 15.5561
R10523 avss.n7445 avss.n410 15.5561
R10524 avss.n7446 avss.n7445 15.5561
R10525 avss.n7446 avss.n382 15.5561
R10526 avss.n406 avss.n382 15.5561
R10527 avss.n406 avss.n393 15.5561
R10528 avss.n7453 avss.n393 15.5561
R10529 avss.n7453 avss.n401 15.5561
R10530 avss.n454 avss.n433 15.5561
R10531 avss.n463 avss.n454 15.5561
R10532 avss.n463 avss.n455 15.5561
R10533 avss.n455 avss.n415 15.5561
R10534 avss.n7436 avss.n415 15.5561
R10535 avss.n7436 avss.n411 15.5561
R10536 avss.n7443 avss.n411 15.5561
R10537 avss.n7443 avss.n384 15.5561
R10538 avss.n7478 avss.n384 15.5561
R10539 avss.n7478 avss.n385 15.5561
R10540 avss.n7474 avss.n385 15.5561
R10541 avss.n7474 avss.n391 15.5561
R10542 avss.n7462 avss.n391 15.5561
R10543 avss.n7312 avss.n7306 15.5561
R10544 avss.n7360 avss.n7312 15.5561
R10545 avss.n7360 avss.n496 15.5561
R10546 avss.n7357 avss.n496 15.5561
R10547 avss.n7357 avss.n507 15.5561
R10548 avss.n508 avss.n507 15.5561
R10549 avss.n7353 avss.n508 15.5561
R10550 avss.n7353 avss.n7352 15.5561
R10551 avss.n7352 avss.n7341 15.5561
R10552 avss.n7341 avss.n481 15.5561
R10553 avss.n7337 avss.n481 15.5561
R10554 avss.n7337 avss.n492 15.5561
R10555 avss.n7333 avss.n492 15.5561
R10556 avss.n7371 avss.n7309 15.5561
R10557 avss.n7309 avss.n498 15.5561
R10558 avss.n7389 avss.n498 15.5561
R10559 avss.n7389 avss.n499 15.5561
R10560 avss.n7385 avss.n499 15.5561
R10561 avss.n7385 avss.n505 15.5561
R10562 avss.n7343 avss.n505 15.5561
R10563 avss.n7350 avss.n7343 15.5561
R10564 avss.n7350 avss.n483 15.5561
R10565 avss.n7401 avss.n483 15.5561
R10566 avss.n7401 avss.n484 15.5561
R10567 avss.n7397 avss.n484 15.5561
R10568 avss.n7397 avss.n490 15.5561
R10569 avss.n7948 avss.n7945 15.5561
R10570 avss.n8056 avss.n7948 15.5561
R10571 avss.n8056 avss.n8055 15.5561
R10572 avss.n8055 avss.n8054 15.5561
R10573 avss.n8054 avss.n7951 15.5561
R10574 avss.n8050 avss.n7951 15.5561
R10575 avss.n8050 avss.n7957 15.5561
R10576 avss.n7985 avss.n7957 15.5561
R10577 avss.n7986 avss.n7985 15.5561
R10578 avss.n7987 avss.n7986 15.5561
R10579 avss.n8025 avss.n7987 15.5561
R10580 avss.n8025 avss.n7997 15.5561
R10581 avss.n7998 avss.n7997 15.5561
R10582 avss.n7964 avss.n7944 15.5561
R10583 avss.n7970 avss.n7964 15.5561
R10584 avss.n7971 avss.n7970 15.5561
R10585 avss.n7972 avss.n7971 15.5561
R10586 avss.n7972 avss.n7959 15.5561
R10587 avss.n8048 avss.n7959 15.5561
R10588 avss.n8048 avss.n7960 15.5561
R10589 avss.n8044 avss.n7960 15.5561
R10590 avss.n8044 avss.n7980 15.5561
R10591 avss.n8040 avss.n7980 15.5561
R10592 avss.n8040 avss.n7989 15.5561
R10593 avss.n8036 avss.n7989 15.5561
R10594 avss.n8036 avss.n7995 15.5561
R10595 avss.n7492 avss.n7489 15.5561
R10596 avss.n8891 avss.n7492 15.5561
R10597 avss.n8891 avss.n7495 15.5561
R10598 avss.n7512 avss.n7495 15.5561
R10599 avss.n8288 avss.n7512 15.5561
R10600 avss.n8288 avss.n7525 15.5561
R10601 avss.n8291 avss.n7525 15.5561
R10602 avss.n8291 avss.n7537 15.5561
R10603 avss.n8296 avss.n7537 15.5561
R10604 avss.n8296 avss.n7549 15.5561
R10605 avss.n8299 avss.n7549 15.5561
R10606 avss.n8299 avss.n7561 15.5561
R10607 avss.n8304 avss.n7561 15.5561
R10608 avss.n8304 avss.n7573 15.5561
R10609 avss.n8307 avss.n7573 15.5561
R10610 avss.n8307 avss.n7585 15.5561
R10611 avss.n8312 avss.n7585 15.5561
R10612 avss.n8312 avss.n7597 15.5561
R10613 avss.n8315 avss.n7597 15.5561
R10614 avss.n8315 avss.n7609 15.5561
R10615 avss.n8320 avss.n7609 15.5561
R10616 avss.n8320 avss.n7621 15.5561
R10617 avss.n8323 avss.n7621 15.5561
R10618 avss.n8323 avss.n7633 15.5561
R10619 avss.n8328 avss.n7633 15.5561
R10620 avss.n8328 avss.n7645 15.5561
R10621 avss.n8331 avss.n7645 15.5561
R10622 avss.n8331 avss.n7657 15.5561
R10623 avss.n8336 avss.n7657 15.5561
R10624 avss.n8336 avss.n7669 15.5561
R10625 avss.n8339 avss.n7669 15.5561
R10626 avss.n8339 avss.n7681 15.5561
R10627 avss.n8344 avss.n7681 15.5561
R10628 avss.n8344 avss.n7693 15.5561
R10629 avss.n8347 avss.n7693 15.5561
R10630 avss.n8347 avss.n7705 15.5561
R10631 avss.n8352 avss.n7705 15.5561
R10632 avss.n8352 avss.n7717 15.5561
R10633 avss.n8064 avss.n7717 15.5561
R10634 avss.n8064 avss.n7730 15.5561
R10635 avss.n8388 avss.n7730 15.5561
R10636 avss.n8388 avss.n7743 15.5561
R10637 avss.n7850 avss.n7743 15.5561
R10638 avss.n7850 avss.n7756 15.5561
R10639 avss.n8382 avss.n7756 15.5561
R10640 avss.n8382 avss.n8364 15.5561
R10641 avss.n8375 avss.n8364 15.5561
R10642 avss.n8375 avss.n123 15.5561
R10643 avss.n123 avss.n115 15.5561
R10644 avss.n9231 avss.n115 15.5561
R10645 avss.n9231 avss.n111 15.5561
R10646 avss.n9237 avss.n111 15.5561
R10647 avss.n9237 avss.n101 15.5561
R10648 avss.n9263 avss.n101 15.5561
R10649 avss.n9263 avss.n97 15.5561
R10650 avss.n9269 avss.n97 15.5561
R10651 avss.n9269 avss.n88 15.5561
R10652 avss.n9280 avss.n88 15.5561
R10653 avss.n9280 avss.n83 15.5561
R10654 avss.n9291 avss.n83 15.5561
R10655 avss.n9291 avss.n84 15.5561
R10656 avss.n84 avss.n76 15.5561
R10657 avss.n76 avss.n67 15.5561
R10658 avss.n7502 avss.n7488 15.5561
R10659 avss.n8889 avss.n7502 15.5561
R10660 avss.n8889 avss.n7503 15.5561
R10661 avss.n8885 avss.n7503 15.5561
R10662 avss.n8885 avss.n7511 15.5561
R10663 avss.n8877 avss.n7511 15.5561
R10664 avss.n8877 avss.n7530 15.5561
R10665 avss.n8873 avss.n7530 15.5561
R10666 avss.n8873 avss.n7536 15.5561
R10667 avss.n8865 avss.n7536 15.5561
R10668 avss.n8865 avss.n7554 15.5561
R10669 avss.n8861 avss.n7554 15.5561
R10670 avss.n8861 avss.n7560 15.5561
R10671 avss.n8853 avss.n7560 15.5561
R10672 avss.n8853 avss.n7578 15.5561
R10673 avss.n8849 avss.n7578 15.5561
R10674 avss.n8849 avss.n7584 15.5561
R10675 avss.n8841 avss.n7584 15.5561
R10676 avss.n8841 avss.n7602 15.5561
R10677 avss.n8837 avss.n7602 15.5561
R10678 avss.n8837 avss.n7608 15.5561
R10679 avss.n8829 avss.n7608 15.5561
R10680 avss.n8829 avss.n7626 15.5561
R10681 avss.n8825 avss.n7626 15.5561
R10682 avss.n8825 avss.n7632 15.5561
R10683 avss.n8817 avss.n7632 15.5561
R10684 avss.n8817 avss.n7650 15.5561
R10685 avss.n8813 avss.n7650 15.5561
R10686 avss.n8813 avss.n7656 15.5561
R10687 avss.n8805 avss.n7656 15.5561
R10688 avss.n8805 avss.n7674 15.5561
R10689 avss.n8801 avss.n7674 15.5561
R10690 avss.n8801 avss.n7680 15.5561
R10691 avss.n8793 avss.n7680 15.5561
R10692 avss.n8793 avss.n7698 15.5561
R10693 avss.n8789 avss.n7698 15.5561
R10694 avss.n8789 avss.n7704 15.5561
R10695 avss.n8781 avss.n7704 15.5561
R10696 avss.n8781 avss.n7722 15.5561
R10697 avss.n8777 avss.n7722 15.5561
R10698 avss.n8777 avss.n7728 15.5561
R10699 avss.n8769 avss.n7728 15.5561
R10700 avss.n8769 avss.n7748 15.5561
R10701 avss.n8765 avss.n7748 15.5561
R10702 avss.n8765 avss.n7754 15.5561
R10703 avss.n8368 avss.n7754 15.5561
R10704 avss.n8368 avss.n122 15.5561
R10705 avss.n9223 avss.n122 15.5561
R10706 avss.n9223 avss.n118 15.5561
R10707 avss.n9229 avss.n118 15.5561
R10708 avss.n9229 avss.n109 15.5561
R10709 avss.n9255 avss.n109 15.5561
R10710 avss.n9255 avss.n105 15.5561
R10711 avss.n9261 avss.n105 15.5561
R10712 avss.n9261 avss.n95 15.5561
R10713 avss.n9272 avss.n95 15.5561
R10714 avss.n9272 avss.n91 15.5561
R10715 avss.n9278 avss.n91 15.5561
R10716 avss.n9278 avss.n81 15.5561
R10717 avss.n9294 avss.n81 15.5561
R10718 avss.n9294 avss.n77 15.5561
R10719 avss.n9302 avss.n77 15.5561
R10720 avss.n9302 avss.n66 15.5561
R10721 avss.n8905 avss.n366 15.5561
R10722 avss.n8911 avss.n366 15.5561
R10723 avss.n8911 avss.n358 15.5561
R10724 avss.n8921 avss.n358 15.5561
R10725 avss.n8921 avss.n354 15.5561
R10726 avss.n8927 avss.n354 15.5561
R10727 avss.n8927 avss.n346 15.5561
R10728 avss.n8937 avss.n346 15.5561
R10729 avss.n8937 avss.n342 15.5561
R10730 avss.n8943 avss.n342 15.5561
R10731 avss.n8943 avss.n334 15.5561
R10732 avss.n8953 avss.n334 15.5561
R10733 avss.n8953 avss.n330 15.5561
R10734 avss.n8959 avss.n330 15.5561
R10735 avss.n8959 avss.n322 15.5561
R10736 avss.n8969 avss.n322 15.5561
R10737 avss.n8969 avss.n318 15.5561
R10738 avss.n8978 avss.n318 15.5561
R10739 avss.n8978 avss.n310 15.5561
R10740 avss.n8989 avss.n310 15.5561
R10741 avss.n8990 avss.n8989 15.5561
R10742 avss.n8990 avss.n226 15.5561
R10743 avss.n306 avss.n226 15.5561
R10744 avss.n306 avss.n236 15.5561
R10745 avss.n237 avss.n236 15.5561
R10746 avss.n238 avss.n237 15.5561
R10747 avss.n303 avss.n238 15.5561
R10748 avss.n303 avss.n247 15.5561
R10749 avss.n248 avss.n247 15.5561
R10750 avss.n249 avss.n248 15.5561
R10751 avss.n300 avss.n249 15.5561
R10752 avss.n300 avss.n258 15.5561
R10753 avss.n259 avss.n258 15.5561
R10754 avss.n260 avss.n259 15.5561
R10755 avss.n297 avss.n260 15.5561
R10756 avss.n297 avss.n269 15.5561
R10757 avss.n270 avss.n269 15.5561
R10758 avss.n271 avss.n270 15.5561
R10759 avss.n294 avss.n271 15.5561
R10760 avss.n294 avss.n280 15.5561
R10761 avss.n281 avss.n280 15.5561
R10762 avss.n282 avss.n281 15.5561
R10763 avss.n290 avss.n282 15.5561
R10764 avss.n9080 avss.n290 15.5561
R10765 avss.n9080 avss.n291 15.5561
R10766 avss.n291 avss.n152 15.5561
R10767 avss.n9075 avss.n152 15.5561
R10768 avss.n9075 avss.n163 15.5561
R10769 avss.n9072 avss.n163 15.5561
R10770 avss.n9072 avss.n166 15.5561
R10771 avss.n9069 avss.n166 15.5561
R10772 avss.n9069 avss.n176 15.5561
R10773 avss.n9066 avss.n176 15.5561
R10774 avss.n9066 avss.n9065 15.5561
R10775 avss.n9065 avss.n9057 15.5561
R10776 avss.n9057 avss.n184 15.5561
R10777 avss.n9053 avss.n184 15.5561
R10778 avss.n9053 avss.n195 15.5561
R10779 avss.n197 avss.n195 15.5561
R10780 avss.n198 avss.n197 15.5561
R10781 avss.n9048 avss.n198 15.5561
R10782 avss.n9048 avss.n208 15.5561
R10783 avss.n222 avss.n208 15.5561
R10784 avss.n8903 avss.n364 15.5561
R10785 avss.n8913 avss.n364 15.5561
R10786 avss.n8913 avss.n360 15.5561
R10787 avss.n8919 avss.n360 15.5561
R10788 avss.n8919 avss.n352 15.5561
R10789 avss.n8929 avss.n352 15.5561
R10790 avss.n8929 avss.n348 15.5561
R10791 avss.n8935 avss.n348 15.5561
R10792 avss.n8935 avss.n340 15.5561
R10793 avss.n8945 avss.n340 15.5561
R10794 avss.n8945 avss.n336 15.5561
R10795 avss.n8951 avss.n336 15.5561
R10796 avss.n8951 avss.n328 15.5561
R10797 avss.n8961 avss.n328 15.5561
R10798 avss.n8961 avss.n324 15.5561
R10799 avss.n8967 avss.n324 15.5561
R10800 avss.n8967 avss.n316 15.5561
R10801 avss.n8980 avss.n316 15.5561
R10802 avss.n8980 avss.n312 15.5561
R10803 avss.n8987 avss.n312 15.5561
R10804 avss.n8987 avss.n228 15.5561
R10805 avss.n9126 avss.n228 15.5561
R10806 avss.n9126 avss.n229 15.5561
R10807 avss.n9122 avss.n229 15.5561
R10808 avss.n9122 avss.n235 15.5561
R10809 avss.n9118 avss.n235 15.5561
R10810 avss.n9118 avss.n240 15.5561
R10811 avss.n9114 avss.n240 15.5561
R10812 avss.n9114 avss.n246 15.5561
R10813 avss.n9110 avss.n246 15.5561
R10814 avss.n9110 avss.n251 15.5561
R10815 avss.n9106 avss.n251 15.5561
R10816 avss.n9106 avss.n257 15.5561
R10817 avss.n9102 avss.n257 15.5561
R10818 avss.n9102 avss.n262 15.5561
R10819 avss.n9098 avss.n262 15.5561
R10820 avss.n9098 avss.n268 15.5561
R10821 avss.n9094 avss.n268 15.5561
R10822 avss.n9094 avss.n273 15.5561
R10823 avss.n9090 avss.n273 15.5561
R10824 avss.n9090 avss.n279 15.5561
R10825 avss.n9086 avss.n279 15.5561
R10826 avss.n9086 avss.n284 15.5561
R10827 avss.n9082 avss.n284 15.5561
R10828 avss.n9082 avss.n154 15.5561
R10829 avss.n9191 avss.n154 15.5561
R10830 avss.n9191 avss.n155 15.5561
R10831 avss.n9187 avss.n155 15.5561
R10832 avss.n9187 avss.n161 15.5561
R10833 avss.n9176 avss.n161 15.5561
R10834 avss.n9176 avss.n168 15.5561
R10835 avss.n9172 avss.n168 15.5561
R10836 avss.n9172 avss.n174 15.5561
R10837 avss.n9063 avss.n174 15.5561
R10838 avss.n9063 avss.n186 15.5561
R10839 avss.n9157 avss.n186 15.5561
R10840 avss.n9157 avss.n187 15.5561
R10841 avss.n9153 avss.n187 15.5561
R10842 avss.n9153 avss.n193 15.5561
R10843 avss.n9148 avss.n193 15.5561
R10844 avss.n9148 avss.n200 15.5561
R10845 avss.n9144 avss.n200 15.5561
R10846 avss.n9144 avss.n206 15.5561
R10847 avss.n9141 avss.n211 15.5561
R10848 avss.n9163 avss.n178 15.5561
R10849 avss.n9184 avss.n149 15.5561
R10850 avss.n8179 avss.n8178 15.5561
R10851 avss.n8178 avss.n7498 15.5561
R10852 avss.n8174 avss.n7498 15.5561
R10853 avss.n8174 avss.n7514 15.5561
R10854 avss.n8171 avss.n7514 15.5561
R10855 avss.n8171 avss.n7527 15.5561
R10856 avss.n8168 avss.n7527 15.5561
R10857 avss.n8168 avss.n7539 15.5561
R10858 avss.n8165 avss.n7539 15.5561
R10859 avss.n8165 avss.n7551 15.5561
R10860 avss.n8162 avss.n7551 15.5561
R10861 avss.n8162 avss.n7563 15.5561
R10862 avss.n8159 avss.n7563 15.5561
R10863 avss.n8159 avss.n7575 15.5561
R10864 avss.n8156 avss.n7575 15.5561
R10865 avss.n8156 avss.n7587 15.5561
R10866 avss.n8153 avss.n7587 15.5561
R10867 avss.n8153 avss.n7599 15.5561
R10868 avss.n8150 avss.n7599 15.5561
R10869 avss.n8150 avss.n7611 15.5561
R10870 avss.n8147 avss.n7611 15.5561
R10871 avss.n8147 avss.n7623 15.5561
R10872 avss.n8144 avss.n7623 15.5561
R10873 avss.n8144 avss.n7635 15.5561
R10874 avss.n8141 avss.n7635 15.5561
R10875 avss.n8141 avss.n7647 15.5561
R10876 avss.n8138 avss.n7647 15.5561
R10877 avss.n8138 avss.n7659 15.5561
R10878 avss.n8135 avss.n7659 15.5561
R10879 avss.n8135 avss.n7671 15.5561
R10880 avss.n8132 avss.n7671 15.5561
R10881 avss.n8132 avss.n7683 15.5561
R10882 avss.n8129 avss.n7683 15.5561
R10883 avss.n8129 avss.n7695 15.5561
R10884 avss.n8126 avss.n7695 15.5561
R10885 avss.n8126 avss.n7707 15.5561
R10886 avss.n8123 avss.n7707 15.5561
R10887 avss.n8123 avss.n7719 15.5561
R10888 avss.n8513 avss.n7719 15.5561
R10889 avss.n8513 avss.n7732 15.5561
R10890 avss.n8505 avss.n7732 15.5561
R10891 avss.n8505 avss.n7745 15.5561
R10892 avss.n7851 avss.n7745 15.5561
R10893 avss.n7851 avss.n7758 15.5561
R10894 avss.n7858 avss.n7758 15.5561
R10895 avss.n8526 avss.n7858 15.5561
R10896 avss.n8534 avss.n8526 15.5561
R10897 avss.n8535 avss.n8534 15.5561
R10898 avss.n8535 avss.n7869 15.5561
R10899 avss.n8540 avss.n7869 15.5561
R10900 avss.n8540 avss.n7880 15.5561
R10901 avss.n7881 avss.n7880 15.5561
R10902 avss.n7933 avss.n7881 15.5561
R10903 avss.n8548 avss.n7933 15.5561
R10904 avss.n8548 avss.n7917 15.5561
R10905 avss.n8560 avss.n7917 15.5561
R10906 avss.n8560 avss.n7913 15.5561
R10907 avss.n8568 avss.n7913 15.5561
R10908 avss.n8568 avss.n7904 15.5561
R10909 avss.n8579 avss.n7904 15.5561
R10910 avss.n8580 avss.n8579 15.5561
R10911 avss.n8580 avss.n7896 15.5561
R10912 avss.n8586 avss.n7896 15.5561
R10913 avss.n8186 avss.n8185 15.5561
R10914 avss.n8186 avss.n7500 15.5561
R10915 avss.n8191 avss.n7500 15.5561
R10916 avss.n8191 avss.n7516 15.5561
R10917 avss.n8194 avss.n7516 15.5561
R10918 avss.n8194 avss.n7529 15.5561
R10919 avss.n8199 avss.n7529 15.5561
R10920 avss.n8199 avss.n7541 15.5561
R10921 avss.n8202 avss.n7541 15.5561
R10922 avss.n8202 avss.n7553 15.5561
R10923 avss.n8207 avss.n7553 15.5561
R10924 avss.n8207 avss.n7565 15.5561
R10925 avss.n8210 avss.n7565 15.5561
R10926 avss.n8210 avss.n7577 15.5561
R10927 avss.n8215 avss.n7577 15.5561
R10928 avss.n8215 avss.n7589 15.5561
R10929 avss.n8218 avss.n7589 15.5561
R10930 avss.n8218 avss.n7601 15.5561
R10931 avss.n8223 avss.n7601 15.5561
R10932 avss.n8223 avss.n7613 15.5561
R10933 avss.n8226 avss.n7613 15.5561
R10934 avss.n8226 avss.n7625 15.5561
R10935 avss.n8231 avss.n7625 15.5561
R10936 avss.n8231 avss.n7637 15.5561
R10937 avss.n8234 avss.n7637 15.5561
R10938 avss.n8234 avss.n7649 15.5561
R10939 avss.n8239 avss.n7649 15.5561
R10940 avss.n8239 avss.n7661 15.5561
R10941 avss.n8242 avss.n7661 15.5561
R10942 avss.n8242 avss.n7673 15.5561
R10943 avss.n8247 avss.n7673 15.5561
R10944 avss.n8247 avss.n7685 15.5561
R10945 avss.n8250 avss.n7685 15.5561
R10946 avss.n8250 avss.n7697 15.5561
R10947 avss.n8255 avss.n7697 15.5561
R10948 avss.n8255 avss.n7709 15.5561
R10949 avss.n8258 avss.n7709 15.5561
R10950 avss.n8258 avss.n7721 15.5561
R10951 avss.n8511 avss.n7721 15.5561
R10952 avss.n8511 avss.n7734 15.5561
R10953 avss.n8507 avss.n7734 15.5561
R10954 avss.n8507 avss.n7747 15.5561
R10955 avss.n8640 avss.n7747 15.5561
R10956 avss.n8640 avss.n7760 15.5561
R10957 avss.n8636 avss.n7760 15.5561
R10958 avss.n8636 avss.n7857 15.5561
R10959 avss.n8532 avss.n7857 15.5561
R10960 avss.n8532 avss.n7871 15.5561
R10961 avss.n8621 avss.n7871 15.5561
R10962 avss.n8621 avss.n7872 15.5561
R10963 avss.n8617 avss.n7872 15.5561
R10964 avss.n8617 avss.n7878 15.5561
R10965 avss.n7932 avss.n7878 15.5561
R10966 avss.n8552 avss.n7932 15.5561
R10967 avss.n8552 avss.n7927 15.5561
R10968 avss.n8558 avss.n7927 15.5561
R10969 avss.n8558 avss.n7911 15.5561
R10970 avss.n8570 avss.n7911 15.5561
R10971 avss.n8570 avss.n7907 15.5561
R10972 avss.n8577 avss.n7907 15.5561
R10973 avss.n8577 avss.n7897 15.5561
R10974 avss.n8594 avss.n7897 15.5561
R10975 avss.n8594 avss.n7898 15.5561
R10976 avss.n8603 avss.n8597 15.5561
R10977 avss.n7924 avss.n7883 15.5561
R10978 avss.n8627 avss.n7860 15.5561
R10979 avss.n8411 avss.n8410 15.5561
R10980 avss.n8411 avss.n7497 15.5561
R10981 avss.n8426 avss.n7497 15.5561
R10982 avss.n8426 avss.n7513 15.5561
R10983 avss.n8431 avss.n7513 15.5561
R10984 avss.n8431 avss.n7526 15.5561
R10985 avss.n8434 avss.n7526 15.5561
R10986 avss.n8434 avss.n7538 15.5561
R10987 avss.n8439 avss.n7538 15.5561
R10988 avss.n8439 avss.n7550 15.5561
R10989 avss.n8442 avss.n7550 15.5561
R10990 avss.n8442 avss.n7562 15.5561
R10991 avss.n8447 avss.n7562 15.5561
R10992 avss.n8447 avss.n7574 15.5561
R10993 avss.n8450 avss.n7574 15.5561
R10994 avss.n8450 avss.n7586 15.5561
R10995 avss.n8455 avss.n7586 15.5561
R10996 avss.n8455 avss.n7598 15.5561
R10997 avss.n8458 avss.n7598 15.5561
R10998 avss.n8458 avss.n7610 15.5561
R10999 avss.n8463 avss.n7610 15.5561
R11000 avss.n8463 avss.n7622 15.5561
R11001 avss.n8466 avss.n7622 15.5561
R11002 avss.n8466 avss.n7634 15.5561
R11003 avss.n8471 avss.n7634 15.5561
R11004 avss.n8471 avss.n7646 15.5561
R11005 avss.n8474 avss.n7646 15.5561
R11006 avss.n8474 avss.n7658 15.5561
R11007 avss.n8479 avss.n7658 15.5561
R11008 avss.n8479 avss.n7670 15.5561
R11009 avss.n8482 avss.n7670 15.5561
R11010 avss.n8482 avss.n7682 15.5561
R11011 avss.n8487 avss.n7682 15.5561
R11012 avss.n8487 avss.n7694 15.5561
R11013 avss.n8490 avss.n7694 15.5561
R11014 avss.n8490 avss.n7706 15.5561
R11015 avss.n8495 avss.n7706 15.5561
R11016 avss.n8495 avss.n7718 15.5561
R11017 avss.n8065 avss.n7718 15.5561
R11018 avss.n8065 avss.n7731 15.5561
R11019 avss.n8504 avss.n7731 15.5561
R11020 avss.n8504 avss.n7744 15.5561
R11021 avss.n8642 avss.n7744 15.5561
R11022 avss.n8642 avss.n7757 15.5561
R11023 avss.n7846 avss.n7757 15.5561
R11024 avss.n7846 avss.n7769 15.5561
R11025 avss.n7770 avss.n7769 15.5561
R11026 avss.n8658 avss.n7770 15.5561
R11027 avss.n8658 avss.n8650 15.5561
R11028 avss.n8650 avss.n7780 15.5561
R11029 avss.n8664 avss.n7780 15.5561
R11030 avss.n8664 avss.n7791 15.5561
R11031 avss.n7840 avss.n7791 15.5561
R11032 avss.n8671 avss.n7840 15.5561
R11033 avss.n8671 avss.n7827 15.5561
R11034 avss.n8683 avss.n7827 15.5561
R11035 avss.n8683 avss.n7823 15.5561
R11036 avss.n8691 avss.n7823 15.5561
R11037 avss.n8691 avss.n7814 15.5561
R11038 avss.n8703 avss.n7814 15.5561
R11039 avss.n8704 avss.n8703 15.5561
R11040 avss.n8704 avss.n7806 15.5561
R11041 avss.n8710 avss.n7806 15.5561
R11042 avss.n8418 avss.n8417 15.5561
R11043 avss.n8417 avss.n7501 15.5561
R11044 avss.n7517 avss.n7501 15.5561
R11045 avss.n8883 avss.n7517 15.5561
R11046 avss.n8883 avss.n7518 15.5561
R11047 avss.n8879 avss.n7518 15.5561
R11048 avss.n8879 avss.n7524 15.5561
R11049 avss.n8871 avss.n7524 15.5561
R11050 avss.n8871 avss.n7542 15.5561
R11051 avss.n8867 avss.n7542 15.5561
R11052 avss.n8867 avss.n7548 15.5561
R11053 avss.n8859 avss.n7548 15.5561
R11054 avss.n8859 avss.n7566 15.5561
R11055 avss.n8855 avss.n7566 15.5561
R11056 avss.n8855 avss.n7572 15.5561
R11057 avss.n8847 avss.n7572 15.5561
R11058 avss.n8847 avss.n7590 15.5561
R11059 avss.n8843 avss.n7590 15.5561
R11060 avss.n8843 avss.n7596 15.5561
R11061 avss.n8835 avss.n7596 15.5561
R11062 avss.n8835 avss.n7614 15.5561
R11063 avss.n8831 avss.n7614 15.5561
R11064 avss.n8831 avss.n7620 15.5561
R11065 avss.n8823 avss.n7620 15.5561
R11066 avss.n8823 avss.n7638 15.5561
R11067 avss.n8819 avss.n7638 15.5561
R11068 avss.n8819 avss.n7644 15.5561
R11069 avss.n8811 avss.n7644 15.5561
R11070 avss.n8811 avss.n7662 15.5561
R11071 avss.n8807 avss.n7662 15.5561
R11072 avss.n8807 avss.n7668 15.5561
R11073 avss.n8799 avss.n7668 15.5561
R11074 avss.n8799 avss.n7686 15.5561
R11075 avss.n8795 avss.n7686 15.5561
R11076 avss.n8795 avss.n7692 15.5561
R11077 avss.n8787 avss.n7692 15.5561
R11078 avss.n8787 avss.n7710 15.5561
R11079 avss.n8783 avss.n7710 15.5561
R11080 avss.n8783 avss.n7716 15.5561
R11081 avss.n8775 avss.n7716 15.5561
R11082 avss.n8775 avss.n7735 15.5561
R11083 avss.n8771 avss.n7735 15.5561
R11084 avss.n8771 avss.n7741 15.5561
R11085 avss.n8763 avss.n7741 15.5561
R11086 avss.n8763 avss.n7761 15.5561
R11087 avss.n8759 avss.n7761 15.5561
R11088 avss.n8759 avss.n7767 15.5561
R11089 avss.n8656 avss.n7767 15.5561
R11090 avss.n8656 avss.n7782 15.5561
R11091 avss.n8746 avss.n7782 15.5561
R11092 avss.n8746 avss.n7783 15.5561
R11093 avss.n8742 avss.n7783 15.5561
R11094 avss.n8742 avss.n7789 15.5561
R11095 avss.n8675 avss.n7789 15.5561
R11096 avss.n8675 avss.n7837 15.5561
R11097 avss.n8681 avss.n7837 15.5561
R11098 avss.n8681 avss.n7821 15.5561
R11099 avss.n8694 avss.n7821 15.5561
R11100 avss.n8694 avss.n7817 15.5561
R11101 avss.n8701 avss.n7817 15.5561
R11102 avss.n8701 avss.n7807 15.5561
R11103 avss.n8718 avss.n7807 15.5561
R11104 avss.n8718 avss.n7808 15.5561
R11105 avss.n8727 avss.n8721 15.5561
R11106 avss.n7834 avss.n7793 15.5561
R11107 avss.n8755 avss.n7773 15.5561
R11108 avss.n1127 avss.n1113 15.5561
R11109 avss.n1126 avss.n1112 15.5561
R11110 avss.n6813 avss.n1104 15.5561
R11111 avss.n6875 avss.n1107 15.5561
R11112 avss.n1167 avss.n1165 15.5561
R11113 avss.n6803 avss.n1164 15.5561
R11114 avss.n6791 avss.n1011 15.5561
R11115 avss.n6789 avss.n1010 15.5561
R11116 avss.n6981 avss.n975 15.5561
R11117 avss.n6982 avss.n6981 15.5561
R11118 avss.n6982 avss.n985 15.5561
R11119 avss.n6985 avss.n985 15.5561
R11120 avss.n7015 avss.n978 15.5561
R11121 avss.n983 avss.n978 15.5561
R11122 avss.n7008 avss.n983 15.5561
R11123 avss.n7008 avss.n984 15.5561
R11124 avss.n6342 avss.n6333 15.5561
R11125 avss.n6346 avss.n6342 15.5561
R11126 avss.n6346 avss.n1063 15.5561
R11127 avss.n1063 avss.n1052 15.5561
R11128 avss.n6924 avss.n1052 15.5561
R11129 avss.n6924 avss.n1048 15.5561
R11130 avss.n6932 avss.n1048 15.5561
R11131 avss.n6932 avss.n1038 15.5561
R11132 avss.n1038 avss.n1026 15.5561
R11133 avss.n6966 avss.n1026 15.5561
R11134 avss.n6966 avss.n1027 15.5561
R11135 avss.n1027 avss.n1022 15.5561
R11136 avss.n6973 avss.n1022 15.5561
R11137 avss.n6340 avss.n6332 15.5561
R11138 avss.n6340 avss.n1061 15.5561
R11139 avss.n6914 avss.n1061 15.5561
R11140 avss.n6914 avss.n1055 15.5561
R11141 avss.n6922 avss.n1055 15.5561
R11142 avss.n6922 avss.n1057 15.5561
R11143 avss.n1057 avss.n1036 15.5561
R11144 avss.n6950 avss.n1036 15.5561
R11145 avss.n6950 avss.n1030 15.5561
R11146 avss.n6964 avss.n1030 15.5561
R11147 avss.n6964 avss.n1032 15.5561
R11148 avss.n6960 avss.n1032 15.5561
R11149 avss.n6960 avss.n1021 15.5561
R11150 avss.n1152 avss.n1092 15.5561
R11151 avss.n1152 avss.n1151 15.5561
R11152 avss.n1151 avss.n1103 15.5561
R11153 avss.n1159 avss.n1103 15.5561
R11154 avss.n6821 avss.n1159 15.5561
R11155 avss.n6821 avss.n1144 15.5561
R11156 avss.n6827 avss.n1144 15.5561
R11157 avss.n6827 avss.n1136 15.5561
R11158 avss.n6839 avss.n1136 15.5561
R11159 avss.n6839 avss.n1137 15.5561
R11160 avss.n1137 avss.n1115 15.5561
R11161 avss.n6846 avss.n1115 15.5561
R11162 avss.n6846 avss.n1125 15.5561
R11163 avss.n6885 avss.n1095 15.5561
R11164 avss.n1100 avss.n1095 15.5561
R11165 avss.n6878 avss.n1100 15.5561
R11166 avss.n6878 avss.n1101 15.5561
R11167 avss.n6819 avss.n1101 15.5561
R11168 avss.n6819 avss.n1143 15.5561
R11169 avss.n6830 avss.n1143 15.5561
R11170 avss.n6830 avss.n1139 15.5561
R11171 avss.n6837 avss.n1139 15.5561
R11172 avss.n6837 avss.n1117 15.5561
R11173 avss.n6866 avss.n1117 15.5561
R11174 avss.n6866 avss.n1118 15.5561
R11175 avss.n6862 avss.n1118 15.5561
R11176 avss.n991 avss.n988 15.5561
R11177 avss.n6999 avss.n991 15.5561
R11178 avss.n6999 avss.n994 15.5561
R11179 avss.n1008 avss.n994 15.5561
R11180 avss.n6739 avss.n1008 15.5561
R11181 avss.n6740 avss.n6739 15.5561
R11182 avss.n6749 avss.n6740 15.5561
R11183 avss.n6749 avss.n1175 15.5561
R11184 avss.n6753 avss.n1175 15.5561
R11185 avss.n6753 avss.n6727 15.5561
R11186 avss.n6777 avss.n6727 15.5561
R11187 avss.n6777 avss.n6728 15.5561
R11188 avss.n6773 avss.n6728 15.5561
R11189 avss.n997 avss.n987 15.5561
R11190 avss.n6997 avss.n997 15.5561
R11191 avss.n6997 avss.n998 15.5561
R11192 avss.n6993 avss.n998 15.5561
R11193 avss.n6993 avss.n1006 15.5561
R11194 avss.n6745 avss.n1006 15.5561
R11195 avss.n6745 avss.n6718 15.5561
R11196 avss.n6784 avss.n6718 15.5561
R11197 avss.n6784 avss.n6719 15.5561
R11198 avss.n6780 avss.n6719 15.5561
R11199 avss.n6780 avss.n6725 15.5561
R11200 avss.n6763 avss.n6725 15.5561
R11201 avss.n6771 avss.n6763 15.5561
R11202 avss.n1070 avss.n1066 15.5561
R11203 avss.n1070 avss.n1047 15.5561
R11204 avss.n6904 avss.n1047 15.5561
R11205 avss.n6904 avss.n1039 15.5561
R11206 avss.n6901 avss.n1039 15.5561
R11207 avss.n6901 avss.n6900 15.5561
R11208 avss.n6900 avss.n6899 15.5561
R11209 avss.n6899 avss.n955 15.5561
R11210 avss.n6894 avss.n955 15.5561
R11211 avss.n6894 avss.n965 15.5561
R11212 avss.n966 avss.n965 15.5561
R11213 avss.n967 avss.n966 15.5561
R11214 avss.n973 avss.n967 15.5561
R11215 avss.n1065 avss.n1046 15.5561
R11216 avss.n6935 avss.n1046 15.5561
R11217 avss.n6935 avss.n1041 15.5561
R11218 avss.n6947 avss.n1041 15.5561
R11219 avss.n6947 avss.n1042 15.5561
R11220 avss.n6943 avss.n1042 15.5561
R11221 avss.n6943 avss.n956 15.5561
R11222 avss.n7031 avss.n956 15.5561
R11223 avss.n7031 avss.n957 15.5561
R11224 avss.n7027 avss.n957 15.5561
R11225 avss.n7027 avss.n963 15.5561
R11226 avss.n7023 avss.n963 15.5561
R11227 avss.n7023 avss.n969 15.5561
R11228 avss.n2453 avss.n2276 15.5561
R11229 avss.n2665 avss.n2279 15.5561
R11230 avss.n2592 avss.n2254 15.5561
R11231 avss.n2593 avss.n2592 15.5561
R11232 avss.n2593 avss.n2484 15.5561
R11233 avss.n2596 avss.n2484 15.5561
R11234 avss.n2590 avss.n2253 15.5561
R11235 avss.n2590 avss.n2485 15.5561
R11236 avss.n2605 avss.n2485 15.5561
R11237 avss.n2605 avss.n2486 15.5561
R11238 avss.n2512 avss.n1996 15.5561
R11239 avss.n2545 avss.n2512 15.5561
R11240 avss.n2545 avss.n2011 15.5561
R11241 avss.n2542 avss.n2011 15.5561
R11242 avss.n2542 avss.n2541 15.5561
R11243 avss.n2538 avss.n2537 15.5561
R11244 avss.n2534 avss.n2533 15.5561
R11245 avss.n2530 avss.n2529 15.5561
R11246 avss.n2526 avss.n2250 15.5561
R11247 avss.n2556 avss.n1998 15.5561
R11248 avss.n2557 avss.n2556 15.5561
R11249 avss.n2557 avss.n2013 15.5561
R11250 avss.n2561 avss.n2013 15.5561
R11251 avss.n2561 avss.n2560 15.5561
R11252 avss.n2568 avss.n2567 15.5561
R11253 avss.n2571 avss.n2570 15.5561
R11254 avss.n2579 avss.n2578 15.5561
R11255 avss.n2581 avss.n2249 15.5561
R11256 avss.n2714 avss.n2693 15.5561
R11257 avss.n2707 avss.n2706 15.5561
R11258 avss.n2704 avss.n2703 15.5561
R11259 avss.n2700 avss.n2689 15.5561
R11260 avss.n2717 avss.n2247 15.5561
R11261 avss.n2724 avss.n2247 15.5561
R11262 avss.n2725 avss.n2724 15.5561
R11263 avss.n2738 avss.n2725 15.5561
R11264 avss.n2738 avss.n2258 15.5561
R11265 avss.n2772 avss.n2237 15.5561
R11266 avss.n2765 avss.n2764 15.5561
R11267 avss.n2762 avss.n2761 15.5561
R11268 avss.n2758 avss.n2757 15.5561
R11269 avss.n2754 avss.n2753 15.5561
R11270 avss.n2753 avss.n2246 15.5561
R11271 avss.n2727 avss.n2246 15.5561
R11272 avss.n2736 avss.n2727 15.5561
R11273 avss.n2736 avss.n2257 15.5561
R11274 avss.n2093 avss.n2085 15.5561
R11275 avss.n3222 avss.n2088 15.5561
R11276 avss.n2041 avss.n2040 15.5561
R11277 avss.n2043 avss.n2041 15.5561
R11278 avss.n2201 avss.n2043 15.5561
R11279 avss.n2201 avss.n2050 15.5561
R11280 avss.n3251 avss.n2038 15.5561
R11281 avss.n3248 avss.n2038 15.5561
R11282 avss.n3248 avss.n2044 15.5561
R11283 avss.n3244 avss.n2044 15.5561
R11284 avss.n2166 avss.n1995 15.5561
R11285 avss.n2167 avss.n2166 15.5561
R11286 avss.n2167 avss.n2010 15.5561
R11287 avss.n2225 avss.n2010 15.5561
R11288 avss.n2225 avss.n2152 15.5561
R11289 avss.n2221 avss.n2220 15.5561
R11290 avss.n2218 avss.n2176 15.5561
R11291 avss.n2214 avss.n2213 15.5561
R11292 avss.n2211 avss.n2183 15.5561
R11293 avss.n2157 avss.n1999 15.5561
R11294 avss.n2157 avss.n2014 15.5561
R11295 avss.n3274 avss.n2014 15.5561
R11296 avss.n3274 avss.n2015 15.5561
R11297 avss.n3270 avss.n2015 15.5561
R11298 avss.n3268 avss.n3267 15.5561
R11299 avss.n3265 avss.n2023 15.5561
R11300 avss.n3261 avss.n3260 15.5561
R11301 avss.n3258 avss.n2031 15.5561
R11302 avss.n2951 avss.n2147 15.5561
R11303 avss.n2948 avss.n2931 15.5561
R11304 avss.n2944 avss.n2943 15.5561
R11305 avss.n2940 avss.n2939 15.5561
R11306 avss.n2982 avss.n2131 15.5561
R11307 avss.n2982 avss.n2127 15.5561
R11308 avss.n2988 avss.n2127 15.5561
R11309 avss.n2988 avss.n2117 15.5561
R11310 avss.n2998 avss.n2117 15.5561
R11311 avss.n2971 avss.n2144 15.5561
R11312 avss.n2964 avss.n2963 15.5561
R11313 avss.n2961 avss.n2960 15.5561
R11314 avss.n2974 avss.n2138 15.5561
R11315 avss.n2980 avss.n2134 15.5561
R11316 avss.n2980 avss.n2125 15.5561
R11317 avss.n2990 avss.n2125 15.5561
R11318 avss.n2990 avss.n2121 15.5561
R11319 avss.n2996 avss.n2121 15.5561
R11320 avss.n2322 avss.n2311 15.5561
R11321 avss.n2336 avss.n2310 15.5561
R11322 avss.n2307 avss.n2294 15.5561
R11323 avss.n2440 avss.n2292 15.5561
R11324 avss.n2449 avss.n2285 15.5561
R11325 avss.n2447 avss.n2287 15.5561
R11326 avss.n2374 avss.n2349 15.5561
R11327 avss.n2386 avss.n2349 15.5561
R11328 avss.n2387 avss.n2386 15.5561
R11329 avss.n2387 avss.n2295 15.5561
R11330 avss.n2390 avss.n2295 15.5561
R11331 avss.n2390 avss.n2306 15.5561
R11332 avss.n2399 avss.n2306 15.5561
R11333 avss.n2399 avss.n2343 15.5561
R11334 avss.n2411 avss.n2343 15.5561
R11335 avss.n2412 avss.n2411 15.5561
R11336 avss.n2412 avss.n2313 15.5561
R11337 avss.n2339 avss.n2313 15.5561
R11338 avss.n2419 avss.n2339 15.5561
R11339 avss.n2377 avss.n2351 15.5561
R11340 avss.n2384 avss.n2351 15.5561
R11341 avss.n2384 avss.n2297 15.5561
R11342 avss.n2437 avss.n2297 15.5561
R11343 avss.n2437 avss.n2298 15.5561
R11344 avss.n2433 avss.n2298 15.5561
R11345 avss.n2433 avss.n2304 15.5561
R11346 avss.n2402 avss.n2304 15.5561
R11347 avss.n2409 avss.n2402 15.5561
R11348 avss.n2409 avss.n2315 15.5561
R11349 avss.n2425 avss.n2315 15.5561
R11350 avss.n2425 avss.n2316 15.5561
R11351 avss.n2421 avss.n2316 15.5561
R11352 avss.n2613 avss.n2482 15.5561
R11353 avss.n2613 avss.n2473 15.5561
R11354 avss.n2626 avss.n2473 15.5561
R11355 avss.n2626 avss.n2468 15.5561
R11356 avss.n2634 avss.n2468 15.5561
R11357 avss.n2634 avss.n2469 15.5561
R11358 avss.n2469 avss.n2459 15.5561
R11359 avss.n2647 avss.n2459 15.5561
R11360 avss.n2647 avss.n2455 15.5561
R11361 avss.n2655 avss.n2455 15.5561
R11362 avss.n2655 avss.n2274 15.5561
R11363 avss.n2274 avss.n2264 15.5561
R11364 avss.n2678 avss.n2264 15.5561
R11365 avss.n2616 avss.n2480 15.5561
R11366 avss.n2616 avss.n2476 15.5561
R11367 avss.n2624 avss.n2476 15.5561
R11368 avss.n2624 avss.n2466 15.5561
R11369 avss.n2636 avss.n2466 15.5561
R11370 avss.n2637 avss.n2636 15.5561
R11371 avss.n2637 avss.n2461 15.5561
R11372 avss.n2645 avss.n2461 15.5561
R11373 avss.n2645 avss.n2462 15.5561
R11374 avss.n2462 avss.n2272 15.5561
R11375 avss.n2670 avss.n2272 15.5561
R11376 avss.n2670 avss.n2268 15.5561
R11377 avss.n2676 avss.n2268 15.5561
R11378 avss.n3157 avss.n3015 15.5561
R11379 avss.n3155 avss.n3016 15.5561
R11380 avss.n3064 avss.n3060 15.5561
R11381 avss.n3085 avss.n3059 15.5561
R11382 avss.n3094 avss.n3070 15.5561
R11383 avss.n3092 avss.n3083 15.5561
R11384 avss.n3074 avss.n3058 15.5561
R11385 avss.n3058 avss.n3048 15.5561
R11386 avss.n3110 avss.n3048 15.5561
R11387 avss.n3110 avss.n3044 15.5561
R11388 avss.n3116 avss.n3044 15.5561
R11389 avss.n3116 avss.n3036 15.5561
R11390 avss.n3128 avss.n3036 15.5561
R11391 avss.n3128 avss.n3031 15.5561
R11392 avss.n3138 avss.n3031 15.5561
R11393 avss.n3138 avss.n3032 15.5561
R11394 avss.n3032 avss.n3022 15.5561
R11395 avss.n3022 avss.n3006 15.5561
R11396 avss.n3166 avss.n3006 15.5561
R11397 avss.n3102 avss.n3056 15.5561
R11398 avss.n3102 avss.n3052 15.5561
R11399 avss.n3108 avss.n3052 15.5561
R11400 avss.n3108 avss.n3042 15.5561
R11401 avss.n3120 avss.n3042 15.5561
R11402 avss.n3120 avss.n3038 15.5561
R11403 avss.n3126 avss.n3038 15.5561
R11404 avss.n3126 avss.n3029 15.5561
R11405 avss.n3140 avss.n3029 15.5561
R11406 avss.n3140 avss.n3025 15.5561
R11407 avss.n3146 avss.n3025 15.5561
R11408 avss.n3146 avss.n3009 15.5561
R11409 avss.n3164 avss.n3009 15.5561
R11410 avss.n2061 avss.n2051 15.5561
R11411 avss.n3235 avss.n2061 15.5561
R11412 avss.n3235 avss.n2062 15.5561
R11413 avss.n3231 avss.n2062 15.5561
R11414 avss.n3231 avss.n2072 15.5561
R11415 avss.n2083 avss.n2072 15.5561
R11416 avss.n3180 avss.n2083 15.5561
R11417 avss.n3188 avss.n3180 15.5561
R11418 avss.n3189 avss.n3188 15.5561
R11419 avss.n3189 avss.n2095 15.5561
R11420 avss.n3195 avss.n2095 15.5561
R11421 avss.n3195 avss.n2105 15.5561
R11422 avss.n2107 avss.n2105 15.5561
R11423 avss.n3241 avss.n2054 15.5561
R11424 avss.n3237 avss.n2054 15.5561
R11425 avss.n3237 avss.n2059 15.5561
R11426 avss.n3229 avss.n2059 15.5561
R11427 avss.n3229 avss.n2075 15.5561
R11428 avss.n3225 avss.n2075 15.5561
R11429 avss.n3225 avss.n2081 15.5561
R11430 avss.n3186 avss.n2081 15.5561
R11431 avss.n3186 avss.n2097 15.5561
R11432 avss.n3212 avss.n2097 15.5561
R11433 avss.n3212 avss.n2098 15.5561
R11434 avss.n3208 avss.n2098 15.5561
R11435 avss.n3208 avss.n2104 15.5561
R11436 avss.n4438 avss.n3736 15.5561
R11437 avss.n4451 avss.n3734 15.5561
R11438 avss.n3724 avss.n3710 15.5561
R11439 avss.n4457 avss.n3709 15.5561
R11440 avss.n3699 avss.n3698 15.5561
R11441 avss.n4473 avss.n3696 15.5561
R11442 avss.n4385 avss.n4384 15.5561
R11443 avss.n4385 avss.n3712 15.5561
R11444 avss.n3759 avss.n3712 15.5561
R11445 avss.n3759 avss.n3723 15.5561
R11446 avss.n4393 avss.n3723 15.5561
R11447 avss.n4400 avss.n4393 15.5561
R11448 avss.n4400 avss.n3756 15.5561
R11449 avss.n4408 avss.n3756 15.5561
R11450 avss.n4408 avss.n3747 15.5561
R11451 avss.n4420 avss.n3747 15.5561
R11452 avss.n4421 avss.n4420 15.5561
R11453 avss.n4421 avss.n3737 15.5561
R11454 avss.n4441 avss.n3737 15.5561
R11455 avss.n4382 avss.n3714 15.5561
R11456 avss.n4464 avss.n3714 15.5561
R11457 avss.n4464 avss.n3715 15.5561
R11458 avss.n4460 avss.n3715 15.5561
R11459 avss.n4460 avss.n3721 15.5561
R11460 avss.n4398 avss.n3721 15.5561
R11461 avss.n4398 avss.n3754 15.5561
R11462 avss.n4411 avss.n3754 15.5561
R11463 avss.n4411 avss.n3750 15.5561
R11464 avss.n4418 avss.n3750 15.5561
R11465 avss.n4418 avss.n3738 15.5561
R11466 avss.n4448 avss.n3738 15.5561
R11467 avss.n4448 avss.n3739 15.5561
R11468 avss.n4327 avss.n3879 15.5561
R11469 avss.n4340 avss.n3877 15.5561
R11470 avss.n3869 avss.n3855 15.5561
R11471 avss.n4346 avss.n3854 15.5561
R11472 avss.n4261 avss.n3847 15.5561
R11473 avss.n4363 avss.n3849 15.5561
R11474 avss.n4274 avss.n4273 15.5561
R11475 avss.n4274 avss.n3857 15.5561
R11476 avss.n3902 avss.n3857 15.5561
R11477 avss.n3902 avss.n3868 15.5561
R11478 avss.n4282 avss.n3868 15.5561
R11479 avss.n4289 avss.n4282 15.5561
R11480 avss.n4289 avss.n3899 15.5561
R11481 avss.n4297 avss.n3899 15.5561
R11482 avss.n4297 avss.n3890 15.5561
R11483 avss.n4309 avss.n3890 15.5561
R11484 avss.n4310 avss.n4309 15.5561
R11485 avss.n4310 avss.n3880 15.5561
R11486 avss.n4330 avss.n3880 15.5561
R11487 avss.n4271 avss.n3859 15.5561
R11488 avss.n4353 avss.n3859 15.5561
R11489 avss.n4353 avss.n3860 15.5561
R11490 avss.n4349 avss.n3860 15.5561
R11491 avss.n4349 avss.n3866 15.5561
R11492 avss.n4287 avss.n3866 15.5561
R11493 avss.n4287 avss.n3897 15.5561
R11494 avss.n4300 avss.n3897 15.5561
R11495 avss.n4300 avss.n3893 15.5561
R11496 avss.n4307 avss.n3893 15.5561
R11497 avss.n4307 avss.n3881 15.5561
R11498 avss.n4337 avss.n3881 15.5561
R11499 avss.n4337 avss.n3882 15.5561
R11500 avss.n7071 avss.n822 15.5561
R11501 avss.n7084 avss.n820 15.5561
R11502 avss.n812 avss.n798 15.5561
R11503 avss.n7090 avss.n797 15.5561
R11504 avss.n7109 avss.n780 15.5561
R11505 avss.n7106 avss.n779 15.5561
R11506 avss.n842 avss.n839 15.5561
R11507 avss.n842 avss.n800 15.5561
R11508 avss.n896 avss.n800 15.5561
R11509 avss.n896 avss.n811 15.5561
R11510 avss.n893 avss.n811 15.5561
R11511 avss.n893 avss.n892 15.5561
R11512 avss.n892 avss.n848 15.5561
R11513 avss.n884 avss.n848 15.5561
R11514 avss.n884 avss.n858 15.5561
R11515 avss.n880 avss.n858 15.5561
R11516 avss.n880 avss.n871 15.5561
R11517 avss.n871 avss.n823 15.5561
R11518 avss.n829 avss.n823 15.5561
R11519 avss.n906 avss.n802 15.5561
R11520 avss.n7097 avss.n802 15.5561
R11521 avss.n7097 avss.n803 15.5561
R11522 avss.n7093 avss.n803 15.5561
R11523 avss.n7093 avss.n809 15.5561
R11524 avss.n890 avss.n809 15.5561
R11525 avss.n890 avss.n850 15.5561
R11526 avss.n886 avss.n850 15.5561
R11527 avss.n886 avss.n856 15.5561
R11528 avss.n878 avss.n856 15.5561
R11529 avss.n878 avss.n824 15.5561
R11530 avss.n7081 avss.n824 15.5561
R11531 avss.n7081 avss.n825 15.5561
R11532 avss.n773 avss.n679 15.5561
R11533 avss.n771 avss.n678 15.5561
R11534 avss.n654 avss.n653 15.5561
R11535 avss.n656 avss.n654 15.5561
R11536 avss.n7161 avss.n656 15.5561
R11537 avss.n7161 avss.n663 15.5561
R11538 avss.n7188 avss.n651 15.5561
R11539 avss.n7185 avss.n651 15.5561
R11540 avss.n7185 avss.n657 15.5561
R11541 avss.n7181 avss.n657 15.5561
R11542 avss.n747 avss.n664 15.5561
R11543 avss.n750 avss.n747 15.5561
R11544 avss.n750 avss.n675 15.5561
R11545 avss.n676 avss.n675 15.5561
R11546 avss.n757 avss.n676 15.5561
R11547 avss.n758 avss.n757 15.5561
R11548 avss.n758 avss.n724 15.5561
R11549 avss.n761 avss.n724 15.5561
R11550 avss.n761 avss.n736 15.5561
R11551 avss.n769 avss.n736 15.5561
R11552 avss.n769 avss.n721 15.5561
R11553 avss.n721 avss.n711 15.5561
R11554 avss.n7133 avss.n711 15.5561
R11555 avss.n7178 avss.n667 15.5561
R11556 avss.n672 avss.n667 15.5561
R11557 avss.n7171 avss.n672 15.5561
R11558 avss.n7171 avss.n673 15.5561
R11559 avss.n728 avss.n673 15.5561
R11560 avss.n728 avss.n725 15.5561
R11561 avss.n7119 avss.n725 15.5561
R11562 avss.n7119 avss.n726 15.5561
R11563 avss.n7115 avss.n726 15.5561
R11564 avss.n7115 avss.n719 15.5561
R11565 avss.n7125 avss.n719 15.5561
R11566 avss.n7125 avss.n715 15.5561
R11567 avss.n7131 avss.n715 15.5561
R11568 avss.n3940 avss.n3912 15.5561
R11569 avss.n3937 avss.n3911 15.5561
R11570 avss.n4195 avss.n3992 15.5561
R11571 avss.n4201 avss.n3992 15.5561
R11572 avss.n4201 avss.n3953 15.5561
R11573 avss.n4210 avss.n3953 15.5561
R11574 avss.n4193 avss.n3989 15.5561
R11575 avss.n4202 avss.n3989 15.5561
R11576 avss.n4202 avss.n3985 15.5561
R11577 avss.n4208 avss.n3985 15.5561
R11578 avss.n3961 avss.n3955 15.5561
R11579 avss.n3974 avss.n3961 15.5561
R11580 avss.n3974 avss.n3962 15.5561
R11581 avss.n3962 avss.n3936 15.5561
R11582 avss.n3936 avss.n3928 15.5561
R11583 avss.n4226 avss.n3928 15.5561
R11584 avss.n4226 avss.n3923 15.5561
R11585 avss.n4243 avss.n3923 15.5561
R11586 avss.n4243 avss.n3924 15.5561
R11587 avss.n3924 avss.n3914 15.5561
R11588 avss.n4238 avss.n3914 15.5561
R11589 avss.n4238 avss.n3837 15.5561
R11590 avss.n3844 avss.n3837 15.5561
R11591 avss.n3983 avss.n3958 15.5561
R11592 avss.n3977 avss.n3958 15.5561
R11593 avss.n3977 avss.n3934 15.5561
R11594 avss.n4218 avss.n3934 15.5561
R11595 avss.n4218 avss.n3930 15.5561
R11596 avss.n4224 avss.n3930 15.5561
R11597 avss.n4224 avss.n3921 15.5561
R11598 avss.n4245 avss.n3921 15.5561
R11599 avss.n4245 avss.n3917 15.5561
R11600 avss.n4252 avss.n3917 15.5561
R11601 avss.n4252 avss.n3839 15.5561
R11602 avss.n4371 avss.n3839 15.5561
R11603 avss.n4371 avss.n3840 15.5561
R11604 avss.n4481 avss.n3681 15.5561
R11605 avss.n4479 avss.n3680 15.5561
R11606 avss.n4524 avss.n3567 15.5561
R11607 avss.n4489 avss.n3567 15.5561
R11608 avss.n4489 avss.n3655 15.5561
R11609 avss.n4492 avss.n3655 15.5561
R11610 avss.n4521 avss.n3566 15.5561
R11611 avss.n4521 avss.n3570 15.5561
R11612 avss.n4515 avss.n3570 15.5561
R11613 avss.n4515 avss.n3654 15.5561
R11614 avss.n3661 avss.n3658 15.5561
R11615 avss.n4506 avss.n3661 15.5561
R11616 avss.n4506 avss.n3664 15.5561
R11617 avss.n3678 avss.n3664 15.5561
R11618 avss.n3795 avss.n3678 15.5561
R11619 avss.n3795 avss.n3790 15.5561
R11620 avss.n3804 avss.n3790 15.5561
R11621 avss.n3804 avss.n3780 15.5561
R11622 avss.n3815 avss.n3780 15.5561
R11623 avss.n3816 avss.n3815 15.5561
R11624 avss.n3816 avss.n3766 15.5561
R11625 avss.n3776 avss.n3766 15.5561
R11626 avss.n3825 avss.n3776 15.5561
R11627 avss.n3667 avss.n3657 15.5561
R11628 avss.n4504 avss.n3667 15.5561
R11629 avss.n4504 avss.n3668 15.5561
R11630 avss.n4500 avss.n3668 15.5561
R11631 avss.n4500 avss.n3676 15.5561
R11632 avss.n3787 avss.n3676 15.5561
R11633 avss.n3806 avss.n3787 15.5561
R11634 avss.n3806 avss.n3782 15.5561
R11635 avss.n3813 avss.n3782 15.5561
R11636 avss.n3813 avss.n3768 15.5561
R11637 avss.n3832 avss.n3768 15.5561
R11638 avss.n3832 avss.n3769 15.5561
R11639 avss.n3828 avss.n3769 15.5561
R11640 avss.n4586 avss.n4538 15.5561
R11641 avss.n4582 avss.n4581 15.5561
R11642 avss.n4578 avss.n4577 15.5561
R11643 avss.n4589 avss.n3433 15.5561
R11644 avss.n4595 avss.n3429 15.5561
R11645 avss.n4595 avss.n3420 15.5561
R11646 avss.n4605 avss.n3420 15.5561
R11647 avss.n4605 avss.n3416 15.5561
R11648 avss.n4611 avss.n3416 15.5561
R11649 avss.n4566 avss.n4541 15.5561
R11650 avss.n4563 avss.n4546 15.5561
R11651 avss.n4559 avss.n4558 15.5561
R11652 avss.n4555 avss.n4554 15.5561
R11653 avss.n4597 avss.n3426 15.5561
R11654 avss.n4597 avss.n3422 15.5561
R11655 avss.n4603 avss.n3422 15.5561
R11656 avss.n4603 avss.n3412 15.5561
R11657 avss.n4613 avss.n3412 15.5561
R11658 avss.n5118 avss.n5115 15.5561
R11659 avss.n5337 avss.n5118 15.5561
R11660 avss.n5337 avss.n5121 15.5561
R11661 avss.n5139 avss.n5121 15.5561
R11662 avss.n5176 avss.n5139 15.5561
R11663 avss.n5176 avss.n5152 15.5561
R11664 avss.n5179 avss.n5152 15.5561
R11665 avss.n5179 avss.n5166 15.5561
R11666 avss.n5194 avss.n5166 15.5561
R11667 avss.n5194 avss.n5169 15.5561
R11668 avss.n5169 avss.n587 15.5561
R11669 avss.n5189 avss.n587 15.5561
R11670 avss.n5189 avss.n574 15.5561
R11671 avss.n5128 avss.n5114 15.5561
R11672 avss.n5335 avss.n5128 15.5561
R11673 avss.n5335 avss.n5129 15.5561
R11674 avss.n5331 avss.n5129 15.5561
R11675 avss.n5331 avss.n5138 15.5561
R11676 avss.n5323 avss.n5138 15.5561
R11677 avss.n5323 avss.n5156 15.5561
R11678 avss.n5319 avss.n5156 15.5561
R11679 avss.n5319 avss.n5164 15.5561
R11680 avss.n5164 avss.n591 15.5561
R11681 avss.n7230 avss.n591 15.5561
R11682 avss.n7230 avss.n592 15.5561
R11683 avss.n592 avss.n573 15.5561
R11684 avss.n3448 avss.n597 15.5561
R11685 avss.n3448 avss.n610 15.5561
R11686 avss.n3442 avss.n610 15.5561
R11687 avss.n3442 avss.n624 15.5561
R11688 avss.n3455 avss.n624 15.5561
R11689 avss.n3458 avss.n3457 15.5561
R11690 avss.n3465 avss.n3464 15.5561
R11691 avss.n3467 avss.n3437 15.5561
R11692 avss.n3474 avss.n685 15.5561
R11693 avss.n7221 avss.n604 15.5561
R11694 avss.n7217 avss.n604 15.5561
R11695 avss.n7217 avss.n609 15.5561
R11696 avss.n7209 avss.n609 15.5561
R11697 avss.n7209 avss.n629 15.5561
R11698 avss.n7205 avss.n7204 15.5561
R11699 avss.n7202 avss.n637 15.5561
R11700 avss.n7198 avss.n7197 15.5561
R11701 avss.n7195 avss.n644 15.5561
R11702 avss.n3537 avss.n3536 15.5561
R11703 avss.n3485 avss.n3484 15.5561
R11704 avss.n3545 avss.n3544 15.5561
R11705 avss.n3552 avss.n3480 15.5561
R11706 avss.n3552 avss.n689 15.5561
R11707 avss.n7150 avss.n689 15.5561
R11708 avss.n7150 avss.n690 15.5561
R11709 avss.n7146 avss.n690 15.5561
R11710 avss.n7146 avss.n696 15.5561
R11711 avss.n3528 avss.n3492 15.5561
R11712 avss.n3497 avss.n3496 15.5561
R11713 avss.n3502 avss.n3499 15.5561
R11714 avss.n3505 avss.n3504 15.5561
R11715 avss.n3514 avss.n3505 15.5561
R11716 avss.n3514 avss.n687 15.5561
R11717 avss.n3509 avss.n687 15.5561
R11718 avss.n3509 avss.n697 15.5561
R11719 avss.n7142 avss.n697 15.5561
R11720 avss.n5202 avss.n5201 15.5561
R11721 avss.n5202 avss.n5123 15.5561
R11722 avss.n5218 avss.n5123 15.5561
R11723 avss.n5218 avss.n5140 15.5561
R11724 avss.n5223 avss.n5140 15.5561
R11725 avss.n5223 avss.n5153 15.5561
R11726 avss.n5226 avss.n5153 15.5561
R11727 avss.n5226 avss.n5167 15.5561
R11728 avss.n5236 avss.n5167 15.5561
R11729 avss.n5236 avss.n5195 15.5561
R11730 avss.n5195 avss.n588 15.5561
R11731 avss.n588 avss.n570 15.5561
R11732 avss.n7243 avss.n570 15.5561
R11733 avss.n5209 avss.n5208 15.5561
R11734 avss.n5208 avss.n5127 15.5561
R11735 avss.n5144 avss.n5127 15.5561
R11736 avss.n5329 avss.n5144 15.5561
R11737 avss.n5329 avss.n5145 15.5561
R11738 avss.n5325 avss.n5145 15.5561
R11739 avss.n5325 avss.n5151 15.5561
R11740 avss.n5317 avss.n5151 15.5561
R11741 avss.n5317 avss.n5301 15.5561
R11742 avss.n5313 avss.n5301 15.5561
R11743 avss.n5313 avss.n590 15.5561
R11744 avss.n5310 avss.n590 15.5561
R11745 avss.n5310 avss.n575 15.5561
R11746 avss.n4089 avss.n598 15.5561
R11747 avss.n4089 avss.n611 15.5561
R11748 avss.n4079 avss.n611 15.5561
R11749 avss.n4079 avss.n625 15.5561
R11750 avss.n4096 avss.n625 15.5561
R11751 avss.n4099 avss.n4098 15.5561
R11752 avss.n4106 avss.n4105 15.5561
R11753 avss.n4108 avss.n4074 15.5561
R11754 avss.n4116 avss.n4027 15.5561
R11755 avss.n615 avss.n602 15.5561
R11756 avss.n7215 avss.n615 15.5561
R11757 avss.n7215 avss.n616 15.5561
R11758 avss.n7211 avss.n616 15.5561
R11759 avss.n7211 avss.n622 15.5561
R11760 avss.n4008 avss.n4004 15.5561
R11761 avss.n4014 avss.n4005 15.5561
R11762 avss.n4019 avss.n4018 15.5561
R11763 avss.n4026 avss.n3998 15.5561
R11764 avss.n4062 avss.n4061 15.5561
R11765 avss.n4064 avss.n4063 15.5561
R11766 avss.n4120 avss.n4067 15.5561
R11767 avss.n4124 avss.n4068 15.5561
R11768 avss.n4124 avss.n4031 15.5561
R11769 avss.n4184 avss.n4031 15.5561
R11770 avss.n4184 avss.n4032 15.5561
R11771 avss.n4180 avss.n4032 15.5561
R11772 avss.n4180 avss.n4038 15.5561
R11773 avss.n4056 avss.n4055 15.5561
R11774 avss.n4148 avss.n4147 15.5561
R11775 avss.n4156 avss.n4050 15.5561
R11776 avss.n4159 avss.n4045 15.5561
R11777 avss.n4162 avss.n4159 15.5561
R11778 avss.n4162 avss.n4029 15.5561
R11779 avss.n4165 avss.n4029 15.5561
R11780 avss.n4165 avss.n4039 15.5561
R11781 avss.n4176 avss.n4039 15.5561
R11782 avss.n3587 avss.n599 15.5561
R11783 avss.n3587 avss.n612 15.5561
R11784 avss.n3611 avss.n612 15.5561
R11785 avss.n3611 avss.n626 15.5561
R11786 avss.n3608 avss.n626 15.5561
R11787 avss.n3606 avss.n3605 15.5561
R11788 avss.n3602 avss.n3601 15.5561
R11789 avss.n3598 avss.n3558 15.5561
R11790 avss.n4531 avss.n3559 15.5561
R11791 avss.n3584 avss.n601 15.5561
R11792 avss.n3584 avss.n614 15.5561
R11793 avss.n3624 avss.n614 15.5561
R11794 avss.n3624 avss.n628 15.5561
R11795 avss.n3581 avss.n628 15.5561
R11796 avss.n3632 avss.n3631 15.5561
R11797 avss.n3634 avss.n3578 15.5561
R11798 avss.n3642 avss.n3575 15.5561
R11799 avss.n3647 avss.n3646 15.5561
R11800 avss.n5280 avss.n5279 15.5561
R11801 avss.n5280 avss.n5126 15.5561
R11802 avss.n5243 avss.n5126 15.5561
R11803 avss.n5243 avss.n5143 15.5561
R11804 avss.n5287 avss.n5143 15.5561
R11805 avss.n5287 avss.n5155 15.5561
R11806 avss.n5238 avss.n5155 15.5561
R11807 avss.n5300 avss.n5238 15.5561
R11808 avss.n5300 avss.n5239 15.5561
R11809 avss.n5293 avss.n5239 15.5561
R11810 avss.n5293 avss.n589 15.5561
R11811 avss.n589 avss.n578 15.5561
R11812 avss.n7241 avss.n578 15.5561
R11813 avss.n5248 avss.n5247 15.5561
R11814 avss.n5248 avss.n5124 15.5561
R11815 avss.n5249 avss.n5124 15.5561
R11816 avss.n5249 avss.n5141 15.5561
R11817 avss.n5252 avss.n5141 15.5561
R11818 avss.n5252 avss.n5154 15.5561
R11819 avss.n5253 avss.n5154 15.5561
R11820 avss.n5253 avss.n5168 15.5561
R11821 avss.n5256 avss.n5168 15.5561
R11822 avss.n5256 avss.n585 15.5561
R11823 avss.n7232 avss.n585 15.5561
R11824 avss.n7233 avss.n7232 15.5561
R11825 avss.n7233 avss.n576 15.5561
R11826 avss.n1952 avss.n1819 15.5561
R11827 avss.n1952 avss.n1815 15.5561
R11828 avss.n1958 avss.n1815 15.5561
R11829 avss.n1958 avss.n1797 15.5561
R11830 avss.n1973 avss.n1797 15.5561
R11831 avss.n1973 avss.n1793 15.5561
R11832 avss.n1979 avss.n1793 15.5561
R11833 avss.n1979 avss.n1770 15.5561
R11834 avss.n3297 avss.n1770 15.5561
R11835 avss.n3297 avss.n1766 15.5561
R11836 avss.n3303 avss.n1766 15.5561
R11837 avss.n3303 avss.n1754 15.5561
R11838 avss.n3314 avss.n1754 15.5561
R11839 avss.n1852 avss.n1821 15.5561
R11840 avss.n1852 avss.n1822 15.5561
R11841 avss.n1822 avss.n1811 15.5561
R11842 avss.n1830 avss.n1811 15.5561
R11843 avss.n1830 avss.n1799 15.5561
R11844 avss.n1831 avss.n1799 15.5561
R11845 avss.n1831 avss.n1789 15.5561
R11846 avss.n1834 avss.n1789 15.5561
R11847 avss.n1834 avss.n1772 15.5561
R11848 avss.n1772 avss.n1760 15.5561
R11849 avss.n3305 avss.n1760 15.5561
R11850 avss.n3306 avss.n3305 15.5561
R11851 avss.n3306 avss.n1749 15.5561
R11852 avss.n9220 avss.n126 15.5561
R11853 avss.n6210 avss.n4684 15.3914
R11854 avss.n8043 avss.n7984 15.3267
R11855 avss.n1105 avss.n1093 15.2398
R11856 avss avss.n6315 15.1601
R11857 avss avss.n6240 15.1601
R11858 avss.n6820 avss.n6814 15.0904
R11859 avss.n6893 avss.n6892 14.3433
R11860 avss.n7496 avss.n7486 14.2194
R11861 avss.n8890 avss.n7496 14.2194
R11862 avss.n8890 avss.n7499 14.2194
R11863 avss.n8884 avss.n7499 14.2194
R11864 avss.n8884 avss.n7515 14.2194
R11865 avss.n8878 avss.n7515 14.2194
R11866 avss.n8878 avss.n7528 14.2194
R11867 avss.n8872 avss.n7528 14.2194
R11868 avss.n8872 avss.n7540 14.2194
R11869 avss.n8866 avss.n7540 14.2194
R11870 avss.n8866 avss.n7552 14.2194
R11871 avss.n8860 avss.n7552 14.2194
R11872 avss.n8860 avss.n7564 14.2194
R11873 avss.n8854 avss.n7564 14.2194
R11874 avss.n8854 avss.n7576 14.2194
R11875 avss.n8848 avss.n7576 14.2194
R11876 avss.n8848 avss.n7588 14.2194
R11877 avss.n8842 avss.n7588 14.2194
R11878 avss.n8842 avss.n7600 14.2194
R11879 avss.n8836 avss.n7600 14.2194
R11880 avss.n8836 avss.n7612 14.2194
R11881 avss.n8830 avss.n7612 14.2194
R11882 avss.n8830 avss.n7624 14.2194
R11883 avss.n8824 avss.n7624 14.2194
R11884 avss.n8824 avss.n7636 14.2194
R11885 avss.n8818 avss.n7636 14.2194
R11886 avss.n8818 avss.n7648 14.2194
R11887 avss.n8812 avss.n7648 14.2194
R11888 avss.n8812 avss.n7660 14.2194
R11889 avss.n8806 avss.n7660 14.2194
R11890 avss.n8806 avss.n7672 14.2194
R11891 avss.n8800 avss.n7684 14.2194
R11892 avss.n8794 avss.n7684 14.2194
R11893 avss.n8794 avss.n7696 14.2194
R11894 avss.n8788 avss.n7696 14.2194
R11895 avss.n8788 avss.n7708 14.2194
R11896 avss.n8782 avss.n7708 14.2194
R11897 avss.n8702 avss.n7816 14.172
R11898 avss.n8578 avss.n7906 14.172
R11899 avss.n9293 avss.n9292 14.172
R11900 avss avss.n6605 13.5221
R11901 avss.n5070 avss 13.5005
R11902 avss.n6324 avss 13.5005
R11903 avss.n1742 avss 13.5005
R11904 avss.n2113 avss 13.5005
R11905 avss.n706 avss 13.5005
R11906 avss.n566 avss 13.5005
R11907 avss avss.n4618 13.5005
R11908 avss.n7264 avss 13.5005
R11909 avss avss.n9405 13.5005
R11910 avss.n2668 avss.n2667 13.3138
R11911 avss.n3207 avss.n2084 13.3138
R11912 avss.n4373 avss.n4372 13.3138
R11913 avss.n3775 avss.n3767 13.3138
R11914 avss.n6480 avss.n1685 13.2365
R11915 avss.n6483 avss.n1685 13.2365
R11916 avss.n7482 avss.n378 13.1481
R11917 avss.n2751 avss.n2750 13.1109
R11918 avss.n3564 avss.n3428 13.1109
R11919 avss.n7396 avss.n491 13.0005
R11920 avss.n7123 avss.n7122 13.0005
R11921 avss.n9178 avss.n9177 12.8512
R11922 avss.n6108 avss.n6107 12.8078
R11923 avss.n1632 avss.n1263 12.8078
R11924 avss.n5071 avss.n4813 12.7958
R11925 avss.n6396 avss.n6395 12.7958
R11926 avss.n3321 avss.n3320 12.7958
R11927 avss.n2111 avss.n2110 12.7958
R11928 avss.n704 avss.n703 12.7958
R11929 avss.n7248 avss.n7247 12.7958
R11930 avss.n4619 avss.n582 12.7958
R11931 avss.n7262 avss.n551 12.7958
R11932 avss.n6625 avss.n6624 12.7505
R11933 avss.n6628 avss.n6627 12.7505
R11934 avss.n6627 avss.n6626 12.7505
R11935 avss.n6630 avss.n6629 12.7505
R11936 avss.n6630 avss.n6522 12.7505
R11937 avss.n6633 avss.n1663 12.7505
R11938 avss.n6634 avss.n6633 12.7505
R11939 avss.n6655 avss.n6654 12.7505
R11940 avss.n6654 avss.n1665 12.7505
R11941 avss.n6651 avss.n1664 12.7505
R11942 avss.n6651 avss.n6650 12.7505
R11943 avss.n6648 avss.n6647 12.7505
R11944 avss.n6649 avss.n6648 12.7505
R11945 avss.n6646 avss.n6645 12.7505
R11946 avss.n6645 avss.n1668 12.7505
R11947 avss.n6642 avss.n1669 12.7505
R11948 avss.n6642 avss.n6641 12.7505
R11949 avss.n6485 avss.n6484 12.7505
R11950 avss.n6485 avss.n1683 12.7505
R11951 avss.n6488 avss.n1682 12.7505
R11952 avss.n6489 avss.n6488 12.7505
R11953 avss.n6492 avss.n6491 12.7505
R11954 avss.n6491 avss.n6490 12.7505
R11955 avss.n6494 avss.n6493 12.7505
R11956 avss.n6494 avss.n1680 12.7505
R11957 avss.n6497 avss.n1677 12.7505
R11958 avss.n6498 avss.n6497 12.7505
R11959 avss.n6504 avss.n6503 12.7505
R11960 avss.n6504 avss.n1675 12.7505
R11961 avss.n6507 avss.n1674 12.7505
R11962 avss.n6508 avss.n6507 12.7505
R11963 avss.n6511 avss.n6510 12.7505
R11964 avss.n6510 avss.n6509 12.7505
R11965 avss.n6513 avss.n6512 12.7505
R11966 avss.n6513 avss.n1671 12.7505
R11967 avss.n6516 avss.n1672 12.7505
R11968 avss.n6517 avss.n6516 12.7505
R11969 avss.n2186 avss.n2133 12.5005
R11970 avss.n4186 avss.n4028 12.5005
R11971 avss.n5821 avss.t54 12.4531
R11972 avss.n1598 avss.t119 12.4531
R11973 avss.n68 avss.t90 12.4531
R11974 avss.n221 avss.t207 12.4531
R11975 avss.n8590 avss.t8 12.4531
R11976 avss.n8714 avss.t204 12.4531
R11977 avss.n5467 avss.n4794 12.3147
R11978 avss.n5544 avss.n5543 12.3147
R11979 avss.n5578 avss.n5577 12.3147
R11980 avss.n4740 avss.n4722 12.3147
R11981 avss.n6913 avss.n6912 12.3147
R11982 avss.n7033 avss.n7032 12.3147
R11983 avss.n7836 avss.n7822 12.2825
R11984 avss.n7926 avss.n7912 12.2825
R11985 avss.n9270 avss.n89 12.2825
R11986 avss.n7279 avss.n534 12.2525
R11987 avss.n7152 avss.n686 12.2525
R11988 avss.n175 avss.n167 12.2393
R11989 avss.n4664 avss.t117 12.2015
R11990 avss.n6250 avss.t114 12.2015
R11991 avss.n5720 avss.n5711 12.1979
R11992 avss.t171 avss.n6746 11.9529
R11993 avss.n6790 avss.t61 11.9529
R11994 avss.t99 avss.n6804 11.9529
R11995 avss.n6805 avss.t99 11.9529
R11996 avss.n6876 avss.t210 11.9529
R11997 avss.n6829 avss.t170 11.9529
R11998 avss.t94 avss.n1124 11.9529
R11999 avss.n6579 avss.t183 11.8888
R12000 avss.n6531 avss.n6526 11.8397
R12001 avss.n6804 avss.n1166 11.8035
R12002 avss.n3364 avss.n3363 11.7948
R12003 avss.n8512 avss.n7729 11.7311
R12004 avss.n8776 avss.n7733 11.7311
R12005 avss.n8506 avss.n7742 11.7311
R12006 avss.n8770 avss.n7746 11.7311
R12007 avss.n8641 avss.n7755 11.7311
R12008 avss.n9170 avss.n177 11.6273
R12009 avss.n6100 avss.n5722 11.588
R12010 avss.n1214 avss.n1205 11.588
R12011 avss.n5122 avss.n5112 11.5361
R12012 avss.n5336 avss.n5122 11.5361
R12013 avss.n5336 avss.n5125 11.5361
R12014 avss.n5330 avss.n5125 11.5361
R12015 avss.n5330 avss.n5142 11.5361
R12016 avss.n5324 avss.n5142 11.5361
R12017 avss.n5318 avss.n5165 11.5361
R12018 avss.n5318 avss.n5237 11.5361
R12019 avss.n5237 avss.n586 11.5361
R12020 avss.n7231 avss.n586 11.5361
R12021 avss.n7231 avss.n572 11.5361
R12022 avss.n7242 avss.n572 11.5361
R12023 avss.n7222 avss.n600 11.5361
R12024 avss.n7216 avss.n600 11.5361
R12025 avss.n7216 avss.n613 11.5361
R12026 avss.n1951 avss.n1820 11.5361
R12027 avss.n1951 avss.n1810 11.5361
R12028 avss.n1959 avss.n1810 11.5361
R12029 avss.n1959 avss.n1798 11.5361
R12030 avss.n1972 avss.n1798 11.5361
R12031 avss.n1972 avss.n1802 11.5361
R12032 avss.n1980 avss.n1771 11.5361
R12033 avss.n3296 avss.n1771 11.5361
R12034 avss.n3296 avss.n1761 11.5361
R12035 avss.n3304 avss.n1761 11.5361
R12036 avss.n3304 avss.n1748 11.5361
R12037 avss.n3315 avss.n1748 11.5361
R12038 avss.n3284 avss.n1997 11.5361
R12039 avss.n2008 avss.n1997 11.5361
R12040 avss.n3275 avss.n2008 11.5361
R12041 avss.n6543 avss.t176 11.5094
R12042 avss.n6126 avss.n6125 11.2831
R12043 avss.n6672 avss.n1244 11.1326
R12044 avss.n6095 avss.n6094 11.1326
R12045 avss.n9317 avss.n9316 11.1326
R12046 avss.n9135 avss.n9134 11.1326
R12047 avss.n8608 avss.n7888 11.1326
R12048 avss.n8732 avss.n7798 11.1326
R12049 avss.n4915 avss.n4906 10.8938
R12050 avss.n4999 avss.n4914 10.8938
R12051 avss.n8512 avss.n8063 10.8424
R12052 avss.n8764 avss.n7759 10.8424
R12053 avss.n5562 avss.n4735 10.4202
R12054 avss.n7242 avss.n577 9.94992
R12055 avss.n7223 avss.n7222 9.94992
R12056 avss.n3315 avss.n1751 9.94992
R12057 avss.n3285 avss.n3284 9.94992
R12058 avss.t84 avss.n5017 9.94658
R12059 avss.t117 avss.n4662 9.8285
R12060 avss.t114 avss.n6248 9.8285
R12061 avss.n6700 avss.n6699 9.75843
R12062 avss.n6748 avss.n6747 9.7118
R12063 avss.n6790 avss.n6785 9.7118
R12064 avss.n7210 avss.n623 9.66153
R12065 avss.n2226 avss.n2012 9.66153
R12066 avss.n6815 avss.t170 9.5624
R12067 avss.n5006 avss.n4904 9.47296
R12068 avss.n9149 avss.n199 9.17956
R12069 avss.n6072 avss.n6071 9.14856
R12070 avss.n6677 avss.n6676 9.14856
R12071 avss.n2338 avss.n2314 9.00652
R12072 avss.n2420 avss.n2337 9.00652
R12073 avss.n3024 avss.n3023 9.00652
R12074 avss.n3165 avss.n3008 9.00652
R12075 avss.n4339 avss.n4338 9.00652
R12076 avss.n4329 avss.n4328 9.00652
R12077 avss.n4450 avss.n4449 9.00652
R12078 avss.n4440 avss.n4439 9.00652
R12079 avss.n2750 avss.n2248 8.97078
R12080 avss.n2607 avss.n2606 8.97078
R12081 avss.n2615 avss.n2481 8.97078
R12082 avss.n3564 avss.n3421 8.97078
R12083 avss.n4514 avss.n4513 8.97078
R12084 avss.n3685 avss.n3665 8.97078
R12085 avss.n6887 avss.n6886 8.96478
R12086 avss.n6877 avss.n6876 8.81538
R12087 avss.n6814 avss.n1160 8.81538
R12088 avss.n7472 avss.n395 8.79462
R12089 avss.n7464 avss.n7463 8.79462
R12090 avss.n7083 avss.n7082 8.79462
R12091 avss.n7070 avss.n830 8.79462
R12092 avss.n1105 avss.n1102 8.66597
R12093 avss.n2669 avss.n2273 8.62577
R12094 avss.n3834 avss.n3833 8.62577
R12095 avss.n2186 avss.n2126 8.55313
R12096 avss.n2049 avss.n2042 8.55313
R12097 avss.n2060 avss.n2052 8.55313
R12098 avss.n4186 avss.n4185 8.55313
R12099 avss.n3991 avss.n3954 8.55313
R12100 avss.n3960 avss.n3956 8.55313
R12101 avss.n6845 avss.t94 8.51657
R12102 avss.n8720 avss.n8719 8.50341
R12103 avss.n8728 avss.n7803 8.50341
R12104 avss.n8596 avss.n8595 8.50341
R12105 avss.n8604 avss.n7893 8.50341
R12106 avss.n9304 avss.n9303 8.50341
R12107 avss.n9312 avss.n64 8.50341
R12108 avss.n7279 avss.n7278 8.38344
R12109 avss.n524 avss.n517 8.38344
R12110 avss.n7311 avss.n7307 8.38344
R12111 avss.n7152 avss.n7151 8.38344
R12112 avss.n662 avss.n655 8.38344
R12113 avss.n748 avss.n665 8.38344
R12114 avss.n6772 avss.n6762 8.36716
R12115 avss.n7223 avss.n577 8.36378
R12116 avss.n3285 avss.n1751 8.36378
R12117 avss.n2625 avss.n2474 8.28076
R12118 avss.n3677 avss.n3666 8.28076
R12119 avss.n3194 avss.n2096 8.22418
R12120 avss.n3916 avss.n3836 8.22418
R12121 avss.t14 avss.n2438 8.22339
R12122 avss.t202 avss.n3050 8.22339
R12123 avss.n4348 avss.t5 8.22339
R12124 avss.n4459 avss.t66 8.22339
R12125 avss.n5067 avss.n4814 8.11756
R12126 avss.n7457 avss.n404 8.11756
R12127 avss.n6850 avss.n1131 8.11756
R12128 avss.n2682 avss.n2260 8.11756
R12129 avss.n3170 avss.n3169 8.11756
R12130 avss.n7137 avss.n707 8.11756
R12131 avss.n4171 avss.n3886 8.11756
R12132 avss.n3743 avss.n3408 8.11756
R12133 avss.n6785 avss.n6717 8.06835
R12134 avss.n6778 avss.n1090 8.06835
R12135 avss.n7336 avss.n482 8.06102
R12136 avss.n7124 avss.n720 8.06102
R12137 avss.n448 avss.t80 8.02991
R12138 avss.n7092 avss.t110 8.02991
R12139 avss.n194 avss.n185 7.95569
R12140 avss.n6049 avss.n5847 7.92882
R12141 avss.n6684 avss.n1224 7.92882
R12142 avss.n2073 avss.n494 7.89524
R12143 avss.n3975 avss.n3935 7.89524
R12144 avss.n2427 avss.n2312 7.83183
R12145 avss.n3148 avss.n3021 7.83183
R12146 avss.n4308 avss.n3892 7.83183
R12147 avss.n4419 avss.n3749 7.83183
R12148 avss.n6752 avss.n6726 7.76954
R12149 avss.n7391 avss.n7390 7.7386
R12150 avss.n7170 avss.n674 7.7386
R12151 avss.n392 avss.n383 7.64756
R12152 avss.n879 avss.n873 7.64756
R12153 avss.n2635 avss.n2467 7.59073
R12154 avss.n4498 avss.n3679 7.59073
R12155 avss.n5011 avss.n5010 7.57847
R12156 avss.n6670 avss.n6669 7.41805
R12157 avss.n5818 avss.n5817 7.41805
R12158 avss.n9198 avss.n9197 7.41805
R12159 avss.n7866 avss.n7865 7.41805
R12160 avss.n8735 avss.n8734 7.41805
R12161 avss.n9214 avss.n9213 7.41805
R12162 avss.n2082 avss.n2074 7.23734
R12163 avss.n4216 avss.n3929 7.23734
R12164 avss.n1685 avss.n1684 7.2365
R12165 avss.n3361 avss.n3359 7.2005
R12166 avss.t7 avss.n7672 7.10996
R12167 avss.n8800 avss.t7 7.10996
R12168 avss.t180 avss.n4841 7.10484
R12169 avss.n5037 avss.t26 7.10484
R12170 avss.n7384 avss.n506 7.09375
R12171 avss.n7168 avss.n677 7.09375
R12172 avss.n2401 avss.n2344 7.04869
R12173 avss.n3037 avss.n3030 7.04869
R12174 avss.n4299 avss.n4298 7.04869
R12175 avss.n4410 avss.n4409 7.04869
R12176 avss.n6607 avss.n6531 6.9429
R12177 avss.n6891 avss.n1089 6.90071
R12178 avss.n3684 avss.n3683 6.90071
R12179 avss.n7480 avss.n381 6.88285
R12180 avss.n885 avss.n837 6.88285
R12181 avss.n7210 avss.n627 6.77764
R12182 avss.n2926 avss.n2226 6.77764
R12183 avss.n6643 avss.n6642 6.7505
R12184 avss.n6645 avss.n6644 6.7505
R12185 avss.n6648 avss.n1667 6.7505
R12186 avss.n6652 avss.n6651 6.7505
R12187 avss.n6654 avss.n6653 6.7505
R12188 avss.n6633 avss.n6632 6.7505
R12189 avss.n6631 avss.n6630 6.7505
R12190 avss.n6627 avss.n6523 6.7505
R12191 avss.n6624 avss.n6623 6.7505
R12192 avss.n6526 avss.n6524 6.7505
R12193 avss.n6516 avss.n6515 6.7505
R12194 avss.n6514 avss.n6513 6.7505
R12195 avss.n6510 avss.n1673 6.7505
R12196 avss.n6507 avss.n6506 6.7505
R12197 avss.n6505 avss.n6504 6.7505
R12198 avss.n6497 avss.n6496 6.7505
R12199 avss.n6495 avss.n6494 6.7505
R12200 avss.n6491 avss.n1681 6.7505
R12201 avss.n6488 avss.n6487 6.7505
R12202 avss.n6486 avss.n6485 6.7505
R12203 avss.n1631 avss.n1202 6.70908
R12204 avss.n3363 avss.n3362 6.34412
R12205 avss.n2432 avss.n2431 6.26556
R12206 avss.n3118 avss.n3117 6.26556
R12207 avss.n4288 avss.n4283 6.26556
R12208 avss.n4399 avss.n4394 6.26556
R12209 avss.n7434 avss.n7433 6.11815
R12210 avss.n891 avss.n849 6.11815
R12211 avss.n6605 avss.n6533 6.08215
R12212 avss.n3359 avss.n3354 6.0439
R12213 avss.n6624 avss.n6526 6.0005
R12214 avss.n5324 avss.t142 5.76828
R12215 avss.n5165 avss.t142 5.76828
R12216 avss.n1802 avss.t137 5.76828
R12217 avss.n1980 avss.t137 5.76828
R12218 avss.n6892 avss.n964 5.67788
R12219 avss.n4665 avss.n4662 5.59803
R12220 avss.n6251 avss.n6248 5.59803
R12221 avss.n6578 avss.n6569 5.55683
R12222 avss.n6597 avss.n6534 5.55683
R12223 avss.n6558 avss.n6557 5.53703
R12224 avss.n6550 avss.n6549 5.53703
R12225 avss.n9143 avss.n207 5.50794
R12226 avss.n9142 avss.n210 5.50794
R12227 avss.n6083 avss.n6082 5.48933
R12228 avss.n5834 avss.n5824 5.48933
R12229 avss.n1603 avss.n1582 5.48933
R12230 avss.n1592 avss.n1586 5.48933
R12231 avss.n3362 avss.n3361 5.40985
R12232 avss.n1385 avss.n1377 5.35452
R12233 avss.n1386 avss.n1385 5.35452
R12234 avss.n6205 avss.n6204 5.35452
R12235 avss.n6205 avss.n5599 5.35452
R12236 avss.n8896 avss.n8895 5.35452
R12237 avss.n8896 avss.n7490 5.35452
R12238 avss.n8901 avss.n368 5.35452
R12239 avss.n8907 avss.n368 5.35452
R12240 avss.n8183 avss.n8182 5.35452
R12241 avss.n8182 avss.n8181 5.35452
R12242 avss.n8421 avss.n8420 5.35452
R12243 avss.n8422 avss.n8421 5.35452
R12244 avss.n6519 avss.n6518 5.33383
R12245 avss.n5067 avss.n5066 5.20876
R12246 avss.n5068 avss.n4699 5.20876
R12247 avss.n5414 avss.n5071 5.20876
R12248 avss.n7266 avss.n7265 5.20876
R12249 avss.n7327 avss.n404 5.20876
R12250 avss.n6767 avss.n1131 5.20876
R12251 avss.n6395 avss.n6394 5.20876
R12252 avss.n6323 avss.n972 5.20876
R12253 avss.n2742 avss.n2683 5.20876
R12254 avss.n3320 avss.n3319 5.20876
R12255 avss.n2682 avss.n2681 5.20876
R12256 avss.n3002 avss.n3001 5.20876
R12257 avss.n2110 avss.n1993 5.20876
R12258 avss.n3200 avss.n3170 5.20876
R12259 avss.n3822 avss.n3408 5.20876
R12260 avss.n7137 avss.n7136 5.20876
R12261 avss.n7139 avss.n7138 5.20876
R12262 avss.n703 avss.n596 5.20876
R12263 avss.n4171 avss.n3843 5.20876
R12264 avss.n4173 avss.n4172 5.20876
R12265 avss.n7247 avss.n7246 5.20876
R12266 avss.n7237 avss.n582 5.20876
R12267 avss.n4617 avss.n4616 5.20876
R12268 avss.n3310 avss.n551 5.20876
R12269 avss.n8753 avss.n7773 5.2005
R12270 avss.n8651 avss.n7773 5.2005
R12271 avss.n8755 avss.n8754 5.2005
R12272 avss.n8756 avss.n8755 5.2005
R12273 avss.n8651 avss.n7778 5.2005
R12274 avss.n8756 avss.n7771 5.2005
R12275 avss.n7834 avss.n7833 5.2005
R12276 avss.n7835 avss.n7834 5.2005
R12277 avss.n7830 avss.n7793 5.2005
R12278 avss.n8673 avss.n7793 5.2005
R12279 avss.n7835 avss.n7828 5.2005
R12280 avss.n8673 avss.n7794 5.2005
R12281 avss.n8727 avss.n8726 5.2005
R12282 avss.n8728 avss.n8727 5.2005
R12283 avss.n8722 avss.n8721 5.2005
R12284 avss.n8721 avss.n8720 5.2005
R12285 avss.n8729 avss.n8728 5.2005
R12286 avss.n8720 avss.n7801 5.2005
R12287 avss.n8716 avss.n7808 5.2005
R12288 avss.n7808 avss.n7803 5.2005
R12289 avss.n8718 avss.n8717 5.2005
R12290 avss.n8719 avss.n8718 5.2005
R12291 avss.n7809 avss.n7807 5.2005
R12292 avss.n7807 avss.n7805 5.2005
R12293 avss.n8701 avss.n8700 5.2005
R12294 avss.n8702 avss.n8701 5.2005
R12295 avss.n7818 avss.n7817 5.2005
R12296 avss.n7817 avss.n7815 5.2005
R12297 avss.n8695 avss.n8694 5.2005
R12298 avss.n8694 avss.n8693 5.2005
R12299 avss.n7821 avss.n7820 5.2005
R12300 avss.n7836 avss.n7821 5.2005
R12301 avss.n8681 avss.n8680 5.2005
R12302 avss.n8682 avss.n8681 5.2005
R12303 avss.n7838 avss.n7837 5.2005
R12304 avss.n8672 avss.n7837 5.2005
R12305 avss.n8676 avss.n8675 5.2005
R12306 avss.n8675 avss.n8674 5.2005
R12307 avss.n7789 avss.n7788 5.2005
R12308 avss.n7792 avss.n7789 5.2005
R12309 avss.n8743 avss.n8742 5.2005
R12310 avss.n8742 avss.n8741 5.2005
R12311 avss.n8744 avss.n7783 5.2005
R12312 avss.n7783 avss.n7781 5.2005
R12313 avss.n8746 avss.n8745 5.2005
R12314 avss.n8747 avss.n8746 5.2005
R12315 avss.n7784 avss.n7782 5.2005
R12316 avss.n7782 avss.n7779 5.2005
R12317 avss.n8656 avss.n8655 5.2005
R12318 avss.n8657 avss.n8656 5.2005
R12319 avss.n7767 avss.n7766 5.2005
R12320 avss.n8757 avss.n7767 5.2005
R12321 avss.n8760 avss.n8759 5.2005
R12322 avss.n8759 avss.n8758 5.2005
R12323 avss.n8761 avss.n7761 5.2005
R12324 avss.n7845 avss.n7761 5.2005
R12325 avss.n8710 avss.n8709 5.2005
R12326 avss.n8710 avss.n7803 5.2005
R12327 avss.n7811 avss.n7806 5.2005
R12328 avss.n8719 avss.n7806 5.2005
R12329 avss.n8705 avss.n8704 5.2005
R12330 avss.n8704 avss.n7805 5.2005
R12331 avss.n8703 avss.n7813 5.2005
R12332 avss.n8703 avss.n8702 5.2005
R12333 avss.n8689 avss.n7814 5.2005
R12334 avss.n7815 avss.n7814 5.2005
R12335 avss.n8691 avss.n8690 5.2005
R12336 avss.n8693 avss.n8691 5.2005
R12337 avss.n7824 avss.n7823 5.2005
R12338 avss.n7836 avss.n7823 5.2005
R12339 avss.n8684 avss.n8683 5.2005
R12340 avss.n8683 avss.n8682 5.2005
R12341 avss.n7827 avss.n7826 5.2005
R12342 avss.n8672 avss.n7827 5.2005
R12343 avss.n8671 avss.n8670 5.2005
R12344 avss.n8674 avss.n8671 5.2005
R12345 avss.n7841 avss.n7840 5.2005
R12346 avss.n7840 avss.n7792 5.2005
R12347 avss.n8666 avss.n7791 5.2005
R12348 avss.n8741 avss.n7791 5.2005
R12349 avss.n8665 avss.n8664 5.2005
R12350 avss.n8664 avss.n7781 5.2005
R12351 avss.n8663 avss.n7780 5.2005
R12352 avss.n8747 avss.n7780 5.2005
R12353 avss.n8650 avss.n7843 5.2005
R12354 avss.n8650 avss.n7779 5.2005
R12355 avss.n8659 avss.n8658 5.2005
R12356 avss.n8658 avss.n8657 5.2005
R12357 avss.n8649 avss.n7770 5.2005
R12358 avss.n8757 avss.n7770 5.2005
R12359 avss.n8648 avss.n7769 5.2005
R12360 avss.n8758 avss.n7769 5.2005
R12361 avss.n7847 avss.n7846 5.2005
R12362 avss.n7846 avss.n7845 5.2005
R12363 avss.n8627 avss.n8626 5.2005
R12364 avss.n8628 avss.n8627 5.2005
R12365 avss.n8623 avss.n7860 5.2005
R12366 avss.n8527 avss.n7860 5.2005
R12367 avss.n8629 avss.n8628 5.2005
R12368 avss.n8527 avss.n7861 5.2005
R12369 avss.n7924 avss.n7923 5.2005
R12370 avss.n7925 avss.n7924 5.2005
R12371 avss.n7920 avss.n7883 5.2005
R12372 avss.n8550 avss.n7883 5.2005
R12373 avss.n7925 avss.n7918 5.2005
R12374 avss.n8550 avss.n7884 5.2005
R12375 avss.n8603 avss.n8602 5.2005
R12376 avss.n8604 avss.n8603 5.2005
R12377 avss.n8598 avss.n8597 5.2005
R12378 avss.n8597 avss.n8596 5.2005
R12379 avss.n8605 avss.n8604 5.2005
R12380 avss.n8596 avss.n7891 5.2005
R12381 avss.n8592 avss.n7898 5.2005
R12382 avss.n7898 avss.n7893 5.2005
R12383 avss.n8594 avss.n8593 5.2005
R12384 avss.n8595 avss.n8594 5.2005
R12385 avss.n7899 avss.n7897 5.2005
R12386 avss.n7897 avss.n7895 5.2005
R12387 avss.n8577 avss.n8576 5.2005
R12388 avss.n8578 avss.n8577 5.2005
R12389 avss.n7908 avss.n7907 5.2005
R12390 avss.n7907 avss.n7905 5.2005
R12391 avss.n8571 avss.n8570 5.2005
R12392 avss.n8570 avss.n8569 5.2005
R12393 avss.n7911 avss.n7910 5.2005
R12394 avss.n7926 avss.n7911 5.2005
R12395 avss.n8558 avss.n8557 5.2005
R12396 avss.n8559 avss.n8558 5.2005
R12397 avss.n7928 avss.n7927 5.2005
R12398 avss.n8549 avss.n7927 5.2005
R12399 avss.n8553 avss.n8552 5.2005
R12400 avss.n8552 avss.n8551 5.2005
R12401 avss.n7932 avss.n7931 5.2005
R12402 avss.n7932 avss.n7882 5.2005
R12403 avss.n7878 avss.n7877 5.2005
R12404 avss.n8614 avss.n7878 5.2005
R12405 avss.n8618 avss.n8617 5.2005
R12406 avss.n8617 avss.n8616 5.2005
R12407 avss.n8619 avss.n7872 5.2005
R12408 avss.n7879 avss.n7872 5.2005
R12409 avss.n8621 avss.n8620 5.2005
R12410 avss.n8622 avss.n8621 5.2005
R12411 avss.n7873 avss.n7871 5.2005
R12412 avss.n7871 avss.n7868 5.2005
R12413 avss.n8532 avss.n8531 5.2005
R12414 avss.n8533 avss.n8532 5.2005
R12415 avss.n7857 avss.n7856 5.2005
R12416 avss.n7859 avss.n7857 5.2005
R12417 avss.n8637 avss.n8636 5.2005
R12418 avss.n8636 avss.n8635 5.2005
R12419 avss.n8586 avss.n8585 5.2005
R12420 avss.n8586 avss.n7893 5.2005
R12421 avss.n7901 avss.n7896 5.2005
R12422 avss.n8595 avss.n7896 5.2005
R12423 avss.n8581 avss.n8580 5.2005
R12424 avss.n8580 avss.n7895 5.2005
R12425 avss.n8579 avss.n7903 5.2005
R12426 avss.n8579 avss.n8578 5.2005
R12427 avss.n8566 avss.n7904 5.2005
R12428 avss.n7905 avss.n7904 5.2005
R12429 avss.n8568 avss.n8567 5.2005
R12430 avss.n8569 avss.n8568 5.2005
R12431 avss.n7914 avss.n7913 5.2005
R12432 avss.n7926 avss.n7913 5.2005
R12433 avss.n8561 avss.n8560 5.2005
R12434 avss.n8560 avss.n8559 5.2005
R12435 avss.n7917 avss.n7916 5.2005
R12436 avss.n8549 avss.n7917 5.2005
R12437 avss.n8548 avss.n8547 5.2005
R12438 avss.n8551 avss.n8548 5.2005
R12439 avss.n7934 avss.n7933 5.2005
R12440 avss.n7933 avss.n7882 5.2005
R12441 avss.n8543 avss.n7881 5.2005
R12442 avss.n8614 avss.n7881 5.2005
R12443 avss.n8542 avss.n7880 5.2005
R12444 avss.n8616 avss.n7880 5.2005
R12445 avss.n8541 avss.n8540 5.2005
R12446 avss.n8540 avss.n7879 5.2005
R12447 avss.n7936 avss.n7869 5.2005
R12448 avss.n8622 avss.n7869 5.2005
R12449 avss.n8536 avss.n8535 5.2005
R12450 avss.n8535 avss.n7868 5.2005
R12451 avss.n8534 avss.n7938 5.2005
R12452 avss.n8534 avss.n8533 5.2005
R12453 avss.n8526 avss.n8525 5.2005
R12454 avss.n8526 avss.n7859 5.2005
R12455 avss.n7939 avss.n7858 5.2005
R12456 avss.n8635 avss.n7858 5.2005
R12457 avss.n2676 avss.n2675 5.2005
R12458 avss.n2677 avss.n2676 5.2005
R12459 avss.n2269 avss.n2268 5.2005
R12460 avss.n2667 avss.n2268 5.2005
R12461 avss.n2679 avss.n2678 5.2005
R12462 avss.n2678 avss.n2677 5.2005
R12463 avss.n2264 avss.n2263 5.2005
R12464 avss.n2667 avss.n2264 5.2005
R12465 avss.n2422 avss.n2421 5.2005
R12466 avss.n2421 avss.n2420 5.2005
R12467 avss.n2423 avss.n2316 5.2005
R12468 avss.n2338 avss.n2316 5.2005
R12469 avss.n2425 avss.n2424 5.2005
R12470 avss.n2426 avss.n2425 5.2005
R12471 avss.n2317 avss.n2315 5.2005
R12472 avss.n2315 avss.n2312 5.2005
R12473 avss.n2409 avss.n2408 5.2005
R12474 avss.n2410 avss.n2409 5.2005
R12475 avss.n2403 avss.n2402 5.2005
R12476 avss.n2402 avss.n2401 5.2005
R12477 avss.n2304 avss.n2303 5.2005
R12478 avss.n2400 avss.n2304 5.2005
R12479 avss.n2434 avss.n2433 5.2005
R12480 avss.n2433 avss.n2432 5.2005
R12481 avss.n2435 avss.n2298 5.2005
R12482 avss.n2305 avss.n2298 5.2005
R12483 avss.n2437 avss.n2436 5.2005
R12484 avss.n2438 avss.n2437 5.2005
R12485 avss.n2299 avss.n2297 5.2005
R12486 avss.n2297 avss.n2293 5.2005
R12487 avss.n2384 avss.n2383 5.2005
R12488 avss.n2385 avss.n2384 5.2005
R12489 avss.n2352 avss.n2351 5.2005
R12490 avss.n2375 avss.n2351 5.2005
R12491 avss.n2378 avss.n2377 5.2005
R12492 avss.n2377 avss.n2376 5.2005
R12493 avss.n2419 avss.n2418 5.2005
R12494 avss.n2420 avss.n2419 5.2005
R12495 avss.n2340 avss.n2339 5.2005
R12496 avss.n2339 avss.n2338 5.2005
R12497 avss.n2414 avss.n2313 5.2005
R12498 avss.n2426 avss.n2313 5.2005
R12499 avss.n2413 avss.n2412 5.2005
R12500 avss.n2412 avss.n2312 5.2005
R12501 avss.n2411 avss.n2342 5.2005
R12502 avss.n2411 avss.n2410 5.2005
R12503 avss.n2397 avss.n2343 5.2005
R12504 avss.n2401 avss.n2343 5.2005
R12505 avss.n2399 avss.n2398 5.2005
R12506 avss.n2400 avss.n2399 5.2005
R12507 avss.n2345 avss.n2306 5.2005
R12508 avss.n2432 avss.n2306 5.2005
R12509 avss.n2391 avss.n2390 5.2005
R12510 avss.n2390 avss.n2305 5.2005
R12511 avss.n2389 avss.n2295 5.2005
R12512 avss.n2438 avss.n2295 5.2005
R12513 avss.n2388 avss.n2387 5.2005
R12514 avss.n2387 avss.n2293 5.2005
R12515 avss.n2386 avss.n2347 5.2005
R12516 avss.n2386 avss.n2385 5.2005
R12517 avss.n2372 avss.n2349 5.2005
R12518 avss.n2375 avss.n2349 5.2005
R12519 avss.n2374 avss.n2373 5.2005
R12520 avss.n2376 avss.n2374 5.2005
R12521 avss.n2445 avss.n2287 5.2005
R12522 avss.n2358 avss.n2287 5.2005
R12523 avss.n2447 avss.n2446 5.2005
R12524 avss.n2448 avss.n2447 5.2005
R12525 avss.n2285 avss.n2284 5.2005
R12526 avss.n2358 avss.n2285 5.2005
R12527 avss.n2450 avss.n2449 5.2005
R12528 avss.n2449 avss.n2448 5.2005
R12529 avss.n2292 avss.n2290 5.2005
R12530 avss.n2296 avss.n2292 5.2005
R12531 avss.n2441 avss.n2440 5.2005
R12532 avss.n2440 avss.n2439 5.2005
R12533 avss.n2360 avss.n2307 5.2005
R12534 avss.n2307 avss.n2296 5.2005
R12535 avss.n2361 avss.n2294 5.2005
R12536 avss.n2439 avss.n2294 5.2005
R12537 avss.n2336 avss.n2335 5.2005
R12538 avss.n2337 avss.n2336 5.2005
R12539 avss.n2324 avss.n2310 5.2005
R12540 avss.n2314 avss.n2310 5.2005
R12541 avss.n2330 avss.n2322 5.2005
R12542 avss.n2337 avss.n2322 5.2005
R12543 avss.n2329 avss.n2311 5.2005
R12544 avss.n2314 avss.n2311 5.2005
R12545 avss.n2104 avss.n2103 5.2005
R12546 avss.n3205 avss.n2104 5.2005
R12547 avss.n3209 avss.n3208 5.2005
R12548 avss.n3208 avss.n3207 5.2005
R12549 avss.n3198 avss.n2107 5.2005
R12550 avss.n3205 avss.n2107 5.2005
R12551 avss.n3197 avss.n2105 5.2005
R12552 avss.n3207 avss.n2105 5.2005
R12553 avss.n3164 avss.n3163 5.2005
R12554 avss.n3165 avss.n3164 5.2005
R12555 avss.n3010 avss.n3009 5.2005
R12556 avss.n3023 avss.n3009 5.2005
R12557 avss.n3146 avss.n3145 5.2005
R12558 avss.n3147 avss.n3146 5.2005
R12559 avss.n3026 avss.n3025 5.2005
R12560 avss.n3025 avss.n3021 5.2005
R12561 avss.n3141 avss.n3140 5.2005
R12562 avss.n3140 avss.n3139 5.2005
R12563 avss.n3029 avss.n3028 5.2005
R12564 avss.n3037 avss.n3029 5.2005
R12565 avss.n3126 avss.n3125 5.2005
R12566 avss.n3127 avss.n3126 5.2005
R12567 avss.n3039 avss.n3038 5.2005
R12568 avss.n3118 avss.n3038 5.2005
R12569 avss.n3121 avss.n3120 5.2005
R12570 avss.n3120 avss.n3119 5.2005
R12571 avss.n3042 avss.n3041 5.2005
R12572 avss.n3050 avss.n3042 5.2005
R12573 avss.n3108 avss.n3107 5.2005
R12574 avss.n3109 avss.n3108 5.2005
R12575 avss.n3053 avss.n3052 5.2005
R12576 avss.n3052 avss.n3049 5.2005
R12577 avss.n3103 avss.n3102 5.2005
R12578 avss.n3102 avss.n3101 5.2005
R12579 avss.n3056 avss.n3055 5.2005
R12580 avss.n3057 avss.n3056 5.2005
R12581 avss.n3167 avss.n3166 5.2005
R12582 avss.n3166 avss.n3165 5.2005
R12583 avss.n3006 avss.n3005 5.2005
R12584 avss.n3023 avss.n3006 5.2005
R12585 avss.n3135 avss.n3022 5.2005
R12586 avss.n3147 avss.n3022 5.2005
R12587 avss.n3136 avss.n3032 5.2005
R12588 avss.n3032 avss.n3021 5.2005
R12589 avss.n3138 avss.n3137 5.2005
R12590 avss.n3139 avss.n3138 5.2005
R12591 avss.n3033 avss.n3031 5.2005
R12592 avss.n3037 avss.n3031 5.2005
R12593 avss.n3129 avss.n3128 5.2005
R12594 avss.n3128 avss.n3127 5.2005
R12595 avss.n3036 avss.n3035 5.2005
R12596 avss.n3118 avss.n3036 5.2005
R12597 avss.n3116 avss.n3115 5.2005
R12598 avss.n3119 avss.n3116 5.2005
R12599 avss.n3045 avss.n3044 5.2005
R12600 avss.n3050 avss.n3044 5.2005
R12601 avss.n3111 avss.n3110 5.2005
R12602 avss.n3110 avss.n3109 5.2005
R12603 avss.n3048 avss.n3047 5.2005
R12604 avss.n3049 avss.n3048 5.2005
R12605 avss.n3076 avss.n3058 5.2005
R12606 avss.n3101 avss.n3058 5.2005
R12607 avss.n3077 avss.n3074 5.2005
R12608 avss.n3074 avss.n3057 5.2005
R12609 avss.n3092 avss.n3091 5.2005
R12610 avss.n3093 avss.n3092 5.2005
R12611 avss.n3084 avss.n3083 5.2005
R12612 avss.n3083 avss.n2108 5.2005
R12613 avss.n3095 avss.n3094 5.2005
R12614 avss.n3094 avss.n3093 5.2005
R12615 avss.n3070 avss.n3069 5.2005
R12616 avss.n3070 avss.n2108 5.2005
R12617 avss.n3086 avss.n3085 5.2005
R12618 avss.n3085 avss.n3043 5.2005
R12619 avss.n3087 avss.n3059 5.2005
R12620 avss.n3059 avss.n3051 5.2005
R12621 avss.n3065 avss.n3064 5.2005
R12622 avss.n3064 avss.n3043 5.2005
R12623 avss.n3066 avss.n3060 5.2005
R12624 avss.n3060 avss.n3051 5.2005
R12625 avss.n3155 avss.n3154 5.2005
R12626 avss.n3155 avss.n3008 5.2005
R12627 avss.n3017 avss.n3016 5.2005
R12628 avss.n3024 avss.n3016 5.2005
R12629 avss.n3158 avss.n3157 5.2005
R12630 avss.n3157 avss.n3008 5.2005
R12631 avss.n3015 avss.n3014 5.2005
R12632 avss.n3024 avss.n3015 5.2005
R12633 avss.n2996 avss.n2995 5.2005
R12634 avss.n2997 avss.n2996 5.2005
R12635 avss.n2122 avss.n2121 5.2005
R12636 avss.n2121 avss.n2119 5.2005
R12637 avss.n2991 avss.n2990 5.2005
R12638 avss.n2990 avss.n2989 5.2005
R12639 avss.n2125 avss.n2124 5.2005
R12640 avss.n2126 avss.n2125 5.2005
R12641 avss.n2980 avss.n2979 5.2005
R12642 avss.n2981 avss.n2980 5.2005
R12643 avss.n2999 avss.n2998 5.2005
R12644 avss.n2998 avss.n2997 5.2005
R12645 avss.n2117 avss.n2116 5.2005
R12646 avss.n2119 avss.n2117 5.2005
R12647 avss.n2988 avss.n2987 5.2005
R12648 avss.n2989 avss.n2988 5.2005
R12649 avss.n2128 avss.n2127 5.2005
R12650 avss.n2127 avss.n2126 5.2005
R12651 avss.n2983 avss.n2982 5.2005
R12652 avss.n2982 avss.n2981 5.2005
R12653 avss.n3210 avss.n2098 5.2005
R12654 avss.n3194 avss.n2098 5.2005
R12655 avss.n3212 avss.n3211 5.2005
R12656 avss.n3213 avss.n3212 5.2005
R12657 avss.n2099 avss.n2097 5.2005
R12658 avss.n2097 avss.n2094 5.2005
R12659 avss.n3186 avss.n3185 5.2005
R12660 avss.n3187 avss.n3186 5.2005
R12661 avss.n2081 avss.n2080 5.2005
R12662 avss.n2086 avss.n2081 5.2005
R12663 avss.n3226 avss.n3225 5.2005
R12664 avss.n3225 avss.n3224 5.2005
R12665 avss.n3227 avss.n2075 5.2005
R12666 avss.n2082 avss.n2075 5.2005
R12667 avss.n3229 avss.n3228 5.2005
R12668 avss.n3230 avss.n3229 5.2005
R12669 avss.n2059 avss.n2058 5.2005
R12670 avss.n2073 avss.n2059 5.2005
R12671 avss.n3238 avss.n3237 5.2005
R12672 avss.n3237 avss.n3236 5.2005
R12673 avss.n3239 avss.n2054 5.2005
R12674 avss.n2060 avss.n2054 5.2005
R12675 avss.n3241 avss.n3240 5.2005
R12676 avss.n3242 avss.n3241 5.2005
R12677 avss.n3196 avss.n3195 5.2005
R12678 avss.n3195 avss.n3194 5.2005
R12679 avss.n3172 avss.n2095 5.2005
R12680 avss.n3213 avss.n2095 5.2005
R12681 avss.n3190 avss.n3189 5.2005
R12682 avss.n3189 avss.n2094 5.2005
R12683 avss.n3188 avss.n3174 5.2005
R12684 avss.n3188 avss.n3187 5.2005
R12685 avss.n3180 avss.n3179 5.2005
R12686 avss.n3180 avss.n2086 5.2005
R12687 avss.n3175 avss.n2083 5.2005
R12688 avss.n3224 avss.n2083 5.2005
R12689 avss.n2072 avss.n2071 5.2005
R12690 avss.n2082 avss.n2072 5.2005
R12691 avss.n3232 avss.n3231 5.2005
R12692 avss.n3231 avss.n3230 5.2005
R12693 avss.n3233 avss.n2062 5.2005
R12694 avss.n2073 avss.n2062 5.2005
R12695 avss.n3235 avss.n3234 5.2005
R12696 avss.n3236 avss.n3235 5.2005
R12697 avss.n2063 avss.n2061 5.2005
R12698 avss.n2061 avss.n2060 5.2005
R12699 avss.n2065 avss.n2051 5.2005
R12700 avss.n3242 avss.n2051 5.2005
R12701 avss.n3256 avss.n2031 5.2005
R12702 avss.n2132 avss.n2031 5.2005
R12703 avss.n2209 avss.n2183 5.2005
R12704 avss.n2183 avss.n2132 5.2005
R12705 avss.n3245 avss.n3244 5.2005
R12706 avss.n3244 avss.n3243 5.2005
R12707 avss.n3246 avss.n2044 5.2005
R12708 avss.n2044 avss.n2042 5.2005
R12709 avss.n3248 avss.n3247 5.2005
R12710 avss.t128 avss.n3248 5.2005
R12711 avss.n2038 avss.n2036 5.2005
R12712 avss.n3249 avss.n2038 5.2005
R12713 avss.n3252 avss.n3251 5.2005
R12714 avss.n3251 avss.n3250 5.2005
R12715 avss.n2200 avss.n2050 5.2005
R12716 avss.n3243 avss.n2050 5.2005
R12717 avss.n2202 avss.n2201 5.2005
R12718 avss.n2201 avss.n2042 5.2005
R12719 avss.n2203 avss.n2043 5.2005
R12720 avss.t128 avss.n2043 5.2005
R12721 avss.n2204 avss.n2041 5.2005
R12722 avss.n3249 avss.n2041 5.2005
R12723 avss.n2205 avss.n2040 5.2005
R12724 avss.n3250 avss.n2040 5.2005
R12725 avss.n3220 avss.n2088 5.2005
R12726 avss.n3181 avss.n2088 5.2005
R12727 avss.n3222 avss.n3221 5.2005
R12728 avss.n3223 avss.n3222 5.2005
R12729 avss.n2193 avss.n2093 5.2005
R12730 avss.n3181 avss.n2093 5.2005
R12731 avss.n2194 avss.n2085 5.2005
R12732 avss.n3223 avss.n2085 5.2005
R12733 avss.n2734 avss.n2257 5.2005
R12734 avss.n2257 avss.n2255 5.2005
R12735 avss.n2736 avss.n2735 5.2005
R12736 avss.n2737 avss.n2736 5.2005
R12737 avss.n2728 avss.n2727 5.2005
R12738 avss.n2727 avss.n2726 5.2005
R12739 avss.n2730 avss.n2246 5.2005
R12740 avss.n2248 avss.n2246 5.2005
R12741 avss.n2753 avss.n2245 5.2005
R12742 avss.n2753 avss.n2752 5.2005
R12743 avss.n2740 avss.n2258 5.2005
R12744 avss.n2258 avss.n2255 5.2005
R12745 avss.n2739 avss.n2738 5.2005
R12746 avss.n2738 avss.n2737 5.2005
R12747 avss.n2725 avss.n2685 5.2005
R12748 avss.n2726 avss.n2725 5.2005
R12749 avss.n2724 avss.n2723 5.2005
R12750 avss.n2724 avss.n2248 5.2005
R12751 avss.n2686 avss.n2247 5.2005
R12752 avss.n2752 avss.n2247 5.2005
R12753 avss.n2671 avss.n2670 5.2005
R12754 avss.n2670 avss.n2669 5.2005
R12755 avss.n2272 avss.n2271 5.2005
R12756 avss.n2656 avss.n2272 5.2005
R12757 avss.n2643 avss.n2462 5.2005
R12758 avss.n2462 avss.n2454 5.2005
R12759 avss.n2645 avss.n2644 5.2005
R12760 avss.n2646 avss.n2645 5.2005
R12761 avss.n2463 avss.n2461 5.2005
R12762 avss.n2461 avss.n2277 5.2005
R12763 avss.n2638 avss.n2637 5.2005
R12764 avss.n2637 avss.n2275 5.2005
R12765 avss.n2636 avss.n2465 5.2005
R12766 avss.n2636 avss.n2635 5.2005
R12767 avss.n2622 avss.n2466 5.2005
R12768 avss.n2475 avss.n2466 5.2005
R12769 avss.n2624 avss.n2623 5.2005
R12770 avss.n2625 avss.n2624 5.2005
R12771 avss.n2477 avss.n2476 5.2005
R12772 avss.n2614 avss.n2476 5.2005
R12773 avss.n2617 avss.n2616 5.2005
R12774 avss.n2616 avss.n2615 5.2005
R12775 avss.n2480 avss.n2479 5.2005
R12776 avss.n2480 avss.n1089 5.2005
R12777 avss.n2653 avss.n2274 5.2005
R12778 avss.n2669 avss.n2274 5.2005
R12779 avss.n2655 avss.n2654 5.2005
R12780 avss.n2656 avss.n2655 5.2005
R12781 avss.n2456 avss.n2455 5.2005
R12782 avss.n2455 avss.n2454 5.2005
R12783 avss.n2648 avss.n2647 5.2005
R12784 avss.n2647 avss.n2646 5.2005
R12785 avss.n2459 avss.n2458 5.2005
R12786 avss.n2459 avss.n2277 5.2005
R12787 avss.n2632 avss.n2469 5.2005
R12788 avss.n2469 avss.n2275 5.2005
R12789 avss.n2634 avss.n2633 5.2005
R12790 avss.n2635 avss.n2634 5.2005
R12791 avss.n2470 avss.n2468 5.2005
R12792 avss.n2475 avss.n2468 5.2005
R12793 avss.n2627 avss.n2626 5.2005
R12794 avss.n2626 avss.n2625 5.2005
R12795 avss.n2473 avss.n2472 5.2005
R12796 avss.n2614 avss.n2473 5.2005
R12797 avss.n2613 avss.n2612 5.2005
R12798 avss.n2615 avss.n2613 5.2005
R12799 avss.n2483 avss.n2482 5.2005
R12800 avss.n2482 avss.n1089 5.2005
R12801 avss.n2583 avss.n2249 5.2005
R12802 avss.n2249 avss.n2148 5.2005
R12803 avss.n2525 avss.n2250 5.2005
R12804 avss.n2250 avss.n2148 5.2005
R12805 avss.n2603 avss.n2486 5.2005
R12806 avss.n2486 avss.n1088 5.2005
R12807 avss.n2605 avss.n2604 5.2005
R12808 avss.n2606 avss.n2605 5.2005
R12809 avss.n2487 avss.n2485 5.2005
R12810 avss.n2485 avss.t124 5.2005
R12811 avss.n2590 avss.n2589 5.2005
R12812 avss.n2591 avss.n2590 5.2005
R12813 avss.n2500 avss.n2253 5.2005
R12814 avss.n2256 avss.n2253 5.2005
R12815 avss.n2597 avss.n2596 5.2005
R12816 avss.n2596 avss.n1088 5.2005
R12817 avss.n2595 avss.n2484 5.2005
R12818 avss.n2606 avss.n2484 5.2005
R12819 avss.n2594 avss.n2593 5.2005
R12820 avss.n2593 avss.t124 5.2005
R12821 avss.n2592 avss.n2495 5.2005
R12822 avss.n2592 avss.n2591 5.2005
R12823 avss.n2496 avss.n2254 5.2005
R12824 avss.n2256 avss.n2254 5.2005
R12825 avss.n2663 avss.n2279 5.2005
R12826 avss.n2460 avss.n2279 5.2005
R12827 avss.n2665 avss.n2664 5.2005
R12828 avss.n2666 avss.n2665 5.2005
R12829 avss.n2491 avss.n2453 5.2005
R12830 avss.n2460 avss.n2453 5.2005
R12831 avss.n2492 avss.n2276 5.2005
R12832 avss.n2666 avss.n2276 5.2005
R12833 avss.n7021 avss.n969 5.2005
R12834 avss.n969 avss.n968 5.2005
R12835 avss.n7023 avss.n7022 5.2005
R12836 avss.n7024 avss.n7023 5.2005
R12837 avss.n963 avss.n962 5.2005
R12838 avss.n7025 avss.n963 5.2005
R12839 avss.n7028 avss.n7027 5.2005
R12840 avss.n7027 avss.n7026 5.2005
R12841 avss.n7029 avss.n957 5.2005
R12842 avss.n6893 avss.n957 5.2005
R12843 avss.n1084 avss.n973 5.2005
R12844 avss.n973 avss.n968 5.2005
R12845 avss.n1085 avss.n967 5.2005
R12846 avss.n7024 avss.n967 5.2005
R12847 avss.n1086 avss.n966 5.2005
R12848 avss.n7025 avss.n966 5.2005
R12849 avss.n1087 avss.n965 5.2005
R12850 avss.n7026 avss.n965 5.2005
R12851 avss.n6895 avss.n6894 5.2005
R12852 avss.n6894 avss.n6893 5.2005
R12853 avss.n6771 avss.n6770 5.2005
R12854 avss.n6772 avss.n6771 5.2005
R12855 avss.n6764 avss.n6763 5.2005
R12856 avss.n6763 avss.n6761 5.2005
R12857 avss.n6725 avss.n6724 5.2005
R12858 avss.n6778 avss.n6725 5.2005
R12859 avss.n6781 avss.n6780 5.2005
R12860 avss.n6780 avss.n6779 5.2005
R12861 avss.n6782 avss.n6719 5.2005
R12862 avss.n6752 avss.n6719 5.2005
R12863 avss.n6784 avss.n6783 5.2005
R12864 avss.n6785 avss.n6784 5.2005
R12865 avss.n6720 avss.n6718 5.2005
R12866 avss.n6748 avss.n6718 5.2005
R12867 avss.n6745 avss.n6744 5.2005
R12868 avss.n6746 avss.n6745 5.2005
R12869 avss.n1006 avss.n1005 5.2005
R12870 avss.n1009 avss.n1006 5.2005
R12871 avss.n6994 avss.n6993 5.2005
R12872 avss.n6993 avss.n6992 5.2005
R12873 avss.n6995 avss.n998 5.2005
R12874 avss.n1007 avss.n998 5.2005
R12875 avss.n6997 avss.n6996 5.2005
R12876 avss.n6998 avss.n6997 5.2005
R12877 avss.n1000 avss.n997 5.2005
R12878 avss.n997 avss.n995 5.2005
R12879 avss.n999 avss.n987 5.2005
R12880 avss.n1013 avss.n987 5.2005
R12881 avss.n6774 avss.n6773 5.2005
R12882 avss.n6773 avss.n6772 5.2005
R12883 avss.n6775 avss.n6728 5.2005
R12884 avss.n6761 avss.n6728 5.2005
R12885 avss.n6777 avss.n6776 5.2005
R12886 avss.n6778 avss.n6777 5.2005
R12887 avss.n6729 avss.n6727 5.2005
R12888 avss.n6779 avss.n6727 5.2005
R12889 avss.n6754 avss.n6753 5.2005
R12890 avss.n6753 avss.n6752 5.2005
R12891 avss.n6751 avss.n1175 5.2005
R12892 avss.n6785 avss.n1175 5.2005
R12893 avss.n6750 avss.n6749 5.2005
R12894 avss.n6749 avss.n6748 5.2005
R12895 avss.n6740 avss.n6731 5.2005
R12896 avss.n6746 avss.n6740 5.2005
R12897 avss.n6739 avss.n6738 5.2005
R12898 avss.n6739 avss.n1009 5.2005
R12899 avss.n6733 avss.n1008 5.2005
R12900 avss.n6992 avss.n1008 5.2005
R12901 avss.n994 avss.n993 5.2005
R12902 avss.n1007 avss.n994 5.2005
R12903 avss.n7000 avss.n6999 5.2005
R12904 avss.n6999 avss.n6998 5.2005
R12905 avss.n7001 avss.n991 5.2005
R12906 avss.n995 avss.n991 5.2005
R12907 avss.n7002 avss.n988 5.2005
R12908 avss.n1013 avss.n988 5.2005
R12909 avss.n6863 avss.n6862 5.2005
R12910 avss.n6862 avss.n6861 5.2005
R12911 avss.n6864 avss.n1118 5.2005
R12912 avss.n6845 avss.n1118 5.2005
R12913 avss.n6866 avss.n6865 5.2005
R12914 avss.n6867 avss.n6866 5.2005
R12915 avss.n1119 avss.n1117 5.2005
R12916 avss.n1117 avss.n1114 5.2005
R12917 avss.n6837 avss.n6836 5.2005
R12918 avss.n6838 avss.n6837 5.2005
R12919 avss.n1140 avss.n1139 5.2005
R12920 avss.n6828 avss.n1139 5.2005
R12921 avss.n6831 avss.n6830 5.2005
R12922 avss.n6830 avss.n6829 5.2005
R12923 avss.n1143 avss.n1142 5.2005
R12924 avss.n6816 avss.n1143 5.2005
R12925 avss.n6819 avss.n6818 5.2005
R12926 avss.n6820 avss.n6819 5.2005
R12927 avss.n1101 avss.n1099 5.2005
R12928 avss.n1160 avss.n1101 5.2005
R12929 avss.n6879 avss.n6878 5.2005
R12930 avss.n6878 avss.n6877 5.2005
R12931 avss.n1100 avss.n1097 5.2005
R12932 avss.n1102 avss.n1100 5.2005
R12933 avss.n6883 avss.n1095 5.2005
R12934 avss.n1095 avss.n1093 5.2005
R12935 avss.n6885 avss.n6884 5.2005
R12936 avss.n6886 avss.n6885 5.2005
R12937 avss.n6848 avss.n1125 5.2005
R12938 avss.n6861 avss.n1125 5.2005
R12939 avss.n6847 avss.n6846 5.2005
R12940 avss.n6846 avss.n6845 5.2005
R12941 avss.n6844 avss.n1115 5.2005
R12942 avss.n6867 avss.n1115 5.2005
R12943 avss.n1137 avss.n1133 5.2005
R12944 avss.n1137 avss.n1114 5.2005
R12945 avss.n6840 avss.n6839 5.2005
R12946 avss.n6839 avss.n6838 5.2005
R12947 avss.n1136 avss.n1135 5.2005
R12948 avss.n6828 avss.n1136 5.2005
R12949 avss.n6827 avss.n6826 5.2005
R12950 avss.n6829 avss.n6827 5.2005
R12951 avss.n1145 avss.n1144 5.2005
R12952 avss.n6816 avss.n1144 5.2005
R12953 avss.n6822 avss.n6821 5.2005
R12954 avss.n6821 avss.n6820 5.2005
R12955 avss.n1159 avss.n1158 5.2005
R12956 avss.n1160 avss.n1159 5.2005
R12957 avss.n1157 avss.n1103 5.2005
R12958 avss.n6877 avss.n1103 5.2005
R12959 avss.n1151 avss.n1147 5.2005
R12960 avss.n1151 avss.n1102 5.2005
R12961 avss.n1153 avss.n1152 5.2005
R12962 avss.n1152 avss.n1093 5.2005
R12963 avss.n1150 avss.n1092 5.2005
R12964 avss.n6886 avss.n1092 5.2005
R12965 avss.n6959 avss.n1021 5.2005
R12966 avss.n1021 avss.n953 5.2005
R12967 avss.n6973 avss.n6972 5.2005
R12968 avss.n6973 avss.n953 5.2005
R12969 avss.n984 avss.n982 5.2005
R12970 avss.n986 avss.n984 5.2005
R12971 avss.n7009 avss.n7008 5.2005
R12972 avss.n7008 avss.n7007 5.2005
R12973 avss.n983 avss.n980 5.2005
R12974 avss.t166 avss.n983 5.2005
R12975 avss.n7013 avss.n978 5.2005
R12976 avss.n978 avss.n976 5.2005
R12977 avss.n7015 avss.n7014 5.2005
R12978 avss.n7016 avss.n7015 5.2005
R12979 avss.n6986 avss.n6985 5.2005
R12980 avss.n6985 avss.n986 5.2005
R12981 avss.n6984 avss.n985 5.2005
R12982 avss.n7007 avss.n985 5.2005
R12983 avss.n6983 avss.n6982 5.2005
R12984 avss.n6982 avss.t166 5.2005
R12985 avss.n6981 avss.n1018 5.2005
R12986 avss.n6981 avss.n976 5.2005
R12987 avss.n6977 avss.n975 5.2005
R12988 avss.n7016 avss.n975 5.2005
R12989 avss.n6789 avss.n6788 5.2005
R12990 avss.n6790 avss.n6789 5.2005
R12991 avss.n6787 avss.n1010 5.2005
R12992 avss.n6747 avss.n1010 5.2005
R12993 avss.n6792 avss.n6791 5.2005
R12994 avss.n6791 avss.n6790 5.2005
R12995 avss.n1174 avss.n1011 5.2005
R12996 avss.n6747 avss.n1011 5.2005
R12997 avss.n6801 avss.n1164 5.2005
R12998 avss.n6805 avss.n1164 5.2005
R12999 avss.n6803 avss.n6802 5.2005
R13000 avss.n6804 avss.n6803 5.2005
R13001 avss.n1171 avss.n1165 5.2005
R13002 avss.n6805 avss.n1165 5.2005
R13003 avss.n1172 avss.n1167 5.2005
R13004 avss.n6804 avss.n1167 5.2005
R13005 avss.n6873 avss.n1107 5.2005
R13006 avss.n6814 avss.n1107 5.2005
R13007 avss.n6875 avss.n6874 5.2005
R13008 avss.n6876 avss.n6875 5.2005
R13009 avss.n6813 avss.n6812 5.2005
R13010 avss.n6814 avss.n6813 5.2005
R13011 avss.n1161 avss.n1104 5.2005
R13012 avss.n6876 avss.n1104 5.2005
R13013 avss.n1129 avss.n1126 5.2005
R13014 avss.n1126 avss.n1124 5.2005
R13015 avss.n1128 avss.n1112 5.2005
R13016 avss.n1116 avss.n1112 5.2005
R13017 avss.n6855 avss.n1127 5.2005
R13018 avss.n1127 avss.n1124 5.2005
R13019 avss.n6854 avss.n1113 5.2005
R13020 avss.n1116 avss.n1113 5.2005
R13021 avss.n9184 avss.n9183 5.2005
R13022 avss.n9185 avss.n9184 5.2005
R13023 avss.n9180 avss.n149 5.2005
R13024 avss.n162 avss.n149 5.2005
R13025 avss.n9185 avss.n164 5.2005
R13026 avss.n162 avss.n150 5.2005
R13027 avss.n9163 avss.n9162 5.2005
R13028 avss.n9164 avss.n9163 5.2005
R13029 avss.n9159 avss.n178 5.2005
R13030 avss.n9058 avss.n178 5.2005
R13031 avss.n9165 avss.n9164 5.2005
R13032 avss.n9058 avss.n179 5.2005
R13033 avss.n9141 avss.n9140 5.2005
R13034 avss.n9142 avss.n9141 5.2005
R13035 avss.n213 avss.n211 5.2005
R13036 avss.n211 avss.n207 5.2005
R13037 avss.n9142 avss.n209 5.2005
R13038 avss.n217 avss.n207 5.2005
R13039 avss.n206 avss.n205 5.2005
R13040 avss.n210 avss.n206 5.2005
R13041 avss.n9145 avss.n9144 5.2005
R13042 avss.n9144 avss.n9143 5.2005
R13043 avss.n9146 avss.n200 5.2005
R13044 avss.n9047 avss.n200 5.2005
R13045 avss.n9148 avss.n9147 5.2005
R13046 avss.n9149 avss.n9148 5.2005
R13047 avss.n193 avss.n192 5.2005
R13048 avss.n9150 avss.n193 5.2005
R13049 avss.n9154 avss.n9153 5.2005
R13050 avss.n9153 avss.n9152 5.2005
R13051 avss.n9155 avss.n187 5.2005
R13052 avss.n187 avss.n185 5.2005
R13053 avss.n9157 avss.n9156 5.2005
R13054 avss.n9158 avss.n9157 5.2005
R13055 avss.n188 avss.n186 5.2005
R13056 avss.n186 avss.n183 5.2005
R13057 avss.n9063 avss.n9062 5.2005
R13058 avss.n9064 avss.n9063 5.2005
R13059 avss.n174 avss.n173 5.2005
R13060 avss.n177 avss.n174 5.2005
R13061 avss.n9173 avss.n9172 5.2005
R13062 avss.n9172 avss.n9171 5.2005
R13063 avss.n9174 avss.n168 5.2005
R13064 avss.n168 avss.n167 5.2005
R13065 avss.n9176 avss.n9175 5.2005
R13066 avss.n9177 avss.n9176 5.2005
R13067 avss.n161 avss.n160 5.2005
R13068 avss.n165 avss.n161 5.2005
R13069 avss.n9188 avss.n9187 5.2005
R13070 avss.n9187 avss.n9186 5.2005
R13071 avss.n9189 avss.n155 5.2005
R13072 avss.n155 avss.n153 5.2005
R13073 avss.n9191 avss.n9190 5.2005
R13074 avss.n9192 avss.n9191 5.2005
R13075 avss.n156 avss.n154 5.2005
R13076 avss.n154 avss.n151 5.2005
R13077 avss.n9083 avss.n9082 5.2005
R13078 avss.n9082 avss.n9081 5.2005
R13079 avss.n9084 avss.n284 5.2005
R13080 avss.n284 avss.n283 5.2005
R13081 avss.n9086 avss.n9085 5.2005
R13082 avss.n9087 avss.n9086 5.2005
R13083 avss.n279 avss.n278 5.2005
R13084 avss.n9088 avss.n279 5.2005
R13085 avss.n9091 avss.n9090 5.2005
R13086 avss.n9090 avss.n9089 5.2005
R13087 avss.n9092 avss.n273 5.2005
R13088 avss.n273 avss.n272 5.2005
R13089 avss.n9094 avss.n9093 5.2005
R13090 avss.n9095 avss.n9094 5.2005
R13091 avss.n268 avss.n267 5.2005
R13092 avss.n9096 avss.n268 5.2005
R13093 avss.n9099 avss.n9098 5.2005
R13094 avss.n9098 avss.n9097 5.2005
R13095 avss.n9100 avss.n262 5.2005
R13096 avss.n262 avss.n261 5.2005
R13097 avss.n9102 avss.n9101 5.2005
R13098 avss.n9103 avss.n9102 5.2005
R13099 avss.n257 avss.n256 5.2005
R13100 avss.n9104 avss.n257 5.2005
R13101 avss.n9107 avss.n9106 5.2005
R13102 avss.n9106 avss.n9105 5.2005
R13103 avss.n9108 avss.n251 5.2005
R13104 avss.n251 avss.n250 5.2005
R13105 avss.n9110 avss.n9109 5.2005
R13106 avss.n9111 avss.n9110 5.2005
R13107 avss.n246 avss.n245 5.2005
R13108 avss.n9112 avss.n246 5.2005
R13109 avss.n9115 avss.n9114 5.2005
R13110 avss.n9114 avss.n9113 5.2005
R13111 avss.n9116 avss.n240 5.2005
R13112 avss.n240 avss.n239 5.2005
R13113 avss.n9118 avss.n9117 5.2005
R13114 avss.n9119 avss.n9118 5.2005
R13115 avss.n235 avss.n234 5.2005
R13116 avss.n9120 avss.n235 5.2005
R13117 avss.n9123 avss.n9122 5.2005
R13118 avss.n9122 avss.n9121 5.2005
R13119 avss.n9124 avss.n229 5.2005
R13120 avss.n229 avss.n227 5.2005
R13121 avss.n9126 avss.n9125 5.2005
R13122 avss.n9127 avss.n9126 5.2005
R13123 avss.n230 avss.n228 5.2005
R13124 avss.n228 avss.n225 5.2005
R13125 avss.n8987 avss.n8986 5.2005
R13126 avss.n8988 avss.n8987 5.2005
R13127 avss.n313 avss.n312 5.2005
R13128 avss.n312 avss.n311 5.2005
R13129 avss.n8981 avss.n8980 5.2005
R13130 avss.n8980 avss.n8979 5.2005
R13131 avss.n316 avss.n315 5.2005
R13132 avss.n317 avss.n316 5.2005
R13133 avss.n8967 avss.n8966 5.2005
R13134 avss.n8968 avss.n8967 5.2005
R13135 avss.n325 avss.n324 5.2005
R13136 avss.n324 avss.n323 5.2005
R13137 avss.n8962 avss.n8961 5.2005
R13138 avss.n8961 avss.n8960 5.2005
R13139 avss.n328 avss.n327 5.2005
R13140 avss.n329 avss.n328 5.2005
R13141 avss.n8951 avss.n8950 5.2005
R13142 avss.n8952 avss.n8951 5.2005
R13143 avss.n337 avss.n336 5.2005
R13144 avss.n336 avss.n335 5.2005
R13145 avss.n8946 avss.n8945 5.2005
R13146 avss.n8945 avss.n8944 5.2005
R13147 avss.n340 avss.n339 5.2005
R13148 avss.n341 avss.n340 5.2005
R13149 avss.n8935 avss.n8934 5.2005
R13150 avss.n8936 avss.n8935 5.2005
R13151 avss.n349 avss.n348 5.2005
R13152 avss.n348 avss.n347 5.2005
R13153 avss.n8930 avss.n8929 5.2005
R13154 avss.n8929 avss.n8928 5.2005
R13155 avss.n352 avss.n351 5.2005
R13156 avss.n353 avss.n352 5.2005
R13157 avss.n8919 avss.n8918 5.2005
R13158 avss.n8920 avss.n8919 5.2005
R13159 avss.n361 avss.n360 5.2005
R13160 avss.n360 avss.n359 5.2005
R13161 avss.n8914 avss.n8913 5.2005
R13162 avss.n8913 avss.n8912 5.2005
R13163 avss.n364 avss.n363 5.2005
R13164 avss.n365 avss.n364 5.2005
R13165 avss.n8903 avss.n8902 5.2005
R13166 avss.n8904 avss.n8903 5.2005
R13167 avss.n9045 avss.n222 5.2005
R13168 avss.n222 avss.n210 5.2005
R13169 avss.n9046 avss.n208 5.2005
R13170 avss.n9143 avss.n208 5.2005
R13171 avss.n9049 avss.n9048 5.2005
R13172 avss.n9048 avss.n9047 5.2005
R13173 avss.n9050 avss.n198 5.2005
R13174 avss.n9149 avss.n198 5.2005
R13175 avss.n9051 avss.n197 5.2005
R13176 avss.n9150 avss.n197 5.2005
R13177 avss.n9052 avss.n195 5.2005
R13178 avss.n9152 avss.n195 5.2005
R13179 avss.n9054 avss.n9053 5.2005
R13180 avss.n9053 avss.n185 5.2005
R13181 avss.n9055 avss.n184 5.2005
R13182 avss.n9158 avss.n184 5.2005
R13183 avss.n9057 avss.n9056 5.2005
R13184 avss.n9057 avss.n183 5.2005
R13185 avss.n9065 avss.n9035 5.2005
R13186 avss.n9065 avss.n9064 5.2005
R13187 avss.n9067 avss.n9066 5.2005
R13188 avss.n9066 avss.n177 5.2005
R13189 avss.n9068 avss.n176 5.2005
R13190 avss.n9171 avss.n176 5.2005
R13191 avss.n9070 avss.n9069 5.2005
R13192 avss.n9069 avss.n167 5.2005
R13193 avss.n9071 avss.n166 5.2005
R13194 avss.n9177 avss.n166 5.2005
R13195 avss.n9073 avss.n9072 5.2005
R13196 avss.n9072 avss.n165 5.2005
R13197 avss.n9074 avss.n163 5.2005
R13198 avss.n9186 avss.n163 5.2005
R13199 avss.n9076 avss.n9075 5.2005
R13200 avss.n9075 avss.n153 5.2005
R13201 avss.n9077 avss.n152 5.2005
R13202 avss.n9192 avss.n152 5.2005
R13203 avss.n9078 avss.n291 5.2005
R13204 avss.n291 avss.n151 5.2005
R13205 avss.n9080 avss.n9079 5.2005
R13206 avss.n9081 avss.n9080 5.2005
R13207 avss.n292 avss.n290 5.2005
R13208 avss.n290 avss.n283 5.2005
R13209 avss.n9022 avss.n282 5.2005
R13210 avss.n9087 avss.n282 5.2005
R13211 avss.n9021 avss.n281 5.2005
R13212 avss.n9088 avss.n281 5.2005
R13213 avss.n9020 avss.n280 5.2005
R13214 avss.n9089 avss.n280 5.2005
R13215 avss.n295 avss.n294 5.2005
R13216 avss.n294 avss.n272 5.2005
R13217 avss.n9016 avss.n271 5.2005
R13218 avss.n9095 avss.n271 5.2005
R13219 avss.n9015 avss.n270 5.2005
R13220 avss.n9096 avss.n270 5.2005
R13221 avss.n9014 avss.n269 5.2005
R13222 avss.n9097 avss.n269 5.2005
R13223 avss.n298 avss.n297 5.2005
R13224 avss.n297 avss.n261 5.2005
R13225 avss.n9010 avss.n260 5.2005
R13226 avss.n9103 avss.n260 5.2005
R13227 avss.n9009 avss.n259 5.2005
R13228 avss.n9104 avss.n259 5.2005
R13229 avss.n9008 avss.n258 5.2005
R13230 avss.n9105 avss.n258 5.2005
R13231 avss.n301 avss.n300 5.2005
R13232 avss.n300 avss.n250 5.2005
R13233 avss.n9004 avss.n249 5.2005
R13234 avss.n9111 avss.n249 5.2005
R13235 avss.n9003 avss.n248 5.2005
R13236 avss.n9112 avss.n248 5.2005
R13237 avss.n9002 avss.n247 5.2005
R13238 avss.n9113 avss.n247 5.2005
R13239 avss.n304 avss.n303 5.2005
R13240 avss.n303 avss.n239 5.2005
R13241 avss.n8998 avss.n238 5.2005
R13242 avss.n9119 avss.n238 5.2005
R13243 avss.n8997 avss.n237 5.2005
R13244 avss.n9120 avss.n237 5.2005
R13245 avss.n8996 avss.n236 5.2005
R13246 avss.n9121 avss.n236 5.2005
R13247 avss.n307 avss.n306 5.2005
R13248 avss.n306 avss.n227 5.2005
R13249 avss.n8992 avss.n226 5.2005
R13250 avss.n9127 avss.n226 5.2005
R13251 avss.n8991 avss.n8990 5.2005
R13252 avss.n8990 avss.n225 5.2005
R13253 avss.n8989 avss.n309 5.2005
R13254 avss.n8989 avss.n8988 5.2005
R13255 avss.n8976 avss.n310 5.2005
R13256 avss.n311 avss.n310 5.2005
R13257 avss.n8978 avss.n8977 5.2005
R13258 avss.n8979 avss.n8978 5.2005
R13259 avss.n319 avss.n318 5.2005
R13260 avss.n318 avss.n317 5.2005
R13261 avss.n8970 avss.n8969 5.2005
R13262 avss.n8969 avss.n8968 5.2005
R13263 avss.n322 avss.n321 5.2005
R13264 avss.n323 avss.n322 5.2005
R13265 avss.n8959 avss.n8958 5.2005
R13266 avss.n8960 avss.n8959 5.2005
R13267 avss.n331 avss.n330 5.2005
R13268 avss.n330 avss.n329 5.2005
R13269 avss.n8954 avss.n8953 5.2005
R13270 avss.n8953 avss.n8952 5.2005
R13271 avss.n334 avss.n333 5.2005
R13272 avss.n335 avss.n334 5.2005
R13273 avss.n8943 avss.n8942 5.2005
R13274 avss.n8944 avss.n8943 5.2005
R13275 avss.n343 avss.n342 5.2005
R13276 avss.n342 avss.n341 5.2005
R13277 avss.n8938 avss.n8937 5.2005
R13278 avss.n8937 avss.n8936 5.2005
R13279 avss.n346 avss.n345 5.2005
R13280 avss.n347 avss.n346 5.2005
R13281 avss.n8927 avss.n8926 5.2005
R13282 avss.n8928 avss.n8927 5.2005
R13283 avss.n355 avss.n354 5.2005
R13284 avss.n354 avss.n353 5.2005
R13285 avss.n8922 avss.n8921 5.2005
R13286 avss.n8921 avss.n8920 5.2005
R13287 avss.n358 avss.n357 5.2005
R13288 avss.n359 avss.n358 5.2005
R13289 avss.n8911 avss.n8910 5.2005
R13290 avss.n8912 avss.n8911 5.2005
R13291 avss.n367 avss.n366 5.2005
R13292 avss.n366 avss.n365 5.2005
R13293 avss.n8906 avss.n8905 5.2005
R13294 avss.n8905 avss.n8904 5.2005
R13295 avss.n8638 avss.n7760 5.2005
R13296 avss.n8764 avss.n7760 5.2005
R13297 avss.n8640 avss.n8639 5.2005
R13298 avss.n8641 avss.n8640 5.2005
R13299 avss.n7852 avss.n7747 5.2005
R13300 avss.n8770 avss.n7747 5.2005
R13301 avss.n8508 avss.n8507 5.2005
R13302 avss.n8507 avss.n8506 5.2005
R13303 avss.n8509 avss.n7734 5.2005
R13304 avss.n8776 avss.n7734 5.2005
R13305 avss.n8511 avss.n8510 5.2005
R13306 avss.n8512 avss.n8511 5.2005
R13307 avss.n8066 avss.n7721 5.2005
R13308 avss.n8782 avss.n7721 5.2005
R13309 avss.n8259 avss.n8258 5.2005
R13310 avss.n8258 avss.n7708 5.2005
R13311 avss.n8257 avss.n7709 5.2005
R13312 avss.n8788 avss.n7709 5.2005
R13313 avss.n8256 avss.n8255 5.2005
R13314 avss.n8255 avss.n7696 5.2005
R13315 avss.n8068 avss.n7697 5.2005
R13316 avss.n8794 avss.n7697 5.2005
R13317 avss.n8251 avss.n8250 5.2005
R13318 avss.n8250 avss.n7684 5.2005
R13319 avss.n8249 avss.n7685 5.2005
R13320 avss.n8800 avss.n7685 5.2005
R13321 avss.n8248 avss.n8247 5.2005
R13322 avss.n8247 avss.n7672 5.2005
R13323 avss.n8070 avss.n7673 5.2005
R13324 avss.n8806 avss.n7673 5.2005
R13325 avss.n8243 avss.n8242 5.2005
R13326 avss.n8242 avss.n7660 5.2005
R13327 avss.n8241 avss.n7661 5.2005
R13328 avss.n8812 avss.n7661 5.2005
R13329 avss.n8240 avss.n8239 5.2005
R13330 avss.n8239 avss.n7648 5.2005
R13331 avss.n8072 avss.n7649 5.2005
R13332 avss.n8818 avss.n7649 5.2005
R13333 avss.n8235 avss.n8234 5.2005
R13334 avss.n8234 avss.n7636 5.2005
R13335 avss.n8233 avss.n7637 5.2005
R13336 avss.n8824 avss.n7637 5.2005
R13337 avss.n8232 avss.n8231 5.2005
R13338 avss.n8231 avss.n7624 5.2005
R13339 avss.n8074 avss.n7625 5.2005
R13340 avss.n8830 avss.n7625 5.2005
R13341 avss.n8227 avss.n8226 5.2005
R13342 avss.n8226 avss.n7612 5.2005
R13343 avss.n8225 avss.n7613 5.2005
R13344 avss.n8836 avss.n7613 5.2005
R13345 avss.n8224 avss.n8223 5.2005
R13346 avss.n8223 avss.n7600 5.2005
R13347 avss.n8076 avss.n7601 5.2005
R13348 avss.n8842 avss.n7601 5.2005
R13349 avss.n8219 avss.n8218 5.2005
R13350 avss.n8218 avss.n7588 5.2005
R13351 avss.n8217 avss.n7589 5.2005
R13352 avss.n8848 avss.n7589 5.2005
R13353 avss.n8216 avss.n8215 5.2005
R13354 avss.n8215 avss.n7576 5.2005
R13355 avss.n8078 avss.n7577 5.2005
R13356 avss.n8854 avss.n7577 5.2005
R13357 avss.n8211 avss.n8210 5.2005
R13358 avss.n8210 avss.n7564 5.2005
R13359 avss.n8209 avss.n7565 5.2005
R13360 avss.n8860 avss.n7565 5.2005
R13361 avss.n8208 avss.n8207 5.2005
R13362 avss.n8207 avss.n7552 5.2005
R13363 avss.n8080 avss.n7553 5.2005
R13364 avss.n8866 avss.n7553 5.2005
R13365 avss.n8203 avss.n8202 5.2005
R13366 avss.n8202 avss.n7540 5.2005
R13367 avss.n8201 avss.n7541 5.2005
R13368 avss.n8872 avss.n7541 5.2005
R13369 avss.n8200 avss.n8199 5.2005
R13370 avss.n8199 avss.n7528 5.2005
R13371 avss.n8082 avss.n7529 5.2005
R13372 avss.n8878 avss.n7529 5.2005
R13373 avss.n8195 avss.n8194 5.2005
R13374 avss.n8194 avss.n7515 5.2005
R13375 avss.n8193 avss.n7516 5.2005
R13376 avss.n8884 avss.n7516 5.2005
R13377 avss.n8192 avss.n8191 5.2005
R13378 avss.n8191 avss.n7499 5.2005
R13379 avss.n8084 avss.n7500 5.2005
R13380 avss.n8890 avss.n7500 5.2005
R13381 avss.n8187 avss.n8186 5.2005
R13382 avss.n8186 avss.n7496 5.2005
R13383 avss.n8185 avss.n8184 5.2005
R13384 avss.n8185 avss.n7486 5.2005
R13385 avss.n8521 avss.n7758 5.2005
R13386 avss.n8764 avss.n7758 5.2005
R13387 avss.n8520 avss.n7851 5.2005
R13388 avss.n8641 avss.n7851 5.2005
R13389 avss.n8519 avss.n7745 5.2005
R13390 avss.n8770 avss.n7745 5.2005
R13391 avss.n8505 avss.n7941 5.2005
R13392 avss.n8506 avss.n8505 5.2005
R13393 avss.n8515 avss.n7732 5.2005
R13394 avss.n8776 avss.n7732 5.2005
R13395 avss.n8514 avss.n8513 5.2005
R13396 avss.n8513 avss.n8512 5.2005
R13397 avss.n7943 avss.n7719 5.2005
R13398 avss.n8782 avss.n7719 5.2005
R13399 avss.n8124 avss.n8123 5.2005
R13400 avss.n8123 avss.n7708 5.2005
R13401 avss.n8125 avss.n7707 5.2005
R13402 avss.n8788 avss.n7707 5.2005
R13403 avss.n8127 avss.n8126 5.2005
R13404 avss.n8126 avss.n7696 5.2005
R13405 avss.n8128 avss.n7695 5.2005
R13406 avss.n8794 avss.n7695 5.2005
R13407 avss.n8130 avss.n8129 5.2005
R13408 avss.n8129 avss.n7684 5.2005
R13409 avss.n8131 avss.n7683 5.2005
R13410 avss.n8800 avss.n7683 5.2005
R13411 avss.n8133 avss.n8132 5.2005
R13412 avss.n8132 avss.n7672 5.2005
R13413 avss.n8134 avss.n7671 5.2005
R13414 avss.n8806 avss.n7671 5.2005
R13415 avss.n8136 avss.n8135 5.2005
R13416 avss.n8135 avss.n7660 5.2005
R13417 avss.n8137 avss.n7659 5.2005
R13418 avss.n8812 avss.n7659 5.2005
R13419 avss.n8139 avss.n8138 5.2005
R13420 avss.n8138 avss.n7648 5.2005
R13421 avss.n8140 avss.n7647 5.2005
R13422 avss.n8818 avss.n7647 5.2005
R13423 avss.n8142 avss.n8141 5.2005
R13424 avss.n8141 avss.n7636 5.2005
R13425 avss.n8143 avss.n7635 5.2005
R13426 avss.n8824 avss.n7635 5.2005
R13427 avss.n8145 avss.n8144 5.2005
R13428 avss.n8144 avss.n7624 5.2005
R13429 avss.n8146 avss.n7623 5.2005
R13430 avss.n8830 avss.n7623 5.2005
R13431 avss.n8148 avss.n8147 5.2005
R13432 avss.n8147 avss.n7612 5.2005
R13433 avss.n8149 avss.n7611 5.2005
R13434 avss.n8836 avss.n7611 5.2005
R13435 avss.n8151 avss.n8150 5.2005
R13436 avss.n8150 avss.n7600 5.2005
R13437 avss.n8152 avss.n7599 5.2005
R13438 avss.n8842 avss.n7599 5.2005
R13439 avss.n8154 avss.n8153 5.2005
R13440 avss.n8153 avss.n7588 5.2005
R13441 avss.n8155 avss.n7587 5.2005
R13442 avss.n8848 avss.n7587 5.2005
R13443 avss.n8157 avss.n8156 5.2005
R13444 avss.n8156 avss.n7576 5.2005
R13445 avss.n8158 avss.n7575 5.2005
R13446 avss.n8854 avss.n7575 5.2005
R13447 avss.n8160 avss.n8159 5.2005
R13448 avss.n8159 avss.n7564 5.2005
R13449 avss.n8161 avss.n7563 5.2005
R13450 avss.n8860 avss.n7563 5.2005
R13451 avss.n8163 avss.n8162 5.2005
R13452 avss.n8162 avss.n7552 5.2005
R13453 avss.n8164 avss.n7551 5.2005
R13454 avss.n8866 avss.n7551 5.2005
R13455 avss.n8166 avss.n8165 5.2005
R13456 avss.n8165 avss.n7540 5.2005
R13457 avss.n8167 avss.n7539 5.2005
R13458 avss.n8872 avss.n7539 5.2005
R13459 avss.n8169 avss.n8168 5.2005
R13460 avss.n8168 avss.n7528 5.2005
R13461 avss.n8170 avss.n7527 5.2005
R13462 avss.n8878 avss.n7527 5.2005
R13463 avss.n8172 avss.n8171 5.2005
R13464 avss.n8171 avss.n7515 5.2005
R13465 avss.n8173 avss.n7514 5.2005
R13466 avss.n8884 avss.n7514 5.2005
R13467 avss.n8175 avss.n8174 5.2005
R13468 avss.n8174 avss.n7499 5.2005
R13469 avss.n8176 avss.n7498 5.2005
R13470 avss.n8890 avss.n7498 5.2005
R13471 avss.n8178 avss.n8177 5.2005
R13472 avss.n8178 avss.n7496 5.2005
R13473 avss.n8180 avss.n8179 5.2005
R13474 avss.n8179 avss.n7486 5.2005
R13475 avss.n8763 avss.n8762 5.2005
R13476 avss.n8764 avss.n8763 5.2005
R13477 avss.n7741 avss.n7740 5.2005
R13478 avss.n8641 avss.n7741 5.2005
R13479 avss.n8772 avss.n8771 5.2005
R13480 avss.n8771 avss.n8770 5.2005
R13481 avss.n8773 avss.n7735 5.2005
R13482 avss.n8506 avss.n7735 5.2005
R13483 avss.n8775 avss.n8774 5.2005
R13484 avss.n8776 avss.n8775 5.2005
R13485 avss.n7716 avss.n7715 5.2005
R13486 avss.n8512 avss.n7716 5.2005
R13487 avss.n8784 avss.n8783 5.2005
R13488 avss.n8783 avss.n8782 5.2005
R13489 avss.n8785 avss.n7710 5.2005
R13490 avss.n7710 avss.n7708 5.2005
R13491 avss.n8787 avss.n8786 5.2005
R13492 avss.n8788 avss.n8787 5.2005
R13493 avss.n7692 avss.n7691 5.2005
R13494 avss.n7696 avss.n7692 5.2005
R13495 avss.n8796 avss.n8795 5.2005
R13496 avss.n8795 avss.n8794 5.2005
R13497 avss.n8797 avss.n7686 5.2005
R13498 avss.n7686 avss.n7684 5.2005
R13499 avss.n8799 avss.n8798 5.2005
R13500 avss.n8800 avss.n8799 5.2005
R13501 avss.n7668 avss.n7667 5.2005
R13502 avss.n7672 avss.n7668 5.2005
R13503 avss.n8808 avss.n8807 5.2005
R13504 avss.n8807 avss.n8806 5.2005
R13505 avss.n8809 avss.n7662 5.2005
R13506 avss.n7662 avss.n7660 5.2005
R13507 avss.n8811 avss.n8810 5.2005
R13508 avss.n8812 avss.n8811 5.2005
R13509 avss.n7644 avss.n7643 5.2005
R13510 avss.n7648 avss.n7644 5.2005
R13511 avss.n8820 avss.n8819 5.2005
R13512 avss.n8819 avss.n8818 5.2005
R13513 avss.n8821 avss.n7638 5.2005
R13514 avss.n7638 avss.n7636 5.2005
R13515 avss.n8823 avss.n8822 5.2005
R13516 avss.n8824 avss.n8823 5.2005
R13517 avss.n7620 avss.n7619 5.2005
R13518 avss.n7624 avss.n7620 5.2005
R13519 avss.n8832 avss.n8831 5.2005
R13520 avss.n8831 avss.n8830 5.2005
R13521 avss.n8833 avss.n7614 5.2005
R13522 avss.n7614 avss.n7612 5.2005
R13523 avss.n8835 avss.n8834 5.2005
R13524 avss.n8836 avss.n8835 5.2005
R13525 avss.n7596 avss.n7595 5.2005
R13526 avss.n7600 avss.n7596 5.2005
R13527 avss.n8844 avss.n8843 5.2005
R13528 avss.n8843 avss.n8842 5.2005
R13529 avss.n8845 avss.n7590 5.2005
R13530 avss.n7590 avss.n7588 5.2005
R13531 avss.n8847 avss.n8846 5.2005
R13532 avss.n8848 avss.n8847 5.2005
R13533 avss.n7572 avss.n7571 5.2005
R13534 avss.n7576 avss.n7572 5.2005
R13535 avss.n8856 avss.n8855 5.2005
R13536 avss.n8855 avss.n8854 5.2005
R13537 avss.n8857 avss.n7566 5.2005
R13538 avss.n7566 avss.n7564 5.2005
R13539 avss.n8859 avss.n8858 5.2005
R13540 avss.n8860 avss.n8859 5.2005
R13541 avss.n7548 avss.n7547 5.2005
R13542 avss.n7552 avss.n7548 5.2005
R13543 avss.n8868 avss.n8867 5.2005
R13544 avss.n8867 avss.n8866 5.2005
R13545 avss.n8869 avss.n7542 5.2005
R13546 avss.n7542 avss.n7540 5.2005
R13547 avss.n8871 avss.n8870 5.2005
R13548 avss.n8872 avss.n8871 5.2005
R13549 avss.n7524 avss.n7523 5.2005
R13550 avss.n7528 avss.n7524 5.2005
R13551 avss.n8880 avss.n8879 5.2005
R13552 avss.n8879 avss.n8878 5.2005
R13553 avss.n8881 avss.n7518 5.2005
R13554 avss.n7518 avss.n7515 5.2005
R13555 avss.n8883 avss.n8882 5.2005
R13556 avss.n8884 avss.n8883 5.2005
R13557 avss.n7519 avss.n7517 5.2005
R13558 avss.n7517 avss.n7499 5.2005
R13559 avss.n8415 avss.n7501 5.2005
R13560 avss.n8890 avss.n7501 5.2005
R13561 avss.n8417 avss.n8416 5.2005
R13562 avss.n8417 avss.n7496 5.2005
R13563 avss.n8419 avss.n8418 5.2005
R13564 avss.n8418 avss.n7486 5.2005
R13565 avss.n8644 avss.n7757 5.2005
R13566 avss.n8764 avss.n7757 5.2005
R13567 avss.n8643 avss.n8642 5.2005
R13568 avss.n8642 avss.n8641 5.2005
R13569 avss.n7849 avss.n7744 5.2005
R13570 avss.n8770 avss.n7744 5.2005
R13571 avss.n8504 avss.n8503 5.2005
R13572 avss.n8506 avss.n8504 5.2005
R13573 avss.n8389 avss.n7731 5.2005
R13574 avss.n8776 avss.n7731 5.2005
R13575 avss.n8498 avss.n8065 5.2005
R13576 avss.n8512 avss.n8065 5.2005
R13577 avss.n8497 avss.n7718 5.2005
R13578 avss.n8782 avss.n7718 5.2005
R13579 avss.n8496 avss.n8495 5.2005
R13580 avss.n8495 avss.n7708 5.2005
R13581 avss.n8391 avss.n7706 5.2005
R13582 avss.n8788 avss.n7706 5.2005
R13583 avss.n8491 avss.n8490 5.2005
R13584 avss.n8490 avss.n7696 5.2005
R13585 avss.n8489 avss.n7694 5.2005
R13586 avss.n8794 avss.n7694 5.2005
R13587 avss.n8488 avss.n8487 5.2005
R13588 avss.n8487 avss.n7684 5.2005
R13589 avss.n8393 avss.n7682 5.2005
R13590 avss.n8800 avss.n7682 5.2005
R13591 avss.n8483 avss.n8482 5.2005
R13592 avss.n8482 avss.n7672 5.2005
R13593 avss.n8481 avss.n7670 5.2005
R13594 avss.n8806 avss.n7670 5.2005
R13595 avss.n8480 avss.n8479 5.2005
R13596 avss.n8479 avss.n7660 5.2005
R13597 avss.n8395 avss.n7658 5.2005
R13598 avss.n8812 avss.n7658 5.2005
R13599 avss.n8475 avss.n8474 5.2005
R13600 avss.n8474 avss.n7648 5.2005
R13601 avss.n8473 avss.n7646 5.2005
R13602 avss.n8818 avss.n7646 5.2005
R13603 avss.n8472 avss.n8471 5.2005
R13604 avss.n8471 avss.n7636 5.2005
R13605 avss.n8397 avss.n7634 5.2005
R13606 avss.n8824 avss.n7634 5.2005
R13607 avss.n8467 avss.n8466 5.2005
R13608 avss.n8466 avss.n7624 5.2005
R13609 avss.n8465 avss.n7622 5.2005
R13610 avss.n8830 avss.n7622 5.2005
R13611 avss.n8464 avss.n8463 5.2005
R13612 avss.n8463 avss.n7612 5.2005
R13613 avss.n8399 avss.n7610 5.2005
R13614 avss.n8836 avss.n7610 5.2005
R13615 avss.n8459 avss.n8458 5.2005
R13616 avss.n8458 avss.n7600 5.2005
R13617 avss.n8457 avss.n7598 5.2005
R13618 avss.n8842 avss.n7598 5.2005
R13619 avss.n8456 avss.n8455 5.2005
R13620 avss.n8455 avss.n7588 5.2005
R13621 avss.n8401 avss.n7586 5.2005
R13622 avss.n8848 avss.n7586 5.2005
R13623 avss.n8451 avss.n8450 5.2005
R13624 avss.n8450 avss.n7576 5.2005
R13625 avss.n8449 avss.n7574 5.2005
R13626 avss.n8854 avss.n7574 5.2005
R13627 avss.n8448 avss.n8447 5.2005
R13628 avss.n8447 avss.n7564 5.2005
R13629 avss.n8403 avss.n7562 5.2005
R13630 avss.n8860 avss.n7562 5.2005
R13631 avss.n8443 avss.n8442 5.2005
R13632 avss.n8442 avss.n7552 5.2005
R13633 avss.n8441 avss.n7550 5.2005
R13634 avss.n8866 avss.n7550 5.2005
R13635 avss.n8440 avss.n8439 5.2005
R13636 avss.n8439 avss.n7540 5.2005
R13637 avss.n8405 avss.n7538 5.2005
R13638 avss.n8872 avss.n7538 5.2005
R13639 avss.n8435 avss.n8434 5.2005
R13640 avss.n8434 avss.n7528 5.2005
R13641 avss.n8433 avss.n7526 5.2005
R13642 avss.n8878 avss.n7526 5.2005
R13643 avss.n8432 avss.n8431 5.2005
R13644 avss.n8431 avss.n7515 5.2005
R13645 avss.n8407 avss.n7513 5.2005
R13646 avss.n8884 avss.n7513 5.2005
R13647 avss.n8427 avss.n8426 5.2005
R13648 avss.n8426 avss.n7499 5.2005
R13649 avss.n8425 avss.n7497 5.2005
R13650 avss.n8890 avss.n7497 5.2005
R13651 avss.n8424 avss.n8411 5.2005
R13652 avss.n8411 avss.n7496 5.2005
R13653 avss.n8410 avss.n8409 5.2005
R13654 avss.n8410 avss.n7486 5.2005
R13655 avss.n8766 avss.n8765 5.2005
R13656 avss.n8765 avss.n8764 5.2005
R13657 avss.n8767 avss.n7748 5.2005
R13658 avss.n8641 avss.n7748 5.2005
R13659 avss.n8769 avss.n8768 5.2005
R13660 avss.n8770 avss.n8769 5.2005
R13661 avss.n7728 avss.n7727 5.2005
R13662 avss.n8506 avss.n7728 5.2005
R13663 avss.n8778 avss.n8777 5.2005
R13664 avss.n8777 avss.n8776 5.2005
R13665 avss.n8779 avss.n7722 5.2005
R13666 avss.n8512 avss.n7722 5.2005
R13667 avss.n8781 avss.n8780 5.2005
R13668 avss.n8782 avss.n8781 5.2005
R13669 avss.n7704 avss.n7703 5.2005
R13670 avss.n7708 avss.n7704 5.2005
R13671 avss.n8790 avss.n8789 5.2005
R13672 avss.n8789 avss.n8788 5.2005
R13673 avss.n8791 avss.n7698 5.2005
R13674 avss.n7698 avss.n7696 5.2005
R13675 avss.n8793 avss.n8792 5.2005
R13676 avss.n8794 avss.n8793 5.2005
R13677 avss.n7680 avss.n7679 5.2005
R13678 avss.n7684 avss.n7680 5.2005
R13679 avss.n8802 avss.n8801 5.2005
R13680 avss.n8801 avss.n8800 5.2005
R13681 avss.n8803 avss.n7674 5.2005
R13682 avss.n7674 avss.n7672 5.2005
R13683 avss.n8805 avss.n8804 5.2005
R13684 avss.n8806 avss.n8805 5.2005
R13685 avss.n7656 avss.n7655 5.2005
R13686 avss.n7660 avss.n7656 5.2005
R13687 avss.n8814 avss.n8813 5.2005
R13688 avss.n8813 avss.n8812 5.2005
R13689 avss.n8815 avss.n7650 5.2005
R13690 avss.n7650 avss.n7648 5.2005
R13691 avss.n8817 avss.n8816 5.2005
R13692 avss.n8818 avss.n8817 5.2005
R13693 avss.n7632 avss.n7631 5.2005
R13694 avss.n7636 avss.n7632 5.2005
R13695 avss.n8826 avss.n8825 5.2005
R13696 avss.n8825 avss.n8824 5.2005
R13697 avss.n8827 avss.n7626 5.2005
R13698 avss.n7626 avss.n7624 5.2005
R13699 avss.n8829 avss.n8828 5.2005
R13700 avss.n8830 avss.n8829 5.2005
R13701 avss.n7608 avss.n7607 5.2005
R13702 avss.n7612 avss.n7608 5.2005
R13703 avss.n8838 avss.n8837 5.2005
R13704 avss.n8837 avss.n8836 5.2005
R13705 avss.n8839 avss.n7602 5.2005
R13706 avss.n7602 avss.n7600 5.2005
R13707 avss.n8841 avss.n8840 5.2005
R13708 avss.n8842 avss.n8841 5.2005
R13709 avss.n7584 avss.n7583 5.2005
R13710 avss.n7588 avss.n7584 5.2005
R13711 avss.n8850 avss.n8849 5.2005
R13712 avss.n8849 avss.n8848 5.2005
R13713 avss.n8851 avss.n7578 5.2005
R13714 avss.n7578 avss.n7576 5.2005
R13715 avss.n8853 avss.n8852 5.2005
R13716 avss.n8854 avss.n8853 5.2005
R13717 avss.n7560 avss.n7559 5.2005
R13718 avss.n7564 avss.n7560 5.2005
R13719 avss.n8862 avss.n8861 5.2005
R13720 avss.n8861 avss.n8860 5.2005
R13721 avss.n8863 avss.n7554 5.2005
R13722 avss.n7554 avss.n7552 5.2005
R13723 avss.n8865 avss.n8864 5.2005
R13724 avss.n8866 avss.n8865 5.2005
R13725 avss.n7536 avss.n7535 5.2005
R13726 avss.n7540 avss.n7536 5.2005
R13727 avss.n8874 avss.n8873 5.2005
R13728 avss.n8873 avss.n8872 5.2005
R13729 avss.n8875 avss.n7530 5.2005
R13730 avss.n7530 avss.n7528 5.2005
R13731 avss.n8877 avss.n8876 5.2005
R13732 avss.n8878 avss.n8877 5.2005
R13733 avss.n7511 avss.n7510 5.2005
R13734 avss.n7515 avss.n7511 5.2005
R13735 avss.n8886 avss.n8885 5.2005
R13736 avss.n8885 avss.n8884 5.2005
R13737 avss.n8887 avss.n7503 5.2005
R13738 avss.n7503 avss.n7499 5.2005
R13739 avss.n8889 avss.n8888 5.2005
R13740 avss.n8890 avss.n8889 5.2005
R13741 avss.n7505 avss.n7502 5.2005
R13742 avss.n7502 avss.n7496 5.2005
R13743 avss.n7504 avss.n7488 5.2005
R13744 avss.n7488 avss.n7486 5.2005
R13745 avss.n8384 avss.n7756 5.2005
R13746 avss.n8764 avss.n7756 5.2005
R13747 avss.n8385 avss.n7850 5.2005
R13748 avss.n8641 avss.n7850 5.2005
R13749 avss.n8386 avss.n7743 5.2005
R13750 avss.n8770 avss.n7743 5.2005
R13751 avss.n8388 avss.n8387 5.2005
R13752 avss.n8506 avss.n8388 5.2005
R13753 avss.n8266 avss.n7730 5.2005
R13754 avss.n8776 avss.n7730 5.2005
R13755 avss.n8355 avss.n8064 5.2005
R13756 avss.n8512 avss.n8064 5.2005
R13757 avss.n8354 avss.n7717 5.2005
R13758 avss.n8782 avss.n7717 5.2005
R13759 avss.n8353 avss.n8352 5.2005
R13760 avss.n8352 avss.n7708 5.2005
R13761 avss.n8268 avss.n7705 5.2005
R13762 avss.n8788 avss.n7705 5.2005
R13763 avss.n8348 avss.n8347 5.2005
R13764 avss.n8347 avss.n7696 5.2005
R13765 avss.n8346 avss.n7693 5.2005
R13766 avss.n8794 avss.n7693 5.2005
R13767 avss.n8345 avss.n8344 5.2005
R13768 avss.n8344 avss.n7684 5.2005
R13769 avss.n8270 avss.n7681 5.2005
R13770 avss.n8800 avss.n7681 5.2005
R13771 avss.n8340 avss.n8339 5.2005
R13772 avss.n8339 avss.n7672 5.2005
R13773 avss.n8338 avss.n7669 5.2005
R13774 avss.n8806 avss.n7669 5.2005
R13775 avss.n8337 avss.n8336 5.2005
R13776 avss.n8336 avss.n7660 5.2005
R13777 avss.n8272 avss.n7657 5.2005
R13778 avss.n8812 avss.n7657 5.2005
R13779 avss.n8332 avss.n8331 5.2005
R13780 avss.n8331 avss.n7648 5.2005
R13781 avss.n8330 avss.n7645 5.2005
R13782 avss.n8818 avss.n7645 5.2005
R13783 avss.n8329 avss.n8328 5.2005
R13784 avss.n8328 avss.n7636 5.2005
R13785 avss.n8274 avss.n7633 5.2005
R13786 avss.n8824 avss.n7633 5.2005
R13787 avss.n8324 avss.n8323 5.2005
R13788 avss.n8323 avss.n7624 5.2005
R13789 avss.n8322 avss.n7621 5.2005
R13790 avss.n8830 avss.n7621 5.2005
R13791 avss.n8321 avss.n8320 5.2005
R13792 avss.n8320 avss.n7612 5.2005
R13793 avss.n8276 avss.n7609 5.2005
R13794 avss.n8836 avss.n7609 5.2005
R13795 avss.n8316 avss.n8315 5.2005
R13796 avss.n8315 avss.n7600 5.2005
R13797 avss.n8314 avss.n7597 5.2005
R13798 avss.n8842 avss.n7597 5.2005
R13799 avss.n8313 avss.n8312 5.2005
R13800 avss.n8312 avss.n7588 5.2005
R13801 avss.n8278 avss.n7585 5.2005
R13802 avss.n8848 avss.n7585 5.2005
R13803 avss.n8308 avss.n8307 5.2005
R13804 avss.n8307 avss.n7576 5.2005
R13805 avss.n8306 avss.n7573 5.2005
R13806 avss.n8854 avss.n7573 5.2005
R13807 avss.n8305 avss.n8304 5.2005
R13808 avss.n8304 avss.n7564 5.2005
R13809 avss.n8280 avss.n7561 5.2005
R13810 avss.n8860 avss.n7561 5.2005
R13811 avss.n8300 avss.n8299 5.2005
R13812 avss.n8299 avss.n7552 5.2005
R13813 avss.n8298 avss.n7549 5.2005
R13814 avss.n8866 avss.n7549 5.2005
R13815 avss.n8297 avss.n8296 5.2005
R13816 avss.n8296 avss.n7540 5.2005
R13817 avss.n8282 avss.n7537 5.2005
R13818 avss.n8872 avss.n7537 5.2005
R13819 avss.n8292 avss.n8291 5.2005
R13820 avss.n8291 avss.n7528 5.2005
R13821 avss.n8290 avss.n7525 5.2005
R13822 avss.n8878 avss.n7525 5.2005
R13823 avss.n8289 avss.n8288 5.2005
R13824 avss.n8288 avss.n7515 5.2005
R13825 avss.n8284 avss.n7512 5.2005
R13826 avss.n8884 avss.n7512 5.2005
R13827 avss.n7495 avss.n7494 5.2005
R13828 avss.n7499 avss.n7495 5.2005
R13829 avss.n8892 avss.n8891 5.2005
R13830 avss.n8891 avss.n8890 5.2005
R13831 avss.n8893 avss.n7492 5.2005
R13832 avss.n7496 avss.n7492 5.2005
R13833 avss.n8894 avss.n7489 5.2005
R13834 avss.n7489 avss.n7486 5.2005
R13835 avss.n7973 avss.n7972 5.2005
R13836 avss.n7972 avss.n7755 5.2005
R13837 avss.n7971 avss.n7963 5.2005
R13838 avss.n7971 avss.n7746 5.2005
R13839 avss.n7970 avss.n7969 5.2005
R13840 avss.n7970 avss.n7742 5.2005
R13841 avss.n7966 avss.n7964 5.2005
R13842 avss.n7964 avss.n7733 5.2005
R13843 avss.n7965 avss.n7944 5.2005
R13844 avss.n7944 avss.n7729 5.2005
R13845 avss.n8054 avss.n8053 5.2005
R13846 avss.n8054 avss.n7755 5.2005
R13847 avss.n8055 avss.n7950 5.2005
R13848 avss.n8055 avss.n7746 5.2005
R13849 avss.n8057 avss.n8056 5.2005
R13850 avss.n8056 avss.n7742 5.2005
R13851 avss.n8058 avss.n7948 5.2005
R13852 avss.n7948 avss.n7733 5.2005
R13853 avss.n8059 avss.n7945 5.2005
R13854 avss.n7945 avss.n7729 5.2005
R13855 avss.n490 avss.n489 5.2005
R13856 avss.n493 avss.n490 5.2005
R13857 avss.n7398 avss.n7397 5.2005
R13858 avss.n7397 avss.n7396 5.2005
R13859 avss.n7334 avss.n7333 5.2005
R13860 avss.n7333 avss.n493 5.2005
R13861 avss.n7335 avss.n492 5.2005
R13862 avss.n7396 avss.n492 5.2005
R13863 avss.n7462 avss.n7461 5.2005
R13864 avss.n7463 avss.n7462 5.2005
R13865 avss.n391 avss.n390 5.2005
R13866 avss.n395 avss.n391 5.2005
R13867 avss.n7475 avss.n7474 5.2005
R13868 avss.n7474 avss.n7473 5.2005
R13869 avss.n7476 avss.n385 5.2005
R13870 avss.n385 avss.n383 5.2005
R13871 avss.n7478 avss.n7477 5.2005
R13872 avss.n7479 avss.n7478 5.2005
R13873 avss.n386 avss.n384 5.2005
R13874 avss.n384 avss.n381 5.2005
R13875 avss.n7443 avss.n7442 5.2005
R13876 avss.n7444 avss.n7443 5.2005
R13877 avss.n412 avss.n411 5.2005
R13878 avss.n7434 avss.n411 5.2005
R13879 avss.n7437 avss.n7436 5.2005
R13880 avss.n7436 avss.n7435 5.2005
R13881 avss.n415 avss.n414 5.2005
R13882 avss.n448 avss.n415 5.2005
R13883 avss.n461 avss.n455 5.2005
R13884 avss.n455 avss.n426 5.2005
R13885 avss.n463 avss.n462 5.2005
R13886 avss.n464 avss.n463 5.2005
R13887 avss.n457 avss.n454 5.2005
R13888 avss.n454 avss.n453 5.2005
R13889 avss.n456 avss.n433 5.2005
R13890 avss.n452 avss.n433 5.2005
R13891 avss.n7455 avss.n401 5.2005
R13892 avss.n7463 avss.n401 5.2005
R13893 avss.n7454 avss.n7453 5.2005
R13894 avss.n7453 avss.n395 5.2005
R13895 avss.n7452 avss.n393 5.2005
R13896 avss.n7473 avss.n393 5.2005
R13897 avss.n407 avss.n406 5.2005
R13898 avss.n406 avss.n383 5.2005
R13899 avss.n7448 avss.n382 5.2005
R13900 avss.n7479 avss.n382 5.2005
R13901 avss.n7447 avss.n7446 5.2005
R13902 avss.n7446 avss.n381 5.2005
R13903 avss.n7445 avss.n409 5.2005
R13904 avss.n7445 avss.n7444 5.2005
R13905 avss.n445 avss.n410 5.2005
R13906 avss.n7434 avss.n410 5.2005
R13907 avss.n446 avss.n417 5.2005
R13908 avss.n7435 avss.n417 5.2005
R13909 avss.n449 avss.n447 5.2005
R13910 avss.n449 avss.n448 5.2005
R13911 avss.n450 avss.n439 5.2005
R13912 avss.n450 avss.n426 5.2005
R13913 avss.n466 avss.n465 5.2005
R13914 avss.n465 avss.n464 5.2005
R13915 avss.n467 avss.n437 5.2005
R13916 avss.n453 avss.n437 5.2005
R13917 avss.n468 avss.n434 5.2005
R13918 avss.n452 avss.n434 5.2005
R13919 avss.n7411 avss.n7410 5.2005
R13920 avss.n7412 avss.n7411 5.2005
R13921 avss.n7409 avss.n474 5.2005
R13922 avss.n7330 avss.n474 5.2005
R13923 avss.n7414 avss.n7413 5.2005
R13924 avss.n7413 avss.n7412 5.2005
R13925 avss.n431 avss.n430 5.2005
R13926 avss.n7330 avss.n431 5.2005
R13927 avss.n7422 avss.n418 5.2005
R13928 avss.n418 avss.n416 5.2005
R13929 avss.n7424 avss.n7423 5.2005
R13930 avss.n7425 avss.n7424 5.2005
R13931 avss.n7428 avss.n419 5.2005
R13932 avss.n419 avss.n416 5.2005
R13933 avss.n7427 avss.n7426 5.2005
R13934 avss.n7426 avss.n7425 5.2005
R13935 avss.n7469 avss.n397 5.2005
R13936 avss.n7464 avss.n397 5.2005
R13937 avss.n7471 avss.n7470 5.2005
R13938 avss.n7472 avss.n7471 5.2005
R13939 avss.n7465 avss.n400 5.2005
R13940 avss.n7465 avss.n7464 5.2005
R13941 avss.n422 avss.n394 5.2005
R13942 avss.n7472 avss.n394 5.2005
R13943 avss.n544 avss.n543 5.2005
R13944 avss.n7271 avss.n544 5.2005
R13945 avss.n7274 avss.n7273 5.2005
R13946 avss.n7273 avss.n7272 5.2005
R13947 avss.n7275 avss.n538 5.2005
R13948 avss.n538 avss.n536 5.2005
R13949 avss.n7277 avss.n7276 5.2005
R13950 avss.n7278 avss.n7277 5.2005
R13951 avss.n539 avss.n537 5.2005
R13952 avss.n2876 avss.n537 5.2005
R13953 avss.n7269 avss.n7268 5.2005
R13954 avss.n7271 avss.n7269 5.2005
R13955 avss.n547 avss.n545 5.2005
R13956 avss.n7272 avss.n545 5.2005
R13957 avss.n2873 avss.n2872 5.2005
R13958 avss.n2872 avss.n536 5.2005
R13959 avss.n2874 avss.n535 5.2005
R13960 avss.n7278 avss.n535 5.2005
R13961 avss.n2877 avss.n2875 5.2005
R13962 avss.n2877 avss.n2876 5.2005
R13963 avss.n7399 avss.n484 5.2005
R13964 avss.n7336 avss.n484 5.2005
R13965 avss.n7401 avss.n7400 5.2005
R13966 avss.n7402 avss.n7401 5.2005
R13967 avss.n485 avss.n483 5.2005
R13968 avss.n483 avss.n480 5.2005
R13969 avss.n7350 avss.n7349 5.2005
R13970 avss.n7351 avss.n7350 5.2005
R13971 avss.n7344 avss.n7343 5.2005
R13972 avss.n7343 avss.n510 5.2005
R13973 avss.n505 avss.n504 5.2005
R13974 avss.n7383 avss.n505 5.2005
R13975 avss.n7386 avss.n7385 5.2005
R13976 avss.n7385 avss.n7384 5.2005
R13977 avss.n7387 avss.n499 5.2005
R13978 avss.n499 avss.n497 5.2005
R13979 avss.n7389 avss.n7388 5.2005
R13980 avss.n7390 avss.n7389 5.2005
R13981 avss.n500 avss.n498 5.2005
R13982 avss.n498 avss.n495 5.2005
R13983 avss.n7369 avss.n7309 5.2005
R13984 avss.n7311 avss.n7309 5.2005
R13985 avss.n7371 avss.n7370 5.2005
R13986 avss.n7372 avss.n7371 5.2005
R13987 avss.n7338 avss.n7337 5.2005
R13988 avss.n7337 avss.n7336 5.2005
R13989 avss.n7339 avss.n481 5.2005
R13990 avss.n7402 avss.n481 5.2005
R13991 avss.n7341 avss.n7340 5.2005
R13992 avss.n7341 avss.n480 5.2005
R13993 avss.n7352 avss.n7319 5.2005
R13994 avss.n7352 avss.n7351 5.2005
R13995 avss.n7354 avss.n7353 5.2005
R13996 avss.n7353 avss.n510 5.2005
R13997 avss.n7355 avss.n508 5.2005
R13998 avss.n7383 avss.n508 5.2005
R13999 avss.n7356 avss.n507 5.2005
R14000 avss.n7384 avss.n507 5.2005
R14001 avss.n7358 avss.n7357 5.2005
R14002 avss.n7357 avss.n497 5.2005
R14003 avss.n7359 avss.n496 5.2005
R14004 avss.n7390 avss.n496 5.2005
R14005 avss.n7361 avss.n7360 5.2005
R14006 avss.n7360 avss.n495 5.2005
R14007 avss.n7362 avss.n7312 5.2005
R14008 avss.n7312 avss.n7311 5.2005
R14009 avss.n7363 avss.n7306 5.2005
R14010 avss.n7372 avss.n7306 5.2005
R14011 avss.n2801 avss.n532 5.2005
R14012 avss.n2149 avss.n532 5.2005
R14013 avss.n2845 avss.n533 5.2005
R14014 avss.n2149 avss.n533 5.2005
R14015 avss.n7375 avss.n7374 5.2005
R14016 avss.n7374 avss.n7373 5.2005
R14017 avss.n515 avss.n514 5.2005
R14018 avss.n524 avss.n515 5.2005
R14019 avss.n7293 avss.n7292 5.2005
R14020 avss.t130 avss.n7293 5.2005
R14021 avss.n526 avss.n525 5.2005
R14022 avss.n525 avss.n523 5.2005
R14023 avss.n7288 avss.n7287 5.2005
R14024 avss.n7287 avss.n7286 5.2005
R14025 avss.n7305 avss.n7304 5.2005
R14026 avss.n7373 avss.n7305 5.2005
R14027 avss.n519 avss.n518 5.2005
R14028 avss.n524 avss.n518 5.2005
R14029 avss.n7295 avss.n7294 5.2005
R14030 avss.n7294 avss.t130 5.2005
R14031 avss.n522 avss.n521 5.2005
R14032 avss.n523 avss.n522 5.2005
R14033 avss.n7285 avss.n7284 5.2005
R14034 avss.n7286 avss.n7285 5.2005
R14035 avss.n7379 avss.n478 5.2005
R14036 avss.n7342 avss.n478 5.2005
R14037 avss.n7381 avss.n7380 5.2005
R14038 avss.n7382 avss.n7381 5.2005
R14039 avss.n7299 avss.n479 5.2005
R14040 avss.n7342 avss.n479 5.2005
R14041 avss.n7300 avss.n509 5.2005
R14042 avss.n7382 avss.n509 5.2005
R14043 avss.n2135 avss.n2134 5.2005
R14044 avss.n2975 avss.n2974 5.2005
R14045 avss.n2138 avss.n2137 5.2005
R14046 avss.n2960 avss.n2959 5.2005
R14047 avss.n2962 avss.n2961 5.2005
R14048 avss.n2965 avss.n2964 5.2005
R14049 avss.n2963 avss.n2956 5.2005
R14050 avss.n2969 avss.n2144 5.2005
R14051 avss.n2971 avss.n2970 5.2005
R14052 avss.n2972 avss.n2971 5.2005
R14053 avss.n2131 avss.n2130 5.2005
R14054 avss.n2939 avss.n2938 5.2005
R14055 avss.n2941 avss.n2940 5.2005
R14056 avss.n2943 avss.n2942 5.2005
R14057 avss.n2945 avss.n2944 5.2005
R14058 avss.n2946 avss.n2931 5.2005
R14059 avss.n2948 avss.n2947 5.2005
R14060 avss.n2147 avss.n2146 5.2005
R14061 avss.n2952 avss.n2951 5.2005
R14062 avss.n2951 avss.n2950 5.2005
R14063 avss.n3258 avss.n3257 5.2005
R14064 avss.n3260 avss.n2029 5.2005
R14065 avss.n3262 avss.n3261 5.2005
R14066 avss.n3263 avss.n2023 5.2005
R14067 avss.n3265 avss.n3264 5.2005
R14068 avss.n3267 avss.n2022 5.2005
R14069 avss.n3268 avss.n2020 5.2005
R14070 avss.n3271 avss.n3270 5.2005
R14071 avss.n2211 avss.n2210 5.2005
R14072 avss.n2213 avss.n2181 5.2005
R14073 avss.n2215 avss.n2214 5.2005
R14074 avss.n2216 avss.n2176 5.2005
R14075 avss.n2218 avss.n2217 5.2005
R14076 avss.n2220 avss.n2174 5.2005
R14077 avss.n2222 avss.n2221 5.2005
R14078 avss.n2223 avss.n2152 5.2005
R14079 avss.n2755 avss.n2754 5.2005
R14080 avss.n2757 avss.n2756 5.2005
R14081 avss.n2759 avss.n2758 5.2005
R14082 avss.n2761 avss.n2760 5.2005
R14083 avss.n2763 avss.n2762 5.2005
R14084 avss.n2766 avss.n2765 5.2005
R14085 avss.n2764 avss.n2239 5.2005
R14086 avss.n2770 avss.n2237 5.2005
R14087 avss.n2772 avss.n2771 5.2005
R14088 avss.n2773 avss.n2772 5.2005
R14089 avss.n2718 avss.n2717 5.2005
R14090 avss.n2689 avss.n2688 5.2005
R14091 avss.n2701 avss.n2700 5.2005
R14092 avss.n2703 avss.n2702 5.2005
R14093 avss.n2705 avss.n2704 5.2005
R14094 avss.n2708 avss.n2707 5.2005
R14095 avss.n2706 avss.n2696 5.2005
R14096 avss.n2712 avss.n2693 5.2005
R14097 avss.n2714 avss.n2713 5.2005
R14098 avss.n2715 avss.n2714 5.2005
R14099 avss.n2582 avss.n2581 5.2005
R14100 avss.n2579 avss.n2502 5.2005
R14101 avss.n2578 avss.n2577 5.2005
R14102 avss.n2570 avss.n2504 5.2005
R14103 avss.n2572 avss.n2571 5.2005
R14104 avss.n2568 avss.n2506 5.2005
R14105 avss.n2567 avss.n2566 5.2005
R14106 avss.n2560 avss.n2508 5.2005
R14107 avss.n2527 avss.n2526 5.2005
R14108 avss.n2529 avss.n2528 5.2005
R14109 avss.n2531 avss.n2530 5.2005
R14110 avss.n2533 avss.n2532 5.2005
R14111 avss.n2535 avss.n2534 5.2005
R14112 avss.n2537 avss.n2536 5.2005
R14113 avss.n2539 avss.n2538 5.2005
R14114 avss.n2541 avss.n2540 5.2005
R14115 avss.n2908 avss.n2907 5.2005
R14116 avss.n2910 avss.n2909 5.2005
R14117 avss.n2912 avss.n2911 5.2005
R14118 avss.n2914 avss.n2913 5.2005
R14119 avss.n2916 avss.n2915 5.2005
R14120 avss.n2918 avss.n2917 5.2005
R14121 avss.n2920 avss.n2919 5.2005
R14122 avss.n2921 avss.n2854 5.2005
R14123 avss.n2923 avss.n2922 5.2005
R14124 avss.n2924 avss.n2923 5.2005
R14125 avss.n2879 avss.n2878 5.2005
R14126 avss.n2881 avss.n2880 5.2005
R14127 avss.n2883 avss.n2882 5.2005
R14128 avss.n2885 avss.n2884 5.2005
R14129 avss.n2887 avss.n2886 5.2005
R14130 avss.n2888 avss.n2861 5.2005
R14131 avss.n2890 avss.n2889 5.2005
R14132 avss.n2857 avss.n2856 5.2005
R14133 avss.n2894 avss.n2893 5.2005
R14134 avss.n2893 avss.n2892 5.2005
R14135 avss.n2803 avss.n2802 5.2005
R14136 avss.n2779 avss.n2778 5.2005
R14137 avss.n2796 avss.n2795 5.2005
R14138 avss.n2794 avss.n2793 5.2005
R14139 avss.n2792 avss.n2791 5.2005
R14140 avss.n2785 avss.n2781 5.2005
R14141 avss.n2787 avss.n2786 5.2005
R14142 avss.n2784 avss.n2783 5.2005
R14143 avss.n2847 avss.n2846 5.2005
R14144 avss.n2810 avss.n2809 5.2005
R14145 avss.n2841 avss.n2840 5.2005
R14146 avss.n2839 avss.n2838 5.2005
R14147 avss.n2837 avss.n2836 5.2005
R14148 avss.n2830 avss.n2812 5.2005
R14149 avss.n2832 avss.n2831 5.2005
R14150 avss.n2829 avss.n2828 5.2005
R14151 avss.n7195 avss.n7194 5.2005
R14152 avss.n7197 avss.n642 5.2005
R14153 avss.n7199 avss.n7198 5.2005
R14154 avss.n7200 avss.n637 5.2005
R14155 avss.n7202 avss.n7201 5.2005
R14156 avss.n7204 avss.n634 5.2005
R14157 avss.n7206 avss.n7205 5.2005
R14158 avss.n7207 avss.n629 5.2005
R14159 avss.n3474 avss.n3473 5.2005
R14160 avss.n3438 avss.n3437 5.2005
R14161 avss.n3468 avss.n3467 5.2005
R14162 avss.n3466 avss.n3465 5.2005
R14163 avss.n3464 avss.n3463 5.2005
R14164 avss.n3457 avss.n3440 5.2005
R14165 avss.n3459 avss.n3458 5.2005
R14166 avss.n3456 avss.n3455 5.2005
R14167 avss.n3552 avss.n3551 5.2005
R14168 avss.n3553 avss.n3552 5.2005
R14169 avss.n3481 avss.n3480 5.2005
R14170 avss.n3546 avss.n3545 5.2005
R14171 avss.n3544 avss.n3543 5.2005
R14172 avss.n3542 avss.n3485 5.2005
R14173 avss.n3484 avss.n3483 5.2005
R14174 avss.n3538 avss.n3537 5.2005
R14175 avss.n3536 avss.n3535 5.2005
R14176 avss.n3534 avss.n3487 5.2005
R14177 avss.n3516 avss.n3505 5.2005
R14178 avss.n3505 avss.n3491 5.2005
R14179 avss.n3517 avss.n3504 5.2005
R14180 avss.n3502 avss.n3500 5.2005
R14181 avss.n3521 avss.n3499 5.2005
R14182 avss.n3522 avss.n3497 5.2005
R14183 avss.n3523 avss.n3496 5.2005
R14184 avss.n3493 avss.n3492 5.2005
R14185 avss.n3528 avss.n3527 5.2005
R14186 avss.n3530 avss.n3489 5.2005
R14187 avss.n4024 avss.n3998 5.2005
R14188 avss.n4018 avss.n3999 5.2005
R14189 avss.n4020 avss.n4019 5.2005
R14190 avss.n4005 avss.n4001 5.2005
R14191 avss.n4014 avss.n4013 5.2005
R14192 avss.n4006 avss.n4004 5.2005
R14193 avss.n4009 avss.n4008 5.2005
R14194 avss.n622 avss.n621 5.2005
R14195 avss.n4116 avss.n4115 5.2005
R14196 avss.n4075 avss.n4074 5.2005
R14197 avss.n4109 avss.n4108 5.2005
R14198 avss.n4107 avss.n4106 5.2005
R14199 avss.n4105 avss.n4104 5.2005
R14200 avss.n4098 avss.n4077 5.2005
R14201 avss.n4100 avss.n4099 5.2005
R14202 avss.n4097 avss.n4096 5.2005
R14203 avss.n4125 avss.n4124 5.2005
R14204 avss.n4124 avss.n4123 5.2005
R14205 avss.n4126 avss.n4068 5.2005
R14206 avss.n4127 avss.n4067 5.2005
R14207 avss.n4120 avss.n4065 5.2005
R14208 avss.n4131 avss.n4064 5.2005
R14209 avss.n4132 avss.n4063 5.2005
R14210 avss.n4133 avss.n4062 5.2005
R14211 avss.n4061 avss.n4059 5.2005
R14212 avss.n4138 avss.n4137 5.2005
R14213 avss.n4159 avss.n4043 5.2005
R14214 avss.n4159 avss.n4158 5.2005
R14215 avss.n4052 avss.n4045 5.2005
R14216 avss.n4156 avss.n4155 5.2005
R14217 avss.n4051 avss.n4050 5.2005
R14218 avss.n4149 avss.n4148 5.2005
R14219 avss.n4147 avss.n4146 5.2005
R14220 avss.n4145 avss.n4056 5.2005
R14221 avss.n4055 avss.n4054 5.2005
R14222 avss.n4141 avss.n4140 5.2005
R14223 avss.n3626 avss.n628 5.2005
R14224 avss.n7210 avss.n628 5.2005
R14225 avss.n3625 avss.n3624 5.2005
R14226 avss.n3624 avss.n613 5.2005
R14227 avss.n3623 avss.n614 5.2005
R14228 avss.n7216 avss.n614 5.2005
R14229 avss.n3585 avss.n3584 5.2005
R14230 avss.n3584 avss.n600 5.2005
R14231 avss.n3619 avss.n601 5.2005
R14232 avss.n7222 avss.n601 5.2005
R14233 avss.n3610 avss.n626 5.2005
R14234 avss.n7210 avss.n626 5.2005
R14235 avss.n3612 avss.n3611 5.2005
R14236 avss.n3611 avss.n613 5.2005
R14237 avss.n3613 avss.n612 5.2005
R14238 avss.n7216 avss.n612 5.2005
R14239 avss.n3614 avss.n3587 5.2005
R14240 avss.n3587 avss.n600 5.2005
R14241 avss.n3615 avss.n599 5.2005
R14242 avss.n7222 avss.n599 5.2005
R14243 avss.n5309 avss.n575 5.2005
R14244 avss.n7242 avss.n575 5.2005
R14245 avss.n5311 avss.n5310 5.2005
R14246 avss.n5310 avss.n572 5.2005
R14247 avss.n5312 avss.n590 5.2005
R14248 avss.n7231 avss.n590 5.2005
R14249 avss.n5314 avss.n5313 5.2005
R14250 avss.n5313 avss.n586 5.2005
R14251 avss.n5315 avss.n5301 5.2005
R14252 avss.n5301 avss.n5237 5.2005
R14253 avss.n5317 avss.n5316 5.2005
R14254 avss.n5318 avss.n5317 5.2005
R14255 avss.n5151 avss.n5150 5.2005
R14256 avss.n5165 avss.n5151 5.2005
R14257 avss.n5326 avss.n5325 5.2005
R14258 avss.n5325 avss.n5324 5.2005
R14259 avss.n5327 avss.n5145 5.2005
R14260 avss.n5145 avss.n5142 5.2005
R14261 avss.n5329 avss.n5328 5.2005
R14262 avss.n5330 avss.n5329 5.2005
R14263 avss.n5146 avss.n5144 5.2005
R14264 avss.n5144 avss.n5125 5.2005
R14265 avss.n5206 avss.n5127 5.2005
R14266 avss.n5336 avss.n5127 5.2005
R14267 avss.n5208 avss.n5207 5.2005
R14268 avss.n5208 avss.n5122 5.2005
R14269 avss.n5210 avss.n5209 5.2005
R14270 avss.n5209 avss.n5112 5.2005
R14271 avss.n7244 avss.n7243 5.2005
R14272 avss.n7243 avss.n7242 5.2005
R14273 avss.n570 avss.n569 5.2005
R14274 avss.n572 avss.n570 5.2005
R14275 avss.n5233 avss.n588 5.2005
R14276 avss.n7231 avss.n588 5.2005
R14277 avss.n5234 avss.n5195 5.2005
R14278 avss.n5195 avss.n586 5.2005
R14279 avss.n5236 avss.n5235 5.2005
R14280 avss.n5237 avss.n5236 5.2005
R14281 avss.n5196 avss.n5167 5.2005
R14282 avss.n5318 avss.n5167 5.2005
R14283 avss.n5227 avss.n5226 5.2005
R14284 avss.n5226 avss.n5165 5.2005
R14285 avss.n5225 avss.n5153 5.2005
R14286 avss.n5324 avss.n5153 5.2005
R14287 avss.n5224 avss.n5223 5.2005
R14288 avss.n5223 avss.n5142 5.2005
R14289 avss.n5198 avss.n5140 5.2005
R14290 avss.n5330 avss.n5140 5.2005
R14291 avss.n5219 avss.n5218 5.2005
R14292 avss.n5218 avss.n5125 5.2005
R14293 avss.n5217 avss.n5123 5.2005
R14294 avss.n5336 avss.n5123 5.2005
R14295 avss.n5216 avss.n5202 5.2005
R14296 avss.n5202 avss.n5122 5.2005
R14297 avss.n5201 avss.n5200 5.2005
R14298 avss.n5201 avss.n5112 5.2005
R14299 avss.n7212 avss.n7211 5.2005
R14300 avss.n7211 avss.n7210 5.2005
R14301 avss.n7213 avss.n616 5.2005
R14302 avss.n616 avss.n613 5.2005
R14303 avss.n7215 avss.n7214 5.2005
R14304 avss.n7216 avss.n7215 5.2005
R14305 avss.n617 avss.n615 5.2005
R14306 avss.n615 avss.n600 5.2005
R14307 avss.n4083 avss.n602 5.2005
R14308 avss.n7222 avss.n602 5.2005
R14309 avss.n4095 avss.n625 5.2005
R14310 avss.n7210 avss.n625 5.2005
R14311 avss.n4080 avss.n4079 5.2005
R14312 avss.n4079 avss.n613 5.2005
R14313 avss.n4091 avss.n611 5.2005
R14314 avss.n7216 avss.n611 5.2005
R14315 avss.n4090 avss.n4089 5.2005
R14316 avss.n4089 avss.n600 5.2005
R14317 avss.n4088 avss.n598 5.2005
R14318 avss.n7222 avss.n598 5.2005
R14319 avss.n7227 avss.n573 5.2005
R14320 avss.n7242 avss.n573 5.2005
R14321 avss.n7228 avss.n592 5.2005
R14322 avss.n592 avss.n572 5.2005
R14323 avss.n7230 avss.n7229 5.2005
R14324 avss.n7231 avss.n7230 5.2005
R14325 avss.n593 avss.n591 5.2005
R14326 avss.n591 avss.n586 5.2005
R14327 avss.n5164 avss.n5163 5.2005
R14328 avss.n5237 avss.n5164 5.2005
R14329 avss.n5320 avss.n5319 5.2005
R14330 avss.n5319 avss.n5318 5.2005
R14331 avss.n5321 avss.n5156 5.2005
R14332 avss.n5165 avss.n5156 5.2005
R14333 avss.n5323 avss.n5322 5.2005
R14334 avss.n5324 avss.n5323 5.2005
R14335 avss.n5138 avss.n5137 5.2005
R14336 avss.n5142 avss.n5138 5.2005
R14337 avss.n5332 avss.n5331 5.2005
R14338 avss.n5331 avss.n5330 5.2005
R14339 avss.n5333 avss.n5129 5.2005
R14340 avss.n5129 avss.n5125 5.2005
R14341 avss.n5335 avss.n5334 5.2005
R14342 avss.n5336 avss.n5335 5.2005
R14343 avss.n5130 avss.n5128 5.2005
R14344 avss.n5128 avss.n5122 5.2005
R14345 avss.n5131 avss.n5114 5.2005
R14346 avss.n5114 avss.n5112 5.2005
R14347 avss.n5188 avss.n574 5.2005
R14348 avss.n7242 avss.n574 5.2005
R14349 avss.n5190 avss.n5189 5.2005
R14350 avss.n5189 avss.n572 5.2005
R14351 avss.n5191 avss.n587 5.2005
R14352 avss.n7231 avss.n587 5.2005
R14353 avss.n5192 avss.n5169 5.2005
R14354 avss.n5169 avss.n586 5.2005
R14355 avss.n5194 avss.n5193 5.2005
R14356 avss.n5237 avss.n5194 5.2005
R14357 avss.n5170 avss.n5166 5.2005
R14358 avss.n5318 avss.n5166 5.2005
R14359 avss.n5180 avss.n5179 5.2005
R14360 avss.n5179 avss.n5165 5.2005
R14361 avss.n5178 avss.n5152 5.2005
R14362 avss.n5324 avss.n5152 5.2005
R14363 avss.n5177 avss.n5176 5.2005
R14364 avss.n5176 avss.n5142 5.2005
R14365 avss.n5172 avss.n5139 5.2005
R14366 avss.n5330 avss.n5139 5.2005
R14367 avss.n5121 avss.n5120 5.2005
R14368 avss.n5125 avss.n5121 5.2005
R14369 avss.n5338 avss.n5337 5.2005
R14370 avss.n5337 avss.n5336 5.2005
R14371 avss.n5339 avss.n5118 5.2005
R14372 avss.n5122 avss.n5118 5.2005
R14373 avss.n5340 avss.n5115 5.2005
R14374 avss.n5115 avss.n5112 5.2005
R14375 avss.n7209 avss.n7208 5.2005
R14376 avss.n7210 avss.n7209 5.2005
R14377 avss.n609 avss.n608 5.2005
R14378 avss.n613 avss.n609 5.2005
R14379 avss.n7218 avss.n7217 5.2005
R14380 avss.n7217 avss.n7216 5.2005
R14381 avss.n7219 avss.n604 5.2005
R14382 avss.n604 avss.n600 5.2005
R14383 avss.n7221 avss.n7220 5.2005
R14384 avss.n7222 avss.n7221 5.2005
R14385 avss.n3454 avss.n624 5.2005
R14386 avss.n7210 avss.n624 5.2005
R14387 avss.n3443 avss.n3442 5.2005
R14388 avss.n3442 avss.n613 5.2005
R14389 avss.n3450 avss.n610 5.2005
R14390 avss.n7216 avss.n610 5.2005
R14391 avss.n3449 avss.n3448 5.2005
R14392 avss.n3448 avss.n600 5.2005
R14393 avss.n3447 avss.n597 5.2005
R14394 avss.n7222 avss.n597 5.2005
R14395 avss.n7241 avss.n7240 5.2005
R14396 avss.n7242 avss.n7241 5.2005
R14397 avss.n580 avss.n578 5.2005
R14398 avss.n578 avss.n572 5.2005
R14399 avss.n5294 avss.n589 5.2005
R14400 avss.n7231 avss.n589 5.2005
R14401 avss.n5295 avss.n5293 5.2005
R14402 avss.n5293 avss.n586 5.2005
R14403 avss.n5241 avss.n5239 5.2005
R14404 avss.n5239 avss.n5237 5.2005
R14405 avss.n5300 avss.n5299 5.2005
R14406 avss.n5318 avss.n5300 5.2005
R14407 avss.n5240 avss.n5238 5.2005
R14408 avss.n5238 avss.n5165 5.2005
R14409 avss.n5289 avss.n5155 5.2005
R14410 avss.n5324 avss.n5155 5.2005
R14411 avss.n5288 avss.n5287 5.2005
R14412 avss.n5287 avss.n5142 5.2005
R14413 avss.n5286 avss.n5143 5.2005
R14414 avss.n5330 avss.n5143 5.2005
R14415 avss.n5244 avss.n5243 5.2005
R14416 avss.n5243 avss.n5125 5.2005
R14417 avss.n5282 avss.n5126 5.2005
R14418 avss.n5336 avss.n5126 5.2005
R14419 avss.n5281 avss.n5280 5.2005
R14420 avss.n5280 avss.n5122 5.2005
R14421 avss.n5279 avss.n5278 5.2005
R14422 avss.n5279 avss.n5112 5.2005
R14423 avss.n7235 avss.n576 5.2005
R14424 avss.n7242 avss.n576 5.2005
R14425 avss.n7234 avss.n7233 5.2005
R14426 avss.n7233 avss.n572 5.2005
R14427 avss.n7232 avss.n584 5.2005
R14428 avss.n7232 avss.n7231 5.2005
R14429 avss.n5259 avss.n585 5.2005
R14430 avss.n586 avss.n585 5.2005
R14431 avss.n5260 avss.n5256 5.2005
R14432 avss.n5256 avss.n5237 5.2005
R14433 avss.n5261 avss.n5168 5.2005
R14434 avss.n5318 avss.n5168 5.2005
R14435 avss.n5254 avss.n5253 5.2005
R14436 avss.n5253 avss.n5165 5.2005
R14437 avss.n5265 avss.n5154 5.2005
R14438 avss.n5324 avss.n5154 5.2005
R14439 avss.n5266 avss.n5252 5.2005
R14440 avss.n5252 avss.n5142 5.2005
R14441 avss.n5267 avss.n5141 5.2005
R14442 avss.n5330 avss.n5141 5.2005
R14443 avss.n5250 avss.n5249 5.2005
R14444 avss.n5249 avss.n5125 5.2005
R14445 avss.n5271 avss.n5124 5.2005
R14446 avss.n5336 avss.n5124 5.2005
R14447 avss.n5272 avss.n5248 5.2005
R14448 avss.n5248 avss.n5122 5.2005
R14449 avss.n5273 avss.n5247 5.2005
R14450 avss.n5247 avss.n5112 5.2005
R14451 avss.n3430 avss.n3429 5.2005
R14452 avss.n4590 avss.n4589 5.2005
R14453 avss.n3433 avss.n3432 5.2005
R14454 avss.n4577 avss.n4576 5.2005
R14455 avss.n4579 avss.n4578 5.2005
R14456 avss.n4581 avss.n4580 5.2005
R14457 avss.n4583 avss.n4582 5.2005
R14458 avss.n4584 avss.n4538 5.2005
R14459 avss.n4586 avss.n4585 5.2005
R14460 avss.n4587 avss.n4586 5.2005
R14461 avss.n3426 avss.n3425 5.2005
R14462 avss.n4554 avss.n4553 5.2005
R14463 avss.n4556 avss.n4555 5.2005
R14464 avss.n4558 avss.n4557 5.2005
R14465 avss.n4560 avss.n4559 5.2005
R14466 avss.n4561 avss.n4546 5.2005
R14467 avss.n4563 avss.n4562 5.2005
R14468 avss.n4541 avss.n4540 5.2005
R14469 avss.n4567 avss.n4566 5.2005
R14470 avss.n4566 avss.n4565 5.2005
R14471 avss.n3646 avss.n3574 5.2005
R14472 avss.n3640 avss.n3575 5.2005
R14473 avss.n3642 avss.n3641 5.2005
R14474 avss.n3579 avss.n3578 5.2005
R14475 avss.n3635 avss.n3634 5.2005
R14476 avss.n3633 avss.n3632 5.2005
R14477 avss.n3631 avss.n3630 5.2005
R14478 avss.n3582 avss.n3581 5.2005
R14479 avss.n4531 avss.n4530 5.2005
R14480 avss.n3560 avss.n3558 5.2005
R14481 avss.n3599 avss.n3598 5.2005
R14482 avss.n3601 avss.n3600 5.2005
R14483 avss.n3603 avss.n3602 5.2005
R14484 avss.n3605 avss.n3604 5.2005
R14485 avss.n3607 avss.n3606 5.2005
R14486 avss.n3609 avss.n3608 5.2005
R14487 avss.n4611 avss.n4610 5.2005
R14488 avss.n4612 avss.n4611 5.2005
R14489 avss.n3417 avss.n3416 5.2005
R14490 avss.n3416 avss.n3414 5.2005
R14491 avss.n4606 avss.n4605 5.2005
R14492 avss.n4605 avss.n4604 5.2005
R14493 avss.n3420 avss.n3419 5.2005
R14494 avss.n3421 avss.n3420 5.2005
R14495 avss.n4595 avss.n4594 5.2005
R14496 avss.n4596 avss.n4595 5.2005
R14497 avss.n4614 avss.n4613 5.2005
R14498 avss.n4613 avss.n4612 5.2005
R14499 avss.n3412 avss.n3411 5.2005
R14500 avss.n3414 avss.n3412 5.2005
R14501 avss.n4603 avss.n4602 5.2005
R14502 avss.n4604 avss.n4603 5.2005
R14503 avss.n3423 avss.n3422 5.2005
R14504 avss.n3422 avss.n3421 5.2005
R14505 avss.n4598 avss.n4597 5.2005
R14506 avss.n4597 avss.n4596 5.2005
R14507 avss.n3832 avss.n3831 5.2005
R14508 avss.n3833 avss.n3832 5.2005
R14509 avss.n3770 avss.n3768 5.2005
R14510 avss.n3768 avss.n3765 5.2005
R14511 avss.n3813 avss.n3812 5.2005
R14512 avss.n3814 avss.n3813 5.2005
R14513 avss.n3783 avss.n3782 5.2005
R14514 avss.n3782 avss.n3689 5.2005
R14515 avss.n3807 avss.n3806 5.2005
R14516 avss.n3806 avss.n3805 5.2005
R14517 avss.n3787 avss.n3786 5.2005
R14518 avss.n3789 avss.n3787 5.2005
R14519 avss.n3676 avss.n3675 5.2005
R14520 avss.n3679 avss.n3676 5.2005
R14521 avss.n4501 avss.n4500 5.2005
R14522 avss.n4500 avss.n4499 5.2005
R14523 avss.n4502 avss.n3668 5.2005
R14524 avss.n3677 avss.n3668 5.2005
R14525 avss.n4504 avss.n4503 5.2005
R14526 avss.n4505 avss.n4504 5.2005
R14527 avss.n3670 avss.n3667 5.2005
R14528 avss.n3667 avss.n3665 5.2005
R14529 avss.n3669 avss.n3657 5.2005
R14530 avss.n3684 avss.n3657 5.2005
R14531 avss.n3818 avss.n3766 5.2005
R14532 avss.n3833 avss.n3766 5.2005
R14533 avss.n3817 avss.n3816 5.2005
R14534 avss.n3816 avss.n3765 5.2005
R14535 avss.n3815 avss.n3779 5.2005
R14536 avss.n3815 avss.n3814 5.2005
R14537 avss.n3802 avss.n3780 5.2005
R14538 avss.n3780 avss.n3689 5.2005
R14539 avss.n3804 avss.n3803 5.2005
R14540 avss.n3805 avss.n3804 5.2005
R14541 avss.n3791 avss.n3790 5.2005
R14542 avss.n3790 avss.n3789 5.2005
R14543 avss.n3796 avss.n3795 5.2005
R14544 avss.n3795 avss.n3679 5.2005
R14545 avss.n3794 avss.n3678 5.2005
R14546 avss.n4499 avss.n3678 5.2005
R14547 avss.n3664 avss.n3663 5.2005
R14548 avss.n3677 avss.n3664 5.2005
R14549 avss.n4507 avss.n4506 5.2005
R14550 avss.n4506 avss.n4505 5.2005
R14551 avss.n4508 avss.n3661 5.2005
R14552 avss.n3665 avss.n3661 5.2005
R14553 avss.n4509 avss.n3658 5.2005
R14554 avss.n3684 avss.n3658 5.2005
R14555 avss.n3648 avss.n3647 5.2005
R14556 avss.n3647 avss.n3427 5.2005
R14557 avss.n4529 avss.n3559 5.2005
R14558 avss.n3559 avss.n3427 5.2005
R14559 avss.n3654 avss.n3653 5.2005
R14560 avss.n3656 avss.n3654 5.2005
R14561 avss.n4516 avss.n4515 5.2005
R14562 avss.n4515 avss.n4514 5.2005
R14563 avss.n3572 avss.n3570 5.2005
R14564 avss.n3570 avss.t157 5.2005
R14565 avss.n4521 avss.n4520 5.2005
R14566 avss.n4522 avss.n4521 5.2005
R14567 avss.n3571 avss.n3566 5.2005
R14568 avss.n4523 avss.n3566 5.2005
R14569 avss.n4493 avss.n4492 5.2005
R14570 avss.n4492 avss.n3656 5.2005
R14571 avss.n4491 avss.n3655 5.2005
R14572 avss.n4514 avss.n3655 5.2005
R14573 avss.n4490 avss.n4489 5.2005
R14574 avss.n4489 avss.t157 5.2005
R14575 avss.n4486 avss.n3567 5.2005
R14576 avss.n4522 avss.n3567 5.2005
R14577 avss.n4524 avss.n3568 5.2005
R14578 avss.n4524 avss.n4523 5.2005
R14579 avss.n4479 avss.n4478 5.2005
R14580 avss.n4480 avss.n4479 5.2005
R14581 avss.n3690 avss.n3680 5.2005
R14582 avss.n3788 avss.n3680 5.2005
R14583 avss.n4482 avss.n4481 5.2005
R14584 avss.n4481 avss.n4480 5.2005
R14585 avss.n4483 avss.n3681 5.2005
R14586 avss.n3788 avss.n3681 5.2005
R14587 avss.n4038 avss.n4037 5.2005
R14588 avss.n4178 avss.n4038 5.2005
R14589 avss.n4181 avss.n4180 5.2005
R14590 avss.n4180 avss.n4179 5.2005
R14591 avss.n4182 avss.n4032 5.2005
R14592 avss.n4032 avss.n4030 5.2005
R14593 avss.n4184 avss.n4183 5.2005
R14594 avss.n4185 avss.n4184 5.2005
R14595 avss.n4033 avss.n4031 5.2005
R14596 avss.n4161 avss.n4031 5.2005
R14597 avss.n4176 avss.n4175 5.2005
R14598 avss.n4178 avss.n4176 5.2005
R14599 avss.n4041 avss.n4039 5.2005
R14600 avss.n4179 avss.n4039 5.2005
R14601 avss.n4166 avss.n4165 5.2005
R14602 avss.n4165 avss.n4030 5.2005
R14603 avss.n4164 avss.n4029 5.2005
R14604 avss.n4185 avss.n4029 5.2005
R14605 avss.n4163 avss.n4162 5.2005
R14606 avss.n4162 avss.n4161 5.2005
R14607 avss.n3841 avss.n3839 5.2005
R14608 avss.n3839 avss.n3836 5.2005
R14609 avss.n4252 avss.n4251 5.2005
R14610 avss.n4253 avss.n4252 5.2005
R14611 avss.n3918 avss.n3917 5.2005
R14612 avss.n3917 avss.n3913 5.2005
R14613 avss.n4246 avss.n4245 5.2005
R14614 avss.n4245 avss.n4244 5.2005
R14615 avss.n3921 avss.n3920 5.2005
R14616 avss.n3938 avss.n3921 5.2005
R14617 avss.n4224 avss.n4223 5.2005
R14618 avss.n4225 avss.n4224 5.2005
R14619 avss.n3931 avss.n3930 5.2005
R14620 avss.n3930 avss.n3929 5.2005
R14621 avss.n4219 avss.n4218 5.2005
R14622 avss.n4218 avss.n4217 5.2005
R14623 avss.n3934 avss.n3933 5.2005
R14624 avss.n3935 avss.n3934 5.2005
R14625 avss.n3978 avss.n3977 5.2005
R14626 avss.n3977 avss.n3976 5.2005
R14627 avss.n3981 avss.n3958 5.2005
R14628 avss.n3960 avss.n3958 5.2005
R14629 avss.n3983 avss.n3982 5.2005
R14630 avss.n3984 avss.n3983 5.2005
R14631 avss.n4239 avss.n4238 5.2005
R14632 avss.n4238 avss.n3836 5.2005
R14633 avss.n4240 avss.n3914 5.2005
R14634 avss.n4253 avss.n3914 5.2005
R14635 avss.n4241 avss.n3924 5.2005
R14636 avss.n3924 avss.n3913 5.2005
R14637 avss.n4243 avss.n4242 5.2005
R14638 avss.n4244 avss.n4243 5.2005
R14639 avss.n3925 avss.n3923 5.2005
R14640 avss.n3938 avss.n3923 5.2005
R14641 avss.n4227 avss.n4226 5.2005
R14642 avss.n4226 avss.n4225 5.2005
R14643 avss.n3928 avss.n3927 5.2005
R14644 avss.n3929 avss.n3928 5.2005
R14645 avss.n3971 avss.n3936 5.2005
R14646 avss.n4217 avss.n3936 5.2005
R14647 avss.n3972 avss.n3962 5.2005
R14648 avss.n3962 avss.n3935 5.2005
R14649 avss.n3974 avss.n3973 5.2005
R14650 avss.n3976 avss.n3974 5.2005
R14651 avss.n3963 avss.n3961 5.2005
R14652 avss.n3961 avss.n3960 5.2005
R14653 avss.n3965 avss.n3955 5.2005
R14654 avss.n3984 avss.n3955 5.2005
R14655 avss.n4026 avss.n4025 5.2005
R14656 avss.n4160 avss.n4026 5.2005
R14657 avss.n4114 avss.n4027 5.2005
R14658 avss.n4160 avss.n4027 5.2005
R14659 avss.n4208 avss.n4207 5.2005
R14660 avss.n4209 avss.n4208 5.2005
R14661 avss.n3986 avss.n3985 5.2005
R14662 avss.n3991 avss.n3985 5.2005
R14663 avss.n4203 avss.n4202 5.2005
R14664 avss.n4202 avss.t144 5.2005
R14665 avss.n3989 avss.n3988 5.2005
R14666 avss.n3990 avss.n3989 5.2005
R14667 avss.n4193 avss.n4192 5.2005
R14668 avss.n4194 avss.n4193 5.2005
R14669 avss.n4211 avss.n4210 5.2005
R14670 avss.n4210 avss.n4209 5.2005
R14671 avss.n3953 avss.n3952 5.2005
R14672 avss.n3991 avss.n3953 5.2005
R14673 avss.n4201 avss.n4200 5.2005
R14674 avss.t144 avss.n4201 5.2005
R14675 avss.n3993 avss.n3992 5.2005
R14676 avss.n3992 avss.n3990 5.2005
R14677 avss.n4196 avss.n4195 5.2005
R14678 avss.n4195 avss.n4194 5.2005
R14679 avss.n3943 avss.n3911 5.2005
R14680 avss.n3922 avss.n3911 5.2005
R14681 avss.n3944 avss.n3937 5.2005
R14682 avss.n3939 avss.n3937 5.2005
R14683 avss.n3948 avss.n3912 5.2005
R14684 avss.n3922 avss.n3912 5.2005
R14685 avss.n3949 avss.n3940 5.2005
R14686 avss.n3940 avss.n3939 5.2005
R14687 avss.n696 avss.n695 5.2005
R14688 avss.n7144 avss.n696 5.2005
R14689 avss.n7147 avss.n7146 5.2005
R14690 avss.n7146 avss.n7145 5.2005
R14691 avss.n7148 avss.n690 5.2005
R14692 avss.n690 avss.n688 5.2005
R14693 avss.n7150 avss.n7149 5.2005
R14694 avss.n7151 avss.n7150 5.2005
R14695 avss.n691 avss.n689 5.2005
R14696 avss.n3513 avss.n689 5.2005
R14697 avss.n7142 avss.n7141 5.2005
R14698 avss.n7144 avss.n7142 5.2005
R14699 avss.n699 avss.n697 5.2005
R14700 avss.n7145 avss.n697 5.2005
R14701 avss.n3510 avss.n3509 5.2005
R14702 avss.n3509 avss.n688 5.2005
R14703 avss.n3511 avss.n687 5.2005
R14704 avss.n7151 avss.n687 5.2005
R14705 avss.n3515 avss.n3514 5.2005
R14706 avss.n3514 avss.n3513 5.2005
R14707 avss.n7126 avss.n7125 5.2005
R14708 avss.n7125 avss.n7124 5.2005
R14709 avss.n719 avss.n718 5.2005
R14710 avss.n770 avss.n719 5.2005
R14711 avss.n7116 avss.n7115 5.2005
R14712 avss.n7115 avss.n7114 5.2005
R14713 avss.n7117 avss.n726 5.2005
R14714 avss.n735 avss.n726 5.2005
R14715 avss.n7119 avss.n7118 5.2005
R14716 avss.n7120 avss.n7119 5.2005
R14717 avss.n727 avss.n725 5.2005
R14718 avss.n725 avss.n723 5.2005
R14719 avss.n729 avss.n728 5.2005
R14720 avss.n728 avss.n677 5.2005
R14721 avss.n673 avss.n671 5.2005
R14722 avss.n7169 avss.n673 5.2005
R14723 avss.n7172 avss.n7171 5.2005
R14724 avss.n7171 avss.n7170 5.2005
R14725 avss.n672 avss.n669 5.2005
R14726 avss.n749 avss.n672 5.2005
R14727 avss.n7176 avss.n667 5.2005
R14728 avss.n748 avss.n667 5.2005
R14729 avss.n7178 avss.n7177 5.2005
R14730 avss.n7179 avss.n7178 5.2005
R14731 avss.n767 avss.n721 5.2005
R14732 avss.n7124 avss.n721 5.2005
R14733 avss.n769 avss.n768 5.2005
R14734 avss.n770 avss.n769 5.2005
R14735 avss.n737 avss.n736 5.2005
R14736 avss.n7114 avss.n736 5.2005
R14737 avss.n762 avss.n761 5.2005
R14738 avss.n761 avss.n735 5.2005
R14739 avss.n760 avss.n724 5.2005
R14740 avss.n7120 avss.n724 5.2005
R14741 avss.n759 avss.n758 5.2005
R14742 avss.n758 avss.n723 5.2005
R14743 avss.n757 avss.n739 5.2005
R14744 avss.n757 avss.n677 5.2005
R14745 avss.n753 avss.n676 5.2005
R14746 avss.n7169 avss.n676 5.2005
R14747 avss.n752 avss.n675 5.2005
R14748 avss.n7170 avss.n675 5.2005
R14749 avss.n751 avss.n750 5.2005
R14750 avss.n750 avss.n749 5.2005
R14751 avss.n747 avss.n741 5.2005
R14752 avss.n748 avss.n747 5.2005
R14753 avss.n743 avss.n664 5.2005
R14754 avss.n7179 avss.n664 5.2005
R14755 avss.n7193 avss.n644 5.2005
R14756 avss.n3512 avss.n644 5.2005
R14757 avss.n3472 avss.n685 5.2005
R14758 avss.n3512 avss.n685 5.2005
R14759 avss.n7182 avss.n7181 5.2005
R14760 avss.n7181 avss.n7180 5.2005
R14761 avss.n7183 avss.n657 5.2005
R14762 avss.n657 avss.n655 5.2005
R14763 avss.n7185 avss.n7184 5.2005
R14764 avss.t126 avss.n7185 5.2005
R14765 avss.n651 avss.n649 5.2005
R14766 avss.n7186 avss.n651 5.2005
R14767 avss.n7189 avss.n7188 5.2005
R14768 avss.n7188 avss.n7187 5.2005
R14769 avss.n7163 avss.n663 5.2005
R14770 avss.n7180 avss.n663 5.2005
R14771 avss.n7162 avss.n7161 5.2005
R14772 avss.n7161 avss.n655 5.2005
R14773 avss.n7160 avss.n656 5.2005
R14774 avss.t126 avss.n656 5.2005
R14775 avss.n683 avss.n654 5.2005
R14776 avss.n7186 avss.n654 5.2005
R14777 avss.n7156 avss.n653 5.2005
R14778 avss.n7187 avss.n653 5.2005
R14779 avss.n788 avss.n771 5.2005
R14780 avss.n772 avss.n771 5.2005
R14781 avss.n787 avss.n678 5.2005
R14782 avss.n7121 avss.n678 5.2005
R14783 avss.n776 avss.n773 5.2005
R14784 avss.n773 avss.n772 5.2005
R14785 avss.n775 avss.n679 5.2005
R14786 avss.n7121 avss.n679 5.2005
R14787 avss.n7131 avss.n7130 5.2005
R14788 avss.n7132 avss.n7131 5.2005
R14789 avss.n716 avss.n715 5.2005
R14790 avss.n7122 avss.n715 5.2005
R14791 avss.n7134 avss.n7133 5.2005
R14792 avss.n7133 avss.n7132 5.2005
R14793 avss.n711 avss.n710 5.2005
R14794 avss.n7122 avss.n711 5.2005
R14795 avss.n7079 avss.n825 5.2005
R14796 avss.n830 avss.n825 5.2005
R14797 avss.n7081 avss.n7080 5.2005
R14798 avss.n7082 avss.n7081 5.2005
R14799 avss.n826 avss.n824 5.2005
R14800 avss.n824 avss.n821 5.2005
R14801 avss.n878 avss.n877 5.2005
R14802 avss.n879 avss.n878 5.2005
R14803 avss.n856 avss.n855 5.2005
R14804 avss.n872 avss.n856 5.2005
R14805 avss.n887 avss.n886 5.2005
R14806 avss.n886 avss.n885 5.2005
R14807 avss.n888 avss.n850 5.2005
R14808 avss.n857 avss.n850 5.2005
R14809 avss.n890 avss.n889 5.2005
R14810 avss.n891 avss.n890 5.2005
R14811 avss.n809 avss.n808 5.2005
R14812 avss.n813 avss.n809 5.2005
R14813 avss.n7094 avss.n7093 5.2005
R14814 avss.n7093 avss.n7092 5.2005
R14815 avss.n7095 avss.n803 5.2005
R14816 avss.n803 avss.n801 5.2005
R14817 avss.n7097 avss.n7096 5.2005
R14818 avss.n7098 avss.n7097 5.2005
R14819 avss.n804 avss.n802 5.2005
R14820 avss.n802 avss.n799 5.2005
R14821 avss.n906 avss.n905 5.2005
R14822 avss.n907 avss.n906 5.2005
R14823 avss.n868 avss.n829 5.2005
R14824 avss.n830 avss.n829 5.2005
R14825 avss.n869 avss.n823 5.2005
R14826 avss.n7082 avss.n823 5.2005
R14827 avss.n871 avss.n870 5.2005
R14828 avss.n871 avss.n821 5.2005
R14829 avss.n881 avss.n880 5.2005
R14830 avss.n880 avss.n879 5.2005
R14831 avss.n882 avss.n858 5.2005
R14832 avss.n872 avss.n858 5.2005
R14833 avss.n884 avss.n883 5.2005
R14834 avss.n885 avss.n884 5.2005
R14835 avss.n859 avss.n848 5.2005
R14836 avss.n857 avss.n848 5.2005
R14837 avss.n892 avss.n847 5.2005
R14838 avss.n892 avss.n891 5.2005
R14839 avss.n894 avss.n893 5.2005
R14840 avss.n893 avss.n813 5.2005
R14841 avss.n895 avss.n811 5.2005
R14842 avss.n7092 avss.n811 5.2005
R14843 avss.n897 avss.n896 5.2005
R14844 avss.n896 avss.n801 5.2005
R14845 avss.n898 avss.n800 5.2005
R14846 avss.n7098 avss.n800 5.2005
R14847 avss.n899 avss.n842 5.2005
R14848 avss.n842 avss.n799 5.2005
R14849 avss.n900 avss.n839 5.2005
R14850 avss.n907 avss.n839 5.2005
R14851 avss.n7106 avss.n7105 5.2005
R14852 avss.n7107 avss.n7106 5.2005
R14853 avss.n785 avss.n779 5.2005
R14854 avss.n7108 avss.n779 5.2005
R14855 avss.n794 avss.n780 5.2005
R14856 avss.n7107 avss.n780 5.2005
R14857 avss.n7109 avss.n781 5.2005
R14858 avss.n7109 avss.n7108 5.2005
R14859 avss.n7090 avss.n7089 5.2005
R14860 avss.n7091 avss.n7090 5.2005
R14861 avss.n815 avss.n797 5.2005
R14862 avss.n810 avss.n797 5.2005
R14863 avss.n7064 avss.n812 5.2005
R14864 avss.n7091 avss.n812 5.2005
R14865 avss.n7063 avss.n798 5.2005
R14866 avss.n810 avss.n798 5.2005
R14867 avss.n820 avss.n818 5.2005
R14868 avss.n7070 avss.n820 5.2005
R14869 avss.n7085 avss.n7084 5.2005
R14870 avss.n7084 avss.n7083 5.2005
R14871 avss.n7071 avss.n7069 5.2005
R14872 avss.n7071 avss.n7070 5.2005
R14873 avss.n7061 avss.n822 5.2005
R14874 avss.n7083 avss.n822 5.2005
R14875 avss.n4369 avss.n3840 5.2005
R14876 avss.n3845 avss.n3840 5.2005
R14877 avss.n4371 avss.n4370 5.2005
R14878 avss.n4372 avss.n4371 5.2005
R14879 avss.n4236 avss.n3844 5.2005
R14880 avss.n3845 avss.n3844 5.2005
R14881 avss.n4237 avss.n3837 5.2005
R14882 avss.n4372 avss.n3837 5.2005
R14883 avss.n4335 avss.n3882 5.2005
R14884 avss.n4329 avss.n3882 5.2005
R14885 avss.n4337 avss.n4336 5.2005
R14886 avss.n4338 avss.n4337 5.2005
R14887 avss.n3883 avss.n3881 5.2005
R14888 avss.n3881 avss.n3878 5.2005
R14889 avss.n4307 avss.n4306 5.2005
R14890 avss.n4308 avss.n4307 5.2005
R14891 avss.n3894 avss.n3893 5.2005
R14892 avss.n3893 avss.n3891 5.2005
R14893 avss.n4301 avss.n4300 5.2005
R14894 avss.n4300 avss.n4299 5.2005
R14895 avss.n3897 avss.n3896 5.2005
R14896 avss.n3898 avss.n3897 5.2005
R14897 avss.n4287 avss.n4286 5.2005
R14898 avss.n4288 avss.n4287 5.2005
R14899 avss.n3866 avss.n3865 5.2005
R14900 avss.n3870 avss.n3866 5.2005
R14901 avss.n4350 avss.n4349 5.2005
R14902 avss.n4349 avss.n4348 5.2005
R14903 avss.n4351 avss.n3860 5.2005
R14904 avss.n3860 avss.n3858 5.2005
R14905 avss.n4353 avss.n4352 5.2005
R14906 avss.n4354 avss.n4353 5.2005
R14907 avss.n3861 avss.n3859 5.2005
R14908 avss.n3859 avss.n3856 5.2005
R14909 avss.n4271 avss.n4270 5.2005
R14910 avss.n4272 avss.n4271 5.2005
R14911 avss.n4330 avss.n4315 5.2005
R14912 avss.n4330 avss.n4329 5.2005
R14913 avss.n3887 avss.n3880 5.2005
R14914 avss.n4338 avss.n3880 5.2005
R14915 avss.n4311 avss.n4310 5.2005
R14916 avss.n4310 avss.n3878 5.2005
R14917 avss.n4309 avss.n3889 5.2005
R14918 avss.n4309 avss.n4308 5.2005
R14919 avss.n4295 avss.n3890 5.2005
R14920 avss.n3891 avss.n3890 5.2005
R14921 avss.n4297 avss.n4296 5.2005
R14922 avss.n4299 avss.n4297 5.2005
R14923 avss.n3900 avss.n3899 5.2005
R14924 avss.n3899 avss.n3898 5.2005
R14925 avss.n4290 avss.n4289 5.2005
R14926 avss.n4289 avss.n4288 5.2005
R14927 avss.n4282 avss.n4281 5.2005
R14928 avss.n4282 avss.n3870 5.2005
R14929 avss.n4280 avss.n3868 5.2005
R14930 avss.n4348 avss.n3868 5.2005
R14931 avss.n3903 avss.n3902 5.2005
R14932 avss.n3902 avss.n3858 5.2005
R14933 avss.n4276 avss.n3857 5.2005
R14934 avss.n4354 avss.n3857 5.2005
R14935 avss.n4275 avss.n4274 5.2005
R14936 avss.n4274 avss.n3856 5.2005
R14937 avss.n4273 avss.n3905 5.2005
R14938 avss.n4273 avss.n4272 5.2005
R14939 avss.n4361 avss.n3849 5.2005
R14940 avss.n4262 avss.n3849 5.2005
R14941 avss.n4363 avss.n4362 5.2005
R14942 avss.n4364 avss.n4363 5.2005
R14943 avss.n4261 avss.n4260 5.2005
R14944 avss.n4262 avss.n4261 5.2005
R14945 avss.n3908 avss.n3847 5.2005
R14946 avss.n4364 avss.n3847 5.2005
R14947 avss.n4346 avss.n4345 5.2005
R14948 avss.n4347 avss.n4346 5.2005
R14949 avss.n3872 avss.n3854 5.2005
R14950 avss.n3867 avss.n3854 5.2005
R14951 avss.n4321 avss.n3869 5.2005
R14952 avss.n4347 avss.n3869 5.2005
R14953 avss.n4320 avss.n3855 5.2005
R14954 avss.n3867 avss.n3855 5.2005
R14955 avss.n3877 avss.n3875 5.2005
R14956 avss.n4328 avss.n3877 5.2005
R14957 avss.n4341 avss.n4340 5.2005
R14958 avss.n4340 avss.n4339 5.2005
R14959 avss.n4327 avss.n4326 5.2005
R14960 avss.n4328 avss.n4327 5.2005
R14961 avss.n4318 avss.n3879 5.2005
R14962 avss.n4339 avss.n3879 5.2005
R14963 avss.n3829 avss.n3828 5.2005
R14964 avss.n3828 avss.n3827 5.2005
R14965 avss.n3830 avss.n3769 5.2005
R14966 avss.n3775 avss.n3769 5.2005
R14967 avss.n3825 avss.n3824 5.2005
R14968 avss.n3827 avss.n3825 5.2005
R14969 avss.n3777 avss.n3776 5.2005
R14970 avss.n3776 avss.n3775 5.2005
R14971 avss.n4446 avss.n3739 5.2005
R14972 avss.n4440 avss.n3739 5.2005
R14973 avss.n4448 avss.n4447 5.2005
R14974 avss.n4449 avss.n4448 5.2005
R14975 avss.n3740 avss.n3738 5.2005
R14976 avss.n3738 avss.n3735 5.2005
R14977 avss.n4418 avss.n4417 5.2005
R14978 avss.n4419 avss.n4418 5.2005
R14979 avss.n3751 avss.n3750 5.2005
R14980 avss.n3750 avss.n3748 5.2005
R14981 avss.n4412 avss.n4411 5.2005
R14982 avss.n4411 avss.n4410 5.2005
R14983 avss.n3754 avss.n3753 5.2005
R14984 avss.n3755 avss.n3754 5.2005
R14985 avss.n4398 avss.n4397 5.2005
R14986 avss.n4399 avss.n4398 5.2005
R14987 avss.n3721 avss.n3720 5.2005
R14988 avss.n3725 avss.n3721 5.2005
R14989 avss.n4461 avss.n4460 5.2005
R14990 avss.n4460 avss.n4459 5.2005
R14991 avss.n4462 avss.n3715 5.2005
R14992 avss.n3715 avss.n3713 5.2005
R14993 avss.n4464 avss.n4463 5.2005
R14994 avss.n4465 avss.n4464 5.2005
R14995 avss.n3716 avss.n3714 5.2005
R14996 avss.n3714 avss.n3711 5.2005
R14997 avss.n4382 avss.n4381 5.2005
R14998 avss.n4383 avss.n4382 5.2005
R14999 avss.n4441 avss.n4426 5.2005
R15000 avss.n4441 avss.n4440 5.2005
R15001 avss.n3744 avss.n3737 5.2005
R15002 avss.n4449 avss.n3737 5.2005
R15003 avss.n4422 avss.n4421 5.2005
R15004 avss.n4421 avss.n3735 5.2005
R15005 avss.n4420 avss.n3746 5.2005
R15006 avss.n4420 avss.n4419 5.2005
R15007 avss.n4406 avss.n3747 5.2005
R15008 avss.n3748 avss.n3747 5.2005
R15009 avss.n4408 avss.n4407 5.2005
R15010 avss.n4410 avss.n4408 5.2005
R15011 avss.n3757 avss.n3756 5.2005
R15012 avss.n3756 avss.n3755 5.2005
R15013 avss.n4401 avss.n4400 5.2005
R15014 avss.n4400 avss.n4399 5.2005
R15015 avss.n4393 avss.n4392 5.2005
R15016 avss.n4393 avss.n3725 5.2005
R15017 avss.n4391 avss.n3723 5.2005
R15018 avss.n4459 avss.n3723 5.2005
R15019 avss.n3760 avss.n3759 5.2005
R15020 avss.n3759 avss.n3713 5.2005
R15021 avss.n4387 avss.n3712 5.2005
R15022 avss.n4465 avss.n3712 5.2005
R15023 avss.n4386 avss.n4385 5.2005
R15024 avss.n4385 avss.n3711 5.2005
R15025 avss.n4384 avss.n3762 5.2005
R15026 avss.n4384 avss.n4383 5.2005
R15027 avss.n3696 avss.n3694 5.2005
R15028 avss.n4471 avss.n3696 5.2005
R15029 avss.n4474 avss.n4473 5.2005
R15030 avss.n4473 avss.n4472 5.2005
R15031 avss.n3706 avss.n3699 5.2005
R15032 avss.n4471 avss.n3699 5.2005
R15033 avss.n3705 avss.n3698 5.2005
R15034 avss.n4472 avss.n3698 5.2005
R15035 avss.n4457 avss.n4456 5.2005
R15036 avss.n4458 avss.n4457 5.2005
R15037 avss.n3727 avss.n3709 5.2005
R15038 avss.n3722 avss.n3709 5.2005
R15039 avss.n4432 avss.n3724 5.2005
R15040 avss.n4458 avss.n3724 5.2005
R15041 avss.n4431 avss.n3710 5.2005
R15042 avss.n3722 avss.n3710 5.2005
R15043 avss.n3734 avss.n3732 5.2005
R15044 avss.n4439 avss.n3734 5.2005
R15045 avss.n4452 avss.n4451 5.2005
R15046 avss.n4451 avss.n4450 5.2005
R15047 avss.n4438 avss.n4437 5.2005
R15048 avss.n4439 avss.n4438 5.2005
R15049 avss.n4429 avss.n3736 5.2005
R15050 avss.n4450 avss.n3736 5.2005
R15051 avss.n1903 avss.n1752 5.2005
R15052 avss.n3315 avss.n1752 5.2005
R15053 avss.n1905 avss.n1904 5.2005
R15054 avss.n1904 avss.n1748 5.2005
R15055 avss.n1906 avss.n1764 5.2005
R15056 avss.n3304 avss.n1764 5.2005
R15057 avss.n1908 avss.n1907 5.2005
R15058 avss.n1907 avss.n1761 5.2005
R15059 avss.n1909 avss.n1775 5.2005
R15060 avss.n3296 avss.n1775 5.2005
R15061 avss.n1911 avss.n1910 5.2005
R15062 avss.n1910 avss.n1771 5.2005
R15063 avss.n1912 avss.n1791 5.2005
R15064 avss.n1980 avss.n1791 5.2005
R15065 avss.n1914 avss.n1913 5.2005
R15066 avss.n1913 avss.n1802 5.2005
R15067 avss.n1915 avss.n1803 5.2005
R15068 avss.n1972 avss.n1803 5.2005
R15069 avss.n1917 avss.n1916 5.2005
R15070 avss.n1916 avss.n1798 5.2005
R15071 avss.n1918 avss.n1814 5.2005
R15072 avss.n1959 avss.n1814 5.2005
R15073 avss.n1858 avss.n1856 5.2005
R15074 avss.n1856 avss.n1810 5.2005
R15075 avss.n1923 avss.n1922 5.2005
R15076 avss.n1951 avss.n1923 5.2005
R15077 avss.n1857 avss.n1855 5.2005
R15078 avss.n1855 avss.n1820 5.2005
R15079 avss.n3317 avss.n3316 5.2005
R15080 avss.n3316 avss.n3315 5.2005
R15081 avss.n1746 avss.n1745 5.2005
R15082 avss.n1748 avss.n1746 5.2005
R15083 avss.n1870 avss.n1763 5.2005
R15084 avss.n3304 avss.n1763 5.2005
R15085 avss.n1872 avss.n1871 5.2005
R15086 avss.n1871 avss.n1761 5.2005
R15087 avss.n1873 avss.n1774 5.2005
R15088 avss.n3296 avss.n1774 5.2005
R15089 avss.n1875 avss.n1874 5.2005
R15090 avss.n1874 avss.n1771 5.2005
R15091 avss.n1876 avss.n1790 5.2005
R15092 avss.n1980 avss.n1790 5.2005
R15093 avss.n1878 avss.n1877 5.2005
R15094 avss.n1877 avss.n1802 5.2005
R15095 avss.n1879 avss.n1801 5.2005
R15096 avss.n1972 avss.n1801 5.2005
R15097 avss.n1881 avss.n1880 5.2005
R15098 avss.n1880 avss.n1798 5.2005
R15099 avss.n1882 avss.n1813 5.2005
R15100 avss.n1959 avss.n1813 5.2005
R15101 avss.n1861 avss.n1860 5.2005
R15102 avss.n1860 avss.n1810 5.2005
R15103 avss.n1886 avss.n1854 5.2005
R15104 avss.n1951 avss.n1854 5.2005
R15105 avss.n1888 avss.n1887 5.2005
R15106 avss.n1888 avss.n1820 5.2005
R15107 avss.n2562 avss.n2561 5.2005
R15108 avss.n2561 avss.n2226 5.2005
R15109 avss.n2559 avss.n2013 5.2005
R15110 avss.n3275 avss.n2013 5.2005
R15111 avss.n2558 avss.n2557 5.2005
R15112 avss.n2557 avss.n2008 5.2005
R15113 avss.n2556 avss.n2510 5.2005
R15114 avss.n2556 avss.n1997 5.2005
R15115 avss.n2552 avss.n1998 5.2005
R15116 avss.n3284 avss.n1998 5.2005
R15117 avss.n2543 avss.n2542 5.2005
R15118 avss.n2542 avss.n2226 5.2005
R15119 avss.n2544 avss.n2011 5.2005
R15120 avss.n3275 avss.n2011 5.2005
R15121 avss.n2546 avss.n2545 5.2005
R15122 avss.n2545 avss.n2008 5.2005
R15123 avss.n2547 avss.n2512 5.2005
R15124 avss.n2512 avss.n1997 5.2005
R15125 avss.n2548 avss.n1996 5.2005
R15126 avss.n3284 avss.n1996 5.2005
R15127 avss.n3289 avss.n1753 5.2005
R15128 avss.n3315 avss.n1753 5.2005
R15129 avss.n3291 avss.n3290 5.2005
R15130 avss.n3290 avss.n1748 5.2005
R15131 avss.n3292 avss.n1765 5.2005
R15132 avss.n3304 avss.n1765 5.2005
R15133 avss.n3293 avss.n1777 5.2005
R15134 avss.n1777 avss.n1761 5.2005
R15135 avss.n3295 avss.n3294 5.2005
R15136 avss.n3296 avss.n3295 5.2005
R15137 avss.n1778 avss.n1776 5.2005
R15138 avss.n1776 avss.n1771 5.2005
R15139 avss.n1968 avss.n1792 5.2005
R15140 avss.n1980 avss.n1792 5.2005
R15141 avss.n1969 avss.n1805 5.2005
R15142 avss.n1805 avss.n1802 5.2005
R15143 avss.n1971 avss.n1970 5.2005
R15144 avss.n1972 avss.n1971 5.2005
R15145 avss.n1806 avss.n1804 5.2005
R15146 avss.n1804 avss.n1798 5.2005
R15147 avss.n1961 avss.n1960 5.2005
R15148 avss.n1960 avss.n1959 5.2005
R15149 avss.n1809 avss.n1808 5.2005
R15150 avss.n1810 avss.n1809 5.2005
R15151 avss.n1950 avss.n1949 5.2005
R15152 avss.n1951 avss.n1950 5.2005
R15153 avss.n1925 avss.n1924 5.2005
R15154 avss.n1924 avss.n1820 5.2005
R15155 avss.n1991 avss.n1750 5.2005
R15156 avss.n3315 avss.n1750 5.2005
R15157 avss.n1990 avss.n1989 5.2005
R15158 avss.n1989 avss.n1748 5.2005
R15159 avss.n1988 avss.n1762 5.2005
R15160 avss.n3304 avss.n1762 5.2005
R15161 avss.n1785 avss.n1784 5.2005
R15162 avss.n1784 avss.n1761 5.2005
R15163 avss.n1984 avss.n1773 5.2005
R15164 avss.n3296 avss.n1773 5.2005
R15165 avss.n1983 avss.n1982 5.2005
R15166 avss.n1982 avss.n1771 5.2005
R15167 avss.n1981 avss.n1787 5.2005
R15168 avss.n1981 avss.n1980 5.2005
R15169 avss.n1933 avss.n1788 5.2005
R15170 avss.n1802 avss.n1788 5.2005
R15171 avss.n1934 avss.n1800 5.2005
R15172 avss.n1972 avss.n1800 5.2005
R15173 avss.n1936 avss.n1935 5.2005
R15174 avss.n1935 avss.n1798 5.2005
R15175 avss.n1937 avss.n1812 5.2005
R15176 avss.n1959 avss.n1812 5.2005
R15177 avss.n1928 avss.n1927 5.2005
R15178 avss.n1927 avss.n1810 5.2005
R15179 avss.n1941 avss.n1853 5.2005
R15180 avss.n1951 avss.n1853 5.2005
R15181 avss.n1943 avss.n1942 5.2005
R15182 avss.n1943 avss.n1820 5.2005
R15183 avss.n3272 avss.n2015 5.2005
R15184 avss.n2226 avss.n2015 5.2005
R15185 avss.n3274 avss.n3273 5.2005
R15186 avss.n3275 avss.n3274 5.2005
R15187 avss.n2016 avss.n2014 5.2005
R15188 avss.n2014 avss.n2008 5.2005
R15189 avss.n2158 avss.n2157 5.2005
R15190 avss.n2157 avss.n1997 5.2005
R15191 avss.n2159 avss.n1999 5.2005
R15192 avss.n3284 avss.n1999 5.2005
R15193 avss.n2225 avss.n2224 5.2005
R15194 avss.n2226 avss.n2225 5.2005
R15195 avss.n2153 avss.n2010 5.2005
R15196 avss.n3275 avss.n2010 5.2005
R15197 avss.n2168 avss.n2167 5.2005
R15198 avss.n2167 avss.n2008 5.2005
R15199 avss.n2166 avss.n2165 5.2005
R15200 avss.n2166 avss.n1997 5.2005
R15201 avss.n2164 avss.n1995 5.2005
R15202 avss.n3284 avss.n1995 5.2005
R15203 avss.n2007 avss.n2005 5.2005
R15204 avss.n2226 avss.n2007 5.2005
R15205 avss.n3277 avss.n3276 5.2005
R15206 avss.n3276 avss.n3275 5.2005
R15207 avss.n2006 avss.n2003 5.2005
R15208 avss.n2008 avss.n2006 5.2005
R15209 avss.n3281 avss.n2001 5.2005
R15210 avss.n2001 avss.n1997 5.2005
R15211 avss.n3283 avss.n3282 5.2005
R15212 avss.n3284 avss.n3283 5.2005
R15213 avss.n2827 avss.n2826 5.2005
R15214 avss.n2827 avss.n2226 5.2005
R15215 avss.n2814 avss.n2009 5.2005
R15216 avss.n3275 avss.n2009 5.2005
R15217 avss.n2822 avss.n2821 5.2005
R15218 avss.n2821 avss.n2008 5.2005
R15219 avss.n2820 avss.n2819 5.2005
R15220 avss.n2820 avss.n1997 5.2005
R15221 avss.n2818 avss.n1994 5.2005
R15222 avss.n3284 avss.n1994 5.2005
R15223 avss.n3314 avss.n3313 5.2005
R15224 avss.n3315 avss.n3314 5.2005
R15225 avss.n1756 avss.n1754 5.2005
R15226 avss.n1754 avss.n1748 5.2005
R15227 avss.n3303 avss.n3302 5.2005
R15228 avss.n3304 avss.n3303 5.2005
R15229 avss.n1767 avss.n1766 5.2005
R15230 avss.n1766 avss.n1761 5.2005
R15231 avss.n3298 avss.n3297 5.2005
R15232 avss.n3297 avss.n3296 5.2005
R15233 avss.n1770 avss.n1769 5.2005
R15234 avss.n1771 avss.n1770 5.2005
R15235 avss.n1979 avss.n1978 5.2005
R15236 avss.n1980 avss.n1979 5.2005
R15237 avss.n1794 avss.n1793 5.2005
R15238 avss.n1802 avss.n1793 5.2005
R15239 avss.n1974 avss.n1973 5.2005
R15240 avss.n1973 avss.n1972 5.2005
R15241 avss.n1797 avss.n1796 5.2005
R15242 avss.n1798 avss.n1797 5.2005
R15243 avss.n1958 avss.n1957 5.2005
R15244 avss.n1959 avss.n1958 5.2005
R15245 avss.n1816 avss.n1815 5.2005
R15246 avss.n1815 avss.n1810 5.2005
R15247 avss.n1953 avss.n1952 5.2005
R15248 avss.n1952 avss.n1951 5.2005
R15249 avss.n1819 avss.n1818 5.2005
R15250 avss.n1820 avss.n1819 5.2005
R15251 avss.n3308 avss.n1749 5.2005
R15252 avss.n3315 avss.n1749 5.2005
R15253 avss.n3307 avss.n3306 5.2005
R15254 avss.n3306 avss.n1748 5.2005
R15255 avss.n3305 avss.n1759 5.2005
R15256 avss.n3305 avss.n3304 5.2005
R15257 avss.n1835 avss.n1760 5.2005
R15258 avss.n1761 avss.n1760 5.2005
R15259 avss.n1839 avss.n1772 5.2005
R15260 avss.n3296 avss.n1772 5.2005
R15261 avss.n1840 avss.n1834 5.2005
R15262 avss.n1834 avss.n1771 5.2005
R15263 avss.n1841 avss.n1789 5.2005
R15264 avss.n1980 avss.n1789 5.2005
R15265 avss.n1832 avss.n1831 5.2005
R15266 avss.n1831 avss.n1802 5.2005
R15267 avss.n1845 avss.n1799 5.2005
R15268 avss.n1972 avss.n1799 5.2005
R15269 avss.n1846 avss.n1830 5.2005
R15270 avss.n1830 avss.n1798 5.2005
R15271 avss.n1847 avss.n1811 5.2005
R15272 avss.n1959 avss.n1811 5.2005
R15273 avss.n1824 avss.n1822 5.2005
R15274 avss.n1822 avss.n1810 5.2005
R15275 avss.n1852 avss.n1851 5.2005
R15276 avss.n1951 avss.n1852 5.2005
R15277 avss.n1823 avss.n1821 5.2005
R15278 avss.n1821 avss.n1820 5.2005
R15279 avss.n4689 avss.n4688 5.2005
R15280 avss.n4690 avss.n4689 5.2005
R15281 avss.n6213 avss.n6212 5.2005
R15282 avss.n6212 avss.n6211 5.2005
R15283 avss.n4686 avss.n4685 5.2005
R15284 avss.n4685 avss.n4684 5.2005
R15285 avss.n6218 avss.n6217 5.2005
R15286 avss.n6219 avss.n6218 5.2005
R15287 avss.n4677 avss.n4676 5.2005
R15288 avss.n4678 avss.n4677 5.2005
R15289 avss.n6229 avss.n6228 5.2005
R15290 avss.n6228 avss.n6227 5.2005
R15291 avss.n4674 avss.n4673 5.2005
R15292 avss.n4673 avss.n4671 5.2005
R15293 avss.n6234 avss.n6233 5.2005
R15294 avss.n6235 avss.n6234 5.2005
R15295 avss.n6237 avss.n6236 5.2005
R15296 avss.n6236 avss.n6235 5.2005
R15297 avss.n4669 avss.n4668 5.2005
R15298 avss.n4671 avss.n4669 5.2005
R15299 avss.n6226 avss.n6225 5.2005
R15300 avss.n6227 avss.n6226 5.2005
R15301 avss.n4680 avss.n4679 5.2005
R15302 avss.n4679 avss.n4678 5.2005
R15303 avss.n6221 avss.n6220 5.2005
R15304 avss.n6220 avss.n6219 5.2005
R15305 avss.n4683 avss.n4682 5.2005
R15306 avss.n4684 avss.n4683 5.2005
R15307 avss.n5347 avss.n4691 5.2005
R15308 avss.n6211 avss.n4691 5.2005
R15309 avss.n5348 avss.n5345 5.2005
R15310 avss.n5345 avss.n4690 5.2005
R15311 avss.n5406 avss.n4810 5.2005
R15312 avss.n5076 avss.n4810 5.2005
R15313 avss.n5408 avss.n5407 5.2005
R15314 avss.n5409 avss.n5408 5.2005
R15315 avss.n5078 avss.n5077 5.2005
R15316 avss.n5077 avss.n5075 5.2005
R15317 avss.n5402 avss.n5401 5.2005
R15318 avss.n5401 avss.n5400 5.2005
R15319 avss.n5081 avss.n5080 5.2005
R15320 avss.n5082 avss.n5081 5.2005
R15321 avss.n5390 avss.n5389 5.2005
R15322 avss.n5391 avss.n5390 5.2005
R15323 avss.n5090 avss.n5089 5.2005
R15324 avss.n5089 avss.n5088 5.2005
R15325 avss.n5385 avss.n5384 5.2005
R15326 avss.n5384 avss.n5383 5.2005
R15327 avss.n5093 avss.n5092 5.2005
R15328 avss.n5094 avss.n5093 5.2005
R15329 avss.n5374 avss.n5373 5.2005
R15330 avss.n5375 avss.n5374 5.2005
R15331 avss.n5102 avss.n5101 5.2005
R15332 avss.n5101 avss.n5100 5.2005
R15333 avss.n5369 avss.n5368 5.2005
R15334 avss.n5368 avss.n5367 5.2005
R15335 avss.n5105 avss.n5104 5.2005
R15336 avss.n5106 avss.n5105 5.2005
R15337 avss.n5358 avss.n5357 5.2005
R15338 avss.n5359 avss.n5358 5.2005
R15339 avss.n5412 avss.n4811 5.2005
R15340 avss.n5076 avss.n4811 5.2005
R15341 avss.n5411 avss.n5410 5.2005
R15342 avss.n5410 avss.n5409 5.2005
R15343 avss.n5074 avss.n5073 5.2005
R15344 avss.n5075 avss.n5074 5.2005
R15345 avss.n5399 avss.n5398 5.2005
R15346 avss.n5400 avss.n5399 5.2005
R15347 avss.n5084 avss.n5083 5.2005
R15348 avss.n5083 avss.n5082 5.2005
R15349 avss.n5393 avss.n5392 5.2005
R15350 avss.n5392 avss.n5391 5.2005
R15351 avss.n5087 avss.n5086 5.2005
R15352 avss.n5088 avss.n5087 5.2005
R15353 avss.n5382 avss.n5381 5.2005
R15354 avss.n5383 avss.n5382 5.2005
R15355 avss.n5096 avss.n5095 5.2005
R15356 avss.n5095 avss.n5094 5.2005
R15357 avss.n5377 avss.n5376 5.2005
R15358 avss.n5376 avss.n5375 5.2005
R15359 avss.n5099 avss.n5098 5.2005
R15360 avss.n5100 avss.n5099 5.2005
R15361 avss.n5366 avss.n5365 5.2005
R15362 avss.n5367 avss.n5366 5.2005
R15363 avss.n5108 avss.n5107 5.2005
R15364 avss.n5107 avss.n5106 5.2005
R15365 avss.n5361 avss.n5360 5.2005
R15366 avss.n5360 avss.n5359 5.2005
R15367 avss.n5592 avss.n4696 5.2005
R15368 avss.n4696 avss.n4694 5.2005
R15369 avss.n5594 avss.n5593 5.2005
R15370 avss.n5595 avss.n5594 5.2005
R15371 avss.n4697 avss.n4695 5.2005
R15372 avss.n4695 avss.n4692 5.2005
R15373 avss.n5542 avss.n5541 5.2005
R15374 avss.n5543 avss.n5542 5.2005
R15375 avss.n4752 avss.n4751 5.2005
R15376 avss.n4751 avss.n4749 5.2005
R15377 avss.n5536 avss.n5535 5.2005
R15378 avss.n5535 avss.n5534 5.2005
R15379 avss.n4755 avss.n4754 5.2005
R15380 avss.n4764 avss.n4755 5.2005
R15381 avss.n5513 avss.n5512 5.2005
R15382 avss.n5514 avss.n5513 5.2005
R15383 avss.n4767 avss.n4766 5.2005
R15384 avss.n4774 avss.n4766 5.2005
R15385 avss.n5508 avss.n5507 5.2005
R15386 avss.n5507 avss.n5506 5.2005
R15387 avss.n4770 avss.n4769 5.2005
R15388 avss.n5485 avss.n4770 5.2005
R15389 avss.n4793 avss.n4791 5.2005
R15390 avss.n4791 avss.n4781 5.2005
R15391 avss.n5474 avss.n5473 5.2005
R15392 avss.n5475 avss.n5474 5.2005
R15393 avss.n4792 avss.n4790 5.2005
R15394 avss.n4796 avss.n4790 5.2005
R15395 avss.n5525 avss.n4700 5.2005
R15396 avss.n4700 avss.n4694 5.2005
R15397 avss.n5526 avss.n4693 5.2005
R15398 avss.n5595 avss.n4693 5.2005
R15399 avss.n5528 avss.n5527 5.2005
R15400 avss.n5527 avss.n4692 5.2005
R15401 avss.n5529 avss.n4750 5.2005
R15402 avss.n5543 avss.n4750 5.2005
R15403 avss.n5530 avss.n4758 5.2005
R15404 avss.n4758 avss.n4749 5.2005
R15405 avss.n5532 avss.n5531 5.2005
R15406 avss.n5534 avss.n5532 5.2005
R15407 avss.n4759 avss.n4757 5.2005
R15408 avss.n4764 avss.n4757 5.2005
R15409 avss.n5516 avss.n5515 5.2005
R15410 avss.n5515 avss.n5514 5.2005
R15411 avss.n4762 avss.n4761 5.2005
R15412 avss.n4774 avss.n4762 5.2005
R15413 avss.n5482 avss.n4772 5.2005
R15414 avss.n5506 avss.n4772 5.2005
R15415 avss.n5484 avss.n5483 5.2005
R15416 avss.n5485 avss.n5484 5.2005
R15417 avss.n4784 avss.n4783 5.2005
R15418 avss.n4783 avss.n4781 5.2005
R15419 avss.n5477 avss.n5476 5.2005
R15420 avss.n5476 avss.n5475 5.2005
R15421 avss.n4787 avss.n4786 5.2005
R15422 avss.n4796 avss.n4787 5.2005
R15423 avss.n5061 avss.n5060 5.2005
R15424 avss.n5062 avss.n5061 5.2005
R15425 avss.n4823 avss.n4822 5.2005
R15426 avss.n4822 avss.n4820 5.2005
R15427 avss.n5056 avss.n5055 5.2005
R15428 avss.n5055 avss.n5054 5.2005
R15429 avss.n4826 avss.n4825 5.2005
R15430 avss.n4827 avss.n4826 5.2005
R15431 avss.n5044 avss.n5043 5.2005
R15432 avss.n5045 avss.n5044 5.2005
R15433 avss.n4836 avss.n4835 5.2005
R15434 avss.n4835 avss.n4833 5.2005
R15435 avss.n5039 avss.n5038 5.2005
R15436 avss.n5038 avss.n5037 5.2005
R15437 avss.n4840 avss.n4839 5.2005
R15438 avss.n4842 avss.n4840 5.2005
R15439 avss.n4733 avss.n4732 5.2005
R15440 avss.n4735 avss.n4733 5.2005
R15441 avss.n5565 avss.n5564 5.2005
R15442 avss.n5564 avss.n5563 5.2005
R15443 avss.n5566 avss.n4725 5.2005
R15444 avss.n4725 avss.n4723 5.2005
R15445 avss.n5568 avss.n5567 5.2005
R15446 avss.n5569 avss.n5568 5.2005
R15447 avss.n4727 avss.n4724 5.2005
R15448 avss.n4724 avss.n4722 5.2005
R15449 avss.n4726 avss.n4714 5.2005
R15450 avss.n4739 avss.n4714 5.2005
R15451 avss.n5064 avss.n5063 5.2005
R15452 avss.n5063 avss.n5062 5.2005
R15453 avss.n4818 avss.n4817 5.2005
R15454 avss.n4820 avss.n4818 5.2005
R15455 avss.n5052 avss.n5051 5.2005
R15456 avss.n5054 avss.n5052 5.2005
R15457 avss.n4829 avss.n4828 5.2005
R15458 avss.n4828 avss.n4827 5.2005
R15459 avss.n5047 avss.n5046 5.2005
R15460 avss.n5046 avss.n5045 5.2005
R15461 avss.n4832 avss.n4831 5.2005
R15462 avss.n4833 avss.n4832 5.2005
R15463 avss.n4854 avss.n4853 5.2005
R15464 avss.n5037 avss.n4854 5.2005
R15465 avss.n4844 avss.n4843 5.2005
R15466 avss.n4843 avss.n4842 5.2005
R15467 avss.n4849 avss.n4848 5.2005
R15468 avss.n4848 avss.n4735 5.2005
R15469 avss.n4847 avss.n4734 5.2005
R15470 avss.n5563 avss.n4734 5.2005
R15471 avss.n4721 avss.n4720 5.2005
R15472 avss.n4723 avss.n4721 5.2005
R15473 avss.n5571 avss.n5570 5.2005
R15474 avss.n5570 avss.n5569 5.2005
R15475 avss.n5572 avss.n4718 5.2005
R15476 avss.n4722 avss.n4718 5.2005
R15477 avss.n5573 avss.n4715 5.2005
R15478 avss.n4739 avss.n4715 5.2005
R15479 avss.n5001 avss.n5000 5.2005
R15480 avss.n5000 avss.n4999 5.2005
R15481 avss.n5002 avss.n4908 5.2005
R15482 avss.n4915 avss.n4908 5.2005
R15483 avss.n5004 avss.n5003 5.2005
R15484 avss.n5005 avss.n5004 5.2005
R15485 avss.n4909 avss.n4907 5.2005
R15486 avss.n4907 avss.n4904 5.2005
R15487 avss.n4972 avss.n4971 5.2005
R15488 avss.n4973 avss.n4972 5.2005
R15489 avss.n4966 avss.n4965 5.2005
R15490 avss.n4965 avss.n4964 5.2005
R15491 avss.n4887 avss.n4886 5.2005
R15492 avss.n4963 avss.n4887 5.2005
R15493 avss.n5013 avss.n5012 5.2005
R15494 avss.n5012 avss.n5011 5.2005
R15495 avss.n5014 avss.n4881 5.2005
R15496 avss.n4888 avss.n4881 5.2005
R15497 avss.n5016 avss.n5015 5.2005
R15498 avss.n5017 avss.n5016 5.2005
R15499 avss.n4882 avss.n4880 5.2005
R15500 avss.n4880 avss.n4876 5.2005
R15501 avss.n4947 avss.n4946 5.2005
R15502 avss.n4948 avss.n4947 5.2005
R15503 avss.n4928 avss.n4927 5.2005
R15504 avss.n4938 avss.n4927 5.2005
R15505 avss.n4941 avss.n4940 5.2005
R15506 avss.n4940 avss.n4939 5.2005
R15507 avss.n4982 avss.n4981 5.2005
R15508 avss.n4999 avss.n4982 5.2005
R15509 avss.n4917 avss.n4916 5.2005
R15510 avss.n4916 avss.n4915 5.2005
R15511 avss.n4977 avss.n4905 5.2005
R15512 avss.n5005 avss.n4905 5.2005
R15513 avss.n4976 avss.n4975 5.2005
R15514 avss.n4975 avss.n4904 5.2005
R15515 avss.n4974 avss.n4919 5.2005
R15516 avss.n4974 avss.n4973 5.2005
R15517 avss.n4960 avss.n4920 5.2005
R15518 avss.n4964 avss.n4920 5.2005
R15519 avss.n4962 avss.n4961 5.2005
R15520 avss.n4963 avss.n4962 5.2005
R15521 avss.n4921 avss.n4889 5.2005
R15522 avss.n5011 avss.n4889 5.2005
R15523 avss.n4954 avss.n4953 5.2005
R15524 avss.n4953 avss.n4888 5.2005
R15525 avss.n4952 avss.n4878 5.2005
R15526 avss.n5017 avss.n4878 5.2005
R15527 avss.n4951 avss.n4950 5.2005
R15528 avss.n4950 avss.n4876 5.2005
R15529 avss.n4949 avss.n4923 5.2005
R15530 avss.n4949 avss.n4948 5.2005
R15531 avss.n4935 avss.n4925 5.2005
R15532 avss.n4938 avss.n4925 5.2005
R15533 avss.n4937 avss.n4936 5.2005
R15534 avss.n4939 avss.n4937 5.2005
R15535 avss.n5497 avss.n4747 5.2005
R15536 avss.n5533 avss.n4747 5.2005
R15537 avss.n5499 avss.n5498 5.2005
R15538 avss.n5499 avss.n4756 5.2005
R15539 avss.n5501 avss.n5500 5.2005
R15540 avss.n5500 avss.n4765 5.2005
R15541 avss.n5502 avss.n4776 5.2005
R15542 avss.n4776 avss.n4763 5.2005
R15543 avss.n5504 avss.n5503 5.2005
R15544 avss.n5505 avss.n5504 5.2005
R15545 avss.n4777 avss.n4775 5.2005
R15546 avss.n4775 avss.n4771 5.2005
R15547 avss.n5488 avss.n5487 5.2005
R15548 avss.n5487 avss.n5486 5.2005
R15549 avss.n4780 avss.n4779 5.2005
R15550 avss.n4789 avss.n4780 5.2005
R15551 avss.n5463 avss.n4798 5.2005
R15552 avss.n4798 avss.n4788 5.2005
R15553 avss.n5465 avss.n5464 5.2005
R15554 avss.n5466 avss.n5465 5.2005
R15555 avss.n4799 avss.n4797 5.2005
R15556 avss.n4797 avss.n4794 5.2005
R15557 avss.n5458 avss.n5457 5.2005
R15558 avss.n5457 avss.n5456 5.2005
R15559 avss.n4802 avss.n4801 5.2005
R15560 avss.n4803 avss.n4802 5.2005
R15561 avss.n5420 avss.n5419 5.2005
R15562 avss.n5421 avss.n5420 5.2005
R15563 avss.n5438 avss.n4748 5.2005
R15564 avss.n5533 avss.n4748 5.2005
R15565 avss.n5440 avss.n5439 5.2005
R15566 avss.n5440 avss.n4756 5.2005
R15567 avss.n5441 avss.n5435 5.2005
R15568 avss.n5441 avss.n4765 5.2005
R15569 avss.n5443 avss.n5442 5.2005
R15570 avss.n5442 avss.n4763 5.2005
R15571 avss.n5444 avss.n4773 5.2005
R15572 avss.n5505 avss.n4773 5.2005
R15573 avss.n5446 avss.n5445 5.2005
R15574 avss.n5445 avss.n4771 5.2005
R15575 avss.n5447 avss.n4782 5.2005
R15576 avss.n5486 avss.n4782 5.2005
R15577 avss.n5449 avss.n5448 5.2005
R15578 avss.n5449 avss.n4789 5.2005
R15579 avss.n5451 avss.n5450 5.2005
R15580 avss.n5450 avss.n4788 5.2005
R15581 avss.n5452 avss.n4795 5.2005
R15582 avss.n5466 avss.n4795 5.2005
R15583 avss.n5453 avss.n4805 5.2005
R15584 avss.n4805 avss.n4794 5.2005
R15585 avss.n5455 avss.n5454 5.2005
R15586 avss.n5456 avss.n5455 5.2005
R15587 avss.n4806 avss.n4804 5.2005
R15588 avss.n4804 avss.n4803 5.2005
R15589 avss.n5423 avss.n5422 5.2005
R15590 avss.n5422 avss.n5421 5.2005
R15591 avss.n4711 avss.n4709 5.2005
R15592 avss.n4713 avss.n4711 5.2005
R15593 avss.n5580 avss.n5579 5.2005
R15594 avss.n5579 avss.n5578 5.2005
R15595 avss.n4710 avss.n4707 5.2005
R15596 avss.t154 avss.n4710 5.2005
R15597 avss.n5584 avss.n4705 5.2005
R15598 avss.n4705 avss.n4703 5.2005
R15599 avss.n5586 avss.n5585 5.2005
R15600 avss.n5587 avss.n5586 5.2005
R15601 avss.n5557 avss.n5556 5.2005
R15602 avss.n5556 avss.n4713 5.2005
R15603 avss.n5555 avss.n4712 5.2005
R15604 avss.n5578 avss.n4712 5.2005
R15605 avss.n5554 avss.n5553 5.2005
R15606 avss.n5553 avss.t154 5.2005
R15607 avss.n5552 avss.n4744 5.2005
R15608 avss.n5552 avss.n4703 5.2005
R15609 avss.n5548 avss.n4702 5.2005
R15610 avss.n5587 avss.n4702 5.2005
R15611 avss.n5035 avss.n5034 5.2005
R15612 avss.n5036 avss.n5035 5.2005
R15613 avss.n4857 avss.n4736 5.2005
R15614 avss.n4841 avss.n4736 5.2005
R15615 avss.n4861 avss.n4855 5.2005
R15616 avss.n5036 avss.n4855 5.2005
R15617 avss.n4860 avss.n4737 5.2005
R15618 avss.n4841 avss.n4737 5.2005
R15619 avss.n5025 avss.n5024 5.2005
R15620 avss.n5026 avss.n5025 5.2005
R15621 avss.n4870 avss.n4864 5.2005
R15622 avss.n5027 avss.n4864 5.2005
R15623 avss.n4893 avss.n4865 5.2005
R15624 avss.n5026 avss.n4865 5.2005
R15625 avss.n5028 avss.n4866 5.2005
R15626 avss.n5028 avss.n5027 5.2005
R15627 avss.n4875 avss.n4873 5.2005
R15628 avss.n4879 avss.n4875 5.2005
R15629 avss.n5020 avss.n5019 5.2005
R15630 avss.n5019 avss.n5018 5.2005
R15631 avss.n4899 avss.n4890 5.2005
R15632 avss.n4890 avss.n4879 5.2005
R15633 avss.n4898 avss.n4877 5.2005
R15634 avss.n5018 avss.n4877 5.2005
R15635 avss.n4987 avss.n4983 5.2005
R15636 avss.n4983 avss.n4914 5.2005
R15637 avss.n4986 avss.n4902 5.2005
R15638 avss.n4906 avss.n4902 5.2005
R15639 avss.n4993 avss.n4984 5.2005
R15640 avss.n4984 avss.n4914 5.2005
R15641 avss.n4992 avss.n4903 5.2005
R15642 avss.n4906 avss.n4903 5.2005
R15643 avss.n6196 avss.n5608 5.2005
R15644 avss.n5608 avss.n5606 5.2005
R15645 avss.n6198 avss.n6197 5.2005
R15646 avss.n6199 avss.n6198 5.2005
R15647 avss.n5610 avss.n5607 5.2005
R15648 avss.n5607 avss.n5605 5.2005
R15649 avss.n5609 avss.n5597 5.2005
R15650 avss.n5597 avss.n5596 5.2005
R15651 avss.n5604 avss.n5603 5.2005
R15652 avss.n5606 avss.n5604 5.2005
R15653 avss.n6201 avss.n6200 5.2005
R15654 avss.n6200 avss.n6199 5.2005
R15655 avss.n6202 avss.n5601 5.2005
R15656 avss.n5605 avss.n5601 5.2005
R15657 avss.n6203 avss.n5598 5.2005
R15658 avss.n5598 avss.n5596 5.2005
R15659 avss.n6130 avss.n6129 5.2005
R15660 avss.n6131 avss.n5675 5.2005
R15661 avss.n6133 avss.n6132 5.2005
R15662 avss.n6135 avss.n5673 5.2005
R15663 avss.n6137 avss.n6136 5.2005
R15664 avss.n6138 avss.n5668 5.2005
R15665 avss.n6140 avss.n6139 5.2005
R15666 avss.n6142 avss.n5666 5.2005
R15667 avss.n6144 avss.n6143 5.2005
R15668 avss.n6145 avss.n5661 5.2005
R15669 avss.n6147 avss.n6146 5.2005
R15670 avss.n6149 avss.n5659 5.2005
R15671 avss.n6151 avss.n6150 5.2005
R15672 avss.n6152 avss.n5654 5.2005
R15673 avss.n6154 avss.n6153 5.2005
R15674 avss.n6156 avss.n5652 5.2005
R15675 avss.n6158 avss.n6157 5.2005
R15676 avss.n6159 avss.n5647 5.2005
R15677 avss.n6161 avss.n6160 5.2005
R15678 avss.n6163 avss.n5645 5.2005
R15679 avss.n6165 avss.n6164 5.2005
R15680 avss.n6166 avss.n5640 5.2005
R15681 avss.n6168 avss.n6167 5.2005
R15682 avss.n6170 avss.n5638 5.2005
R15683 avss.n6172 avss.n6171 5.2005
R15684 avss.n6173 avss.n5633 5.2005
R15685 avss.n6175 avss.n6174 5.2005
R15686 avss.n6177 avss.n5631 5.2005
R15687 avss.n6179 avss.n6178 5.2005
R15688 avss.n6180 avss.n5626 5.2005
R15689 avss.n6182 avss.n6181 5.2005
R15690 avss.n6184 avss.n5624 5.2005
R15691 avss.n6186 avss.n6185 5.2005
R15692 avss.n6187 avss.n5618 5.2005
R15693 avss.n6189 avss.n6188 5.2005
R15694 avss.n6191 avss.n5617 5.2005
R15695 avss.n6192 avss.n5615 5.2005
R15696 avss.n6195 avss.n6194 5.2005
R15697 avss.n6005 avss.n6004 5.2005
R15698 avss.n5873 avss.n5872 5.2005
R15699 avss.n6000 avss.n5999 5.2005
R15700 avss.n5892 avss.n5891 5.2005
R15701 avss.n5994 avss.n5993 5.2005
R15702 avss.n5992 avss.n5991 5.2005
R15703 avss.n5990 avss.n5989 5.2005
R15704 avss.n5983 avss.n5894 5.2005
R15705 avss.n5985 avss.n5984 5.2005
R15706 avss.n5982 avss.n5981 5.2005
R15707 avss.n5980 avss.n5979 5.2005
R15708 avss.n5973 avss.n5896 5.2005
R15709 avss.n5975 avss.n5974 5.2005
R15710 avss.n5972 avss.n5971 5.2005
R15711 avss.n5970 avss.n5969 5.2005
R15712 avss.n5963 avss.n5898 5.2005
R15713 avss.n5965 avss.n5964 5.2005
R15714 avss.n5962 avss.n5961 5.2005
R15715 avss.n5960 avss.n5959 5.2005
R15716 avss.n5953 avss.n5900 5.2005
R15717 avss.n5955 avss.n5954 5.2005
R15718 avss.n5952 avss.n5951 5.2005
R15719 avss.n5950 avss.n5949 5.2005
R15720 avss.n5943 avss.n5902 5.2005
R15721 avss.n5945 avss.n5944 5.2005
R15722 avss.n5942 avss.n5941 5.2005
R15723 avss.n5940 avss.n5939 5.2005
R15724 avss.n5933 avss.n5904 5.2005
R15725 avss.n5935 avss.n5934 5.2005
R15726 avss.n5932 avss.n5931 5.2005
R15727 avss.n5930 avss.n5929 5.2005
R15728 avss.n5923 avss.n5906 5.2005
R15729 avss.n5925 avss.n5924 5.2005
R15730 avss.n5922 avss.n5921 5.2005
R15731 avss.n5920 avss.n5919 5.2005
R15732 avss.n5913 avss.n5908 5.2005
R15733 avss.n5915 avss.n5914 5.2005
R15734 avss.n5912 avss.n5911 5.2005
R15735 avss.n6275 avss.n6274 5.2005
R15736 avss.n6276 avss.n6275 5.2005
R15737 avss.n6288 avss.n6287 5.2005
R15738 avss.n6287 avss.n6286 5.2005
R15739 avss.n6272 avss.n6271 5.2005
R15740 avss.n6271 avss.n6270 5.2005
R15741 avss.n6293 avss.n6292 5.2005
R15742 avss.n6294 avss.n6293 5.2005
R15743 avss.n6263 avss.n6262 5.2005
R15744 avss.n6264 avss.n6263 5.2005
R15745 avss.n6304 avss.n6303 5.2005
R15746 avss.n6303 avss.n6302 5.2005
R15747 avss.n6260 avss.n6259 5.2005
R15748 avss.n6259 avss.n6257 5.2005
R15749 avss.n6309 avss.n6308 5.2005
R15750 avss.n6310 avss.n6309 5.2005
R15751 avss.n6312 avss.n6311 5.2005
R15752 avss.n6311 avss.n6310 5.2005
R15753 avss.n6255 avss.n6254 5.2005
R15754 avss.n6257 avss.n6255 5.2005
R15755 avss.n6301 avss.n6300 5.2005
R15756 avss.n6302 avss.n6301 5.2005
R15757 avss.n6266 avss.n6265 5.2005
R15758 avss.n6265 avss.n6264 5.2005
R15759 avss.n6296 avss.n6295 5.2005
R15760 avss.n6295 avss.n6294 5.2005
R15761 avss.n6269 avss.n6268 5.2005
R15762 avss.n6270 avss.n6269 5.2005
R15763 avss.n6285 avss.n6284 5.2005
R15764 avss.n6286 avss.n6285 5.2005
R15765 avss.n6278 avss.n6277 5.2005
R15766 avss.n6277 avss.n6276 5.2005
R15767 avss.n6389 avss.n6388 5.2005
R15768 avss.n6390 avss.n6389 5.2005
R15769 avss.n6355 avss.n6354 5.2005
R15770 avss.n6354 avss.n6330 5.2005
R15771 avss.n6384 avss.n6383 5.2005
R15772 avss.n6383 avss.n6382 5.2005
R15773 avss.n6359 avss.n6358 5.2005
R15774 avss.n6360 avss.n6359 5.2005
R15775 avss.n947 avss.n946 5.2005
R15776 avss.n950 avss.n947 5.2005
R15777 avss.n7038 avss.n7037 5.2005
R15778 avss.n7037 avss.n7036 5.2005
R15779 avss.n7039 avss.n941 5.2005
R15780 avss.n948 avss.n941 5.2005
R15781 avss.n7041 avss.n7040 5.2005
R15782 avss.n7042 avss.n7041 5.2005
R15783 avss.n937 avss.n936 5.2005
R15784 avss.n7043 avss.n937 5.2005
R15785 avss.n7046 avss.n7045 5.2005
R15786 avss.n7045 avss.n7044 5.2005
R15787 avss.n7047 avss.n928 5.2005
R15788 avss.n928 avss.n926 5.2005
R15789 avss.n7049 avss.n7048 5.2005
R15790 avss.n7050 avss.n7049 5.2005
R15791 avss.n929 avss.n927 5.2005
R15792 avss.n927 avss.n925 5.2005
R15793 avss.n930 avss.n917 5.2005
R15794 avss.n917 avss.n916 5.2005
R15795 avss.n6392 avss.n6391 5.2005
R15796 avss.n6391 avss.n6390 5.2005
R15797 avss.n6328 avss.n6327 5.2005
R15798 avss.n6330 avss.n6328 5.2005
R15799 avss.n6381 avss.n6380 5.2005
R15800 avss.n6382 avss.n6381 5.2005
R15801 avss.n6362 avss.n6361 5.2005
R15802 avss.n6361 avss.n6360 5.2005
R15803 avss.n6376 avss.n6375 5.2005
R15804 avss.n6375 avss.n950 5.2005
R15805 avss.n6374 avss.n949 5.2005
R15806 avss.n7036 avss.n949 5.2005
R15807 avss.n6373 avss.n6372 5.2005
R15808 avss.n6372 avss.n948 5.2005
R15809 avss.n6364 avss.n940 5.2005
R15810 avss.n7042 avss.n940 5.2005
R15811 avss.n6368 avss.n939 5.2005
R15812 avss.n7043 avss.n939 5.2005
R15813 avss.n6367 avss.n938 5.2005
R15814 avss.n7044 avss.n938 5.2005
R15815 avss.n924 avss.n923 5.2005
R15816 avss.n926 avss.n924 5.2005
R15817 avss.n7052 avss.n7051 5.2005
R15818 avss.n7051 avss.n7050 5.2005
R15819 avss.n7053 avss.n921 5.2005
R15820 avss.n925 avss.n921 5.2005
R15821 avss.n7054 avss.n918 5.2005
R15822 avss.n918 avss.n916 5.2005
R15823 avss.n7031 avss.n7030 5.2005
R15824 avss.n7032 avss.n7031 5.2005
R15825 avss.n958 avss.n956 5.2005
R15826 avss.n6898 avss.n956 5.2005
R15827 avss.n6944 avss.n6943 5.2005
R15828 avss.n6943 avss.n1029 5.2005
R15829 avss.n6945 avss.n1042 5.2005
R15830 avss.n1042 avss.n1028 5.2005
R15831 avss.n6947 avss.n6946 5.2005
R15832 avss.n6948 avss.n6947 5.2005
R15833 avss.n1043 avss.n1041 5.2005
R15834 avss.n1041 avss.n1037 5.2005
R15835 avss.n6936 avss.n6935 5.2005
R15836 avss.n6935 avss.n6934 5.2005
R15837 avss.n1046 avss.n1045 5.2005
R15838 avss.n1054 avss.n1046 5.2005
R15839 avss.n1067 avss.n1065 5.2005
R15840 avss.n1065 avss.n1053 5.2005
R15841 avss.n6896 avss.n955 5.2005
R15842 avss.n7032 avss.n955 5.2005
R15843 avss.n6899 avss.n6897 5.2005
R15844 avss.n6899 avss.n6898 5.2005
R15845 avss.n6900 avss.n1075 5.2005
R15846 avss.n6900 avss.n1029 5.2005
R15847 avss.n6902 avss.n6901 5.2005
R15848 avss.n6901 avss.n1028 5.2005
R15849 avss.n6903 avss.n1039 5.2005
R15850 avss.n6948 avss.n1039 5.2005
R15851 avss.n6905 avss.n6904 5.2005
R15852 avss.n6904 avss.n1037 5.2005
R15853 avss.n6906 avss.n1047 5.2005
R15854 avss.n6934 avss.n1047 5.2005
R15855 avss.n6907 avss.n1070 5.2005
R15856 avss.n1070 avss.n1054 5.2005
R15857 avss.n6908 avss.n1066 5.2005
R15858 avss.n1066 avss.n1053 5.2005
R15859 avss.n6961 avss.n6960 5.2005
R15860 avss.n6960 avss.n954 5.2005
R15861 avss.n6962 avss.n1032 5.2005
R15862 avss.n1032 avss.n1031 5.2005
R15863 avss.n6964 avss.n6963 5.2005
R15864 avss.n6965 avss.n6964 5.2005
R15865 avss.n1033 avss.n1030 5.2005
R15866 avss.n1040 avss.n1030 5.2005
R15867 avss.n6951 avss.n6950 5.2005
R15868 avss.n6950 avss.n6949 5.2005
R15869 avss.n1036 avss.n1035 5.2005
R15870 avss.n6933 avss.n1036 5.2005
R15871 avss.n6920 avss.n1057 5.2005
R15872 avss.n1057 avss.n1056 5.2005
R15873 avss.n6922 avss.n6921 5.2005
R15874 avss.n6923 avss.n6922 5.2005
R15875 avss.n1058 avss.n1055 5.2005
R15876 avss.n1064 avss.n1055 5.2005
R15877 avss.n6915 avss.n6914 5.2005
R15878 avss.n6914 avss.n6913 5.2005
R15879 avss.n1061 avss.n1060 5.2005
R15880 avss.n1062 avss.n1061 5.2005
R15881 avss.n6340 avss.n6339 5.2005
R15882 avss.n6341 avss.n6340 5.2005
R15883 avss.n6337 avss.n6332 5.2005
R15884 avss.n6336 avss.n6332 5.2005
R15885 avss.n6971 avss.n1022 5.2005
R15886 avss.n1022 avss.n954 5.2005
R15887 avss.n1027 avss.n1023 5.2005
R15888 avss.n1031 avss.n1027 5.2005
R15889 avss.n6967 avss.n6966 5.2005
R15890 avss.n6966 avss.n6965 5.2005
R15891 avss.n1026 avss.n1025 5.2005
R15892 avss.n1040 avss.n1026 5.2005
R15893 avss.n6930 avss.n1038 5.2005
R15894 avss.n6949 avss.n1038 5.2005
R15895 avss.n6932 avss.n6931 5.2005
R15896 avss.n6933 avss.n6932 5.2005
R15897 avss.n1049 avss.n1048 5.2005
R15898 avss.n1056 avss.n1048 5.2005
R15899 avss.n6925 avss.n6924 5.2005
R15900 avss.n6924 avss.n6923 5.2005
R15901 avss.n1052 avss.n1051 5.2005
R15902 avss.n1064 avss.n1052 5.2005
R15903 avss.n6345 avss.n1063 5.2005
R15904 avss.n6913 avss.n1063 5.2005
R15905 avss.n6347 avss.n6346 5.2005
R15906 avss.n6346 avss.n1062 5.2005
R15907 avss.n6348 avss.n6342 5.2005
R15908 avss.n6342 avss.n6341 5.2005
R15909 avss.n6349 avss.n6333 5.2005
R15910 avss.n6336 avss.n6333 5.2005
R15911 avss.n6113 avss.n5703 5.2005
R15912 avss.n6018 avss.n5703 5.2005
R15913 avss.n6115 avss.n6114 5.2005
R15914 avss.n6116 avss.n6115 5.2005
R15915 avss.n6018 avss.n5708 5.2005
R15916 avss.n6116 avss.n5701 5.2005
R15917 avss.n5860 avss.n5859 5.2005
R15918 avss.n5861 avss.n5860 5.2005
R15919 avss.n5856 avss.n5723 5.2005
R15920 avss.n6036 avss.n5723 5.2005
R15921 avss.n5861 avss.n5854 5.2005
R15922 avss.n6036 avss.n5724 5.2005
R15923 avss.n6086 avss.n5825 5.2005
R15924 avss.n5834 avss.n5825 5.2005
R15925 avss.n6085 avss.n6084 5.2005
R15926 avss.n6084 avss.n6083 5.2005
R15927 avss.n5834 avss.n5826 5.2005
R15928 avss.n6083 avss.n5832 5.2005
R15929 avss.n6079 avss.n5822 5.2005
R15930 avss.n5824 avss.n5822 5.2005
R15931 avss.n6081 avss.n6080 5.2005
R15932 avss.n6082 avss.n6081 5.2005
R15933 avss.n5836 avss.n5835 5.2005
R15934 avss.n5835 avss.n5830 5.2005
R15935 avss.n6074 avss.n6073 5.2005
R15936 avss.n6073 avss.n6072 5.2005
R15937 avss.n5839 avss.n5838 5.2005
R15938 avss.n5840 avss.n5839 5.2005
R15939 avss.n6057 avss.n6056 5.2005
R15940 avss.n6058 avss.n6057 5.2005
R15941 avss.n5850 avss.n5849 5.2005
R15942 avss.n6049 avss.n5849 5.2005
R15943 avss.n6052 avss.n6051 5.2005
R15944 avss.n6051 avss.n6050 5.2005
R15945 avss.n5853 avss.n5852 5.2005
R15946 avss.n6035 avss.n5853 5.2005
R15947 avss.n6040 avss.n6039 5.2005
R15948 avss.n6041 avss.n6040 5.2005
R15949 avss.n5719 avss.n5718 5.2005
R15950 avss.n5722 avss.n5719 5.2005
R15951 avss.n6103 avss.n6102 5.2005
R15952 avss.n6102 avss.n6101 5.2005
R15953 avss.n6104 avss.n5713 5.2005
R15954 avss.n5713 avss.n5711 5.2005
R15955 avss.n6106 avss.n6105 5.2005
R15956 avss.n6107 avss.n6106 5.2005
R15957 avss.n5714 avss.n5712 5.2005
R15958 avss.n5712 avss.n5709 5.2005
R15959 avss.n6023 avss.n6022 5.2005
R15960 avss.n6024 avss.n6023 5.2005
R15961 avss.n5697 avss.n5696 5.2005
R15962 avss.n6117 avss.n5697 5.2005
R15963 avss.n6120 avss.n6119 5.2005
R15964 avss.n6119 avss.n6118 5.2005
R15965 avss.n6121 avss.n5689 5.2005
R15966 avss.n5689 avss.n5688 5.2005
R15967 avss.n6123 avss.n6122 5.2005
R15968 avss.n6124 avss.n6123 5.2005
R15969 avss.n5690 avss.n5682 5.2005
R15970 avss.n6126 avss.n5682 5.2005
R15971 avss.n6128 avss.n5680 5.2005
R15972 avss.n6128 avss.n6127 5.2005
R15973 avss.n6066 avss.n5823 5.2005
R15974 avss.n5824 avss.n5823 5.2005
R15975 avss.n6067 avss.n5833 5.2005
R15976 avss.n6082 avss.n5833 5.2005
R15977 avss.n6068 avss.n5842 5.2005
R15978 avss.n5842 avss.n5830 5.2005
R15979 avss.n6070 avss.n6069 5.2005
R15980 avss.n6072 avss.n6070 5.2005
R15981 avss.n5843 avss.n5841 5.2005
R15982 avss.n5841 avss.n5840 5.2005
R15983 avss.n6060 avss.n6059 5.2005
R15984 avss.n6059 avss.n6058 5.2005
R15985 avss.n5846 avss.n5845 5.2005
R15986 avss.n6049 avss.n5846 5.2005
R15987 avss.n6048 avss.n6047 5.2005
R15988 avss.n6050 avss.n6048 5.2005
R15989 avss.n5863 avss.n5862 5.2005
R15990 avss.n6035 avss.n5862 5.2005
R15991 avss.n6043 avss.n6042 5.2005
R15992 avss.n6042 avss.n6041 5.2005
R15993 avss.n6034 avss.n6033 5.2005
R15994 avss.n6034 avss.n5722 5.2005
R15995 avss.n6032 avss.n5721 5.2005
R15996 avss.n6101 avss.n5721 5.2005
R15997 avss.n5866 avss.n5865 5.2005
R15998 avss.n5865 avss.n5711 5.2005
R15999 avss.n6028 avss.n5710 5.2005
R16000 avss.n6107 avss.n5710 5.2005
R16001 avss.n6027 avss.n6026 5.2005
R16002 avss.n6026 avss.n5709 5.2005
R16003 avss.n6025 avss.n6017 5.2005
R16004 avss.n6025 avss.n6024 5.2005
R16005 avss.n5868 avss.n5700 5.2005
R16006 avss.n6117 avss.n5700 5.2005
R16007 avss.n6013 avss.n5699 5.2005
R16008 avss.n6118 avss.n5699 5.2005
R16009 avss.n6012 avss.n6011 5.2005
R16010 avss.n6011 avss.n5688 5.2005
R16011 avss.n6010 avss.n5687 5.2005
R16012 avss.n6124 avss.n5687 5.2005
R16013 avss.n5870 avss.n5685 5.2005
R16014 avss.n6126 avss.n5685 5.2005
R16015 avss.n6006 avss.n5684 5.2005
R16016 avss.n6127 avss.n5684 5.2005
R16017 avss.n1367 avss.n1366 5.2005
R16018 avss.n1374 avss.n1367 5.2005
R16019 avss.n1397 avss.n1396 5.2005
R16020 avss.n1398 avss.n1397 5.2005
R16021 avss.n1376 avss.n1375 5.2005
R16022 avss.n1375 avss.n1373 5.2005
R16023 avss.n1392 avss.n1391 5.2005
R16024 avss.n1391 avss.n1390 5.2005
R16025 avss.n1379 avss.n1378 5.2005
R16026 avss.n1380 avss.n1379 5.2005
R16027 avss.n1369 avss.n1368 5.2005
R16028 avss.n1374 avss.n1368 5.2005
R16029 avss.n1400 avss.n1399 5.2005
R16030 avss.n1399 avss.n1398 5.2005
R16031 avss.n1372 avss.n1371 5.2005
R16032 avss.n1373 avss.n1372 5.2005
R16033 avss.n1389 avss.n1388 5.2005
R16034 avss.n1390 avss.n1389 5.2005
R16035 avss.n1382 avss.n1381 5.2005
R16036 avss.n1381 avss.n1380 5.2005
R16037 avss.n1647 avss.n1646 5.2005
R16038 avss.n1648 avss.n1647 5.2005
R16039 avss.n1642 avss.n1641 5.2005
R16040 avss.n1641 avss.n1640 5.2005
R16041 avss.n1649 avss.n1648 5.2005
R16042 avss.n1640 avss.n1247 5.2005
R16043 avss.n1208 avss.n1206 5.2005
R16044 avss.n1206 avss.n1202 5.2005
R16045 avss.n1633 avss.n1262 5.2005
R16046 avss.n1633 avss.n1632 5.2005
R16047 avss.n1635 avss.n1634 5.2005
R16048 avss.n1634 avss.n1250 5.2005
R16049 avss.n1636 avss.n1255 5.2005
R16050 avss.n1255 avss.n1249 5.2005
R16051 avss.n1638 avss.n1637 5.2005
R16052 avss.n1639 avss.n1638 5.2005
R16053 avss.n1256 avss.n1254 5.2005
R16054 avss.n1254 avss.n1252 5.2005
R16055 avss.n1554 avss.n1553 5.2005
R16056 avss.n1555 avss.n1554 5.2005
R16057 avss.n1274 avss.n1273 5.2005
R16058 avss.n1273 avss.n1271 5.2005
R16059 avss.n1548 avss.n1547 5.2005
R16060 avss.n1547 avss.n1546 5.2005
R16061 avss.n1277 avss.n1276 5.2005
R16062 avss.n1278 avss.n1277 5.2005
R16063 avss.n1534 avss.n1533 5.2005
R16064 avss.n1535 avss.n1534 5.2005
R16065 avss.n1286 avss.n1285 5.2005
R16066 avss.n1285 avss.n1284 5.2005
R16067 avss.n1529 avss.n1528 5.2005
R16068 avss.n1528 avss.n1527 5.2005
R16069 avss.n1289 avss.n1288 5.2005
R16070 avss.n1290 avss.n1289 5.2005
R16071 avss.n1518 avss.n1517 5.2005
R16072 avss.n1519 avss.n1518 5.2005
R16073 avss.n1298 avss.n1297 5.2005
R16074 avss.n1297 avss.n1296 5.2005
R16075 avss.n1513 avss.n1512 5.2005
R16076 avss.n1512 avss.n1511 5.2005
R16077 avss.n1301 avss.n1300 5.2005
R16078 avss.n1302 avss.n1301 5.2005
R16079 avss.n1502 avss.n1501 5.2005
R16080 avss.n1503 avss.n1502 5.2005
R16081 avss.n1198 avss.n1197 5.2005
R16082 avss.n1201 avss.n1198 5.2005
R16083 avss.n6704 avss.n6703 5.2005
R16084 avss.n6703 avss.n6702 5.2005
R16085 avss.n6705 avss.n1192 5.2005
R16086 avss.n1192 avss.n1191 5.2005
R16087 avss.n6707 avss.n6706 5.2005
R16088 avss.n6708 avss.n6707 5.2005
R16089 avss.n1187 avss.n1186 5.2005
R16090 avss.n6709 avss.n1187 5.2005
R16091 avss.n6712 avss.n6711 5.2005
R16092 avss.n6711 avss.n6710 5.2005
R16093 avss.n6713 avss.n1181 5.2005
R16094 avss.n1181 avss.n1179 5.2005
R16095 avss.n6715 avss.n6714 5.2005
R16096 avss.n6716 avss.n6715 5.2005
R16097 avss.n1182 avss.n1180 5.2005
R16098 avss.n1180 avss.n1177 5.2005
R16099 avss.n1481 avss.n1480 5.2005
R16100 avss.n1482 avss.n1481 5.2005
R16101 avss.n1316 avss.n1315 5.2005
R16102 avss.n1315 avss.n1314 5.2005
R16103 avss.n1475 avss.n1474 5.2005
R16104 avss.n1474 avss.n1473 5.2005
R16105 avss.n1319 avss.n1318 5.2005
R16106 avss.n1320 avss.n1319 5.2005
R16107 avss.n1461 avss.n1460 5.2005
R16108 avss.n1462 avss.n1461 5.2005
R16109 avss.n1328 avss.n1327 5.2005
R16110 avss.n1327 avss.n1326 5.2005
R16111 avss.n1456 avss.n1455 5.2005
R16112 avss.n1455 avss.n1454 5.2005
R16113 avss.n1331 avss.n1330 5.2005
R16114 avss.n1332 avss.n1331 5.2005
R16115 avss.n1445 avss.n1444 5.2005
R16116 avss.n1446 avss.n1445 5.2005
R16117 avss.n1340 avss.n1339 5.2005
R16118 avss.n1339 avss.n1338 5.2005
R16119 avss.n1440 avss.n1439 5.2005
R16120 avss.n1439 avss.n1438 5.2005
R16121 avss.n1343 avss.n1342 5.2005
R16122 avss.n1344 avss.n1343 5.2005
R16123 avss.n1429 avss.n1428 5.2005
R16124 avss.n1430 avss.n1429 5.2005
R16125 avss.n1352 avss.n1351 5.2005
R16126 avss.n1351 avss.n1350 5.2005
R16127 avss.n1424 avss.n1423 5.2005
R16128 avss.n1423 avss.n1422 5.2005
R16129 avss.n1355 avss.n1354 5.2005
R16130 avss.n1356 avss.n1355 5.2005
R16131 avss.n1413 avss.n1412 5.2005
R16132 avss.n1414 avss.n1413 5.2005
R16133 avss.n1364 avss.n1363 5.2005
R16134 avss.n1363 avss.n1362 5.2005
R16135 avss.n1408 avss.n1407 5.2005
R16136 avss.n1407 avss.n1406 5.2005
R16137 avss.n1628 avss.n1265 5.2005
R16138 avss.n1265 avss.n1202 5.2005
R16139 avss.n1630 avss.n1629 5.2005
R16140 avss.n1632 avss.n1630 5.2005
R16141 avss.n1266 avss.n1264 5.2005
R16142 avss.n1264 avss.n1250 5.2005
R16143 avss.n1561 avss.n1560 5.2005
R16144 avss.n1560 avss.n1249 5.2005
R16145 avss.n1559 avss.n1253 5.2005
R16146 avss.n1639 avss.n1253 5.2005
R16147 avss.n1558 avss.n1557 5.2005
R16148 avss.n1557 avss.n1252 5.2005
R16149 avss.n1556 avss.n1268 5.2005
R16150 avss.n1556 avss.n1555 5.2005
R16151 avss.n1543 avss.n1270 5.2005
R16152 avss.n1271 avss.n1270 5.2005
R16153 avss.n1545 avss.n1544 5.2005
R16154 avss.n1546 avss.n1545 5.2005
R16155 avss.n1280 avss.n1279 5.2005
R16156 avss.n1279 avss.n1278 5.2005
R16157 avss.n1537 avss.n1536 5.2005
R16158 avss.n1536 avss.n1535 5.2005
R16159 avss.n1283 avss.n1282 5.2005
R16160 avss.n1284 avss.n1283 5.2005
R16161 avss.n1526 avss.n1525 5.2005
R16162 avss.n1527 avss.n1526 5.2005
R16163 avss.n1292 avss.n1291 5.2005
R16164 avss.n1291 avss.n1290 5.2005
R16165 avss.n1521 avss.n1520 5.2005
R16166 avss.n1520 avss.n1519 5.2005
R16167 avss.n1295 avss.n1294 5.2005
R16168 avss.n1296 avss.n1295 5.2005
R16169 avss.n1510 avss.n1509 5.2005
R16170 avss.n1511 avss.n1510 5.2005
R16171 avss.n1304 avss.n1303 5.2005
R16172 avss.n1303 avss.n1302 5.2005
R16173 avss.n1505 avss.n1504 5.2005
R16174 avss.n1504 avss.n1503 5.2005
R16175 avss.n1498 avss.n1497 5.2005
R16176 avss.n1498 avss.n1201 5.2005
R16177 avss.n1496 avss.n1199 5.2005
R16178 avss.n6702 avss.n1199 5.2005
R16179 avss.n1307 avss.n1306 5.2005
R16180 avss.n1306 avss.n1191 5.2005
R16181 avss.n1492 avss.n1190 5.2005
R16182 avss.n6708 avss.n1190 5.2005
R16183 avss.n1491 avss.n1189 5.2005
R16184 avss.n6709 avss.n1189 5.2005
R16185 avss.n1490 avss.n1188 5.2005
R16186 avss.n6710 avss.n1188 5.2005
R16187 avss.n1310 avss.n1309 5.2005
R16188 avss.n1309 avss.n1179 5.2005
R16189 avss.n1486 avss.n1178 5.2005
R16190 avss.n6716 avss.n1178 5.2005
R16191 avss.n1485 avss.n1484 5.2005
R16192 avss.n1484 avss.n1177 5.2005
R16193 avss.n1483 avss.n1312 5.2005
R16194 avss.n1483 avss.n1482 5.2005
R16195 avss.n1470 avss.n1313 5.2005
R16196 avss.n1314 avss.n1313 5.2005
R16197 avss.n1472 avss.n1471 5.2005
R16198 avss.n1473 avss.n1472 5.2005
R16199 avss.n1322 avss.n1321 5.2005
R16200 avss.n1321 avss.n1320 5.2005
R16201 avss.n1464 avss.n1463 5.2005
R16202 avss.n1463 avss.n1462 5.2005
R16203 avss.n1325 avss.n1324 5.2005
R16204 avss.n1326 avss.n1325 5.2005
R16205 avss.n1453 avss.n1452 5.2005
R16206 avss.n1454 avss.n1453 5.2005
R16207 avss.n1334 avss.n1333 5.2005
R16208 avss.n1333 avss.n1332 5.2005
R16209 avss.n1448 avss.n1447 5.2005
R16210 avss.n1447 avss.n1446 5.2005
R16211 avss.n1337 avss.n1336 5.2005
R16212 avss.n1338 avss.n1337 5.2005
R16213 avss.n1437 avss.n1436 5.2005
R16214 avss.n1438 avss.n1437 5.2005
R16215 avss.n1346 avss.n1345 5.2005
R16216 avss.n1345 avss.n1344 5.2005
R16217 avss.n1432 avss.n1431 5.2005
R16218 avss.n1431 avss.n1430 5.2005
R16219 avss.n1349 avss.n1348 5.2005
R16220 avss.n1350 avss.n1349 5.2005
R16221 avss.n1421 avss.n1420 5.2005
R16222 avss.n1422 avss.n1421 5.2005
R16223 avss.n1358 avss.n1357 5.2005
R16224 avss.n1357 avss.n1356 5.2005
R16225 avss.n1416 avss.n1415 5.2005
R16226 avss.n1415 avss.n1414 5.2005
R16227 avss.n1361 avss.n1360 5.2005
R16228 avss.n1362 avss.n1361 5.2005
R16229 avss.n1405 avss.n1404 5.2005
R16230 avss.n1406 avss.n1405 5.2005
R16231 avss.n6599 avss.n6598 5.2005
R16232 avss.n6600 avss.n6599 5.2005
R16233 avss.n6563 avss.n6562 5.2005
R16234 avss.n6562 avss.n6539 5.2005
R16235 avss.n6594 avss.n6593 5.2005
R16236 avss.n6593 avss.n6592 5.2005
R16237 avss.n6566 avss.n6565 5.2005
R16238 avss.n6573 avss.n6566 5.2005
R16239 avss.n6583 avss.n6582 5.2005
R16240 avss.n6584 avss.n6583 5.2005
R16241 avss.n6575 avss.n6574 5.2005
R16242 avss.n6574 avss.n6572 5.2005
R16243 avss.n6602 avss.n6601 5.2005
R16244 avss.n6601 avss.n6600 5.2005
R16245 avss.n6537 avss.n6536 5.2005
R16246 avss.n6539 avss.n6537 5.2005
R16247 avss.n6591 avss.n6590 5.2005
R16248 avss.n6592 avss.n6591 5.2005
R16249 avss.n6568 avss.n6567 5.2005
R16250 avss.n6573 avss.n6567 5.2005
R16251 avss.n6586 avss.n6585 5.2005
R16252 avss.n6585 avss.n6584 5.2005
R16253 avss.n6571 avss.n6570 5.2005
R16254 avss.n6572 avss.n6571 5.2005
R16255 avss.n6552 avss.n6551 5.2005
R16256 avss.n6553 avss.n6552 5.2005
R16257 avss.n6547 avss.n6541 5.2005
R16258 avss.n6541 avss.n6540 5.2005
R16259 avss.n6555 avss.n6554 5.2005
R16260 avss.n6554 avss.n6553 5.2005
R16261 avss.n6556 avss.n6542 5.2005
R16262 avss.n6542 avss.n6540 5.2005
R16263 avss.n6689 avss.n1218 5.2005
R16264 avss.n1620 avss.n1218 5.2005
R16265 avss.n6691 avss.n6690 5.2005
R16266 avss.n6692 avss.n6691 5.2005
R16267 avss.n1620 avss.n1223 5.2005
R16268 avss.n6692 avss.n1216 5.2005
R16269 avss.n1591 avss.n1590 5.2005
R16270 avss.n1592 avss.n1591 5.2005
R16271 avss.n1587 avss.n1239 5.2005
R16272 avss.n1582 avss.n1239 5.2005
R16273 avss.n1593 avss.n1592 5.2005
R16274 avss.n1582 avss.n1240 5.2005
R16275 avss.n1600 avss.n1583 5.2005
R16276 avss.n1586 avss.n1583 5.2005
R16277 avss.n1602 avss.n1601 5.2005
R16278 avss.n1603 avss.n1602 5.2005
R16279 avss.n1235 avss.n1234 5.2005
R16280 avss.n1238 avss.n1235 5.2005
R16281 avss.n6679 avss.n6678 5.2005
R16282 avss.n6678 avss.n6677 5.2005
R16283 avss.n6680 avss.n1229 5.2005
R16284 avss.n1236 avss.n1229 5.2005
R16285 avss.n6682 avss.n6681 5.2005
R16286 avss.n6683 avss.n6682 5.2005
R16287 avss.n1230 avss.n1228 5.2005
R16288 avss.n1228 avss.n1224 5.2005
R16289 avss.n1618 avss.n1617 5.2005
R16290 avss.n1619 avss.n1618 5.2005
R16291 avss.n1213 avss.n1212 5.2005
R16292 avss.n1621 avss.n1213 5.2005
R16293 avss.n6695 avss.n6694 5.2005
R16294 avss.n6694 avss.n6693 5.2005
R16295 avss.n6696 avss.n1207 5.2005
R16296 avss.n1214 avss.n1207 5.2005
R16297 avss.n6698 avss.n6697 5.2005
R16298 avss.n6699 avss.n6698 5.2005
R16299 avss.n1581 avss.n1580 5.2005
R16300 avss.n1586 avss.n1581 5.2005
R16301 avss.n1604 avss.n1577 5.2005
R16302 avss.n1604 avss.n1603 5.2005
R16303 avss.n1606 avss.n1605 5.2005
R16304 avss.n1605 avss.n1238 5.2005
R16305 avss.n1607 avss.n1237 5.2005
R16306 avss.n6677 avss.n1237 5.2005
R16307 avss.n1609 avss.n1608 5.2005
R16308 avss.n1608 avss.n1236 5.2005
R16309 avss.n1610 avss.n1225 5.2005
R16310 avss.n6683 avss.n1225 5.2005
R16311 avss.n1612 avss.n1611 5.2005
R16312 avss.n1612 avss.n1224 5.2005
R16313 avss.n1613 avss.n1570 5.2005
R16314 avss.n1619 avss.n1613 5.2005
R16315 avss.n1623 avss.n1622 5.2005
R16316 avss.n1622 avss.n1621 5.2005
R16317 avss.n1624 avss.n1215 5.2005
R16318 avss.n6693 avss.n1215 5.2005
R16319 avss.n1626 avss.n1625 5.2005
R16320 avss.n1625 avss.n1214 5.2005
R16321 avss.n1627 avss.n1204 5.2005
R16322 avss.n6699 avss.n1204 5.2005
R16323 avss.n7995 avss.n7994 5.2005
R16324 avss.n8034 avss.n7995 5.2005
R16325 avss.n8037 avss.n8036 5.2005
R16326 avss.n8036 avss.n8035 5.2005
R16327 avss.n8038 avss.n7989 5.2005
R16328 avss.n7989 avss.n7988 5.2005
R16329 avss.n8040 avss.n8039 5.2005
R16330 avss.n8041 avss.n8040 5.2005
R16331 avss.n7980 avss.n7979 5.2005
R16332 avss.n8042 avss.n7980 5.2005
R16333 avss.n8045 avss.n8044 5.2005
R16334 avss.n8044 avss.n8043 5.2005
R16335 avss.n8046 avss.n7960 5.2005
R16336 avss.n7983 avss.n7960 5.2005
R16337 avss.n8048 avss.n8047 5.2005
R16338 avss.n8049 avss.n8048 5.2005
R16339 avss.n7961 avss.n7959 5.2005
R16340 avss.n7959 avss.n7958 5.2005
R16341 avss.n8028 avss.n7998 5.2005
R16342 avss.n8034 avss.n7998 5.2005
R16343 avss.n8027 avss.n7997 5.2005
R16344 avss.n8035 avss.n7997 5.2005
R16345 avss.n8026 avss.n8025 5.2005
R16346 avss.n8025 avss.n7988 5.2005
R16347 avss.n8017 avss.n7987 5.2005
R16348 avss.n8041 avss.n7987 5.2005
R16349 avss.n8021 avss.n7986 5.2005
R16350 avss.n8042 avss.n7986 5.2005
R16351 avss.n8020 avss.n7985 5.2005
R16352 avss.n8043 avss.n7985 5.2005
R16353 avss.n7957 avss.n7956 5.2005
R16354 avss.n7983 avss.n7957 5.2005
R16355 avss.n8051 avss.n8050 5.2005
R16356 avss.n8050 avss.n8049 5.2005
R16357 avss.n8052 avss.n7951 5.2005
R16358 avss.n7958 avss.n7951 5.2005
R16359 avss.n8008 avss.n5 5.2005
R16360 avss.n7 avss.n5 5.2005
R16361 avss.n8010 avss.n8009 5.2005
R16362 avss.n8011 avss.n8010 5.2005
R16363 avss.n8002 avss.n6 5.2005
R16364 avss.n7 avss.n6 5.2005
R16365 avss.n8013 avss.n8012 5.2005
R16366 avss.n8012 avss.n8011 5.2005
R16367 avss.n9393 avss.n9392 5.2005
R16368 avss.n9392 avss.n9391 5.2005
R16369 avss.n9394 avss.n10 5.2005
R16370 avss.n10 avss.n9 5.2005
R16371 avss.n9383 avss.n14 5.2005
R16372 avss.n9391 avss.n14 5.2005
R16373 avss.n9382 avss.n11 5.2005
R16374 avss.n11 avss.n9 5.2005
R16375 avss.n9345 avss.n62 5.2005
R16376 avss.n9350 avss.n62 5.2005
R16377 avss.n9344 avss.n61 5.2005
R16378 avss.n9351 avss.n61 5.2005
R16379 avss.n9343 avss.n9342 5.2005
R16380 avss.n9342 avss.n53 5.2005
R16381 avss.n9325 avss.n52 5.2005
R16382 avss.n9357 avss.n52 5.2005
R16383 avss.n9338 avss.n51 5.2005
R16384 avss.n9358 avss.n51 5.2005
R16385 avss.n9337 avss.n48 5.2005
R16386 avss.n9360 avss.n48 5.2005
R16387 avss.n9336 avss.n9335 5.2005
R16388 avss.n9335 avss.n47 5.2005
R16389 avss.n9327 avss.n39 5.2005
R16390 avss.n9366 avss.n39 5.2005
R16391 avss.n9331 avss.n38 5.2005
R16392 avss.n9367 avss.n38 5.2005
R16393 avss.n9330 avss.n37 5.2005
R16394 avss.n9368 avss.n37 5.2005
R16395 avss.n23 avss.n22 5.2005
R16396 avss.n26 avss.n23 5.2005
R16397 avss.n9376 avss.n9375 5.2005
R16398 avss.n9375 avss.n9374 5.2005
R16399 avss.n9377 avss.n20 5.2005
R16400 avss.n25 avss.n20 5.2005
R16401 avss.n9378 avss.n17 5.2005
R16402 avss.n24 avss.n17 5.2005
R16403 avss.n29 avss.n16 5.2005
R16404 avss.n24 avss.n16 5.2005
R16405 avss.n30 avss.n27 5.2005
R16406 avss.n27 avss.n25 5.2005
R16407 avss.n9373 avss.n9372 5.2005
R16408 avss.n9374 avss.n9373 5.2005
R16409 avss.n9371 avss.n28 5.2005
R16410 avss.n28 avss.n26 5.2005
R16411 avss.n9370 avss.n9369 5.2005
R16412 avss.n9369 avss.n9368 5.2005
R16413 avss.n36 avss.n35 5.2005
R16414 avss.n9367 avss.n36 5.2005
R16415 avss.n9365 avss.n9364 5.2005
R16416 avss.n9366 avss.n9365 5.2005
R16417 avss.n9363 avss.n40 5.2005
R16418 avss.n47 avss.n40 5.2005
R16419 avss.n9362 avss.n9361 5.2005
R16420 avss.n9361 avss.n9360 5.2005
R16421 avss.n46 avss.n45 5.2005
R16422 avss.n9358 avss.n46 5.2005
R16423 avss.n9356 avss.n9355 5.2005
R16424 avss.n9357 avss.n9356 5.2005
R16425 avss.n9354 avss.n54 5.2005
R16426 avss.n54 avss.n53 5.2005
R16427 avss.n9353 avss.n9352 5.2005
R16428 avss.n9352 avss.n9351 5.2005
R16429 avss.n60 avss.n59 5.2005
R16430 avss.n9350 avss.n60 5.2005
R16431 avss.n9246 avss.n9245 5.2005
R16432 avss.n9246 avss.n96 5.2005
R16433 avss.n9242 avss.n9238 5.2005
R16434 avss.n9238 avss.n104 5.2005
R16435 avss.n9248 avss.n96 5.2005
R16436 avss.n9239 avss.n104 5.2005
R16437 avss.n9311 avss.n9310 5.2005
R16438 avss.n9312 avss.n9311 5.2005
R16439 avss.n9306 avss.n9305 5.2005
R16440 avss.n9305 avss.n9304 5.2005
R16441 avss.n9313 avss.n9312 5.2005
R16442 avss.n9304 avss.n73 5.2005
R16443 avss.n9300 avss.n66 5.2005
R16444 avss.n66 avss.n64 5.2005
R16445 avss.n9302 avss.n9301 5.2005
R16446 avss.n9303 avss.n9302 5.2005
R16447 avss.n78 avss.n77 5.2005
R16448 avss.n77 avss.n75 5.2005
R16449 avss.n9295 avss.n9294 5.2005
R16450 avss.n9294 avss.n9293 5.2005
R16451 avss.n81 avss.n80 5.2005
R16452 avss.n82 avss.n81 5.2005
R16453 avss.n9278 avss.n9277 5.2005
R16454 avss.n9279 avss.n9278 5.2005
R16455 avss.n92 avss.n91 5.2005
R16456 avss.n9270 avss.n91 5.2005
R16457 avss.n9273 avss.n9272 5.2005
R16458 avss.n9272 avss.n9271 5.2005
R16459 avss.n95 avss.n94 5.2005
R16460 avss.n103 avss.n95 5.2005
R16461 avss.n9261 avss.n9260 5.2005
R16462 avss.n9262 avss.n9261 5.2005
R16463 avss.n106 avss.n105 5.2005
R16464 avss.n105 avss.n102 5.2005
R16465 avss.n9256 avss.n9255 5.2005
R16466 avss.n9255 avss.n9254 5.2005
R16467 avss.n109 avss.n108 5.2005
R16468 avss.n117 avss.n109 5.2005
R16469 avss.n9229 avss.n9228 5.2005
R16470 avss.n9230 avss.n9229 5.2005
R16471 avss.n119 avss.n118 5.2005
R16472 avss.n125 avss.n118 5.2005
R16473 avss.n9224 avss.n9223 5.2005
R16474 avss.n9223 avss.n9222 5.2005
R16475 avss.n122 avss.n121 5.2005
R16476 avss.n8376 avss.n122 5.2005
R16477 avss.n8368 avss.n8367 5.2005
R16478 avss.n8369 avss.n8368 5.2005
R16479 avss.n7754 avss.n7753 5.2005
R16480 avss.n8381 avss.n7754 5.2005
R16481 avss.n9287 avss.n67 5.2005
R16482 avss.n67 avss.n64 5.2005
R16483 avss.n9288 avss.n76 5.2005
R16484 avss.n9303 avss.n76 5.2005
R16485 avss.n9289 avss.n84 5.2005
R16486 avss.n84 avss.n75 5.2005
R16487 avss.n9291 avss.n9290 5.2005
R16488 avss.n9293 avss.n9291 5.2005
R16489 avss.n85 avss.n83 5.2005
R16490 avss.n83 avss.n82 5.2005
R16491 avss.n9281 avss.n9280 5.2005
R16492 avss.n9280 avss.n9279 5.2005
R16493 avss.n88 avss.n87 5.2005
R16494 avss.n9270 avss.n88 5.2005
R16495 avss.n9269 avss.n9268 5.2005
R16496 avss.n9271 avss.n9269 5.2005
R16497 avss.n98 avss.n97 5.2005
R16498 avss.n103 avss.n97 5.2005
R16499 avss.n9264 avss.n9263 5.2005
R16500 avss.n9263 avss.n9262 5.2005
R16501 avss.n101 avss.n100 5.2005
R16502 avss.n102 avss.n101 5.2005
R16503 avss.n9237 avss.n9236 5.2005
R16504 avss.n9254 avss.n9237 5.2005
R16505 avss.n112 avss.n111 5.2005
R16506 avss.n117 avss.n111 5.2005
R16507 avss.n9232 avss.n9231 5.2005
R16508 avss.n9231 avss.n9230 5.2005
R16509 avss.n115 avss.n114 5.2005
R16510 avss.n125 avss.n115 5.2005
R16511 avss.n8373 avss.n123 5.2005
R16512 avss.n9222 avss.n123 5.2005
R16513 avss.n8375 avss.n8374 5.2005
R16514 avss.n8376 avss.n8375 5.2005
R16515 avss.n8364 avss.n8363 5.2005
R16516 avss.n8369 avss.n8364 5.2005
R16517 avss.n8383 avss.n8382 5.2005
R16518 avss.n8382 avss.n8381 5.2005
R16519 avss.n9220 avss.n9219 5.2005
R16520 avss.n9221 avss.n9220 5.2005
R16521 avss.n128 avss.n126 5.2005
R16522 avss.n8377 avss.n126 5.2005
R16523 avss.n9221 avss.n124 5.2005
R16524 avss.n8378 avss.n8377 5.2005
R16525 avss.n4996 avss.n4988 5.20011
R16526 avss.n7468 avss.n7467 5.20011
R16527 avss.n6858 avss.n1130 5.20011
R16528 avss.n2334 avss.n2333 5.20011
R16529 avss.n3153 avss.n3012 5.20011
R16530 avss.n7072 avss.n817 5.20011
R16531 avss.n4316 avss.n3874 5.20011
R16532 avss.n4427 avss.n3731 5.20011
R16533 avss.n5816 avss.t9 5.19564
R16534 avss.n6668 avss.t50 5.19564
R16535 avss.n9199 avss.t20 5.19564
R16536 avss.n7864 avss.t186 5.19564
R16537 avss.n8733 avss.t0 5.19564
R16538 avss.n9212 avss.t101 5.19564
R16539 avss.n6674 avss.n1241 5.19561
R16540 avss.n1220 avss.n1219 5.19561
R16541 avss.n1643 avss.n1246 5.19561
R16542 avss.n5705 avss.n5704 5.19561
R16543 avss.n6098 avss.n5725 5.19561
R16544 avss.n5828 avss.n5827 5.19561
R16545 avss.n9403 avss.n4 5.19561
R16546 avss.n9380 avss.n12 5.19561
R16547 avss.n9251 avss.n9240 5.19561
R16548 avss.n9307 avss.n72 5.19561
R16549 avss.n215 avss.n214 5.19561
R16550 avss.n9168 avss.n180 5.19561
R16551 avss.n9195 avss.n148 5.19561
R16552 avss.n8599 avss.n7890 5.19561
R16553 avss.n8611 avss.n7885 5.19561
R16554 avss.n8632 avss.n7862 5.19561
R16555 avss.n8723 avss.n7800 5.19561
R16556 avss.n8738 avss.n7795 5.19561
R16557 avss.n7775 avss.n7774 5.19561
R16558 avss.n130 avss.n129 5.19561
R16559 avss.n4932 avss.n4929 5.17941
R16560 avss.n4942 avss.n4929 5.17941
R16561 avss.n5418 avss.n4807 5.17941
R16562 avss.n5424 avss.n4807 5.17941
R16563 avss.n5575 avss.n5574 5.17941
R16564 avss.n5575 avss.n4716 5.17941
R16565 avss.n5059 avss.n4815 5.17941
R16566 avss.n5469 avss.n4785 5.17941
R16567 avss.n5470 avss.n5469 5.17941
R16568 avss.n5591 avss.n5590 5.17941
R16569 avss.n5362 avss.n5109 5.17941
R16570 avss.n5415 avss.n4812 5.17941
R16571 avss.n550 avss.n549 5.17941
R16572 avss.n2896 avss.n2895 5.17941
R16573 avss.n2897 avss.n2896 5.17941
R16574 avss.n2816 avss.n2002 5.17941
R16575 avss.n2817 avss.n2816 5.17941
R16576 avss.n470 avss.n469 5.17941
R16577 avss.n470 avss.n435 5.17941
R16578 avss.n7328 avss.n7326 5.17941
R16579 avss.n7365 avss.n7364 5.17941
R16580 avss.n7366 avss.n7365 5.17941
R16581 avss.n8031 avss.n8000 5.17941
R16582 avss.n9387 avss.n18 5.17941
R16583 avss.n9347 avss.n9323 5.17941
R16584 avss.n8061 avss.n7946 5.17941
R16585 avss.n7020 avss.n7019 5.17941
R16586 avss.n1149 avss.n1148 5.17941
R16587 avss.n1148 avss.n1096 5.17941
R16588 avss.n6351 avss.n6334 5.17941
R16589 avss.n6351 avss.n6350 5.17941
R16590 avss.n7004 avss.n7003 5.17941
R16591 avss.n7004 avss.n989 5.17941
R16592 avss.n6769 avss.n6768 5.17941
R16593 avss.n7056 avss.n7055 5.17941
R16594 avss.n6387 avss.n6325 5.17941
R16595 avss.n6910 avss.n6909 5.17941
R16596 avss.n6910 avss.n1068 5.17941
R16597 avss.n2674 avss.n2261 5.17941
R16598 avss.n2369 avss.n2353 5.17941
R16599 avss.n2379 avss.n2353 5.17941
R16600 avss.n2553 avss.n2551 5.17941
R16601 avss.n2551 avss.n2549 5.17941
R16602 avss.n2695 avss.n2694 5.17941
R16603 avss.n2694 avss.n2238 5.17941
R16604 avss.n2743 avss.n2259 5.17941
R16605 avss.n1890 avss.n1859 5.17941
R16606 avss.n1902 avss.n1743 5.17941
R16607 avss.n2610 avss.n2609 5.17941
R16608 avss.n2609 avss.n2478 5.17941
R16609 avss.n3201 avss.n2109 5.17941
R16610 avss.n3079 avss.n3078 5.17941
R16611 avss.n3079 avss.n3054 5.17941
R16612 avss.n2162 avss.n2160 5.17941
R16613 avss.n2163 avss.n2162 5.17941
R16614 avss.n2954 avss.n2953 5.17941
R16615 avss.n2955 avss.n2954 5.17941
R16616 avss.n2994 avss.n2114 5.17941
R16617 avss.n1945 avss.n1926 5.17941
R16618 avss.n3288 avss.n3287 5.17941
R16619 avss.n2066 avss.n2064 5.17941
R16620 avss.n2064 avss.n2055 5.17941
R16621 avss.n4609 avss.n3409 5.17941
R16622 avss.n4511 avss.n4510 5.17941
R16623 avss.n4511 avss.n3659 5.17941
R16624 avss.n3821 avss.n3773 5.17941
R16625 avss.n7226 avss.n7225 5.17941
R16626 avss.n744 avss.n742 5.17941
R16627 avss.n742 avss.n668 5.17941
R16628 avss.n7129 avss.n708 5.17941
R16629 avss.n904 avss.n902 5.17941
R16630 avss.n902 avss.n901 5.17941
R16631 avss.n3446 avss.n3445 5.17941
R16632 avss.n3445 avss.n605 5.17941
R16633 avss.n3532 avss.n3488 5.17941
R16634 avss.n3533 avss.n3532 5.17941
R16635 avss.n702 avss.n701 5.17941
R16636 avss.n5342 avss.n5341 5.17941
R16637 avss.n5308 avss.n567 5.17941
R16638 avss.n3966 avss.n3964 5.17941
R16639 avss.n3964 avss.n3959 5.17941
R16640 avss.n4368 avss.n4367 5.17941
R16641 avss.n4269 avss.n4267 5.17941
R16642 avss.n4267 avss.n4266 5.17941
R16643 avss.n4087 avss.n4086 5.17941
R16644 avss.n4086 avss.n4084 5.17941
R16645 avss.n4142 avss.n4057 5.17941
R16646 avss.n4136 avss.n4057 5.17941
R16647 avss.n4170 avss.n4169 5.17941
R16648 avss.n5214 avss.n5213 5.17941
R16649 avss.n4380 avss.n4378 5.17941
R16650 avss.n4378 avss.n4377 5.17941
R16651 avss.n3618 avss.n3616 5.17941
R16652 avss.n3620 avss.n3618 5.17941
R16653 avss.n5275 avss.n5274 5.17941
R16654 avss.n7239 avss.n7238 5.17941
R16655 avss.n4569 avss.n4568 5.17941
R16656 avss.n4570 avss.n4569 5.17941
R16657 avss.n1828 avss.n1827 5.17941
R16658 avss.n3312 avss.n3311 5.17941
R16659 avss.t160 avss.n2666 5.17566
R16660 avss.t60 avss.n2277 5.17566
R16661 avss.t163 avss.n3788 5.17566
R16662 avss.n3805 avss.t25 5.17566
R16663 avss.n6282 avss.n6281 5.16141
R16664 avss.n6281 avss.n6273 5.16141
R16665 avss.n6307 avss.n6252 5.16141
R16666 avss.n5350 avss.n5349 5.16141
R16667 avss.n6232 avss.n4666 5.16141
R16668 avss.n5350 avss.n4687 5.16141
R16669 avss.n6094 avss.n6093 5.12952
R16670 avss.n1597 avss.n1244 5.12952
R16671 avss.n9318 avss.n9317 5.12952
R16672 avss.n9134 avss.n9133 5.12952
R16673 avss.n8589 avss.n7888 5.12952
R16674 avss.n8713 avss.n7798 5.12952
R16675 avss.n6580 avss.n6579 5.08433
R16676 avss.n1589 avss.n1588 5.0655
R16677 avss.n6688 avss.n6687 5.0655
R16678 avss.n1645 avss.n1644 5.0655
R16679 avss.n6112 avss.n6111 5.0655
R16680 avss.n5858 avss.n5857 5.0655
R16681 avss.n6088 avss.n6087 5.0655
R16682 avss.n8007 avss.n8006 5.0655
R16683 avss.n9396 avss.n9395 5.0655
R16684 avss.n9244 avss.n9243 5.0655
R16685 avss.n9309 avss.n9308 5.0655
R16686 avss.n9182 avss.n9181 5.0655
R16687 avss.n9139 avss.n9138 5.0655
R16688 avss.n9161 avss.n9160 5.0655
R16689 avss.n8625 avss.n8624 5.0655
R16690 avss.n8601 avss.n8600 5.0655
R16691 avss.n7922 avss.n7921 5.0655
R16692 avss.n8752 avss.n8751 5.0655
R16693 avss.n8725 avss.n8724 5.0655
R16694 avss.n7832 avss.n7831 5.0655
R16695 avss.n9218 avss.n9217 5.0655
R16696 avss.n6548 avss.n6543 5.06453
R16697 avss.n5356 avss.n5355 5.0493
R16698 avss.n931 avss.n919 5.0493
R16699 avss.n1892 avss.n1891 5.0493
R16700 avss.n1947 avss.n1946 5.0493
R16701 avss.n5132 avss.n5116 5.0493
R16702 avss.n5212 avss.n5211 5.0493
R16703 avss.n5277 avss.n5276 5.0493
R16704 avss.n1825 avss.n1817 5.0493
R16705 avss.n6078 avss.n5821 5.04833
R16706 avss.n1599 avss.n1598 5.04833
R16707 avss.n9299 avss.n68 5.04833
R16708 avss.n221 avss.n220 5.04833
R16709 avss.n8591 avss.n8590 5.04833
R16710 avss.n8715 avss.n8714 5.04833
R16711 avss.n9347 avss.n9346 5.01157
R16712 avss.n8061 avss.n8060 5.01157
R16713 avss.n6674 avss.n6673 4.98321
R16714 avss.n6673 avss.n1242 4.98321
R16715 avss.n1221 avss.n1220 4.98321
R16716 avss.n6686 avss.n1221 4.98321
R16717 avss.n1651 avss.n1246 4.98321
R16718 avss.n1651 avss.n1245 4.98321
R16719 avss.n5706 avss.n5705 4.98321
R16720 avss.n6110 avss.n5706 4.98321
R16721 avss.n6098 avss.n6097 4.98321
R16722 avss.n6097 avss.n5726 4.98321
R16723 avss.n5828 avss.n5819 4.98321
R16724 avss.n6089 avss.n5819 4.98321
R16725 avss.n8031 avss.n8030 4.98321
R16726 avss.n8015 avss.n8001 4.98321
R16727 avss.n9404 avss.n9403 4.98321
R16728 avss.n9397 avss.n3 4.98321
R16729 avss.n9385 avss.n9380 4.98321
R16730 avss.n9387 avss.n9386 4.98321
R16731 avss.n9251 avss.n9250 4.98321
R16732 avss.n9250 avss.n9241 4.98321
R16733 avss.n9315 avss.n72 4.98321
R16734 avss.n9315 avss.n71 4.98321
R16735 avss.n9196 avss.n146 4.98321
R16736 avss.n9136 avss.n215 4.98321
R16737 avss.n9137 avss.n9136 4.98321
R16738 avss.n9168 avss.n9167 4.98321
R16739 avss.n9167 avss.n181 4.98321
R16740 avss.n9196 avss.n9195 4.98321
R16741 avss.n8631 avss.n7863 4.98321
R16742 avss.n8607 avss.n7890 4.98321
R16743 avss.n8607 avss.n7889 4.98321
R16744 avss.n8611 avss.n8610 4.98321
R16745 avss.n8610 avss.n7886 4.98321
R16746 avss.n8632 avss.n8631 4.98321
R16747 avss.n8750 avss.n7776 4.98321
R16748 avss.n8731 avss.n7800 4.98321
R16749 avss.n8731 avss.n7799 4.98321
R16750 avss.n8738 avss.n8737 4.98321
R16751 avss.n8737 avss.n7796 4.98321
R16752 avss.n7776 avss.n7775 4.98321
R16753 avss.n9216 avss.n9215 4.98321
R16754 avss.n9215 avss.n130 4.98321
R16755 avss.t147 avss.n3223 4.93471
R16756 avss.t59 avss.n2086 4.93471
R16757 avss.n3939 avss.t151 4.93471
R16758 avss.n3938 avss.t24 4.93471
R16759 avss.n6605 avss.n6604 4.87615
R16760 avss.n6314 avss.n6313 4.87478
R16761 avss.n6239 avss.n6238 4.87478
R16762 avss.t135 avss.n7382 4.83681
R16763 avss.t58 avss.n510 4.83681
R16764 avss.t140 avss.n7121 4.83681
R16765 avss.n7120 avss.t23 4.83681
R16766 avss.n2926 avss.n2148 4.83065
R16767 avss.n3427 avss.n627 4.83065
R16768 avss.n4647 avss.n4646 4.8005
R16769 avss.n5559 avss.n5558 4.76902
R16770 avss.n7303 avss.n7302 4.76902
R16771 avss.n6988 avss.n6987 4.76902
R16772 avss.n2599 avss.n2598 4.76902
R16773 avss.n2199 avss.n2198 4.76902
R16774 avss.n7165 avss.n7164 4.76902
R16775 avss.n4213 avss.n4212 4.76902
R16776 avss.n4495 avss.n4494 4.76902
R16777 avss.n4738 avss.n4708 4.769
R16778 avss.n7377 avss.n7376 4.769
R16779 avss.n1012 avss.n981 4.769
R16780 avss.n2602 avss.n2601 4.769
R16781 avss.n2196 avss.n2047 4.769
R16782 avss.n680 avss.n660 4.769
R16783 avss.n4206 avss.n3946 4.769
R16784 avss.n3682 avss.n3652 4.769
R16785 avss.n6604 avss.n6603 4.7615
R16786 avss.n4891 avss.n4872 4.75136
R16787 avss.n5033 avss.n5032 4.75136
R16788 avss.n4896 avss.n4894 4.75136
R16789 avss.n4892 avss.n4863 4.75136
R16790 avss.n5023 avss.n5022 4.75136
R16791 avss.n4991 avss.n4901 4.75136
R16792 avss.n7421 avss.n420 4.75136
R16793 avss.n7407 avss.n475 4.75136
R16794 avss.n7416 avss.n7415 4.75136
R16795 avss.n477 avss.n429 4.75136
R16796 avss.n7419 avss.n427 4.75136
R16797 avss.n7430 avss.n423 4.75136
R16798 avss.n6872 avss.n6871 4.75136
R16799 avss.n6797 avss.n1169 4.75136
R16800 avss.n6809 avss.n1162 4.75136
R16801 avss.n6794 avss.n1173 4.75136
R16802 avss.n6800 avss.n6799 4.75136
R16803 avss.n6853 avss.n1111 4.75136
R16804 avss.n2308 avss.n2289 4.75136
R16805 avss.n2662 avss.n2661 4.75136
R16806 avss.n2363 avss.n2283 4.75136
R16807 avss.n2452 avss.n2451 4.75136
R16808 avss.n2444 avss.n2443 4.75136
R16809 avss.n2328 avss.n2309 4.75136
R16810 avss.n3151 avss.n3018 4.75136
R16811 avss.n3219 avss.n3218 4.75136
R16812 avss.n3097 avss.n3096 4.75136
R16813 avss.n3068 avss.n2092 4.75136
R16814 avss.n3090 avss.n3089 4.75136
R16815 avss.n3020 avss.n3013 4.75136
R16816 avss.n793 avss.n778 4.75136
R16817 avss.n7067 avss.n7066 4.75136
R16818 avss.n7103 avss.n792 4.75136
R16819 avss.n7088 avss.n7087 4.75136
R16820 avss.n7062 avss.n796 4.75136
R16821 avss.n790 avss.n789 4.75136
R16822 avss.n4258 avss.n4257 4.75136
R16823 avss.n4324 avss.n4323 4.75136
R16824 avss.n4359 avss.n3851 4.75136
R16825 avss.n4344 avss.n4343 4.75136
R16826 avss.n4319 avss.n3853 4.75136
R16827 avss.n3942 avss.n3941 4.75136
R16828 avss.n3704 avss.n3703 4.75136
R16829 avss.n4435 avss.n4434 4.75136
R16830 avss.n3729 avss.n3728 4.75136
R16831 avss.n4455 avss.n4454 4.75136
R16832 avss.n4430 avss.n3708 4.75136
R16833 avss.n4477 avss.n4476 4.75136
R16834 avss.n4858 avss.n4738 4.75136
R16835 avss.n7378 avss.n7377 4.75136
R16836 avss.n6786 avss.n1012 4.75136
R16837 avss.n2601 avss.n2280 4.75136
R16838 avss.n2196 avss.n2089 4.75136
R16839 avss.n786 avss.n680 4.75136
R16840 avss.n3946 avss.n3945 4.75136
R16841 avss.n3691 avss.n3682 4.75136
R16842 avss.n5559 avss.n4742 4.75135
R16843 avss.n7302 avss.n7301 4.75135
R16844 avss.n6988 avss.n1016 4.75135
R16845 avss.n2599 avss.n2493 4.75135
R16846 avss.n2198 avss.n2195 4.75135
R16847 avss.n7165 avss.n681 4.75135
R16848 avss.n4213 avss.n3950 4.75135
R16849 avss.n4495 avss.n4484 4.75135
R16850 avss.n4863 avss.n4862 4.75135
R16851 avss.n5032 avss.n4859 4.75135
R16852 avss.n5022 avss.n5021 4.75135
R16853 avss.n4897 avss.n4896 4.75135
R16854 avss.n4901 avss.n4900 4.75135
R16855 avss.n4985 avss.n4891 4.75135
R16856 avss.n7298 avss.n477 4.75135
R16857 avss.n7408 avss.n7407 4.75135
R16858 avss.n7420 avss.n7419 4.75135
R16859 avss.n7416 avss.n424 4.75135
R16860 avss.n7430 avss.n7429 4.75135
R16861 avss.n420 avss.n398 4.75135
R16862 avss.n6794 avss.n6793 4.75135
R16863 avss.n6798 avss.n6797 4.75135
R16864 avss.n6799 avss.n1108 4.75135
R16865 avss.n6810 avss.n6809 4.75135
R16866 avss.n6811 avss.n1111 4.75135
R16867 avss.n6871 avss.n1109 4.75135
R16868 avss.n2490 avss.n2452 4.75135
R16869 avss.n2661 avss.n2281 4.75135
R16870 avss.n2443 avss.n2442 4.75135
R16871 avss.n2363 avss.n2362 4.75135
R16872 avss.n2359 avss.n2309 4.75135
R16873 avss.n2325 avss.n2308 4.75135
R16874 avss.n2192 avss.n2092 4.75135
R16875 avss.n3218 avss.n2090 4.75135
R16876 avss.n3089 avss.n3088 4.75135
R16877 avss.n3097 avss.n3067 4.75135
R16878 avss.n3063 avss.n3020 4.75135
R16879 avss.n3152 avss.n3151 4.75135
R16880 avss.n796 avss.n795 4.75135
R16881 avss.n7087 avss.n7086 4.75135
R16882 avss.n7066 avss.n7065 4.75135
R16883 avss.n7104 avss.n7103 4.75135
R16884 avss.n791 avss.n790 4.75135
R16885 avss.n778 avss.n777 4.75135
R16886 avss.n4259 avss.n3853 4.75135
R16887 avss.n4343 avss.n4342 4.75135
R16888 avss.n4323 avss.n4322 4.75135
R16889 avss.n4360 avss.n4359 4.75135
R16890 avss.n3941 avss.n3850 4.75135
R16891 avss.n4257 avss.n3909 4.75135
R16892 avss.n3708 avss.n3707 4.75135
R16893 avss.n4454 avss.n4453 4.75135
R16894 avss.n4434 avss.n4433 4.75135
R16895 avss.n3728 avss.n3693 4.75135
R16896 avss.n4476 avss.n4475 4.75135
R16897 avss.n3703 avss.n3687 4.75135
R16898 avss.n4995 avss.n4994 4.7462
R16899 avss.n421 avss.n399 4.7462
R16900 avss.n6857 avss.n6856 4.7462
R16901 avss.n2332 avss.n2331 4.7462
R16902 avss.n3160 avss.n3159 4.7462
R16903 avss.n7068 avss.n828 4.7462
R16904 avss.n4325 avss.n3885 4.7462
R16905 avss.n4436 avss.n3742 4.7462
R16906 avss.n6544 avss.n6533 4.7417
R16907 avss.n5547 avss.n4745 4.73124
R16908 avss.n7282 avss.n530 4.73124
R16909 avss.n6976 avss.n1019 4.73124
R16910 avss.n2524 avss.n2252 4.73124
R16911 avss.n2208 avss.n2207 4.73124
R16912 avss.n7155 avss.n684 4.73124
R16913 avss.n4113 avss.n3994 4.73124
R16914 avss.n4528 avss.n4527 4.73124
R16915 avss.n5496 avss.n5495 4.73124
R16916 avss.n2800 avss.n527 4.73124
R16917 avss.n6958 avss.n6957 4.73124
R16918 avss.n2585 avss.n2584 4.73124
R16919 avss.n3255 avss.n3254 4.73124
R16920 avss.n7192 avss.n7191 4.73124
R16921 avss.n4190 avss.n3997 4.73124
R16922 avss.n3650 avss.n3649 4.73124
R16923 avss.n5495 avss.n4706 4.73067
R16924 avss.n7289 avss.n527 4.73067
R16925 avss.n6957 avss.n979 4.73067
R16926 avss.n2586 avss.n2585 4.73067
R16927 avss.n3254 avss.n3253 4.73067
R16928 avss.n7191 avss.n7190 4.73067
R16929 avss.n4191 avss.n4190 4.73067
R16930 avss.n3651 avss.n3650 4.73067
R16931 avss.n5549 avss.n5547 4.73067
R16932 avss.n7283 avss.n7282 4.73067
R16933 avss.n6978 avss.n6976 4.73067
R16934 avss.n2497 avss.n2252 4.73067
R16935 avss.n2207 avss.n2206 4.73067
R16936 avss.n7157 avss.n7155 4.73067
R16937 avss.n4197 avss.n3994 4.73067
R16938 avss.n4527 avss.n3562 4.73067
R16939 avss.n4980 avss.n4814 4.7255
R16940 avss.n4990 avss.n4912 4.7255
R16941 avss.n5066 avss.n5065 4.7255
R16942 avss.n5524 avss.n4699 4.7255
R16943 avss.n5414 avss.n5413 4.7255
R16944 avss.n7267 avss.n7266 4.7255
R16945 avss.n7457 avss.n7456 4.7255
R16946 avss.n7460 avss.n7459 4.7255
R16947 avss.n7327 avss.n7325 4.7255
R16948 avss.n6850 avss.n6849 4.7255
R16949 avss.n6852 avss.n1122 4.7255
R16950 avss.n6767 avss.n6759 4.7255
R16951 avss.n6394 avss.n6393 4.7255
R16952 avss.n1083 avss.n972 4.7255
R16953 avss.n2417 avss.n2260 4.7255
R16954 avss.n2327 avss.n2320 4.7255
R16955 avss.n2742 avss.n2741 4.7255
R16956 avss.n3319 avss.n3318 4.7255
R16957 avss.n2681 avss.n2680 4.7255
R16958 avss.n3169 avss.n3168 4.7255
R16959 avss.n3162 avss.n3161 4.7255
R16960 avss.n3001 avss.n3000 4.7255
R16961 avss.n1993 avss.n1992 4.7255
R16962 avss.n3200 avss.n3199 4.7255
R16963 avss.n3823 avss.n3822 4.7255
R16964 avss.n7136 avss.n7135 4.7255
R16965 avss.n7078 avss.n7077 4.7255
R16966 avss.n867 avss.n707 4.7255
R16967 avss.n7140 avss.n7139 4.7255
R16968 avss.n5187 avss.n596 4.7255
R16969 avss.n4235 avss.n3843 4.7255
R16970 avss.n4334 avss.n4333 4.7255
R16971 avss.n4314 avss.n3886 4.7255
R16972 avss.n4174 avss.n4173 4.7255
R16973 avss.n7246 avss.n7245 4.7255
R16974 avss.n4445 avss.n4444 4.7255
R16975 avss.n4425 avss.n3743 4.7255
R16976 avss.n7237 avss.n7236 4.7255
R16977 avss.n4616 avss.n4615 4.7255
R16978 avss.n3310 avss.n3309 4.7255
R16979 avss.n4663 avss.t115 4.62619
R16980 avss.n6249 avss.t112 4.62619
R16981 avss.n2926 avss.n2132 4.60576
R16982 avss.n4160 avss.n627 4.60576
R16983 avss.n4663 avss.n4662 4.60145
R16984 avss.n6249 avss.n6248 4.60145
R16985 avss.n3351 avss.n3350 4.58203
R16986 avss.n2926 avss.n2149 4.51439
R16987 avss.n3512 avss.n627 4.51439
R16988 avss.n6555 avss.n6544 4.5005
R16989 avss.n6557 avss.n6556 4.5005
R16990 avss.n6551 avss.n6550 4.5005
R16991 avss.n6548 avss.n6547 4.5005
R16992 avss.n6587 avss.n6586 4.5005
R16993 avss.n6588 avss.n6568 4.5005
R16994 avss.n6590 avss.n6589 4.5005
R16995 avss.n6536 avss.n6535 4.5005
R16996 avss.n6603 avss.n6602 4.5005
R16997 avss.n6570 avss.n6569 4.5005
R16998 avss.n6582 avss.n6581 4.5005
R16999 avss.n6565 avss.n6564 4.5005
R17000 avss.n6595 avss.n6594 4.5005
R17001 avss.n6596 avss.n6563 4.5005
R17002 avss.n6598 avss.n6597 4.5005
R17003 avss.n6580 avss.n6575 4.5005
R17004 avss.n6663 avss.n1657 4.5005
R17005 avss.n6662 avss.n6661 4.5005
R17006 avss.n6663 avss.n6662 4.5005
R17007 avss.n1393 avss.n1392 4.5005
R17008 avss.n1394 avss.n1376 4.5005
R17009 avss.n1396 avss.n1395 4.5005
R17010 avss.n1366 avss.n1365 4.5005
R17011 avss.n1409 avss.n1408 4.5005
R17012 avss.n1410 avss.n1364 4.5005
R17013 avss.n1412 avss.n1411 4.5005
R17014 avss.n1354 avss.n1353 4.5005
R17015 avss.n1425 avss.n1424 4.5005
R17016 avss.n1426 avss.n1352 4.5005
R17017 avss.n1428 avss.n1427 4.5005
R17018 avss.n1342 avss.n1341 4.5005
R17019 avss.n1441 avss.n1440 4.5005
R17020 avss.n1442 avss.n1340 4.5005
R17021 avss.n1444 avss.n1443 4.5005
R17022 avss.n1330 avss.n1329 4.5005
R17023 avss.n1457 avss.n1456 4.5005
R17024 avss.n1458 avss.n1328 4.5005
R17025 avss.n1460 avss.n1459 4.5005
R17026 avss.n1318 avss.n1317 4.5005
R17027 avss.n1476 avss.n1475 4.5005
R17028 avss.n1477 avss.n1316 4.5005
R17029 avss.n1480 avss.n1479 4.5005
R17030 avss.n1478 avss.n1182 4.5005
R17031 avss.n6714 avss.n1183 4.5005
R17032 avss.n6713 avss.n1184 4.5005
R17033 avss.n6712 avss.n1185 4.5005
R17034 avss.n1193 avss.n1186 4.5005
R17035 avss.n6706 avss.n1194 4.5005
R17036 avss.n6705 avss.n1195 4.5005
R17037 avss.n6704 avss.n1196 4.5005
R17038 avss.n1499 avss.n1197 4.5005
R17039 avss.n1501 avss.n1500 4.5005
R17040 avss.n1300 avss.n1299 4.5005
R17041 avss.n1514 avss.n1513 4.5005
R17042 avss.n1515 avss.n1298 4.5005
R17043 avss.n1517 avss.n1516 4.5005
R17044 avss.n1288 avss.n1287 4.5005
R17045 avss.n1530 avss.n1529 4.5005
R17046 avss.n1531 avss.n1286 4.5005
R17047 avss.n1533 avss.n1532 4.5005
R17048 avss.n1276 avss.n1275 4.5005
R17049 avss.n1549 avss.n1548 4.5005
R17050 avss.n1550 avss.n1274 4.5005
R17051 avss.n1553 avss.n1552 4.5005
R17052 avss.n1551 avss.n1256 4.5005
R17053 avss.n1637 avss.n1257 4.5005
R17054 avss.n1636 avss.n1258 4.5005
R17055 avss.n1635 avss.n1259 4.5005
R17056 avss.n1262 avss.n1261 4.5005
R17057 avss.n1260 avss.n1208 4.5005
R17058 avss.n6697 avss.n1209 4.5005
R17059 avss.n6696 avss.n1210 4.5005
R17060 avss.n6695 avss.n1211 4.5005
R17061 avss.n1614 avss.n1212 4.5005
R17062 avss.n1617 avss.n1616 4.5005
R17063 avss.n1615 avss.n1230 4.5005
R17064 avss.n6681 avss.n1231 4.5005
R17065 avss.n6680 avss.n1232 4.5005
R17066 avss.n6679 avss.n1233 4.5005
R17067 avss.n1584 avss.n1234 4.5005
R17068 avss.n1601 avss.n1585 4.5005
R17069 avss.n1600 avss.n1599 4.5005
R17070 avss.n1378 avss.n1377 4.5005
R17071 avss.n1388 avss.n1387 4.5005
R17072 avss.n1371 avss.n1370 4.5005
R17073 avss.n1401 avss.n1400 4.5005
R17074 avss.n1402 avss.n1369 4.5005
R17075 avss.n1404 avss.n1403 4.5005
R17076 avss.n1360 avss.n1359 4.5005
R17077 avss.n1417 avss.n1416 4.5005
R17078 avss.n1418 avss.n1358 4.5005
R17079 avss.n1420 avss.n1419 4.5005
R17080 avss.n1348 avss.n1347 4.5005
R17081 avss.n1433 avss.n1432 4.5005
R17082 avss.n1434 avss.n1346 4.5005
R17083 avss.n1436 avss.n1435 4.5005
R17084 avss.n1336 avss.n1335 4.5005
R17085 avss.n1449 avss.n1448 4.5005
R17086 avss.n1450 avss.n1334 4.5005
R17087 avss.n1452 avss.n1451 4.5005
R17088 avss.n1324 avss.n1323 4.5005
R17089 avss.n1465 avss.n1464 4.5005
R17090 avss.n1466 avss.n1322 4.5005
R17091 avss.n1471 avss.n1467 4.5005
R17092 avss.n1470 avss.n1469 4.5005
R17093 avss.n1468 avss.n1312 4.5005
R17094 avss.n1485 avss.n1311 4.5005
R17095 avss.n1487 avss.n1486 4.5005
R17096 avss.n1488 avss.n1310 4.5005
R17097 avss.n1490 avss.n1489 4.5005
R17098 avss.n1491 avss.n1308 4.5005
R17099 avss.n1493 avss.n1492 4.5005
R17100 avss.n1494 avss.n1307 4.5005
R17101 avss.n1496 avss.n1495 4.5005
R17102 avss.n1497 avss.n1305 4.5005
R17103 avss.n1506 avss.n1505 4.5005
R17104 avss.n1507 avss.n1304 4.5005
R17105 avss.n1509 avss.n1508 4.5005
R17106 avss.n1294 avss.n1293 4.5005
R17107 avss.n1522 avss.n1521 4.5005
R17108 avss.n1523 avss.n1292 4.5005
R17109 avss.n1525 avss.n1524 4.5005
R17110 avss.n1282 avss.n1281 4.5005
R17111 avss.n1538 avss.n1537 4.5005
R17112 avss.n1539 avss.n1280 4.5005
R17113 avss.n1544 avss.n1540 4.5005
R17114 avss.n1543 avss.n1542 4.5005
R17115 avss.n1541 avss.n1268 4.5005
R17116 avss.n1558 avss.n1269 4.5005
R17117 avss.n1559 avss.n1267 4.5005
R17118 avss.n1562 avss.n1561 4.5005
R17119 avss.n1563 avss.n1266 4.5005
R17120 avss.n1629 avss.n1564 4.5005
R17121 avss.n1628 avss.n1565 4.5005
R17122 avss.n1627 avss.n1566 4.5005
R17123 avss.n1626 avss.n1567 4.5005
R17124 avss.n1624 avss.n1568 4.5005
R17125 avss.n1623 avss.n1569 4.5005
R17126 avss.n1571 avss.n1570 4.5005
R17127 avss.n1611 avss.n1572 4.5005
R17128 avss.n1610 avss.n1573 4.5005
R17129 avss.n1609 avss.n1574 4.5005
R17130 avss.n1607 avss.n1575 4.5005
R17131 avss.n1606 avss.n1576 4.5005
R17132 avss.n1578 avss.n1577 4.5005
R17133 avss.n1580 avss.n1579 4.5005
R17134 avss.n1386 avss.n1382 4.5005
R17135 avss.n1590 avss.n1589 4.5005
R17136 avss.n1587 avss.n1241 4.5005
R17137 avss.n6689 avss.n6688 4.5005
R17138 avss.n6690 avss.n1219 4.5005
R17139 avss.n1646 avss.n1645 4.5005
R17140 avss.n1643 avss.n1642 4.5005
R17141 avss.n1655 avss.n1654 4.5005
R17142 avss.n5792 avss.n5742 4.5005
R17143 avss.n5788 avss.n1652 4.5005
R17144 avss.n5792 avss.n1652 4.5005
R17145 avss.n5784 avss.n5781 4.5005
R17146 avss.n5787 avss.n5781 4.5005
R17147 avss.n5787 avss.n5746 4.5005
R17148 avss.n5800 avss.n5799 4.5005
R17149 avss.n5808 avss.n5807 4.5005
R17150 avss.n5807 avss.n5806 4.5005
R17151 avss.n5806 avss.n5804 4.5005
R17152 avss.n5762 avss.n5760 4.5005
R17153 avss.n5764 avss.n5763 4.5005
R17154 avss.n5763 avss.n5762 4.5005
R17155 avss.n5775 avss.n5774 4.5005
R17156 avss.n5774 avss.n5773 4.5005
R17157 avss.n5773 avss.n5771 4.5005
R17158 avss.n5776 avss.n5748 4.5005
R17159 avss.n5777 avss.n5776 4.5005
R17160 avss.n5778 avss.n5777 4.5005
R17161 avss.n5756 avss.n5755 4.5005
R17162 avss.n5793 avss.n5739 4.5005
R17163 avss.n5796 avss.n5739 4.5005
R17164 avss.n5796 avss.n5738 4.5005
R17165 avss.n5814 avss.n5732 4.5005
R17166 avss.n5814 avss.n5813 4.5005
R17167 avss.n5813 avss.n5809 4.5005
R17168 avss.n6113 avss.n6112 4.5005
R17169 avss.n6114 avss.n5704 4.5005
R17170 avss.n5859 avss.n5858 4.5005
R17171 avss.n5856 avss.n5725 4.5005
R17172 avss.n6087 avss.n6086 4.5005
R17173 avss.n6085 avss.n5827 4.5005
R17174 avss.n6202 avss.n5600 4.5005
R17175 avss.n6201 avss.n5602 4.5005
R17176 avss.n5909 avss.n5603 4.5005
R17177 avss.n5912 avss.n5910 4.5005
R17178 avss.n5916 avss.n5915 4.5005
R17179 avss.n5917 avss.n5908 4.5005
R17180 avss.n5919 avss.n5918 4.5005
R17181 avss.n5922 avss.n5907 4.5005
R17182 avss.n5926 avss.n5925 4.5005
R17183 avss.n5927 avss.n5906 4.5005
R17184 avss.n5929 avss.n5928 4.5005
R17185 avss.n5932 avss.n5905 4.5005
R17186 avss.n5936 avss.n5935 4.5005
R17187 avss.n5937 avss.n5904 4.5005
R17188 avss.n5939 avss.n5938 4.5005
R17189 avss.n5942 avss.n5903 4.5005
R17190 avss.n5946 avss.n5945 4.5005
R17191 avss.n5947 avss.n5902 4.5005
R17192 avss.n5949 avss.n5948 4.5005
R17193 avss.n5952 avss.n5901 4.5005
R17194 avss.n5956 avss.n5955 4.5005
R17195 avss.n5957 avss.n5900 4.5005
R17196 avss.n5959 avss.n5958 4.5005
R17197 avss.n5962 avss.n5899 4.5005
R17198 avss.n5966 avss.n5965 4.5005
R17199 avss.n5967 avss.n5898 4.5005
R17200 avss.n5969 avss.n5968 4.5005
R17201 avss.n5972 avss.n5897 4.5005
R17202 avss.n5976 avss.n5975 4.5005
R17203 avss.n5977 avss.n5896 4.5005
R17204 avss.n5979 avss.n5978 4.5005
R17205 avss.n5982 avss.n5895 4.5005
R17206 avss.n5986 avss.n5985 4.5005
R17207 avss.n5987 avss.n5894 4.5005
R17208 avss.n5989 avss.n5988 4.5005
R17209 avss.n5992 avss.n5893 4.5005
R17210 avss.n5995 avss.n5994 4.5005
R17211 avss.n5996 avss.n5892 4.5005
R17212 avss.n5999 avss.n5998 4.5005
R17213 avss.n5997 avss.n5872 4.5005
R17214 avss.n6005 avss.n5871 4.5005
R17215 avss.n6007 avss.n6006 4.5005
R17216 avss.n6008 avss.n5870 4.5005
R17217 avss.n6010 avss.n6009 4.5005
R17218 avss.n6012 avss.n5869 4.5005
R17219 avss.n6014 avss.n6013 4.5005
R17220 avss.n6015 avss.n5868 4.5005
R17221 avss.n6017 avss.n6016 4.5005
R17222 avss.n6027 avss.n5867 4.5005
R17223 avss.n6029 avss.n6028 4.5005
R17224 avss.n6030 avss.n5866 4.5005
R17225 avss.n6032 avss.n6031 4.5005
R17226 avss.n6033 avss.n5864 4.5005
R17227 avss.n6044 avss.n6043 4.5005
R17228 avss.n6045 avss.n5863 4.5005
R17229 avss.n6047 avss.n6046 4.5005
R17230 avss.n5845 avss.n5844 4.5005
R17231 avss.n6061 avss.n6060 4.5005
R17232 avss.n6062 avss.n5843 4.5005
R17233 avss.n6069 avss.n6063 4.5005
R17234 avss.n6068 avss.n6064 4.5005
R17235 avss.n6067 avss.n6065 4.5005
R17236 avss.n6066 avss.n5820 4.5005
R17237 avss.n6204 avss.n6203 4.5005
R17238 avss.n5611 avss.n5610 4.5005
R17239 avss.n6197 avss.n5612 4.5005
R17240 avss.n6196 avss.n5613 4.5005
R17241 avss.n6195 avss.n5614 4.5005
R17242 avss.n5619 avss.n5615 4.5005
R17243 avss.n5620 avss.n5617 4.5005
R17244 avss.n6188 avss.n5621 4.5005
R17245 avss.n6187 avss.n5622 4.5005
R17246 avss.n6186 avss.n5623 4.5005
R17247 avss.n5627 avss.n5624 4.5005
R17248 avss.n6181 avss.n5628 4.5005
R17249 avss.n6180 avss.n5629 4.5005
R17250 avss.n6179 avss.n5630 4.5005
R17251 avss.n5634 avss.n5631 4.5005
R17252 avss.n6174 avss.n5635 4.5005
R17253 avss.n6173 avss.n5636 4.5005
R17254 avss.n6172 avss.n5637 4.5005
R17255 avss.n5641 avss.n5638 4.5005
R17256 avss.n6167 avss.n5642 4.5005
R17257 avss.n6166 avss.n5643 4.5005
R17258 avss.n6165 avss.n5644 4.5005
R17259 avss.n5648 avss.n5645 4.5005
R17260 avss.n6160 avss.n5649 4.5005
R17261 avss.n6159 avss.n5650 4.5005
R17262 avss.n6158 avss.n5651 4.5005
R17263 avss.n5655 avss.n5652 4.5005
R17264 avss.n6153 avss.n5656 4.5005
R17265 avss.n6152 avss.n5657 4.5005
R17266 avss.n6151 avss.n5658 4.5005
R17267 avss.n5662 avss.n5659 4.5005
R17268 avss.n6146 avss.n5663 4.5005
R17269 avss.n6145 avss.n5664 4.5005
R17270 avss.n6144 avss.n5665 4.5005
R17271 avss.n5669 avss.n5666 4.5005
R17272 avss.n6139 avss.n5670 4.5005
R17273 avss.n6138 avss.n5671 4.5005
R17274 avss.n6137 avss.n5672 4.5005
R17275 avss.n5676 avss.n5673 4.5005
R17276 avss.n6132 avss.n5677 4.5005
R17277 avss.n6131 avss.n5678 4.5005
R17278 avss.n6130 avss.n5679 4.5005
R17279 avss.n5691 avss.n5680 4.5005
R17280 avss.n5692 avss.n5690 4.5005
R17281 avss.n6122 avss.n5693 4.5005
R17282 avss.n6121 avss.n5694 4.5005
R17283 avss.n6120 avss.n5695 4.5005
R17284 avss.n6019 avss.n5696 4.5005
R17285 avss.n6022 avss.n6021 4.5005
R17286 avss.n6020 avss.n5714 4.5005
R17287 avss.n6105 avss.n5715 4.5005
R17288 avss.n6104 avss.n5716 4.5005
R17289 avss.n6103 avss.n5717 4.5005
R17290 avss.n6037 avss.n5718 4.5005
R17291 avss.n6039 avss.n6038 4.5005
R17292 avss.n5852 avss.n5851 4.5005
R17293 avss.n6053 avss.n6052 4.5005
R17294 avss.n6054 avss.n5850 4.5005
R17295 avss.n6056 avss.n6055 4.5005
R17296 avss.n5838 avss.n5837 4.5005
R17297 avss.n6075 avss.n6074 4.5005
R17298 avss.n6076 avss.n5836 4.5005
R17299 avss.n6080 avss.n6077 4.5005
R17300 avss.n6079 avss.n6078 4.5005
R17301 avss.n5609 avss.n5599 4.5005
R17302 avss.n4935 avss.n4934 4.5005
R17303 avss.n4933 avss.n4923 4.5005
R17304 avss.n4951 avss.n4924 4.5005
R17305 avss.n4952 avss.n4922 4.5005
R17306 avss.n4955 avss.n4954 4.5005
R17307 avss.n4956 avss.n4921 4.5005
R17308 avss.n4961 avss.n4957 4.5005
R17309 avss.n4960 avss.n4959 4.5005
R17310 avss.n4958 avss.n4919 4.5005
R17311 avss.n4976 avss.n4918 4.5005
R17312 avss.n4978 avss.n4977 4.5005
R17313 avss.n4979 avss.n4917 4.5005
R17314 avss.n4981 avss.n4980 4.5005
R17315 avss.n4936 avss.n4932 4.5005
R17316 avss.n4943 avss.n4928 4.5005
R17317 avss.n4946 avss.n4945 4.5005
R17318 avss.n4944 avss.n4882 4.5005
R17319 avss.n5015 avss.n4883 4.5005
R17320 avss.n5014 avss.n4884 4.5005
R17321 avss.n5013 avss.n4885 4.5005
R17322 avss.n4967 avss.n4886 4.5005
R17323 avss.n4968 avss.n4966 4.5005
R17324 avss.n4971 avss.n4970 4.5005
R17325 avss.n4969 avss.n4909 4.5005
R17326 avss.n5003 avss.n4910 4.5005
R17327 avss.n5002 avss.n4911 4.5005
R17328 avss.n5001 avss.n4912 4.5005
R17329 avss.n4942 avss.n4941 4.5005
R17330 avss.n4873 avss.n4872 4.5005
R17331 avss.n5021 avss.n5020 4.5005
R17332 avss.n5034 avss.n5033 4.5005
R17333 avss.n4858 avss.n4857 4.5005
R17334 avss.n4801 avss.n4800 4.5005
R17335 avss.n5459 avss.n5458 4.5005
R17336 avss.n5460 avss.n4799 4.5005
R17337 avss.n5464 avss.n5461 4.5005
R17338 avss.n5463 avss.n5462 4.5005
R17339 avss.n4779 avss.n4778 4.5005
R17340 avss.n5489 avss.n5488 4.5005
R17341 avss.n5490 avss.n4777 4.5005
R17342 avss.n5503 avss.n5491 4.5005
R17343 avss.n5502 avss.n5492 4.5005
R17344 avss.n5501 avss.n5493 4.5005
R17345 avss.n5498 avss.n5494 4.5005
R17346 avss.n5497 avss.n5496 4.5005
R17347 avss.n5419 avss.n5418 4.5005
R17348 avss.n5425 avss.n4806 4.5005
R17349 avss.n5454 avss.n5426 4.5005
R17350 avss.n5453 avss.n5427 4.5005
R17351 avss.n5452 avss.n5428 4.5005
R17352 avss.n5451 avss.n5429 4.5005
R17353 avss.n5448 avss.n5430 4.5005
R17354 avss.n5447 avss.n5431 4.5005
R17355 avss.n5446 avss.n5432 4.5005
R17356 avss.n5444 avss.n5433 4.5005
R17357 avss.n5443 avss.n5434 4.5005
R17358 avss.n5436 avss.n5435 4.5005
R17359 avss.n5439 avss.n5437 4.5005
R17360 avss.n5438 avss.n4745 4.5005
R17361 avss.n5424 avss.n5423 4.5005
R17362 avss.n5550 avss.n4744 4.5005
R17363 avss.n5554 avss.n5551 4.5005
R17364 avss.n5555 avss.n4743 4.5005
R17365 avss.n5558 avss.n5557 4.5005
R17366 avss.n5549 avss.n5548 4.5005
R17367 avss.n5584 avss.n5583 4.5005
R17368 avss.n5582 avss.n4707 4.5005
R17369 avss.n5581 avss.n5580 4.5005
R17370 avss.n4709 avss.n4708 4.5005
R17371 avss.n5585 avss.n4706 4.5005
R17372 avss.n4862 avss.n4861 4.5005
R17373 avss.n4860 avss.n4742 4.5005
R17374 avss.n4894 avss.n4893 4.5005
R17375 avss.n4892 avss.n4866 4.5005
R17376 avss.n5024 avss.n5023 4.5005
R17377 avss.n4870 avss.n4859 4.5005
R17378 avss.n4900 avss.n4899 4.5005
R17379 avss.n4898 avss.n4897 4.5005
R17380 avss.n4994 avss.n4993 4.5005
R17381 avss.n4992 avss.n4991 4.5005
R17382 avss.n4988 avss.n4987 4.5005
R17383 avss.n4986 avss.n4985 4.5005
R17384 avss.n5572 avss.n4717 4.5005
R17385 avss.n5571 avss.n4719 4.5005
R17386 avss.n4845 avss.n4720 4.5005
R17387 avss.n4847 avss.n4846 4.5005
R17388 avss.n4850 avss.n4849 4.5005
R17389 avss.n4851 avss.n4844 4.5005
R17390 avss.n4853 avss.n4852 4.5005
R17391 avss.n4831 avss.n4830 4.5005
R17392 avss.n5048 avss.n5047 4.5005
R17393 avss.n5049 avss.n4829 4.5005
R17394 avss.n5051 avss.n5050 4.5005
R17395 avss.n4817 avss.n4816 4.5005
R17396 avss.n5065 avss.n5064 4.5005
R17397 avss.n5574 avss.n5573 4.5005
R17398 avss.n4728 avss.n4727 4.5005
R17399 avss.n5567 avss.n4729 4.5005
R17400 avss.n5566 avss.n4730 4.5005
R17401 avss.n5565 avss.n4731 4.5005
R17402 avss.n4837 avss.n4732 4.5005
R17403 avss.n4839 avss.n4838 4.5005
R17404 avss.n5040 avss.n5039 4.5005
R17405 avss.n5041 avss.n4836 4.5005
R17406 avss.n5043 avss.n5042 4.5005
R17407 avss.n4825 avss.n4824 4.5005
R17408 avss.n5057 avss.n5056 4.5005
R17409 avss.n5058 avss.n4823 4.5005
R17410 avss.n5060 avss.n5059 4.5005
R17411 avss.n4726 avss.n4716 4.5005
R17412 avss.n5478 avss.n5477 4.5005
R17413 avss.n5479 avss.n4784 4.5005
R17414 avss.n5483 avss.n5480 4.5005
R17415 avss.n5482 avss.n5481 4.5005
R17416 avss.n4761 avss.n4760 4.5005
R17417 avss.n5517 avss.n5516 4.5005
R17418 avss.n5518 avss.n4759 4.5005
R17419 avss.n5531 avss.n5519 4.5005
R17420 avss.n5530 avss.n5520 4.5005
R17421 avss.n5529 avss.n5521 4.5005
R17422 avss.n5528 avss.n5522 4.5005
R17423 avss.n5526 avss.n5523 4.5005
R17424 avss.n5525 avss.n5524 4.5005
R17425 avss.n4786 avss.n4785 4.5005
R17426 avss.n5473 avss.n5472 4.5005
R17427 avss.n5471 avss.n4793 4.5005
R17428 avss.n4769 avss.n4768 4.5005
R17429 avss.n5509 avss.n5508 4.5005
R17430 avss.n5510 avss.n4767 4.5005
R17431 avss.n5512 avss.n5511 4.5005
R17432 avss.n4754 avss.n4753 4.5005
R17433 avss.n5537 avss.n5536 4.5005
R17434 avss.n5538 avss.n4752 4.5005
R17435 avss.n5541 avss.n5540 4.5005
R17436 avss.n5539 avss.n4697 4.5005
R17437 avss.n5593 avss.n4698 4.5005
R17438 avss.n5592 avss.n5591 4.5005
R17439 avss.n5470 avss.n4792 4.5005
R17440 avss.n5363 avss.n5108 4.5005
R17441 avss.n5365 avss.n5364 4.5005
R17442 avss.n5098 avss.n5097 4.5005
R17443 avss.n5378 avss.n5377 4.5005
R17444 avss.n5379 avss.n5096 4.5005
R17445 avss.n5381 avss.n5380 4.5005
R17446 avss.n5086 avss.n5085 4.5005
R17447 avss.n5394 avss.n5393 4.5005
R17448 avss.n5395 avss.n5084 4.5005
R17449 avss.n5398 avss.n5397 4.5005
R17450 avss.n5396 avss.n5073 4.5005
R17451 avss.n5411 avss.n5072 4.5005
R17452 avss.n5413 avss.n5412 4.5005
R17453 avss.n5362 avss.n5361 4.5005
R17454 avss.n5104 avss.n5103 4.5005
R17455 avss.n5370 avss.n5369 4.5005
R17456 avss.n5371 avss.n5102 4.5005
R17457 avss.n5373 avss.n5372 4.5005
R17458 avss.n5092 avss.n5091 4.5005
R17459 avss.n5386 avss.n5385 4.5005
R17460 avss.n5387 avss.n5090 4.5005
R17461 avss.n5389 avss.n5388 4.5005
R17462 avss.n5080 avss.n5079 4.5005
R17463 avss.n5403 avss.n5402 4.5005
R17464 avss.n5404 avss.n5078 4.5005
R17465 avss.n5407 avss.n5405 4.5005
R17466 avss.n5406 avss.n4812 4.5005
R17467 avss.n5357 avss.n5356 4.5005
R17468 avss.n5069 avss.n4813 4.5005
R17469 avss.n6284 avss.n6283 4.5005
R17470 avss.n6268 avss.n6267 4.5005
R17471 avss.n6297 avss.n6296 4.5005
R17472 avss.n6298 avss.n6266 4.5005
R17473 avss.n6300 avss.n6299 4.5005
R17474 avss.n6254 avss.n6253 4.5005
R17475 avss.n6313 avss.n6312 4.5005
R17476 avss.n6282 avss.n6278 4.5005
R17477 avss.n6306 avss.n6260 4.5005
R17478 avss.n6305 avss.n6304 4.5005
R17479 avss.n6262 avss.n6261 4.5005
R17480 avss.n6292 avss.n6291 4.5005
R17481 avss.n6290 avss.n6272 4.5005
R17482 avss.n6289 avss.n6288 4.5005
R17483 avss.n6274 avss.n6273 4.5005
R17484 avss.n6308 avss.n6307 4.5005
R17485 avss.n6315 avss.n6314 4.5005
R17486 avss.n6447 avss.n6446 4.5005
R17487 avss.n6450 avss.n1702 4.5005
R17488 avss.n6442 avss.n1709 4.5005
R17489 avss.n6443 avss.n1707 4.5005
R17490 avss.n6443 avss.n6442 4.5005
R17491 avss.n6406 avss.n1737 4.5005
R17492 avss.n3333 avss.n3329 4.5005
R17493 avss.n3336 avss.n3329 4.5005
R17494 avss.n3336 avss.n3328 4.5005
R17495 avss.n6458 avss.n1698 4.5005
R17496 avss.n6461 avss.n1698 4.5005
R17497 avss.n6461 avss.n1697 4.5005
R17498 avss.n6411 avss.n6410 4.5005
R17499 avss.n6409 avss.n1715 4.5005
R17500 avss.n6410 avss.n6409 4.5005
R17501 avss.n6434 avss.n1712 4.5005
R17502 avss.n6435 avss.n6434 4.5005
R17503 avss.n6436 avss.n6435 4.5005
R17504 avss.n2856 avss.n2855 4.5005
R17505 avss.n2889 avss.n2862 4.5005
R17506 avss.n2888 avss.n2863 4.5005
R17507 avss.n2887 avss.n2864 4.5005
R17508 avss.n2884 avss.n2865 4.5005
R17509 avss.n2883 avss.n2866 4.5005
R17510 avss.n2880 avss.n2867 4.5005
R17511 avss.n2879 avss.n2868 4.5005
R17512 avss.n2875 avss.n2869 4.5005
R17513 avss.n2874 avss.n2870 4.5005
R17514 avss.n2873 avss.n2871 4.5005
R17515 avss.n548 avss.n547 4.5005
R17516 avss.n7268 avss.n7267 4.5005
R17517 avss.n2895 avss.n2894 4.5005
R17518 avss.n2921 avss.n2898 4.5005
R17519 avss.n2920 avss.n2899 4.5005
R17520 avss.n2917 avss.n2900 4.5005
R17521 avss.n2916 avss.n2901 4.5005
R17522 avss.n2913 avss.n2902 4.5005
R17523 avss.n2912 avss.n2903 4.5005
R17524 avss.n2909 avss.n2904 4.5005
R17525 avss.n2908 avss.n2906 4.5005
R17526 avss.n2905 avss.n539 4.5005
R17527 avss.n7276 avss.n540 4.5005
R17528 avss.n7275 avss.n541 4.5005
R17529 avss.n7274 avss.n542 4.5005
R17530 avss.n549 avss.n543 4.5005
R17531 avss.n2922 avss.n2897 4.5005
R17532 avss.n7422 avss.n7421 4.5005
R17533 avss.n7423 avss.n7420 4.5005
R17534 avss.n7379 avss.n475 4.5005
R17535 avss.n7380 avss.n7378 4.5005
R17536 avss.n3281 avss.n3280 4.5005
R17537 avss.n3279 avss.n2003 4.5005
R17538 avss.n3278 avss.n3277 4.5005
R17539 avss.n2005 avss.n2004 4.5005
R17540 avss.n2784 avss.n2782 4.5005
R17541 avss.n2788 avss.n2787 4.5005
R17542 avss.n2789 avss.n2781 4.5005
R17543 avss.n2791 avss.n2790 4.5005
R17544 avss.n2794 avss.n2780 4.5005
R17545 avss.n2797 avss.n2796 4.5005
R17546 avss.n2798 avss.n2779 4.5005
R17547 avss.n2802 avss.n2799 4.5005
R17548 avss.n2801 avss.n2800 4.5005
R17549 avss.n3282 avss.n2002 4.5005
R17550 avss.n2819 avss.n2815 4.5005
R17551 avss.n2823 avss.n2822 4.5005
R17552 avss.n2824 avss.n2814 4.5005
R17553 avss.n2826 avss.n2825 4.5005
R17554 avss.n2829 avss.n2813 4.5005
R17555 avss.n2833 avss.n2832 4.5005
R17556 avss.n2834 avss.n2812 4.5005
R17557 avss.n2836 avss.n2835 4.5005
R17558 avss.n2839 avss.n2811 4.5005
R17559 avss.n2842 avss.n2841 4.5005
R17560 avss.n2843 avss.n2810 4.5005
R17561 avss.n2846 avss.n2844 4.5005
R17562 avss.n2845 avss.n530 4.5005
R17563 avss.n2818 avss.n2817 4.5005
R17564 avss.n521 avss.n520 4.5005
R17565 avss.n7296 avss.n7295 4.5005
R17566 avss.n7297 avss.n519 4.5005
R17567 avss.n7304 avss.n7303 4.5005
R17568 avss.n7284 avss.n7283 4.5005
R17569 avss.n7290 avss.n526 4.5005
R17570 avss.n7292 avss.n7291 4.5005
R17571 avss.n514 avss.n513 4.5005
R17572 avss.n7376 avss.n7375 4.5005
R17573 avss.n7289 avss.n7288 4.5005
R17574 avss.n7299 avss.n7298 4.5005
R17575 avss.n7301 avss.n7300 4.5005
R17576 avss.n7415 avss.n7414 4.5005
R17577 avss.n430 avss.n429 4.5005
R17578 avss.n7410 avss.n427 4.5005
R17579 avss.n7409 avss.n7408 4.5005
R17580 avss.n7429 avss.n7428 4.5005
R17581 avss.n7427 avss.n424 4.5005
R17582 avss.n421 avss.n400 4.5005
R17583 avss.n423 avss.n422 4.5005
R17584 avss.n7469 avss.n7468 4.5005
R17585 avss.n7470 avss.n398 4.5005
R17586 avss.n467 avss.n436 4.5005
R17587 avss.n466 avss.n438 4.5005
R17588 avss.n440 avss.n439 4.5005
R17589 avss.n447 avss.n441 4.5005
R17590 avss.n446 avss.n442 4.5005
R17591 avss.n445 avss.n444 4.5005
R17592 avss.n443 avss.n409 4.5005
R17593 avss.n7447 avss.n408 4.5005
R17594 avss.n7449 avss.n7448 4.5005
R17595 avss.n7450 avss.n407 4.5005
R17596 avss.n7452 avss.n7451 4.5005
R17597 avss.n7454 avss.n405 4.5005
R17598 avss.n7456 avss.n7455 4.5005
R17599 avss.n469 avss.n468 4.5005
R17600 avss.n458 avss.n457 4.5005
R17601 avss.n462 avss.n459 4.5005
R17602 avss.n461 avss.n460 4.5005
R17603 avss.n414 avss.n413 4.5005
R17604 avss.n7438 avss.n7437 4.5005
R17605 avss.n7439 avss.n412 4.5005
R17606 avss.n7442 avss.n7441 4.5005
R17607 avss.n7440 avss.n386 4.5005
R17608 avss.n7477 avss.n387 4.5005
R17609 avss.n7476 avss.n388 4.5005
R17610 avss.n7475 avss.n389 4.5005
R17611 avss.n403 avss.n390 4.5005
R17612 avss.n7461 avss.n7460 4.5005
R17613 avss.n456 avss.n435 4.5005
R17614 avss.n7362 avss.n7310 4.5005
R17615 avss.n7361 avss.n7313 4.5005
R17616 avss.n7359 avss.n7314 4.5005
R17617 avss.n7358 avss.n7315 4.5005
R17618 avss.n7356 avss.n7316 4.5005
R17619 avss.n7355 avss.n7317 4.5005
R17620 avss.n7354 avss.n7318 4.5005
R17621 avss.n7320 avss.n7319 4.5005
R17622 avss.n7340 avss.n7321 4.5005
R17623 avss.n7339 avss.n7322 4.5005
R17624 avss.n7338 avss.n7323 4.5005
R17625 avss.n7335 avss.n7324 4.5005
R17626 avss.n7334 avss.n7325 4.5005
R17627 avss.n7364 avss.n7363 4.5005
R17628 avss.n7369 avss.n7368 4.5005
R17629 avss.n7367 avss.n500 4.5005
R17630 avss.n7388 avss.n501 4.5005
R17631 avss.n7387 avss.n502 4.5005
R17632 avss.n7386 avss.n503 4.5005
R17633 avss.n7345 avss.n504 4.5005
R17634 avss.n7346 avss.n7344 4.5005
R17635 avss.n7349 avss.n7348 4.5005
R17636 avss.n7347 avss.n485 4.5005
R17637 avss.n7400 avss.n486 4.5005
R17638 avss.n7399 avss.n487 4.5005
R17639 avss.n7398 avss.n488 4.5005
R17640 avss.n7326 avss.n489 4.5005
R17641 avss.n7370 avss.n7366 4.5005
R17642 avss.n8008 avss.n4 4.5005
R17643 avss.n8009 avss.n8007 4.5005
R17644 avss.n9393 avss.n12 4.5005
R17645 avss.n9395 avss.n9394 4.5005
R17646 avss.n29 avss.n18 4.5005
R17647 avss.n31 avss.n30 4.5005
R17648 avss.n9372 avss.n32 4.5005
R17649 avss.n9371 avss.n33 4.5005
R17650 avss.n9370 avss.n34 4.5005
R17651 avss.n41 avss.n35 4.5005
R17652 avss.n9364 avss.n42 4.5005
R17653 avss.n9363 avss.n43 4.5005
R17654 avss.n9362 avss.n44 4.5005
R17655 avss.n55 avss.n45 4.5005
R17656 avss.n9355 avss.n56 4.5005
R17657 avss.n9354 avss.n57 4.5005
R17658 avss.n9353 avss.n58 4.5005
R17659 avss.n9323 avss.n59 4.5005
R17660 avss.n9377 avss.n19 4.5005
R17661 avss.n9376 avss.n21 4.5005
R17662 avss.n9328 avss.n22 4.5005
R17663 avss.n9330 avss.n9329 4.5005
R17664 avss.n9332 avss.n9331 4.5005
R17665 avss.n9333 avss.n9327 4.5005
R17666 avss.n9336 avss.n9334 4.5005
R17667 avss.n9337 avss.n9326 4.5005
R17668 avss.n9339 avss.n9338 4.5005
R17669 avss.n9340 avss.n9325 4.5005
R17670 avss.n9343 avss.n9341 4.5005
R17671 avss.n9344 avss.n9324 4.5005
R17672 avss.n9346 avss.n9345 4.5005
R17673 avss.n9379 avss.n9378 4.5005
R17674 avss.n9384 avss.n9383 4.5005
R17675 avss.n9382 avss.n9381 4.5005
R17676 avss.n8002 avss.n2 4.5005
R17677 avss.n8014 avss.n8013 4.5005
R17678 avss.n8058 avss.n7947 4.5005
R17679 avss.n8057 avss.n7949 4.5005
R17680 avss.n7952 avss.n7950 4.5005
R17681 avss.n8053 avss.n7953 4.5005
R17682 avss.n8052 avss.n7954 4.5005
R17683 avss.n8051 avss.n7955 4.5005
R17684 avss.n8018 avss.n7956 4.5005
R17685 avss.n8020 avss.n8019 4.5005
R17686 avss.n8022 avss.n8021 4.5005
R17687 avss.n8023 avss.n8017 4.5005
R17688 avss.n8026 avss.n8024 4.5005
R17689 avss.n8027 avss.n8016 4.5005
R17690 avss.n8029 avss.n8028 4.5005
R17691 avss.n8060 avss.n8059 4.5005
R17692 avss.n7967 avss.n7966 4.5005
R17693 avss.n7969 avss.n7968 4.5005
R17694 avss.n7963 avss.n7962 4.5005
R17695 avss.n7974 avss.n7973 4.5005
R17696 avss.n7975 avss.n7961 4.5005
R17697 avss.n8047 avss.n7976 4.5005
R17698 avss.n8046 avss.n7977 4.5005
R17699 avss.n8045 avss.n7978 4.5005
R17700 avss.n7990 avss.n7979 4.5005
R17701 avss.n8039 avss.n7991 4.5005
R17702 avss.n8038 avss.n7992 4.5005
R17703 avss.n8037 avss.n7993 4.5005
R17704 avss.n8000 avss.n7994 4.5005
R17705 avss.n7965 avss.n7946 4.5005
R17706 avss.n9245 avss.n9244 4.5005
R17707 avss.n9242 avss.n9240 4.5005
R17708 avss.n9310 avss.n9309 4.5005
R17709 avss.n9307 avss.n9306 4.5005
R17710 avss.n8893 avss.n7491 4.5005
R17711 avss.n8892 avss.n7493 4.5005
R17712 avss.n8285 avss.n7494 4.5005
R17713 avss.n8286 avss.n8284 4.5005
R17714 avss.n8289 avss.n8287 4.5005
R17715 avss.n8290 avss.n8283 4.5005
R17716 avss.n8293 avss.n8292 4.5005
R17717 avss.n8294 avss.n8282 4.5005
R17718 avss.n8297 avss.n8295 4.5005
R17719 avss.n8298 avss.n8281 4.5005
R17720 avss.n8301 avss.n8300 4.5005
R17721 avss.n8302 avss.n8280 4.5005
R17722 avss.n8305 avss.n8303 4.5005
R17723 avss.n8306 avss.n8279 4.5005
R17724 avss.n8309 avss.n8308 4.5005
R17725 avss.n8310 avss.n8278 4.5005
R17726 avss.n8313 avss.n8311 4.5005
R17727 avss.n8314 avss.n8277 4.5005
R17728 avss.n8317 avss.n8316 4.5005
R17729 avss.n8318 avss.n8276 4.5005
R17730 avss.n8321 avss.n8319 4.5005
R17731 avss.n8322 avss.n8275 4.5005
R17732 avss.n8325 avss.n8324 4.5005
R17733 avss.n8326 avss.n8274 4.5005
R17734 avss.n8329 avss.n8327 4.5005
R17735 avss.n8330 avss.n8273 4.5005
R17736 avss.n8333 avss.n8332 4.5005
R17737 avss.n8334 avss.n8272 4.5005
R17738 avss.n8337 avss.n8335 4.5005
R17739 avss.n8338 avss.n8271 4.5005
R17740 avss.n8341 avss.n8340 4.5005
R17741 avss.n8342 avss.n8270 4.5005
R17742 avss.n8345 avss.n8343 4.5005
R17743 avss.n8346 avss.n8269 4.5005
R17744 avss.n8349 avss.n8348 4.5005
R17745 avss.n8350 avss.n8268 4.5005
R17746 avss.n8353 avss.n8351 4.5005
R17747 avss.n8354 avss.n8267 4.5005
R17748 avss.n8356 avss.n8355 4.5005
R17749 avss.n8357 avss.n8266 4.5005
R17750 avss.n8387 avss.n8358 4.5005
R17751 avss.n8386 avss.n8359 4.5005
R17752 avss.n8385 avss.n8360 4.5005
R17753 avss.n8384 avss.n8361 4.5005
R17754 avss.n8383 avss.n8362 4.5005
R17755 avss.n8370 avss.n8363 4.5005
R17756 avss.n8374 avss.n8371 4.5005
R17757 avss.n8373 avss.n8372 4.5005
R17758 avss.n114 avss.n113 4.5005
R17759 avss.n9233 avss.n9232 4.5005
R17760 avss.n9234 avss.n112 4.5005
R17761 avss.n9236 avss.n9235 4.5005
R17762 avss.n100 avss.n99 4.5005
R17763 avss.n9265 avss.n9264 4.5005
R17764 avss.n9266 avss.n98 4.5005
R17765 avss.n9268 avss.n9267 4.5005
R17766 avss.n87 avss.n86 4.5005
R17767 avss.n9282 avss.n9281 4.5005
R17768 avss.n9283 avss.n85 4.5005
R17769 avss.n9290 avss.n9284 4.5005
R17770 avss.n9289 avss.n9285 4.5005
R17771 avss.n9288 avss.n9286 4.5005
R17772 avss.n9287 avss.n69 4.5005
R17773 avss.n8895 avss.n8894 4.5005
R17774 avss.n7506 avss.n7505 4.5005
R17775 avss.n8888 avss.n7507 4.5005
R17776 avss.n8887 avss.n7508 4.5005
R17777 avss.n8886 avss.n7509 4.5005
R17778 avss.n7531 avss.n7510 4.5005
R17779 avss.n8876 avss.n7532 4.5005
R17780 avss.n8875 avss.n7533 4.5005
R17781 avss.n8874 avss.n7534 4.5005
R17782 avss.n7555 avss.n7535 4.5005
R17783 avss.n8864 avss.n7556 4.5005
R17784 avss.n8863 avss.n7557 4.5005
R17785 avss.n8862 avss.n7558 4.5005
R17786 avss.n7579 avss.n7559 4.5005
R17787 avss.n8852 avss.n7580 4.5005
R17788 avss.n8851 avss.n7581 4.5005
R17789 avss.n8850 avss.n7582 4.5005
R17790 avss.n7603 avss.n7583 4.5005
R17791 avss.n8840 avss.n7604 4.5005
R17792 avss.n8839 avss.n7605 4.5005
R17793 avss.n8838 avss.n7606 4.5005
R17794 avss.n7627 avss.n7607 4.5005
R17795 avss.n8828 avss.n7628 4.5005
R17796 avss.n8827 avss.n7629 4.5005
R17797 avss.n8826 avss.n7630 4.5005
R17798 avss.n7651 avss.n7631 4.5005
R17799 avss.n8816 avss.n7652 4.5005
R17800 avss.n8815 avss.n7653 4.5005
R17801 avss.n8814 avss.n7654 4.5005
R17802 avss.n7675 avss.n7655 4.5005
R17803 avss.n8804 avss.n7676 4.5005
R17804 avss.n8803 avss.n7677 4.5005
R17805 avss.n8802 avss.n7678 4.5005
R17806 avss.n7699 avss.n7679 4.5005
R17807 avss.n8792 avss.n7700 4.5005
R17808 avss.n8791 avss.n7701 4.5005
R17809 avss.n8790 avss.n7702 4.5005
R17810 avss.n7723 avss.n7703 4.5005
R17811 avss.n8780 avss.n7724 4.5005
R17812 avss.n8779 avss.n7725 4.5005
R17813 avss.n8778 avss.n7726 4.5005
R17814 avss.n7749 avss.n7727 4.5005
R17815 avss.n8768 avss.n7750 4.5005
R17816 avss.n8767 avss.n7751 4.5005
R17817 avss.n8766 avss.n7752 4.5005
R17818 avss.n8365 avss.n7753 4.5005
R17819 avss.n8367 avss.n8366 4.5005
R17820 avss.n121 avss.n120 4.5005
R17821 avss.n9225 avss.n9224 4.5005
R17822 avss.n9226 avss.n119 4.5005
R17823 avss.n9228 avss.n9227 4.5005
R17824 avss.n108 avss.n107 4.5005
R17825 avss.n9257 avss.n9256 4.5005
R17826 avss.n9258 avss.n106 4.5005
R17827 avss.n9260 avss.n9259 4.5005
R17828 avss.n94 avss.n93 4.5005
R17829 avss.n9274 avss.n9273 4.5005
R17830 avss.n9275 avss.n92 4.5005
R17831 avss.n9277 avss.n9276 4.5005
R17832 avss.n80 avss.n79 4.5005
R17833 avss.n9296 avss.n9295 4.5005
R17834 avss.n9297 avss.n78 4.5005
R17835 avss.n9301 avss.n9298 4.5005
R17836 avss.n9300 avss.n9299 4.5005
R17837 avss.n7504 avss.n7490 4.5005
R17838 avss.n363 avss.n362 4.5005
R17839 avss.n8915 avss.n8914 4.5005
R17840 avss.n8916 avss.n361 4.5005
R17841 avss.n8918 avss.n8917 4.5005
R17842 avss.n351 avss.n350 4.5005
R17843 avss.n8931 avss.n8930 4.5005
R17844 avss.n8932 avss.n349 4.5005
R17845 avss.n8934 avss.n8933 4.5005
R17846 avss.n339 avss.n338 4.5005
R17847 avss.n8947 avss.n8946 4.5005
R17848 avss.n8948 avss.n337 4.5005
R17849 avss.n8950 avss.n8949 4.5005
R17850 avss.n327 avss.n326 4.5005
R17851 avss.n8963 avss.n8962 4.5005
R17852 avss.n8964 avss.n325 4.5005
R17853 avss.n8966 avss.n8965 4.5005
R17854 avss.n315 avss.n314 4.5005
R17855 avss.n8982 avss.n8981 4.5005
R17856 avss.n8983 avss.n313 4.5005
R17857 avss.n8986 avss.n8985 4.5005
R17858 avss.n8984 avss.n230 4.5005
R17859 avss.n9125 avss.n231 4.5005
R17860 avss.n9124 avss.n232 4.5005
R17861 avss.n9123 avss.n233 4.5005
R17862 avss.n241 avss.n234 4.5005
R17863 avss.n9117 avss.n242 4.5005
R17864 avss.n9116 avss.n243 4.5005
R17865 avss.n9115 avss.n244 4.5005
R17866 avss.n252 avss.n245 4.5005
R17867 avss.n9109 avss.n253 4.5005
R17868 avss.n9108 avss.n254 4.5005
R17869 avss.n9107 avss.n255 4.5005
R17870 avss.n263 avss.n256 4.5005
R17871 avss.n9101 avss.n264 4.5005
R17872 avss.n9100 avss.n265 4.5005
R17873 avss.n9099 avss.n266 4.5005
R17874 avss.n274 avss.n267 4.5005
R17875 avss.n9093 avss.n275 4.5005
R17876 avss.n9092 avss.n276 4.5005
R17877 avss.n9091 avss.n277 4.5005
R17878 avss.n285 avss.n278 4.5005
R17879 avss.n9085 avss.n286 4.5005
R17880 avss.n9084 avss.n287 4.5005
R17881 avss.n9083 avss.n289 4.5005
R17882 avss.n288 avss.n156 4.5005
R17883 avss.n9190 avss.n157 4.5005
R17884 avss.n9189 avss.n158 4.5005
R17885 avss.n9188 avss.n159 4.5005
R17886 avss.n169 avss.n160 4.5005
R17887 avss.n9175 avss.n170 4.5005
R17888 avss.n9174 avss.n171 4.5005
R17889 avss.n9173 avss.n172 4.5005
R17890 avss.n9059 avss.n173 4.5005
R17891 avss.n9062 avss.n9061 4.5005
R17892 avss.n9060 avss.n188 4.5005
R17893 avss.n9156 avss.n189 4.5005
R17894 avss.n9155 avss.n190 4.5005
R17895 avss.n9154 avss.n191 4.5005
R17896 avss.n201 avss.n192 4.5005
R17897 avss.n9147 avss.n202 4.5005
R17898 avss.n9146 avss.n203 4.5005
R17899 avss.n9145 avss.n204 4.5005
R17900 avss.n220 avss.n205 4.5005
R17901 avss.n8902 avss.n8901 4.5005
R17902 avss.n8908 avss.n367 4.5005
R17903 avss.n8910 avss.n8909 4.5005
R17904 avss.n357 avss.n356 4.5005
R17905 avss.n8923 avss.n8922 4.5005
R17906 avss.n8924 avss.n355 4.5005
R17907 avss.n8926 avss.n8925 4.5005
R17908 avss.n345 avss.n344 4.5005
R17909 avss.n8939 avss.n8938 4.5005
R17910 avss.n8940 avss.n343 4.5005
R17911 avss.n8942 avss.n8941 4.5005
R17912 avss.n333 avss.n332 4.5005
R17913 avss.n8955 avss.n8954 4.5005
R17914 avss.n8956 avss.n331 4.5005
R17915 avss.n8958 avss.n8957 4.5005
R17916 avss.n321 avss.n320 4.5005
R17917 avss.n8971 avss.n8970 4.5005
R17918 avss.n8972 avss.n319 4.5005
R17919 avss.n8977 avss.n8973 4.5005
R17920 avss.n8976 avss.n8975 4.5005
R17921 avss.n8974 avss.n309 4.5005
R17922 avss.n8991 avss.n308 4.5005
R17923 avss.n8993 avss.n8992 4.5005
R17924 avss.n8994 avss.n307 4.5005
R17925 avss.n8996 avss.n8995 4.5005
R17926 avss.n8997 avss.n305 4.5005
R17927 avss.n8999 avss.n8998 4.5005
R17928 avss.n9000 avss.n304 4.5005
R17929 avss.n9002 avss.n9001 4.5005
R17930 avss.n9003 avss.n302 4.5005
R17931 avss.n9005 avss.n9004 4.5005
R17932 avss.n9006 avss.n301 4.5005
R17933 avss.n9008 avss.n9007 4.5005
R17934 avss.n9009 avss.n299 4.5005
R17935 avss.n9011 avss.n9010 4.5005
R17936 avss.n9012 avss.n298 4.5005
R17937 avss.n9014 avss.n9013 4.5005
R17938 avss.n9015 avss.n296 4.5005
R17939 avss.n9017 avss.n9016 4.5005
R17940 avss.n9018 avss.n295 4.5005
R17941 avss.n9020 avss.n9019 4.5005
R17942 avss.n9021 avss.n293 4.5005
R17943 avss.n9023 avss.n9022 4.5005
R17944 avss.n9024 avss.n292 4.5005
R17945 avss.n9079 avss.n9025 4.5005
R17946 avss.n9078 avss.n9026 4.5005
R17947 avss.n9077 avss.n9027 4.5005
R17948 avss.n9076 avss.n9028 4.5005
R17949 avss.n9074 avss.n9029 4.5005
R17950 avss.n9073 avss.n9030 4.5005
R17951 avss.n9071 avss.n9031 4.5005
R17952 avss.n9070 avss.n9032 4.5005
R17953 avss.n9068 avss.n9033 4.5005
R17954 avss.n9067 avss.n9034 4.5005
R17955 avss.n9036 avss.n9035 4.5005
R17956 avss.n9056 avss.n9037 4.5005
R17957 avss.n9055 avss.n9038 4.5005
R17958 avss.n9054 avss.n9039 4.5005
R17959 avss.n9052 avss.n9040 4.5005
R17960 avss.n9051 avss.n9041 4.5005
R17961 avss.n9050 avss.n9042 4.5005
R17962 avss.n9049 avss.n9043 4.5005
R17963 avss.n9046 avss.n9044 4.5005
R17964 avss.n9045 avss.n219 4.5005
R17965 avss.n8907 avss.n8906 4.5005
R17966 avss.n9140 avss.n9139 4.5005
R17967 avss.n214 avss.n213 4.5005
R17968 avss.n9162 avss.n9161 4.5005
R17969 avss.n9159 avss.n180 4.5005
R17970 avss.n9183 avss.n9182 4.5005
R17971 avss.n9180 avss.n148 4.5005
R17972 avss.n8188 avss.n8187 4.5005
R17973 avss.n8189 avss.n8084 4.5005
R17974 avss.n8192 avss.n8190 4.5005
R17975 avss.n8193 avss.n8083 4.5005
R17976 avss.n8196 avss.n8195 4.5005
R17977 avss.n8197 avss.n8082 4.5005
R17978 avss.n8200 avss.n8198 4.5005
R17979 avss.n8201 avss.n8081 4.5005
R17980 avss.n8204 avss.n8203 4.5005
R17981 avss.n8205 avss.n8080 4.5005
R17982 avss.n8208 avss.n8206 4.5005
R17983 avss.n8209 avss.n8079 4.5005
R17984 avss.n8212 avss.n8211 4.5005
R17985 avss.n8213 avss.n8078 4.5005
R17986 avss.n8216 avss.n8214 4.5005
R17987 avss.n8217 avss.n8077 4.5005
R17988 avss.n8220 avss.n8219 4.5005
R17989 avss.n8221 avss.n8076 4.5005
R17990 avss.n8224 avss.n8222 4.5005
R17991 avss.n8225 avss.n8075 4.5005
R17992 avss.n8228 avss.n8227 4.5005
R17993 avss.n8229 avss.n8074 4.5005
R17994 avss.n8232 avss.n8230 4.5005
R17995 avss.n8233 avss.n8073 4.5005
R17996 avss.n8236 avss.n8235 4.5005
R17997 avss.n8237 avss.n8072 4.5005
R17998 avss.n8240 avss.n8238 4.5005
R17999 avss.n8241 avss.n8071 4.5005
R18000 avss.n8244 avss.n8243 4.5005
R18001 avss.n8245 avss.n8070 4.5005
R18002 avss.n8248 avss.n8246 4.5005
R18003 avss.n8249 avss.n8069 4.5005
R18004 avss.n8252 avss.n8251 4.5005
R18005 avss.n8253 avss.n8068 4.5005
R18006 avss.n8256 avss.n8254 4.5005
R18007 avss.n8257 avss.n8067 4.5005
R18008 avss.n8260 avss.n8259 4.5005
R18009 avss.n8261 avss.n8066 4.5005
R18010 avss.n8510 avss.n8262 4.5005
R18011 avss.n8509 avss.n8263 4.5005
R18012 avss.n8508 avss.n8265 4.5005
R18013 avss.n8264 avss.n7852 4.5005
R18014 avss.n8639 avss.n7853 4.5005
R18015 avss.n8638 avss.n7854 4.5005
R18016 avss.n8637 avss.n7855 4.5005
R18017 avss.n8528 avss.n7856 4.5005
R18018 avss.n8531 avss.n8530 4.5005
R18019 avss.n8529 avss.n7873 4.5005
R18020 avss.n8620 avss.n7874 4.5005
R18021 avss.n8619 avss.n7875 4.5005
R18022 avss.n8618 avss.n7876 4.5005
R18023 avss.n7929 avss.n7877 4.5005
R18024 avss.n7931 avss.n7930 4.5005
R18025 avss.n8554 avss.n8553 4.5005
R18026 avss.n8555 avss.n7928 4.5005
R18027 avss.n8557 avss.n8556 4.5005
R18028 avss.n7910 avss.n7909 4.5005
R18029 avss.n8572 avss.n8571 4.5005
R18030 avss.n8573 avss.n7908 4.5005
R18031 avss.n8576 avss.n8575 4.5005
R18032 avss.n8574 avss.n7899 4.5005
R18033 avss.n8593 avss.n7900 4.5005
R18034 avss.n8592 avss.n8591 4.5005
R18035 avss.n8184 avss.n8183 4.5005
R18036 avss.n8177 avss.n8085 4.5005
R18037 avss.n8176 avss.n8086 4.5005
R18038 avss.n8175 avss.n8087 4.5005
R18039 avss.n8173 avss.n8088 4.5005
R18040 avss.n8172 avss.n8089 4.5005
R18041 avss.n8170 avss.n8090 4.5005
R18042 avss.n8169 avss.n8091 4.5005
R18043 avss.n8167 avss.n8092 4.5005
R18044 avss.n8166 avss.n8093 4.5005
R18045 avss.n8164 avss.n8094 4.5005
R18046 avss.n8163 avss.n8095 4.5005
R18047 avss.n8161 avss.n8096 4.5005
R18048 avss.n8160 avss.n8097 4.5005
R18049 avss.n8158 avss.n8098 4.5005
R18050 avss.n8157 avss.n8099 4.5005
R18051 avss.n8155 avss.n8100 4.5005
R18052 avss.n8154 avss.n8101 4.5005
R18053 avss.n8152 avss.n8102 4.5005
R18054 avss.n8151 avss.n8103 4.5005
R18055 avss.n8149 avss.n8104 4.5005
R18056 avss.n8148 avss.n8105 4.5005
R18057 avss.n8146 avss.n8106 4.5005
R18058 avss.n8145 avss.n8107 4.5005
R18059 avss.n8143 avss.n8108 4.5005
R18060 avss.n8142 avss.n8109 4.5005
R18061 avss.n8140 avss.n8110 4.5005
R18062 avss.n8139 avss.n8111 4.5005
R18063 avss.n8137 avss.n8112 4.5005
R18064 avss.n8136 avss.n8113 4.5005
R18065 avss.n8134 avss.n8114 4.5005
R18066 avss.n8133 avss.n8115 4.5005
R18067 avss.n8131 avss.n8116 4.5005
R18068 avss.n8130 avss.n8117 4.5005
R18069 avss.n8128 avss.n8118 4.5005
R18070 avss.n8127 avss.n8119 4.5005
R18071 avss.n8125 avss.n8120 4.5005
R18072 avss.n8124 avss.n8122 4.5005
R18073 avss.n8121 avss.n7943 4.5005
R18074 avss.n8514 avss.n7942 4.5005
R18075 avss.n8516 avss.n8515 4.5005
R18076 avss.n8517 avss.n7941 4.5005
R18077 avss.n8519 avss.n8518 4.5005
R18078 avss.n8520 avss.n7940 4.5005
R18079 avss.n8522 avss.n8521 4.5005
R18080 avss.n8523 avss.n7939 4.5005
R18081 avss.n8525 avss.n8524 4.5005
R18082 avss.n7938 avss.n7937 4.5005
R18083 avss.n8537 avss.n8536 4.5005
R18084 avss.n8538 avss.n7936 4.5005
R18085 avss.n8541 avss.n8539 4.5005
R18086 avss.n8542 avss.n7935 4.5005
R18087 avss.n8544 avss.n8543 4.5005
R18088 avss.n8545 avss.n7934 4.5005
R18089 avss.n8547 avss.n8546 4.5005
R18090 avss.n7916 avss.n7915 4.5005
R18091 avss.n8562 avss.n8561 4.5005
R18092 avss.n8563 avss.n7914 4.5005
R18093 avss.n8567 avss.n8564 4.5005
R18094 avss.n8566 avss.n8565 4.5005
R18095 avss.n7903 avss.n7902 4.5005
R18096 avss.n8582 avss.n8581 4.5005
R18097 avss.n8583 avss.n7901 4.5005
R18098 avss.n8585 avss.n8584 4.5005
R18099 avss.n8181 avss.n8180 4.5005
R18100 avss.n8602 avss.n8601 4.5005
R18101 avss.n8599 avss.n8598 4.5005
R18102 avss.n7923 avss.n7922 4.5005
R18103 avss.n7920 avss.n7885 4.5005
R18104 avss.n8626 avss.n8625 4.5005
R18105 avss.n8623 avss.n7862 4.5005
R18106 avss.n8416 avss.n8412 4.5005
R18107 avss.n8415 avss.n8414 4.5005
R18108 avss.n8413 avss.n7519 4.5005
R18109 avss.n8882 avss.n7520 4.5005
R18110 avss.n8881 avss.n7521 4.5005
R18111 avss.n8880 avss.n7522 4.5005
R18112 avss.n7543 avss.n7523 4.5005
R18113 avss.n8870 avss.n7544 4.5005
R18114 avss.n8869 avss.n7545 4.5005
R18115 avss.n8868 avss.n7546 4.5005
R18116 avss.n7567 avss.n7547 4.5005
R18117 avss.n8858 avss.n7568 4.5005
R18118 avss.n8857 avss.n7569 4.5005
R18119 avss.n8856 avss.n7570 4.5005
R18120 avss.n7591 avss.n7571 4.5005
R18121 avss.n8846 avss.n7592 4.5005
R18122 avss.n8845 avss.n7593 4.5005
R18123 avss.n8844 avss.n7594 4.5005
R18124 avss.n7615 avss.n7595 4.5005
R18125 avss.n8834 avss.n7616 4.5005
R18126 avss.n8833 avss.n7617 4.5005
R18127 avss.n8832 avss.n7618 4.5005
R18128 avss.n7639 avss.n7619 4.5005
R18129 avss.n8822 avss.n7640 4.5005
R18130 avss.n8821 avss.n7641 4.5005
R18131 avss.n8820 avss.n7642 4.5005
R18132 avss.n7663 avss.n7643 4.5005
R18133 avss.n8810 avss.n7664 4.5005
R18134 avss.n8809 avss.n7665 4.5005
R18135 avss.n8808 avss.n7666 4.5005
R18136 avss.n7687 avss.n7667 4.5005
R18137 avss.n8798 avss.n7688 4.5005
R18138 avss.n8797 avss.n7689 4.5005
R18139 avss.n8796 avss.n7690 4.5005
R18140 avss.n7711 avss.n7691 4.5005
R18141 avss.n8786 avss.n7712 4.5005
R18142 avss.n8785 avss.n7713 4.5005
R18143 avss.n8784 avss.n7714 4.5005
R18144 avss.n7736 avss.n7715 4.5005
R18145 avss.n8774 avss.n7737 4.5005
R18146 avss.n8773 avss.n7738 4.5005
R18147 avss.n8772 avss.n7739 4.5005
R18148 avss.n7762 avss.n7740 4.5005
R18149 avss.n8762 avss.n7763 4.5005
R18150 avss.n8761 avss.n7764 4.5005
R18151 avss.n8760 avss.n7765 4.5005
R18152 avss.n8652 avss.n7766 4.5005
R18153 avss.n8655 avss.n8654 4.5005
R18154 avss.n8653 avss.n7784 4.5005
R18155 avss.n8745 avss.n7785 4.5005
R18156 avss.n8744 avss.n7786 4.5005
R18157 avss.n8743 avss.n7787 4.5005
R18158 avss.n7839 avss.n7788 4.5005
R18159 avss.n8677 avss.n8676 4.5005
R18160 avss.n8678 avss.n7838 4.5005
R18161 avss.n8680 avss.n8679 4.5005
R18162 avss.n7820 avss.n7819 4.5005
R18163 avss.n8696 avss.n8695 4.5005
R18164 avss.n8697 avss.n7818 4.5005
R18165 avss.n8700 avss.n8699 4.5005
R18166 avss.n8698 avss.n7809 4.5005
R18167 avss.n8717 avss.n7810 4.5005
R18168 avss.n8716 avss.n8715 4.5005
R18169 avss.n8420 avss.n8419 4.5005
R18170 avss.n8424 avss.n8423 4.5005
R18171 avss.n8425 avss.n8408 4.5005
R18172 avss.n8428 avss.n8427 4.5005
R18173 avss.n8429 avss.n8407 4.5005
R18174 avss.n8432 avss.n8430 4.5005
R18175 avss.n8433 avss.n8406 4.5005
R18176 avss.n8436 avss.n8435 4.5005
R18177 avss.n8437 avss.n8405 4.5005
R18178 avss.n8440 avss.n8438 4.5005
R18179 avss.n8441 avss.n8404 4.5005
R18180 avss.n8444 avss.n8443 4.5005
R18181 avss.n8445 avss.n8403 4.5005
R18182 avss.n8448 avss.n8446 4.5005
R18183 avss.n8449 avss.n8402 4.5005
R18184 avss.n8452 avss.n8451 4.5005
R18185 avss.n8453 avss.n8401 4.5005
R18186 avss.n8456 avss.n8454 4.5005
R18187 avss.n8457 avss.n8400 4.5005
R18188 avss.n8460 avss.n8459 4.5005
R18189 avss.n8461 avss.n8399 4.5005
R18190 avss.n8464 avss.n8462 4.5005
R18191 avss.n8465 avss.n8398 4.5005
R18192 avss.n8468 avss.n8467 4.5005
R18193 avss.n8469 avss.n8397 4.5005
R18194 avss.n8472 avss.n8470 4.5005
R18195 avss.n8473 avss.n8396 4.5005
R18196 avss.n8476 avss.n8475 4.5005
R18197 avss.n8477 avss.n8395 4.5005
R18198 avss.n8480 avss.n8478 4.5005
R18199 avss.n8481 avss.n8394 4.5005
R18200 avss.n8484 avss.n8483 4.5005
R18201 avss.n8485 avss.n8393 4.5005
R18202 avss.n8488 avss.n8486 4.5005
R18203 avss.n8489 avss.n8392 4.5005
R18204 avss.n8492 avss.n8491 4.5005
R18205 avss.n8493 avss.n8391 4.5005
R18206 avss.n8496 avss.n8494 4.5005
R18207 avss.n8497 avss.n8390 4.5005
R18208 avss.n8499 avss.n8498 4.5005
R18209 avss.n8500 avss.n8389 4.5005
R18210 avss.n8503 avss.n8502 4.5005
R18211 avss.n8501 avss.n7849 4.5005
R18212 avss.n8643 avss.n7848 4.5005
R18213 avss.n8645 avss.n8644 4.5005
R18214 avss.n8646 avss.n7847 4.5005
R18215 avss.n8648 avss.n8647 4.5005
R18216 avss.n8649 avss.n7844 4.5005
R18217 avss.n8660 avss.n8659 4.5005
R18218 avss.n8661 avss.n7843 4.5005
R18219 avss.n8663 avss.n8662 4.5005
R18220 avss.n8665 avss.n7842 4.5005
R18221 avss.n8667 avss.n8666 4.5005
R18222 avss.n8668 avss.n7841 4.5005
R18223 avss.n8670 avss.n8669 4.5005
R18224 avss.n7826 avss.n7825 4.5005
R18225 avss.n8685 avss.n8684 4.5005
R18226 avss.n8686 avss.n7824 4.5005
R18227 avss.n8690 avss.n8687 4.5005
R18228 avss.n8689 avss.n8688 4.5005
R18229 avss.n7813 avss.n7812 4.5005
R18230 avss.n8706 avss.n8705 4.5005
R18231 avss.n8707 avss.n7811 4.5005
R18232 avss.n8709 avss.n8708 4.5005
R18233 avss.n8422 avss.n8409 4.5005
R18234 avss.n8726 avss.n8725 4.5005
R18235 avss.n8723 avss.n8722 4.5005
R18236 avss.n7833 avss.n7832 4.5005
R18237 avss.n7830 avss.n7795 4.5005
R18238 avss.n8753 avss.n8752 4.5005
R18239 avss.n8754 avss.n7774 4.5005
R18240 avss.n1154 avss.n1153 4.5005
R18241 avss.n1155 avss.n1147 4.5005
R18242 avss.n1157 avss.n1156 4.5005
R18243 avss.n1158 avss.n1146 4.5005
R18244 avss.n6823 avss.n6822 4.5005
R18245 avss.n6824 avss.n1145 4.5005
R18246 avss.n6826 avss.n6825 4.5005
R18247 avss.n1135 avss.n1134 4.5005
R18248 avss.n6841 avss.n6840 4.5005
R18249 avss.n6842 avss.n1133 4.5005
R18250 avss.n6844 avss.n6843 4.5005
R18251 avss.n6847 avss.n1132 4.5005
R18252 avss.n6849 avss.n6848 4.5005
R18253 avss.n1150 avss.n1149 4.5005
R18254 avss.n6883 avss.n6882 4.5005
R18255 avss.n6881 avss.n1097 4.5005
R18256 avss.n6880 avss.n6879 4.5005
R18257 avss.n1099 avss.n1098 4.5005
R18258 avss.n6818 avss.n6817 4.5005
R18259 avss.n1142 avss.n1141 4.5005
R18260 avss.n6832 avss.n6831 4.5005
R18261 avss.n6833 avss.n1140 4.5005
R18262 avss.n6836 avss.n6835 4.5005
R18263 avss.n6834 avss.n1119 4.5005
R18264 avss.n6865 avss.n1120 4.5005
R18265 avss.n6864 avss.n1121 4.5005
R18266 avss.n6863 avss.n1122 4.5005
R18267 avss.n6884 avss.n1096 4.5005
R18268 avss.n6873 avss.n6872 4.5005
R18269 avss.n6874 avss.n1108 4.5005
R18270 avss.n6788 avss.n1169 4.5005
R18271 avss.n6787 avss.n6786 4.5005
R18272 avss.n6339 avss.n6338 4.5005
R18273 avss.n1060 avss.n1059 4.5005
R18274 avss.n6916 avss.n6915 4.5005
R18275 avss.n6917 avss.n1058 4.5005
R18276 avss.n6921 avss.n6918 4.5005
R18277 avss.n6920 avss.n6919 4.5005
R18278 avss.n1035 avss.n1034 4.5005
R18279 avss.n6952 avss.n6951 4.5005
R18280 avss.n6953 avss.n1033 4.5005
R18281 avss.n6963 avss.n6954 4.5005
R18282 avss.n6962 avss.n6955 4.5005
R18283 avss.n6961 avss.n6956 4.5005
R18284 avss.n6959 avss.n6958 4.5005
R18285 avss.n6337 avss.n6334 4.5005
R18286 avss.n6348 avss.n6335 4.5005
R18287 avss.n6347 avss.n6343 4.5005
R18288 avss.n6345 avss.n6344 4.5005
R18289 avss.n1051 avss.n1050 4.5005
R18290 avss.n6926 avss.n6925 4.5005
R18291 avss.n6927 avss.n1049 4.5005
R18292 avss.n6931 avss.n6928 4.5005
R18293 avss.n6930 avss.n6929 4.5005
R18294 avss.n1025 avss.n1024 4.5005
R18295 avss.n6968 avss.n6967 4.5005
R18296 avss.n6969 avss.n1023 4.5005
R18297 avss.n6971 avss.n6970 4.5005
R18298 avss.n6972 avss.n1019 4.5005
R18299 avss.n6350 avss.n6349 4.5005
R18300 avss.n6979 avss.n1018 4.5005
R18301 avss.n6983 avss.n6980 4.5005
R18302 avss.n6984 avss.n1017 4.5005
R18303 avss.n6987 avss.n6986 4.5005
R18304 avss.n6978 avss.n6977 4.5005
R18305 avss.n7013 avss.n7012 4.5005
R18306 avss.n7011 avss.n980 4.5005
R18307 avss.n7010 avss.n7009 4.5005
R18308 avss.n982 avss.n981 4.5005
R18309 avss.n7014 avss.n979 4.5005
R18310 avss.n6793 avss.n6792 4.5005
R18311 avss.n1174 avss.n1016 4.5005
R18312 avss.n1171 avss.n1162 4.5005
R18313 avss.n1173 avss.n1172 4.5005
R18314 avss.n6801 avss.n6800 4.5005
R18315 avss.n6802 avss.n6798 4.5005
R18316 avss.n6812 avss.n6811 4.5005
R18317 avss.n6810 avss.n1161 4.5005
R18318 avss.n6856 avss.n6855 4.5005
R18319 avss.n6854 avss.n6853 4.5005
R18320 avss.n1130 avss.n1129 4.5005
R18321 avss.n1128 avss.n1109 4.5005
R18322 avss.n7001 avss.n990 4.5005
R18323 avss.n7000 avss.n992 4.5005
R18324 avss.n6734 avss.n993 4.5005
R18325 avss.n6735 avss.n6733 4.5005
R18326 avss.n6738 avss.n6737 4.5005
R18327 avss.n6736 avss.n6731 4.5005
R18328 avss.n6750 avss.n6732 4.5005
R18329 avss.n6751 avss.n6730 4.5005
R18330 avss.n6755 avss.n6754 4.5005
R18331 avss.n6756 avss.n6729 4.5005
R18332 avss.n6776 avss.n6757 4.5005
R18333 avss.n6775 avss.n6758 4.5005
R18334 avss.n6774 avss.n6759 4.5005
R18335 avss.n7003 avss.n7002 4.5005
R18336 avss.n1001 avss.n1000 4.5005
R18337 avss.n6996 avss.n1002 4.5005
R18338 avss.n6995 avss.n1003 4.5005
R18339 avss.n6994 avss.n1004 4.5005
R18340 avss.n6741 avss.n1005 4.5005
R18341 avss.n6744 avss.n6743 4.5005
R18342 avss.n6742 avss.n6720 4.5005
R18343 avss.n6783 avss.n6721 4.5005
R18344 avss.n6782 avss.n6722 4.5005
R18345 avss.n6781 avss.n6723 4.5005
R18346 avss.n6765 avss.n6724 4.5005
R18347 avss.n6766 avss.n6764 4.5005
R18348 avss.n6770 avss.n6769 4.5005
R18349 avss.n999 avss.n989 4.5005
R18350 avss.n7053 avss.n920 4.5005
R18351 avss.n7052 avss.n922 4.5005
R18352 avss.n6365 avss.n923 4.5005
R18353 avss.n6367 avss.n6366 4.5005
R18354 avss.n6369 avss.n6368 4.5005
R18355 avss.n6370 avss.n6364 4.5005
R18356 avss.n6373 avss.n6371 4.5005
R18357 avss.n6374 avss.n6363 4.5005
R18358 avss.n6377 avss.n6376 4.5005
R18359 avss.n6378 avss.n6362 4.5005
R18360 avss.n6380 avss.n6379 4.5005
R18361 avss.n6327 avss.n6326 4.5005
R18362 avss.n6393 avss.n6392 4.5005
R18363 avss.n7055 avss.n7054 4.5005
R18364 avss.n932 avss.n929 4.5005
R18365 avss.n7048 avss.n933 4.5005
R18366 avss.n7047 avss.n934 4.5005
R18367 avss.n7046 avss.n935 4.5005
R18368 avss.n942 avss.n936 4.5005
R18369 avss.n7040 avss.n943 4.5005
R18370 avss.n7039 avss.n944 4.5005
R18371 avss.n7038 avss.n945 4.5005
R18372 avss.n6356 avss.n946 4.5005
R18373 avss.n6358 avss.n6357 4.5005
R18374 avss.n6385 avss.n6384 4.5005
R18375 avss.n6386 avss.n6355 4.5005
R18376 avss.n6388 avss.n6387 4.5005
R18377 avss.n931 avss.n930 4.5005
R18378 avss.n6397 avss.n6396 4.5005
R18379 avss.n6907 avss.n1069 4.5005
R18380 avss.n6906 avss.n1071 4.5005
R18381 avss.n6905 avss.n1072 4.5005
R18382 avss.n6903 avss.n1073 4.5005
R18383 avss.n6902 avss.n1074 4.5005
R18384 avss.n1076 avss.n1075 4.5005
R18385 avss.n6897 avss.n1077 4.5005
R18386 avss.n6896 avss.n1078 4.5005
R18387 avss.n6895 avss.n1079 4.5005
R18388 avss.n1087 avss.n1080 4.5005
R18389 avss.n1086 avss.n1081 4.5005
R18390 avss.n1085 avss.n1082 4.5005
R18391 avss.n1084 avss.n1083 4.5005
R18392 avss.n6909 avss.n6908 4.5005
R18393 avss.n1045 avss.n1044 4.5005
R18394 avss.n6937 avss.n6936 4.5005
R18395 avss.n6938 avss.n1043 4.5005
R18396 avss.n6946 avss.n6939 4.5005
R18397 avss.n6945 avss.n6940 4.5005
R18398 avss.n6944 avss.n6942 4.5005
R18399 avss.n6941 avss.n958 4.5005
R18400 avss.n7030 avss.n959 4.5005
R18401 avss.n7029 avss.n960 4.5005
R18402 avss.n7028 avss.n961 4.5005
R18403 avss.n970 avss.n962 4.5005
R18404 avss.n7022 avss.n971 4.5005
R18405 avss.n7021 avss.n7020 4.5005
R18406 avss.n1068 avss.n1067 4.5005
R18407 avss.n2372 avss.n2371 4.5005
R18408 avss.n2370 avss.n2347 4.5005
R18409 avss.n2388 avss.n2348 4.5005
R18410 avss.n2389 avss.n2346 4.5005
R18411 avss.n2392 avss.n2391 4.5005
R18412 avss.n2393 avss.n2345 4.5005
R18413 avss.n2398 avss.n2394 4.5005
R18414 avss.n2397 avss.n2396 4.5005
R18415 avss.n2395 avss.n2342 4.5005
R18416 avss.n2413 avss.n2341 4.5005
R18417 avss.n2415 avss.n2414 4.5005
R18418 avss.n2416 avss.n2340 4.5005
R18419 avss.n2418 avss.n2417 4.5005
R18420 avss.n2373 avss.n2369 4.5005
R18421 avss.n2380 avss.n2352 4.5005
R18422 avss.n2383 avss.n2382 4.5005
R18423 avss.n2381 avss.n2299 4.5005
R18424 avss.n2436 avss.n2300 4.5005
R18425 avss.n2435 avss.n2301 4.5005
R18426 avss.n2434 avss.n2302 4.5005
R18427 avss.n2404 avss.n2303 4.5005
R18428 avss.n2405 avss.n2403 4.5005
R18429 avss.n2408 avss.n2407 4.5005
R18430 avss.n2406 avss.n2317 4.5005
R18431 avss.n2424 avss.n2318 4.5005
R18432 avss.n2423 avss.n2319 4.5005
R18433 avss.n2422 avss.n2320 4.5005
R18434 avss.n2379 avss.n2378 4.5005
R18435 avss.n2290 avss.n2289 4.5005
R18436 avss.n2442 avss.n2441 4.5005
R18437 avss.n2663 avss.n2662 4.5005
R18438 avss.n2664 avss.n2280 4.5005
R18439 avss.n2554 avss.n2510 4.5005
R18440 avss.n2558 avss.n2555 4.5005
R18441 avss.n2559 avss.n2509 4.5005
R18442 avss.n2563 avss.n2562 4.5005
R18443 avss.n2564 avss.n2508 4.5005
R18444 avss.n2566 avss.n2565 4.5005
R18445 avss.n2506 avss.n2505 4.5005
R18446 avss.n2573 avss.n2572 4.5005
R18447 avss.n2574 avss.n2504 4.5005
R18448 avss.n2577 avss.n2576 4.5005
R18449 avss.n2575 avss.n2502 4.5005
R18450 avss.n2582 avss.n2501 4.5005
R18451 avss.n2584 avss.n2583 4.5005
R18452 avss.n2553 avss.n2552 4.5005
R18453 avss.n2547 avss.n2511 4.5005
R18454 avss.n2546 avss.n2513 4.5005
R18455 avss.n2544 avss.n2514 4.5005
R18456 avss.n2543 avss.n2515 4.5005
R18457 avss.n2540 avss.n2516 4.5005
R18458 avss.n2539 avss.n2517 4.5005
R18459 avss.n2536 avss.n2518 4.5005
R18460 avss.n2535 avss.n2519 4.5005
R18461 avss.n2532 avss.n2520 4.5005
R18462 avss.n2531 avss.n2521 4.5005
R18463 avss.n2528 avss.n2522 4.5005
R18464 avss.n2527 avss.n2523 4.5005
R18465 avss.n2525 avss.n2524 4.5005
R18466 avss.n2549 avss.n2548 4.5005
R18467 avss.n2498 avss.n2495 4.5005
R18468 avss.n2594 avss.n2499 4.5005
R18469 avss.n2595 avss.n2494 4.5005
R18470 avss.n2598 avss.n2597 4.5005
R18471 avss.n2497 avss.n2496 4.5005
R18472 avss.n2589 avss.n2588 4.5005
R18473 avss.n2587 avss.n2487 4.5005
R18474 avss.n2604 avss.n2488 4.5005
R18475 avss.n2603 avss.n2602 4.5005
R18476 avss.n2586 avss.n2500 4.5005
R18477 avss.n2491 avss.n2490 4.5005
R18478 avss.n2493 avss.n2492 4.5005
R18479 avss.n2284 avss.n2283 4.5005
R18480 avss.n2451 avss.n2450 4.5005
R18481 avss.n2445 avss.n2444 4.5005
R18482 avss.n2446 avss.n2281 4.5005
R18483 avss.n2360 avss.n2359 4.5005
R18484 avss.n2362 avss.n2361 4.5005
R18485 avss.n2331 avss.n2330 4.5005
R18486 avss.n2329 avss.n2328 4.5005
R18487 avss.n2335 avss.n2334 4.5005
R18488 avss.n2325 avss.n2324 4.5005
R18489 avss.n2712 avss.n2711 4.5005
R18490 avss.n2710 avss.n2696 4.5005
R18491 avss.n2709 avss.n2708 4.5005
R18492 avss.n2705 avss.n2697 4.5005
R18493 avss.n2702 avss.n2698 4.5005
R18494 avss.n2701 avss.n2699 4.5005
R18495 avss.n2688 avss.n2687 4.5005
R18496 avss.n2719 avss.n2718 4.5005
R18497 avss.n2720 avss.n2686 4.5005
R18498 avss.n2723 avss.n2722 4.5005
R18499 avss.n2721 avss.n2685 4.5005
R18500 avss.n2739 avss.n2684 4.5005
R18501 avss.n2741 avss.n2740 4.5005
R18502 avss.n2713 avss.n2695 4.5005
R18503 avss.n2770 avss.n2769 4.5005
R18504 avss.n2768 avss.n2239 4.5005
R18505 avss.n2767 avss.n2766 4.5005
R18506 avss.n2763 avss.n2240 4.5005
R18507 avss.n2760 avss.n2241 4.5005
R18508 avss.n2759 avss.n2242 4.5005
R18509 avss.n2756 avss.n2243 4.5005
R18510 avss.n2755 avss.n2244 4.5005
R18511 avss.n2729 avss.n2245 4.5005
R18512 avss.n2731 avss.n2730 4.5005
R18513 avss.n2732 avss.n2728 4.5005
R18514 avss.n2735 avss.n2733 4.5005
R18515 avss.n2734 avss.n2259 4.5005
R18516 avss.n2771 avss.n2238 4.5005
R18517 avss.n1886 avss.n1885 4.5005
R18518 avss.n1884 avss.n1861 4.5005
R18519 avss.n1883 avss.n1882 4.5005
R18520 avss.n1881 avss.n1862 4.5005
R18521 avss.n1879 avss.n1863 4.5005
R18522 avss.n1878 avss.n1864 4.5005
R18523 avss.n1876 avss.n1865 4.5005
R18524 avss.n1875 avss.n1866 4.5005
R18525 avss.n1873 avss.n1867 4.5005
R18526 avss.n1872 avss.n1868 4.5005
R18527 avss.n1870 avss.n1869 4.5005
R18528 avss.n1745 avss.n1744 4.5005
R18529 avss.n3318 avss.n3317 4.5005
R18530 avss.n1887 avss.n1859 4.5005
R18531 avss.n1922 avss.n1921 4.5005
R18532 avss.n1920 avss.n1858 4.5005
R18533 avss.n1919 avss.n1918 4.5005
R18534 avss.n1917 avss.n1893 4.5005
R18535 avss.n1915 avss.n1894 4.5005
R18536 avss.n1914 avss.n1895 4.5005
R18537 avss.n1912 avss.n1896 4.5005
R18538 avss.n1911 avss.n1897 4.5005
R18539 avss.n1909 avss.n1898 4.5005
R18540 avss.n1908 avss.n1899 4.5005
R18541 avss.n1906 avss.n1900 4.5005
R18542 avss.n1905 avss.n1901 4.5005
R18543 avss.n1903 avss.n1902 4.5005
R18544 avss.n1892 avss.n1857 4.5005
R18545 avss.n3322 avss.n3321 4.5005
R18546 avss.n2612 avss.n2611 4.5005
R18547 avss.n2472 avss.n2471 4.5005
R18548 avss.n2628 avss.n2627 4.5005
R18549 avss.n2629 avss.n2470 4.5005
R18550 avss.n2633 avss.n2630 4.5005
R18551 avss.n2632 avss.n2631 4.5005
R18552 avss.n2458 avss.n2457 4.5005
R18553 avss.n2649 avss.n2648 4.5005
R18554 avss.n2650 avss.n2456 4.5005
R18555 avss.n2654 avss.n2651 4.5005
R18556 avss.n2653 avss.n2652 4.5005
R18557 avss.n2263 avss.n2262 4.5005
R18558 avss.n2680 avss.n2679 4.5005
R18559 avss.n2610 avss.n2483 4.5005
R18560 avss.n2618 avss.n2617 4.5005
R18561 avss.n2619 avss.n2477 4.5005
R18562 avss.n2623 avss.n2620 4.5005
R18563 avss.n2622 avss.n2621 4.5005
R18564 avss.n2465 avss.n2464 4.5005
R18565 avss.n2639 avss.n2638 4.5005
R18566 avss.n2640 avss.n2463 4.5005
R18567 avss.n2644 avss.n2641 4.5005
R18568 avss.n2643 avss.n2642 4.5005
R18569 avss.n2271 avss.n2270 4.5005
R18570 avss.n2672 avss.n2671 4.5005
R18571 avss.n2673 avss.n2269 4.5005
R18572 avss.n2675 avss.n2674 4.5005
R18573 avss.n2479 avss.n2478 4.5005
R18574 avss.n3076 avss.n3075 4.5005
R18575 avss.n3047 avss.n3046 4.5005
R18576 avss.n3112 avss.n3111 4.5005
R18577 avss.n3113 avss.n3045 4.5005
R18578 avss.n3115 avss.n3114 4.5005
R18579 avss.n3035 avss.n3034 4.5005
R18580 avss.n3130 avss.n3129 4.5005
R18581 avss.n3131 avss.n3033 4.5005
R18582 avss.n3137 avss.n3132 4.5005
R18583 avss.n3136 avss.n3133 4.5005
R18584 avss.n3135 avss.n3134 4.5005
R18585 avss.n3005 avss.n3004 4.5005
R18586 avss.n3168 avss.n3167 4.5005
R18587 avss.n3078 avss.n3077 4.5005
R18588 avss.n3104 avss.n3103 4.5005
R18589 avss.n3105 avss.n3053 4.5005
R18590 avss.n3107 avss.n3106 4.5005
R18591 avss.n3041 avss.n3040 4.5005
R18592 avss.n3122 avss.n3121 4.5005
R18593 avss.n3123 avss.n3039 4.5005
R18594 avss.n3125 avss.n3124 4.5005
R18595 avss.n3028 avss.n3027 4.5005
R18596 avss.n3142 avss.n3141 4.5005
R18597 avss.n3143 avss.n3026 4.5005
R18598 avss.n3145 avss.n3144 4.5005
R18599 avss.n3011 avss.n3010 4.5005
R18600 avss.n3163 avss.n3162 4.5005
R18601 avss.n3055 avss.n3054 4.5005
R18602 avss.n3086 avss.n3018 4.5005
R18603 avss.n3088 avss.n3087 4.5005
R18604 avss.n3220 avss.n3219 4.5005
R18605 avss.n3221 avss.n2089 4.5005
R18606 avss.n2158 avss.n2156 4.5005
R18607 avss.n2155 avss.n2016 4.5005
R18608 avss.n3273 avss.n2017 4.5005
R18609 avss.n3272 avss.n2018 4.5005
R18610 avss.n3271 avss.n2019 4.5005
R18611 avss.n2024 avss.n2020 4.5005
R18612 avss.n2025 avss.n2022 4.5005
R18613 avss.n3264 avss.n2026 4.5005
R18614 avss.n3263 avss.n2027 4.5005
R18615 avss.n3262 avss.n2028 4.5005
R18616 avss.n2032 avss.n2029 4.5005
R18617 avss.n3257 avss.n2033 4.5005
R18618 avss.n3256 avss.n3255 4.5005
R18619 avss.n2160 avss.n2159 4.5005
R18620 avss.n2165 avss.n2154 4.5005
R18621 avss.n2169 avss.n2168 4.5005
R18622 avss.n2170 avss.n2153 4.5005
R18623 avss.n2224 avss.n2171 4.5005
R18624 avss.n2223 avss.n2172 4.5005
R18625 avss.n2222 avss.n2173 4.5005
R18626 avss.n2177 avss.n2174 4.5005
R18627 avss.n2217 avss.n2178 4.5005
R18628 avss.n2216 avss.n2179 4.5005
R18629 avss.n2215 avss.n2180 4.5005
R18630 avss.n2184 avss.n2181 4.5005
R18631 avss.n2210 avss.n2185 4.5005
R18632 avss.n2209 avss.n2208 4.5005
R18633 avss.n2164 avss.n2163 4.5005
R18634 avss.n2204 avss.n2189 4.5005
R18635 avss.n2203 avss.n2190 4.5005
R18636 avss.n2202 avss.n2191 4.5005
R18637 avss.n2200 avss.n2199 4.5005
R18638 avss.n2206 avss.n2205 4.5005
R18639 avss.n2036 avss.n2035 4.5005
R18640 avss.n3247 avss.n2045 4.5005
R18641 avss.n3246 avss.n2046 4.5005
R18642 avss.n3245 avss.n2047 4.5005
R18643 avss.n3253 avss.n3252 4.5005
R18644 avss.n2193 avss.n2192 4.5005
R18645 avss.n2195 avss.n2194 4.5005
R18646 avss.n3096 avss.n3095 4.5005
R18647 avss.n3069 avss.n3068 4.5005
R18648 avss.n3091 avss.n3090 4.5005
R18649 avss.n3084 avss.n2090 4.5005
R18650 avss.n3065 avss.n3063 4.5005
R18651 avss.n3067 avss.n3066 4.5005
R18652 avss.n3159 avss.n3158 4.5005
R18653 avss.n3014 avss.n3013 4.5005
R18654 avss.n3154 avss.n3153 4.5005
R18655 avss.n3152 avss.n3017 4.5005
R18656 avss.n2146 avss.n2145 4.5005
R18657 avss.n2947 avss.n2932 4.5005
R18658 avss.n2946 avss.n2933 4.5005
R18659 avss.n2945 avss.n2934 4.5005
R18660 avss.n2942 avss.n2935 4.5005
R18661 avss.n2941 avss.n2936 4.5005
R18662 avss.n2938 avss.n2937 4.5005
R18663 avss.n2130 avss.n2129 4.5005
R18664 avss.n2984 avss.n2983 4.5005
R18665 avss.n2985 avss.n2128 4.5005
R18666 avss.n2987 avss.n2986 4.5005
R18667 avss.n2116 avss.n2115 4.5005
R18668 avss.n3000 avss.n2999 4.5005
R18669 avss.n2953 avss.n2952 4.5005
R18670 avss.n2969 avss.n2968 4.5005
R18671 avss.n2967 avss.n2956 4.5005
R18672 avss.n2966 avss.n2965 4.5005
R18673 avss.n2962 avss.n2957 4.5005
R18674 avss.n2959 avss.n2958 4.5005
R18675 avss.n2137 avss.n2136 4.5005
R18676 avss.n2976 avss.n2975 4.5005
R18677 avss.n2977 avss.n2135 4.5005
R18678 avss.n2979 avss.n2978 4.5005
R18679 avss.n2124 avss.n2123 4.5005
R18680 avss.n2992 avss.n2991 4.5005
R18681 avss.n2993 avss.n2122 4.5005
R18682 avss.n2995 avss.n2994 4.5005
R18683 avss.n2970 avss.n2955 4.5005
R18684 avss.n1941 avss.n1940 4.5005
R18685 avss.n1939 avss.n1928 4.5005
R18686 avss.n1938 avss.n1937 4.5005
R18687 avss.n1936 avss.n1929 4.5005
R18688 avss.n1934 avss.n1930 4.5005
R18689 avss.n1933 avss.n1932 4.5005
R18690 avss.n1931 avss.n1787 4.5005
R18691 avss.n1983 avss.n1786 4.5005
R18692 avss.n1985 avss.n1984 4.5005
R18693 avss.n1986 avss.n1785 4.5005
R18694 avss.n1988 avss.n1987 4.5005
R18695 avss.n1990 avss.n1783 4.5005
R18696 avss.n1992 avss.n1991 4.5005
R18697 avss.n1942 avss.n1926 4.5005
R18698 avss.n1949 avss.n1948 4.5005
R18699 avss.n1808 avss.n1807 4.5005
R18700 avss.n1962 avss.n1961 4.5005
R18701 avss.n1963 avss.n1806 4.5005
R18702 avss.n1970 avss.n1964 4.5005
R18703 avss.n1969 avss.n1965 4.5005
R18704 avss.n1968 avss.n1967 4.5005
R18705 avss.n1966 avss.n1778 4.5005
R18706 avss.n3294 avss.n1779 4.5005
R18707 avss.n3293 avss.n1780 4.5005
R18708 avss.n3292 avss.n1781 4.5005
R18709 avss.n3291 avss.n1782 4.5005
R18710 avss.n3289 avss.n3288 4.5005
R18711 avss.n1947 avss.n1925 4.5005
R18712 avss.n2112 avss.n2111 4.5005
R18713 avss.n2067 avss.n2063 4.5005
R18714 avss.n3234 avss.n2068 4.5005
R18715 avss.n3233 avss.n2069 4.5005
R18716 avss.n3232 avss.n2070 4.5005
R18717 avss.n3176 avss.n2071 4.5005
R18718 avss.n3177 avss.n3175 4.5005
R18719 avss.n3179 avss.n3178 4.5005
R18720 avss.n3174 avss.n3173 4.5005
R18721 avss.n3191 avss.n3190 4.5005
R18722 avss.n3192 avss.n3172 4.5005
R18723 avss.n3196 avss.n3193 4.5005
R18724 avss.n3197 avss.n3171 4.5005
R18725 avss.n3199 avss.n3198 4.5005
R18726 avss.n2066 avss.n2065 4.5005
R18727 avss.n3239 avss.n2056 4.5005
R18728 avss.n3238 avss.n2057 4.5005
R18729 avss.n2076 avss.n2058 4.5005
R18730 avss.n3228 avss.n2077 4.5005
R18731 avss.n3227 avss.n2078 4.5005
R18732 avss.n3226 avss.n2079 4.5005
R18733 avss.n3182 avss.n2080 4.5005
R18734 avss.n3185 avss.n3184 4.5005
R18735 avss.n3183 avss.n2099 4.5005
R18736 avss.n3211 avss.n2100 4.5005
R18737 avss.n3210 avss.n2101 4.5005
R18738 avss.n3209 avss.n2102 4.5005
R18739 avss.n2109 avss.n2103 4.5005
R18740 avss.n3240 avss.n2055 4.5005
R18741 avss.n4508 avss.n3660 4.5005
R18742 avss.n4507 avss.n3662 4.5005
R18743 avss.n3792 avss.n3663 4.5005
R18744 avss.n3794 avss.n3793 4.5005
R18745 avss.n3797 avss.n3796 4.5005
R18746 avss.n3798 avss.n3791 4.5005
R18747 avss.n3803 avss.n3799 4.5005
R18748 avss.n3802 avss.n3801 4.5005
R18749 avss.n3800 avss.n3779 4.5005
R18750 avss.n3817 avss.n3778 4.5005
R18751 avss.n3819 avss.n3818 4.5005
R18752 avss.n3820 avss.n3777 4.5005
R18753 avss.n3824 avss.n3823 4.5005
R18754 avss.n4510 avss.n4509 4.5005
R18755 avss.n3671 avss.n3670 4.5005
R18756 avss.n4503 avss.n3672 4.5005
R18757 avss.n4502 avss.n3673 4.5005
R18758 avss.n4501 avss.n3674 4.5005
R18759 avss.n3784 avss.n3675 4.5005
R18760 avss.n3786 avss.n3785 4.5005
R18761 avss.n3808 avss.n3807 4.5005
R18762 avss.n3809 avss.n3783 4.5005
R18763 avss.n3812 avss.n3811 4.5005
R18764 avss.n3810 avss.n3770 4.5005
R18765 avss.n3831 avss.n3771 4.5005
R18766 avss.n3830 avss.n3772 4.5005
R18767 avss.n3829 avss.n3773 4.5005
R18768 avss.n3669 avss.n3659 4.5005
R18769 avss.n745 avss.n741 4.5005
R18770 avss.n751 avss.n746 4.5005
R18771 avss.n752 avss.n740 4.5005
R18772 avss.n754 avss.n753 4.5005
R18773 avss.n755 avss.n739 4.5005
R18774 avss.n759 avss.n756 4.5005
R18775 avss.n760 avss.n738 4.5005
R18776 avss.n763 avss.n762 4.5005
R18777 avss.n764 avss.n737 4.5005
R18778 avss.n768 avss.n765 4.5005
R18779 avss.n767 avss.n766 4.5005
R18780 avss.n710 avss.n709 4.5005
R18781 avss.n7135 avss.n7134 4.5005
R18782 avss.n744 avss.n743 4.5005
R18783 avss.n7176 avss.n7175 4.5005
R18784 avss.n7174 avss.n669 4.5005
R18785 avss.n7173 avss.n7172 4.5005
R18786 avss.n671 avss.n670 4.5005
R18787 avss.n730 avss.n729 4.5005
R18788 avss.n731 avss.n727 4.5005
R18789 avss.n7118 avss.n732 4.5005
R18790 avss.n7117 avss.n733 4.5005
R18791 avss.n7116 avss.n734 4.5005
R18792 avss.n718 avss.n717 4.5005
R18793 avss.n7127 avss.n7126 4.5005
R18794 avss.n7128 avss.n716 4.5005
R18795 avss.n7130 avss.n7129 4.5005
R18796 avss.n7177 avss.n668 4.5005
R18797 avss.n7158 avss.n683 4.5005
R18798 avss.n7160 avss.n7159 4.5005
R18799 avss.n7162 avss.n682 4.5005
R18800 avss.n7164 avss.n7163 4.5005
R18801 avss.n7157 avss.n7156 4.5005
R18802 avss.n795 avss.n794 4.5005
R18803 avss.n793 avss.n781 4.5005
R18804 avss.n7069 avss.n7068 4.5005
R18805 avss.n7067 avss.n7061 4.5005
R18806 avss.n903 avss.n804 4.5005
R18807 avss.n7096 avss.n805 4.5005
R18808 avss.n7095 avss.n806 4.5005
R18809 avss.n7094 avss.n807 4.5005
R18810 avss.n851 avss.n808 4.5005
R18811 avss.n889 avss.n852 4.5005
R18812 avss.n888 avss.n853 4.5005
R18813 avss.n887 avss.n854 4.5005
R18814 avss.n874 avss.n855 4.5005
R18815 avss.n877 avss.n876 4.5005
R18816 avss.n875 avss.n826 4.5005
R18817 avss.n7080 avss.n827 4.5005
R18818 avss.n7079 avss.n7078 4.5005
R18819 avss.n905 avss.n904 4.5005
R18820 avss.n899 avss.n841 4.5005
R18821 avss.n898 avss.n843 4.5005
R18822 avss.n897 avss.n844 4.5005
R18823 avss.n895 avss.n845 4.5005
R18824 avss.n894 avss.n846 4.5005
R18825 avss.n860 avss.n847 4.5005
R18826 avss.n861 avss.n859 4.5005
R18827 avss.n883 avss.n862 4.5005
R18828 avss.n882 avss.n863 4.5005
R18829 avss.n881 avss.n864 4.5005
R18830 avss.n870 avss.n865 4.5005
R18831 avss.n869 avss.n866 4.5005
R18832 avss.n868 avss.n867 4.5005
R18833 avss.n901 avss.n900 4.5005
R18834 avss.n818 avss.n817 4.5005
R18835 avss.n7086 avss.n7085 4.5005
R18836 avss.n7089 avss.n7088 4.5005
R18837 avss.n815 avss.n792 4.5005
R18838 avss.n7065 avss.n7064 4.5005
R18839 avss.n7063 avss.n7062 4.5005
R18840 avss.n7105 avss.n7104 4.5005
R18841 avss.n791 avss.n785 4.5005
R18842 avss.n789 avss.n788 4.5005
R18843 avss.n787 avss.n786 4.5005
R18844 avss.n777 avss.n776 4.5005
R18845 avss.n775 avss.n681 4.5005
R18846 avss.n649 avss.n648 4.5005
R18847 avss.n7184 avss.n658 4.5005
R18848 avss.n7183 avss.n659 4.5005
R18849 avss.n7182 avss.n660 4.5005
R18850 avss.n7190 avss.n7189 4.5005
R18851 avss.n3449 avss.n3444 4.5005
R18852 avss.n3451 avss.n3450 4.5005
R18853 avss.n3452 avss.n3443 4.5005
R18854 avss.n3454 avss.n3453 4.5005
R18855 avss.n3456 avss.n3441 4.5005
R18856 avss.n3460 avss.n3459 4.5005
R18857 avss.n3461 avss.n3440 4.5005
R18858 avss.n3463 avss.n3462 4.5005
R18859 avss.n3466 avss.n3439 4.5005
R18860 avss.n3469 avss.n3468 4.5005
R18861 avss.n3470 avss.n3438 4.5005
R18862 avss.n3473 avss.n3471 4.5005
R18863 avss.n3472 avss.n684 4.5005
R18864 avss.n3447 avss.n3446 4.5005
R18865 avss.n7219 avss.n606 4.5005
R18866 avss.n7218 avss.n607 4.5005
R18867 avss.n630 avss.n608 4.5005
R18868 avss.n7208 avss.n631 4.5005
R18869 avss.n7207 avss.n632 4.5005
R18870 avss.n7206 avss.n633 4.5005
R18871 avss.n638 avss.n634 4.5005
R18872 avss.n7201 avss.n639 4.5005
R18873 avss.n7200 avss.n640 4.5005
R18874 avss.n7199 avss.n641 4.5005
R18875 avss.n645 avss.n642 4.5005
R18876 avss.n7194 avss.n646 4.5005
R18877 avss.n7193 avss.n7192 4.5005
R18878 avss.n7220 avss.n605 4.5005
R18879 avss.n3527 avss.n3526 4.5005
R18880 avss.n3525 avss.n3493 4.5005
R18881 avss.n3524 avss.n3523 4.5005
R18882 avss.n3522 avss.n3494 4.5005
R18883 avss.n3521 avss.n3520 4.5005
R18884 avss.n3519 avss.n3500 4.5005
R18885 avss.n3518 avss.n3517 4.5005
R18886 avss.n3516 avss.n3501 4.5005
R18887 avss.n3515 avss.n3506 4.5005
R18888 avss.n3511 avss.n3507 4.5005
R18889 avss.n3510 avss.n3508 4.5005
R18890 avss.n700 avss.n699 4.5005
R18891 avss.n7141 avss.n7140 4.5005
R18892 avss.n3489 avss.n3488 4.5005
R18893 avss.n3535 avss.n3486 4.5005
R18894 avss.n3539 avss.n3538 4.5005
R18895 avss.n3540 avss.n3483 4.5005
R18896 avss.n3542 avss.n3541 4.5005
R18897 avss.n3543 avss.n3482 4.5005
R18898 avss.n3547 avss.n3546 4.5005
R18899 avss.n3548 avss.n3481 4.5005
R18900 avss.n3551 avss.n3550 4.5005
R18901 avss.n3549 avss.n691 4.5005
R18902 avss.n7149 avss.n692 4.5005
R18903 avss.n7148 avss.n693 4.5005
R18904 avss.n7147 avss.n694 4.5005
R18905 avss.n701 avss.n695 4.5005
R18906 avss.n3534 avss.n3533 4.5005
R18907 avss.n705 avss.n704 4.5005
R18908 avss.n5339 avss.n5117 4.5005
R18909 avss.n5338 avss.n5119 4.5005
R18910 avss.n5173 avss.n5120 4.5005
R18911 avss.n5174 avss.n5172 4.5005
R18912 avss.n5177 avss.n5175 4.5005
R18913 avss.n5178 avss.n5171 4.5005
R18914 avss.n5181 avss.n5180 4.5005
R18915 avss.n5182 avss.n5170 4.5005
R18916 avss.n5193 avss.n5183 4.5005
R18917 avss.n5192 avss.n5184 4.5005
R18918 avss.n5191 avss.n5185 4.5005
R18919 avss.n5190 avss.n5186 4.5005
R18920 avss.n5188 avss.n5187 4.5005
R18921 avss.n5341 avss.n5340 4.5005
R18922 avss.n5133 avss.n5130 4.5005
R18923 avss.n5334 avss.n5134 4.5005
R18924 avss.n5333 avss.n5135 4.5005
R18925 avss.n5332 avss.n5136 4.5005
R18926 avss.n5157 avss.n5137 4.5005
R18927 avss.n5322 avss.n5158 4.5005
R18928 avss.n5321 avss.n5159 4.5005
R18929 avss.n5320 avss.n5160 4.5005
R18930 avss.n5163 avss.n5162 4.5005
R18931 avss.n5161 avss.n593 4.5005
R18932 avss.n7229 avss.n594 4.5005
R18933 avss.n7228 avss.n595 4.5005
R18934 avss.n7227 avss.n7226 4.5005
R18935 avss.n5132 avss.n5131 4.5005
R18936 avss.n3967 avss.n3963 4.5005
R18937 avss.n3973 avss.n3968 4.5005
R18938 avss.n3972 avss.n3969 4.5005
R18939 avss.n3971 avss.n3970 4.5005
R18940 avss.n3927 avss.n3926 4.5005
R18941 avss.n4228 avss.n4227 4.5005
R18942 avss.n4229 avss.n3925 4.5005
R18943 avss.n4242 avss.n4230 4.5005
R18944 avss.n4241 avss.n4231 4.5005
R18945 avss.n4240 avss.n4232 4.5005
R18946 avss.n4239 avss.n4233 4.5005
R18947 avss.n4237 avss.n4234 4.5005
R18948 avss.n4236 avss.n4235 4.5005
R18949 avss.n3966 avss.n3965 4.5005
R18950 avss.n3981 avss.n3980 4.5005
R18951 avss.n3979 avss.n3978 4.5005
R18952 avss.n3933 avss.n3932 4.5005
R18953 avss.n4220 avss.n4219 4.5005
R18954 avss.n4221 avss.n3931 4.5005
R18955 avss.n4223 avss.n4222 4.5005
R18956 avss.n3920 avss.n3919 4.5005
R18957 avss.n4247 avss.n4246 4.5005
R18958 avss.n4248 avss.n3918 4.5005
R18959 avss.n4251 avss.n4250 4.5005
R18960 avss.n4249 avss.n3841 4.5005
R18961 avss.n4370 avss.n3842 4.5005
R18962 avss.n4369 avss.n4368 4.5005
R18963 avss.n3982 avss.n3959 4.5005
R18964 avss.n4198 avss.n3993 4.5005
R18965 avss.n4200 avss.n4199 4.5005
R18966 avss.n3952 avss.n3951 4.5005
R18967 avss.n4212 avss.n4211 4.5005
R18968 avss.n4197 avss.n4196 4.5005
R18969 avss.n4260 avss.n4259 4.5005
R18970 avss.n4258 avss.n3908 4.5005
R18971 avss.n4326 avss.n4325 4.5005
R18972 avss.n4324 avss.n4318 4.5005
R18973 avss.n4268 avss.n3861 4.5005
R18974 avss.n4352 avss.n3862 4.5005
R18975 avss.n4351 avss.n3863 4.5005
R18976 avss.n4350 avss.n3864 4.5005
R18977 avss.n4284 avss.n3865 4.5005
R18978 avss.n4286 avss.n4285 4.5005
R18979 avss.n3896 avss.n3895 4.5005
R18980 avss.n4302 avss.n4301 4.5005
R18981 avss.n4303 avss.n3894 4.5005
R18982 avss.n4306 avss.n4305 4.5005
R18983 avss.n4304 avss.n3883 4.5005
R18984 avss.n4336 avss.n3884 4.5005
R18985 avss.n4335 avss.n4334 4.5005
R18986 avss.n4270 avss.n4269 4.5005
R18987 avss.n4275 avss.n3904 4.5005
R18988 avss.n4277 avss.n4276 4.5005
R18989 avss.n4278 avss.n3903 4.5005
R18990 avss.n4280 avss.n4279 4.5005
R18991 avss.n4281 avss.n3901 4.5005
R18992 avss.n4291 avss.n4290 4.5005
R18993 avss.n4292 avss.n3900 4.5005
R18994 avss.n4296 avss.n4293 4.5005
R18995 avss.n4295 avss.n4294 4.5005
R18996 avss.n3889 avss.n3888 4.5005
R18997 avss.n4312 avss.n4311 4.5005
R18998 avss.n4313 avss.n3887 4.5005
R18999 avss.n4315 avss.n4314 4.5005
R19000 avss.n4266 avss.n3905 4.5005
R19001 avss.n3875 avss.n3874 4.5005
R19002 avss.n4342 avss.n4341 4.5005
R19003 avss.n4345 avss.n4344 4.5005
R19004 avss.n3872 avss.n3851 4.5005
R19005 avss.n4322 avss.n4321 4.5005
R19006 avss.n4320 avss.n4319 4.5005
R19007 avss.n4361 avss.n4360 4.5005
R19008 avss.n4362 avss.n3850 4.5005
R19009 avss.n3943 avss.n3942 4.5005
R19010 avss.n3945 avss.n3944 4.5005
R19011 avss.n3948 avss.n3909 4.5005
R19012 avss.n3950 avss.n3949 4.5005
R19013 avss.n3988 avss.n3987 4.5005
R19014 avss.n4204 avss.n4203 4.5005
R19015 avss.n4205 avss.n3986 4.5005
R19016 avss.n4207 avss.n4206 4.5005
R19017 avss.n4192 avss.n4191 4.5005
R19018 avss.n4090 avss.n4081 4.5005
R19019 avss.n4092 avss.n4091 4.5005
R19020 avss.n4093 avss.n4080 4.5005
R19021 avss.n4095 avss.n4094 4.5005
R19022 avss.n4097 avss.n4078 4.5005
R19023 avss.n4101 avss.n4100 4.5005
R19024 avss.n4102 avss.n4077 4.5005
R19025 avss.n4104 avss.n4103 4.5005
R19026 avss.n4107 avss.n4076 4.5005
R19027 avss.n4110 avss.n4109 4.5005
R19028 avss.n4111 avss.n4075 4.5005
R19029 avss.n4115 avss.n4112 4.5005
R19030 avss.n4114 avss.n4113 4.5005
R19031 avss.n4088 avss.n4087 4.5005
R19032 avss.n4082 avss.n617 4.5005
R19033 avss.n7214 avss.n618 4.5005
R19034 avss.n7213 avss.n619 4.5005
R19035 avss.n7212 avss.n620 4.5005
R19036 avss.n4007 avss.n621 4.5005
R19037 avss.n4010 avss.n4009 4.5005
R19038 avss.n4011 avss.n4006 4.5005
R19039 avss.n4013 avss.n4012 4.5005
R19040 avss.n4001 avss.n4000 4.5005
R19041 avss.n4021 avss.n4020 4.5005
R19042 avss.n4022 avss.n3999 4.5005
R19043 avss.n4024 avss.n4023 4.5005
R19044 avss.n4025 avss.n3997 4.5005
R19045 avss.n4084 avss.n4083 4.5005
R19046 avss.n4143 avss.n4054 4.5005
R19047 avss.n4145 avss.n4144 4.5005
R19048 avss.n4146 avss.n4053 4.5005
R19049 avss.n4150 avss.n4149 4.5005
R19050 avss.n4151 avss.n4051 4.5005
R19051 avss.n4155 avss.n4154 4.5005
R19052 avss.n4153 avss.n4052 4.5005
R19053 avss.n4152 avss.n4043 4.5005
R19054 avss.n4163 avss.n4044 4.5005
R19055 avss.n4164 avss.n4042 4.5005
R19056 avss.n4167 avss.n4166 4.5005
R19057 avss.n4168 avss.n4041 4.5005
R19058 avss.n4175 avss.n4174 4.5005
R19059 avss.n4142 avss.n4141 4.5005
R19060 avss.n4135 avss.n4059 4.5005
R19061 avss.n4134 avss.n4133 4.5005
R19062 avss.n4132 avss.n4060 4.5005
R19063 avss.n4131 avss.n4130 4.5005
R19064 avss.n4129 avss.n4065 4.5005
R19065 avss.n4128 avss.n4127 4.5005
R19066 avss.n4126 avss.n4066 4.5005
R19067 avss.n4125 avss.n4070 4.5005
R19068 avss.n4069 avss.n4033 4.5005
R19069 avss.n4183 avss.n4034 4.5005
R19070 avss.n4182 avss.n4035 4.5005
R19071 avss.n4181 avss.n4036 4.5005
R19072 avss.n4169 avss.n4037 4.5005
R19073 avss.n4137 avss.n4136 4.5005
R19074 avss.n7249 avss.n7248 4.5005
R19075 avss.n5216 avss.n5215 4.5005
R19076 avss.n5217 avss.n5199 4.5005
R19077 avss.n5220 avss.n5219 4.5005
R19078 avss.n5221 avss.n5198 4.5005
R19079 avss.n5224 avss.n5222 4.5005
R19080 avss.n5225 avss.n5197 4.5005
R19081 avss.n5228 avss.n5227 4.5005
R19082 avss.n5229 avss.n5196 4.5005
R19083 avss.n5235 avss.n5230 4.5005
R19084 avss.n5234 avss.n5231 4.5005
R19085 avss.n5233 avss.n5232 4.5005
R19086 avss.n569 avss.n568 4.5005
R19087 avss.n7245 avss.n7244 4.5005
R19088 avss.n5214 avss.n5200 4.5005
R19089 avss.n5207 avss.n5203 4.5005
R19090 avss.n5206 avss.n5205 4.5005
R19091 avss.n5204 avss.n5146 4.5005
R19092 avss.n5328 avss.n5147 4.5005
R19093 avss.n5327 avss.n5148 4.5005
R19094 avss.n5326 avss.n5149 4.5005
R19095 avss.n5302 avss.n5150 4.5005
R19096 avss.n5316 avss.n5303 4.5005
R19097 avss.n5315 avss.n5304 4.5005
R19098 avss.n5314 avss.n5305 4.5005
R19099 avss.n5312 avss.n5306 4.5005
R19100 avss.n5311 avss.n5307 4.5005
R19101 avss.n5309 avss.n5308 4.5005
R19102 avss.n5211 avss.n5210 4.5005
R19103 avss.n4487 avss.n4486 4.5005
R19104 avss.n4490 avss.n4488 4.5005
R19105 avss.n4491 avss.n4485 4.5005
R19106 avss.n4494 avss.n4493 4.5005
R19107 avss.n3568 avss.n3562 4.5005
R19108 avss.n3707 avss.n3706 4.5005
R19109 avss.n3705 avss.n3704 4.5005
R19110 avss.n4437 avss.n4436 4.5005
R19111 avss.n4435 avss.n4429 4.5005
R19112 avss.n4379 avss.n3716 4.5005
R19113 avss.n4463 avss.n3717 4.5005
R19114 avss.n4462 avss.n3718 4.5005
R19115 avss.n4461 avss.n3719 4.5005
R19116 avss.n4395 avss.n3720 4.5005
R19117 avss.n4397 avss.n4396 4.5005
R19118 avss.n3753 avss.n3752 4.5005
R19119 avss.n4413 avss.n4412 4.5005
R19120 avss.n4414 avss.n3751 4.5005
R19121 avss.n4417 avss.n4416 4.5005
R19122 avss.n4415 avss.n3740 4.5005
R19123 avss.n4447 avss.n3741 4.5005
R19124 avss.n4446 avss.n4445 4.5005
R19125 avss.n4381 avss.n4380 4.5005
R19126 avss.n4386 avss.n3761 4.5005
R19127 avss.n4388 avss.n4387 4.5005
R19128 avss.n4389 avss.n3760 4.5005
R19129 avss.n4391 avss.n4390 4.5005
R19130 avss.n4392 avss.n3758 4.5005
R19131 avss.n4402 avss.n4401 4.5005
R19132 avss.n4403 avss.n3757 4.5005
R19133 avss.n4407 avss.n4404 4.5005
R19134 avss.n4406 avss.n4405 4.5005
R19135 avss.n3746 avss.n3745 4.5005
R19136 avss.n4423 avss.n4422 4.5005
R19137 avss.n4424 avss.n3744 4.5005
R19138 avss.n4426 avss.n4425 4.5005
R19139 avss.n4377 avss.n3762 4.5005
R19140 avss.n3732 avss.n3731 4.5005
R19141 avss.n4453 avss.n4452 4.5005
R19142 avss.n4456 avss.n4455 4.5005
R19143 avss.n3729 avss.n3727 4.5005
R19144 avss.n4433 avss.n4432 4.5005
R19145 avss.n4431 avss.n4430 4.5005
R19146 avss.n3694 avss.n3693 4.5005
R19147 avss.n4475 avss.n4474 4.5005
R19148 avss.n4478 avss.n4477 4.5005
R19149 avss.n3691 avss.n3690 4.5005
R19150 avss.n4482 avss.n3687 4.5005
R19151 avss.n4484 avss.n4483 4.5005
R19152 avss.n4520 avss.n4519 4.5005
R19153 avss.n4518 avss.n3572 4.5005
R19154 avss.n4517 avss.n4516 4.5005
R19155 avss.n3653 avss.n3652 4.5005
R19156 avss.n3651 avss.n3571 4.5005
R19157 avss.n3614 avss.n3586 4.5005
R19158 avss.n3613 avss.n3588 4.5005
R19159 avss.n3612 avss.n3589 4.5005
R19160 avss.n3610 avss.n3590 4.5005
R19161 avss.n3609 avss.n3591 4.5005
R19162 avss.n3607 avss.n3592 4.5005
R19163 avss.n3604 avss.n3593 4.5005
R19164 avss.n3603 avss.n3594 4.5005
R19165 avss.n3600 avss.n3595 4.5005
R19166 avss.n3599 avss.n3597 4.5005
R19167 avss.n3596 avss.n3560 4.5005
R19168 avss.n4530 avss.n3561 4.5005
R19169 avss.n4529 avss.n4528 4.5005
R19170 avss.n3616 avss.n3615 4.5005
R19171 avss.n3621 avss.n3585 4.5005
R19172 avss.n3623 avss.n3622 4.5005
R19173 avss.n3625 avss.n3583 4.5005
R19174 avss.n3627 avss.n3626 4.5005
R19175 avss.n3628 avss.n3582 4.5005
R19176 avss.n3630 avss.n3629 4.5005
R19177 avss.n3633 avss.n3580 4.5005
R19178 avss.n3636 avss.n3635 4.5005
R19179 avss.n3637 avss.n3579 4.5005
R19180 avss.n3641 avss.n3638 4.5005
R19181 avss.n3640 avss.n3639 4.5005
R19182 avss.n3574 avss.n3573 4.5005
R19183 avss.n3649 avss.n3648 4.5005
R19184 avss.n3620 avss.n3619 4.5005
R19185 avss.n5272 avss.n5246 4.5005
R19186 avss.n5271 avss.n5270 4.5005
R19187 avss.n5269 avss.n5250 4.5005
R19188 avss.n5268 avss.n5267 4.5005
R19189 avss.n5266 avss.n5251 4.5005
R19190 avss.n5265 avss.n5264 4.5005
R19191 avss.n5263 avss.n5254 4.5005
R19192 avss.n5262 avss.n5261 4.5005
R19193 avss.n5260 avss.n5255 4.5005
R19194 avss.n5259 avss.n5258 4.5005
R19195 avss.n5257 avss.n584 4.5005
R19196 avss.n7234 avss.n583 4.5005
R19197 avss.n7236 avss.n7235 4.5005
R19198 avss.n5274 avss.n5273 4.5005
R19199 avss.n5281 avss.n5245 4.5005
R19200 avss.n5283 avss.n5282 4.5005
R19201 avss.n5284 avss.n5244 4.5005
R19202 avss.n5286 avss.n5285 4.5005
R19203 avss.n5288 avss.n5242 4.5005
R19204 avss.n5290 avss.n5289 4.5005
R19205 avss.n5291 avss.n5240 4.5005
R19206 avss.n5299 avss.n5298 4.5005
R19207 avss.n5297 avss.n5241 4.5005
R19208 avss.n5296 avss.n5295 4.5005
R19209 avss.n5294 avss.n5292 4.5005
R19210 avss.n581 avss.n580 4.5005
R19211 avss.n7240 avss.n7239 4.5005
R19212 avss.n5278 avss.n5277 4.5005
R19213 avss.n4620 avss.n4619 4.5005
R19214 avss.n4540 avss.n4539 4.5005
R19215 avss.n4562 avss.n4547 4.5005
R19216 avss.n4561 avss.n4548 4.5005
R19217 avss.n4560 avss.n4549 4.5005
R19218 avss.n4557 avss.n4550 4.5005
R19219 avss.n4556 avss.n4551 4.5005
R19220 avss.n4553 avss.n4552 4.5005
R19221 avss.n3425 avss.n3424 4.5005
R19222 avss.n4599 avss.n4598 4.5005
R19223 avss.n4600 avss.n3423 4.5005
R19224 avss.n4602 avss.n4601 4.5005
R19225 avss.n3411 avss.n3410 4.5005
R19226 avss.n4615 avss.n4614 4.5005
R19227 avss.n4568 avss.n4567 4.5005
R19228 avss.n4584 avss.n4571 4.5005
R19229 avss.n4583 avss.n4572 4.5005
R19230 avss.n4580 avss.n4573 4.5005
R19231 avss.n4579 avss.n4574 4.5005
R19232 avss.n4576 avss.n4575 4.5005
R19233 avss.n3432 avss.n3431 4.5005
R19234 avss.n4591 avss.n4590 4.5005
R19235 avss.n4592 avss.n3430 4.5005
R19236 avss.n4594 avss.n4593 4.5005
R19237 avss.n3419 avss.n3418 4.5005
R19238 avss.n4607 avss.n4606 4.5005
R19239 avss.n4608 avss.n3417 4.5005
R19240 avss.n4610 avss.n4609 4.5005
R19241 avss.n4585 avss.n4570 4.5005
R19242 avss.n1851 avss.n1850 4.5005
R19243 avss.n1849 avss.n1824 4.5005
R19244 avss.n1848 avss.n1847 4.5005
R19245 avss.n1846 avss.n1829 4.5005
R19246 avss.n1845 avss.n1844 4.5005
R19247 avss.n1843 avss.n1832 4.5005
R19248 avss.n1842 avss.n1841 4.5005
R19249 avss.n1840 avss.n1833 4.5005
R19250 avss.n1839 avss.n1838 4.5005
R19251 avss.n1837 avss.n1835 4.5005
R19252 avss.n1836 avss.n1759 4.5005
R19253 avss.n3307 avss.n1758 4.5005
R19254 avss.n3309 avss.n3308 4.5005
R19255 avss.n1828 avss.n1823 4.5005
R19256 avss.n1954 avss.n1953 4.5005
R19257 avss.n1955 avss.n1816 4.5005
R19258 avss.n1957 avss.n1956 4.5005
R19259 avss.n1796 avss.n1795 4.5005
R19260 avss.n1975 avss.n1974 4.5005
R19261 avss.n1976 avss.n1794 4.5005
R19262 avss.n1978 avss.n1977 4.5005
R19263 avss.n1769 avss.n1768 4.5005
R19264 avss.n3299 avss.n3298 4.5005
R19265 avss.n3300 avss.n1767 4.5005
R19266 avss.n3302 avss.n3301 4.5005
R19267 avss.n1757 avss.n1756 4.5005
R19268 avss.n3313 avss.n3312 4.5005
R19269 avss.n1818 avss.n1817 4.5005
R19270 avss.n7263 avss.n7262 4.5005
R19271 avss.n4629 avss.n4628 4.5005
R19272 avss.n6403 avss.n6402 4.5005
R19273 avss.n6402 avss.n6401 4.5005
R19274 avss.n6401 avss.n3326 4.5005
R19275 avss.n6322 avss.n3337 4.5005
R19276 avss.n6322 avss.n6321 4.5005
R19277 avss.n6321 avss.n6247 4.5005
R19278 avss.n6462 avss.n1694 4.5005
R19279 avss.n6465 avss.n1694 4.5005
R19280 avss.n6465 avss.n1693 4.5005
R19281 avss.n7256 avss.n554 4.5005
R19282 avss.n7258 avss.n7257 4.5005
R19283 avss.n7257 avss.n7256 4.5005
R19284 avss.n6418 avss.n1720 4.5005
R19285 avss.n6418 avss.n556 4.5005
R19286 avss.n6416 avss.n556 4.5005
R19287 avss.n6429 avss.n1717 4.5005
R19288 avss.n6430 avss.n6429 4.5005
R19289 avss.n6431 avss.n6430 4.5005
R19290 avss.n3395 avss.n3394 4.5005
R19291 avss.n4644 avss.n4638 4.5005
R19292 avss.n4644 avss.n4643 4.5005
R19293 avss.n4643 avss.n4640 4.5005
R19294 avss.n4649 avss.n3345 4.5005
R19295 avss.n4650 avss.n4649 4.5005
R19296 avss.n4651 avss.n4650 4.5005
R19297 avss.n4660 avss.n4659 4.5005
R19298 avss.n4659 avss.n4658 4.5005
R19299 avss.n4658 avss.n4656 4.5005
R19300 avss.n6476 avss.n6470 4.5005
R19301 avss.n6476 avss.n6475 4.5005
R19302 avss.n6475 avss.n6471 4.5005
R19303 avss.n3389 avss.n3385 4.5005
R19304 avss.n3390 avss.n3384 4.5005
R19305 avss.n3390 avss.n3389 4.5005
R19306 avss.n3375 avss.n1728 4.5005
R19307 avss.n3379 avss.n3375 4.5005
R19308 avss.n3379 avss.n3374 4.5005
R19309 avss.n6423 avss.n6422 4.5005
R19310 avss.n6422 avss.n6421 4.5005
R19311 avss.n6421 avss.n1729 4.5005
R19312 avss.n6424 avss.n1722 4.5005
R19313 avss.n6425 avss.n6424 4.5005
R19314 avss.n6426 avss.n6425 4.5005
R19315 avss.n3370 avss.n3369 4.5005
R19316 avss.n7255 avss.n7254 4.5005
R19317 avss.n7254 avss.n7253 4.5005
R19318 avss.n7253 avss.n564 4.5005
R19319 avss.n4634 avss.n565 4.5005
R19320 avss.n4637 avss.n565 4.5005
R19321 avss.n4637 avss.n3399 4.5005
R19322 avss.n3407 avss.n3325 4.5005
R19323 avss.n3407 avss.n3406 4.5005
R19324 avss.n3406 avss.n3401 4.5005
R19325 avss.n6246 avss.n6245 4.5005
R19326 avss.n6245 avss.n6244 4.5005
R19327 avss.n6244 avss.n4661 4.5005
R19328 avss.n6466 avss.n1690 4.5005
R19329 avss.n6469 avss.n1690 4.5005
R19330 avss.n6469 avss.n1689 4.5005
R19331 avss.n5347 avss.n5346 4.5005
R19332 avss.n4682 avss.n4681 4.5005
R19333 avss.n6222 avss.n6221 4.5005
R19334 avss.n6223 avss.n4680 4.5005
R19335 avss.n6225 avss.n6224 4.5005
R19336 avss.n4668 avss.n4667 4.5005
R19337 avss.n6238 avss.n6237 4.5005
R19338 avss.n5349 avss.n5348 4.5005
R19339 avss.n6240 avss.n6239 4.5005
R19340 avss.n6231 avss.n4674 4.5005
R19341 avss.n6230 avss.n6229 4.5005
R19342 avss.n4676 avss.n4675 4.5005
R19343 avss.n6217 avss.n6216 4.5005
R19344 avss.n6215 avss.n4686 4.5005
R19345 avss.n6214 avss.n6213 4.5005
R19346 avss.n4688 avss.n4687 4.5005
R19347 avss.n6233 avss.n6232 4.5005
R19348 avss.n9219 avss.n9218 4.5005
R19349 avss.n129 avss.n128 4.5005
R19350 avss.n3360 avss.n132 4.21457
R19351 avss.n6607 avss.n6606 4.1117
R19352 avss.n3354 avss.n144 4.04657
R19353 avss.n3350 avss.n1 3.959
R19354 avss.n3349 avss.n0 3.959
R19355 avss.n7026 avss.n964 3.88502
R19356 avss.n7007 avss.n7006 3.88502
R19357 avss.n1014 avss.n995 3.88502
R19358 avss.n9211 avss.n132 3.88025
R19359 avss.n1679 avss.n1678 3.68497
R19360 avss.n1007 avss.n996 3.58621
R19361 avss.n6845 avss.n1116 3.43681
R19362 avss.n6861 avss.n1124 3.43681
R19363 avss.n6531 avss.n6528 3.3573
R19364 avss.n6991 avss.n1009 3.2874
R19365 avss.n6673 avss.n1243 3.28078
R19366 avss.n1222 avss.n1221 3.28078
R19367 avss.n1651 avss.n1650 3.28078
R19368 avss.n5707 avss.n5706 3.28078
R19369 avss.n6097 avss.n5727 3.28078
R19370 avss.n5831 avss.n5819 3.28078
R19371 avss.n9250 avss.n9249 3.28078
R19372 avss.n9315 avss.n9314 3.28078
R19373 avss.n9136 avss.n218 3.28078
R19374 avss.n9167 avss.n9166 3.28078
R19375 avss.n9196 avss.n147 3.28078
R19376 avss.n8607 avss.n8606 3.28078
R19377 avss.n8610 avss.n7887 3.28078
R19378 avss.n8631 avss.n8630 3.28078
R19379 avss.n8731 avss.n8730 3.28078
R19380 avss.n8737 avss.n7797 3.28078
R19381 avss.n7777 avss.n7776 3.28078
R19382 avss.n9215 avss.n131 3.28078
R19383 avss.n9202 avss.n140 3.17683
R19384 avss.n3357 avss.n3356 3.17683
R19385 avss.n9209 avss.n134 3.17683
R19386 avss.n135 avss.n132 3.15217
R19387 avss.n9314 avss.n73 3.14293
R19388 avss.n9249 avss.n9239 3.14293
R19389 avss.n1243 avss.n1240 3.14293
R19390 avss.n1222 avss.n1216 3.14293
R19391 avss.n1650 avss.n1247 3.14293
R19392 avss.n5832 avss.n5831 3.14293
R19393 avss.n5727 avss.n5724 3.14293
R19394 avss.n5707 avss.n5701 3.14293
R19395 avss.n1593 avss.n1243 3.14293
R19396 avss.n1223 avss.n1222 3.14293
R19397 avss.n1650 avss.n1649 3.14293
R19398 avss.n5708 avss.n5707 3.14293
R19399 avss.n5854 avss.n5727 3.14293
R19400 avss.n5831 avss.n5826 3.14293
R19401 avss.n9249 avss.n9248 3.14293
R19402 avss.n9314 avss.n9313 3.14293
R19403 avss.n218 avss.n217 3.14293
R19404 avss.n9166 avss.n179 3.14293
R19405 avss.n150 avss.n147 3.14293
R19406 avss.n164 avss.n147 3.14293
R19407 avss.n218 avss.n209 3.14293
R19408 avss.n9166 avss.n9165 3.14293
R19409 avss.n8606 avss.n7891 3.14293
R19410 avss.n7887 avss.n7884 3.14293
R19411 avss.n8630 avss.n7861 3.14293
R19412 avss.n8630 avss.n8629 3.14293
R19413 avss.n8606 avss.n8605 3.14293
R19414 avss.n7918 avss.n7887 3.14293
R19415 avss.n8730 avss.n7801 3.14293
R19416 avss.n7797 avss.n7794 3.14293
R19417 avss.n7777 avss.n7771 3.14293
R19418 avss.n7778 avss.n7777 3.14293
R19419 avss.n8730 avss.n8729 3.14293
R19420 avss.n7828 avss.n7797 3.14293
R19421 avss.n8378 avss.n131 3.14293
R19422 avss.n131 avss.n124 3.14293
R19423 avss.n1160 avss.t210 3.138
R19424 avss.n5914 avss.n5874 3.11744
R19425 avss.n5920 avss.n5875 3.11744
R19426 avss.n5924 avss.n5876 3.11744
R19427 avss.n5930 avss.n5877 3.11744
R19428 avss.n5934 avss.n5878 3.11744
R19429 avss.n5940 avss.n5879 3.11744
R19430 avss.n5944 avss.n5880 3.11744
R19431 avss.n5950 avss.n5881 3.11744
R19432 avss.n5954 avss.n5882 3.11744
R19433 avss.n5960 avss.n5883 3.11744
R19434 avss.n5964 avss.n5884 3.11744
R19435 avss.n5970 avss.n5885 3.11744
R19436 avss.n5974 avss.n5886 3.11744
R19437 avss.n5980 avss.n5887 3.11744
R19438 avss.n5984 avss.n5888 3.11744
R19439 avss.n5990 avss.n5889 3.11744
R19440 avss.n5993 avss.n5890 3.11744
R19441 avss.n6001 avss.n6000 3.11744
R19442 avss.n6004 avss.n6003 3.11744
R19443 avss.n6193 avss.n6192 3.11744
R19444 avss.n6190 avss.n6189 3.11744
R19445 avss.n6185 avss.n5625 3.11744
R19446 avss.n6183 avss.n6182 3.11744
R19447 avss.n6178 avss.n5632 3.11744
R19448 avss.n6176 avss.n6175 3.11744
R19449 avss.n6171 avss.n5639 3.11744
R19450 avss.n6169 avss.n6168 3.11744
R19451 avss.n6164 avss.n5646 3.11744
R19452 avss.n6162 avss.n6161 3.11744
R19453 avss.n6157 avss.n5653 3.11744
R19454 avss.n6155 avss.n6154 3.11744
R19455 avss.n6150 avss.n5660 3.11744
R19456 avss.n6148 avss.n6147 3.11744
R19457 avss.n6143 avss.n5667 3.11744
R19458 avss.n6141 avss.n6140 3.11744
R19459 avss.n6136 avss.n5674 3.11744
R19460 avss.n6134 avss.n6133 3.11744
R19461 avss.n6129 avss.n5681 3.11744
R19462 avss.n2831 avss.n2806 3.11744
R19463 avss.n2837 avss.n2807 3.11744
R19464 avss.n2840 avss.n2808 3.11744
R19465 avss.n2848 avss.n2847 3.11744
R19466 avss.n2786 avss.n2775 3.11744
R19467 avss.n2792 avss.n2776 3.11744
R19468 avss.n2795 avss.n2777 3.11744
R19469 avss.n2804 avss.n2803 3.11744
R19470 avss.n2891 avss.n2890 3.11744
R19471 avss.n2886 avss.n2860 3.11744
R19472 avss.n2882 avss.n2859 3.11744
R19473 avss.n2878 avss.n2858 3.11744
R19474 avss.n2919 avss.n2852 3.11744
R19475 avss.n2915 avss.n2851 3.11744
R19476 avss.n2911 avss.n2850 3.11744
R19477 avss.n2907 avss.n2849 3.11744
R19478 avss.n2538 avss.n2228 3.11744
R19479 avss.n2534 avss.n2229 3.11744
R19480 avss.n2530 avss.n2230 3.11744
R19481 avss.n2526 avss.n2231 3.11744
R19482 avss.n2567 avss.n2507 3.11744
R19483 avss.n2571 avss.n2569 3.11744
R19484 avss.n2578 avss.n2503 3.11744
R19485 avss.n2581 avss.n2580 3.11744
R19486 avss.n2706 avss.n2692 3.11744
R19487 avss.n2704 avss.n2691 3.11744
R19488 avss.n2700 avss.n2690 3.11744
R19489 avss.n2717 avss.n2716 3.11744
R19490 avss.n2764 avss.n2235 3.11744
R19491 avss.n2762 avss.n2234 3.11744
R19492 avss.n2758 avss.n2233 3.11744
R19493 avss.n2754 avss.n2232 3.11744
R19494 avss.n2221 avss.n2175 3.11744
R19495 avss.n2219 avss.n2218 3.11744
R19496 avss.n2214 avss.n2182 3.11744
R19497 avss.n2212 avss.n2211 3.11744
R19498 avss.n3269 avss.n3268 3.11744
R19499 avss.n3266 avss.n3265 3.11744
R19500 avss.n3261 avss.n2030 3.11744
R19501 avss.n3259 avss.n3258 3.11744
R19502 avss.n2949 avss.n2948 3.11744
R19503 avss.n2944 avss.n2930 3.11744
R19504 avss.n2940 avss.n2929 3.11744
R19505 avss.n2928 avss.n2131 3.11744
R19506 avss.n2963 avss.n2142 3.11744
R19507 avss.n2961 avss.n2141 3.11744
R19508 avss.n2140 avss.n2138 3.11744
R19509 avss.n2973 avss.n2134 3.11744
R19510 avss.n2974 avss.n2973 3.11744
R19511 avss.n2960 avss.n2140 3.11744
R19512 avss.n2964 avss.n2141 3.11744
R19513 avss.n2144 avss.n2142 3.11744
R19514 avss.n2939 avss.n2928 3.11744
R19515 avss.n2943 avss.n2929 3.11744
R19516 avss.n2931 avss.n2930 3.11744
R19517 avss.n2949 avss.n2147 3.11744
R19518 avss.n3260 avss.n3259 3.11744
R19519 avss.n2030 avss.n2023 3.11744
R19520 avss.n3267 avss.n3266 3.11744
R19521 avss.n3270 avss.n3269 3.11744
R19522 avss.n2213 avss.n2212 3.11744
R19523 avss.n2182 avss.n2176 3.11744
R19524 avss.n2220 avss.n2219 3.11744
R19525 avss.n2175 avss.n2152 3.11744
R19526 avss.n2757 avss.n2232 3.11744
R19527 avss.n2761 avss.n2233 3.11744
R19528 avss.n2765 avss.n2234 3.11744
R19529 avss.n2237 avss.n2235 3.11744
R19530 avss.n2716 avss.n2689 3.11744
R19531 avss.n2703 avss.n2690 3.11744
R19532 avss.n2707 avss.n2691 3.11744
R19533 avss.n2693 avss.n2692 3.11744
R19534 avss.n2580 avss.n2579 3.11744
R19535 avss.n2570 avss.n2503 3.11744
R19536 avss.n2569 avss.n2568 3.11744
R19537 avss.n2560 avss.n2507 3.11744
R19538 avss.n2529 avss.n2231 3.11744
R19539 avss.n2533 avss.n2230 3.11744
R19540 avss.n2537 avss.n2229 3.11744
R19541 avss.n2541 avss.n2228 3.11744
R19542 avss.n2910 avss.n2849 3.11744
R19543 avss.n2914 avss.n2850 3.11744
R19544 avss.n2918 avss.n2851 3.11744
R19545 avss.n2854 avss.n2852 3.11744
R19546 avss.n2881 avss.n2858 3.11744
R19547 avss.n2885 avss.n2859 3.11744
R19548 avss.n2861 avss.n2860 3.11744
R19549 avss.n2891 avss.n2857 3.11744
R19550 avss.n2804 avss.n2778 3.11744
R19551 avss.n2793 avss.n2777 3.11744
R19552 avss.n2785 avss.n2776 3.11744
R19553 avss.n2783 avss.n2775 3.11744
R19554 avss.n2848 avss.n2809 3.11744
R19555 avss.n2838 avss.n2808 3.11744
R19556 avss.n2830 avss.n2807 3.11744
R19557 avss.n2828 avss.n2806 3.11744
R19558 avss.n4582 avss.n4536 3.11744
R19559 avss.n4578 avss.n4535 3.11744
R19560 avss.n4534 avss.n3433 3.11744
R19561 avss.n4588 avss.n3429 3.11744
R19562 avss.n4564 avss.n4563 3.11744
R19563 avss.n4559 avss.n4545 3.11744
R19564 avss.n4555 avss.n4544 3.11744
R19565 avss.n4543 avss.n3426 3.11744
R19566 avss.n3458 avss.n3434 3.11744
R19567 avss.n3464 avss.n3435 3.11744
R19568 avss.n3467 avss.n3436 3.11744
R19569 avss.n3475 avss.n3474 3.11744
R19570 avss.n7205 avss.n635 3.11744
R19571 avss.n7203 avss.n7202 3.11744
R19572 avss.n7198 avss.n643 3.11744
R19573 avss.n7196 avss.n7195 3.11744
R19574 avss.n7197 avss.n7196 3.11744
R19575 avss.n643 avss.n637 3.11744
R19576 avss.n7204 avss.n7203 3.11744
R19577 avss.n635 avss.n629 3.11744
R19578 avss.n3475 avss.n3437 3.11744
R19579 avss.n3465 avss.n3436 3.11744
R19580 avss.n3457 avss.n3435 3.11744
R19581 avss.n3455 avss.n3434 3.11744
R19582 avss.n3487 avss.n3476 3.11744
R19583 avss.n3537 avss.n3477 3.11744
R19584 avss.n3485 avss.n3478 3.11744
R19585 avss.n3545 avss.n3479 3.11744
R19586 avss.n3480 avss.n3479 3.11744
R19587 avss.n3544 avss.n3478 3.11744
R19588 avss.n3484 avss.n3477 3.11744
R19589 avss.n3536 avss.n3476 3.11744
R19590 avss.n3529 avss.n3528 3.11744
R19591 avss.n3496 avss.n3495 3.11744
R19592 avss.n3499 avss.n3498 3.11744
R19593 avss.n3504 avss.n3503 3.11744
R19594 avss.n3503 avss.n3502 3.11744
R19595 avss.n3498 avss.n3497 3.11744
R19596 avss.n3495 avss.n3492 3.11744
R19597 avss.n3530 avss.n3529 3.11744
R19598 avss.n4099 avss.n4071 3.11744
R19599 avss.n4105 avss.n4072 3.11744
R19600 avss.n4108 avss.n4073 3.11744
R19601 avss.n4117 avss.n4116 3.11744
R19602 avss.n4008 avss.n4003 3.11744
R19603 avss.n4015 avss.n4014 3.11744
R19604 avss.n4019 avss.n4002 3.11744
R19605 avss.n4017 avss.n3998 3.11744
R19606 avss.n4018 avss.n4017 3.11744
R19607 avss.n4005 avss.n4002 3.11744
R19608 avss.n4015 avss.n4004 3.11744
R19609 avss.n4003 avss.n622 3.11744
R19610 avss.n4117 avss.n4074 3.11744
R19611 avss.n4106 avss.n4073 3.11744
R19612 avss.n4098 avss.n4072 3.11744
R19613 avss.n4096 avss.n4071 3.11744
R19614 avss.n4138 avss.n4058 3.11744
R19615 avss.n4119 avss.n4062 3.11744
R19616 avss.n4121 avss.n4064 3.11744
R19617 avss.n4122 avss.n4067 3.11744
R19618 avss.n4122 avss.n4068 3.11744
R19619 avss.n4121 avss.n4120 3.11744
R19620 avss.n4119 avss.n4063 3.11744
R19621 avss.n4061 avss.n4058 3.11744
R19622 avss.n4055 avss.n4047 3.11744
R19623 avss.n4147 avss.n4048 3.11744
R19624 avss.n4050 avss.n4049 3.11744
R19625 avss.n4157 avss.n4045 3.11744
R19626 avss.n4157 avss.n4156 3.11744
R19627 avss.n4148 avss.n4049 3.11744
R19628 avss.n4056 avss.n4048 3.11744
R19629 avss.n4140 avss.n4047 3.11744
R19630 avss.n3606 avss.n3555 3.11744
R19631 avss.n3602 avss.n3556 3.11744
R19632 avss.n3598 avss.n3557 3.11744
R19633 avss.n4532 avss.n4531 3.11744
R19634 avss.n3631 avss.n3576 3.11744
R19635 avss.n3634 avss.n3577 3.11744
R19636 avss.n3643 avss.n3642 3.11744
R19637 avss.n3646 avss.n3645 3.11744
R19638 avss.n4589 avss.n4588 3.11744
R19639 avss.n4577 avss.n4534 3.11744
R19640 avss.n4581 avss.n4535 3.11744
R19641 avss.n4538 avss.n4536 3.11744
R19642 avss.n4554 avss.n4543 3.11744
R19643 avss.n4558 avss.n4544 3.11744
R19644 avss.n4546 avss.n4545 3.11744
R19645 avss.n4564 avss.n4541 3.11744
R19646 avss.n3645 avss.n3575 3.11744
R19647 avss.n3643 avss.n3578 3.11744
R19648 avss.n3632 avss.n3577 3.11744
R19649 avss.n3581 avss.n3576 3.11744
R19650 avss.n4532 avss.n3558 3.11744
R19651 avss.n3601 avss.n3557 3.11744
R19652 avss.n3605 avss.n3556 3.11744
R19653 avss.n3608 avss.n3555 3.11744
R19654 avss.n5681 avss.n5675 3.11744
R19655 avss.n6135 avss.n6134 3.11744
R19656 avss.n5674 avss.n5668 3.11744
R19657 avss.n6142 avss.n6141 3.11744
R19658 avss.n5667 avss.n5661 3.11744
R19659 avss.n6149 avss.n6148 3.11744
R19660 avss.n5660 avss.n5654 3.11744
R19661 avss.n6156 avss.n6155 3.11744
R19662 avss.n5653 avss.n5647 3.11744
R19663 avss.n6163 avss.n6162 3.11744
R19664 avss.n5646 avss.n5640 3.11744
R19665 avss.n6170 avss.n6169 3.11744
R19666 avss.n5639 avss.n5633 3.11744
R19667 avss.n6177 avss.n6176 3.11744
R19668 avss.n5632 avss.n5626 3.11744
R19669 avss.n6184 avss.n6183 3.11744
R19670 avss.n5625 avss.n5618 3.11744
R19671 avss.n6191 avss.n6190 3.11744
R19672 avss.n6194 avss.n6193 3.11744
R19673 avss.n6003 avss.n5873 3.11744
R19674 avss.n6001 avss.n5891 3.11744
R19675 avss.n5991 avss.n5890 3.11744
R19676 avss.n5983 avss.n5889 3.11744
R19677 avss.n5981 avss.n5888 3.11744
R19678 avss.n5973 avss.n5887 3.11744
R19679 avss.n5971 avss.n5886 3.11744
R19680 avss.n5963 avss.n5885 3.11744
R19681 avss.n5961 avss.n5884 3.11744
R19682 avss.n5953 avss.n5883 3.11744
R19683 avss.n5951 avss.n5882 3.11744
R19684 avss.n5943 avss.n5881 3.11744
R19685 avss.n5941 avss.n5880 3.11744
R19686 avss.n5933 avss.n5879 3.11744
R19687 avss.n5931 avss.n5878 3.11744
R19688 avss.n5923 avss.n5877 3.11744
R19689 avss.n5921 avss.n5876 3.11744
R19690 avss.n5913 avss.n5875 3.11744
R19691 avss.n5911 avss.n5874 3.11744
R19692 avss.n6868 avss.n1114 2.98859
R19693 avss.n5068 avss.n5067 2.9093
R19694 avss.n6323 avss.n1131 2.9093
R19695 avss.n2683 avss.n2682 2.9093
R19696 avss.n3170 avss.n3002 2.9093
R19697 avss.n7138 avss.n7137 2.9093
R19698 avss.n4172 avss.n4171 2.9093
R19699 avss.n4617 avss.n3408 2.9093
R19700 avss.n7265 avss.n404 2.9093
R19701 avss.n7958 avss.n7759 2.83868
R19702 avss.n8757 avss.n8756 2.8348
R19703 avss.n8657 avss.n8651 2.8348
R19704 avss.t31 avss.n8672 2.8348
R19705 avss.n8533 avss.n8527 2.8348
R19706 avss.n8628 avss.n7868 2.8348
R19707 avss.t16 avss.n8549 2.8348
R19708 avss.n8377 avss.n8376 2.8348
R19709 avss.n9222 avss.n9221 2.8348
R19710 avss.t104 avss.n103 2.8348
R19711 avss.n3352 avss.n1 2.7293
R19712 avss.n3353 avss.n0 2.7293
R19713 avss.n6500 avss.n6499 2.7255
R19714 avss.n6481 avss.n6480 2.7255
R19715 avss.n6828 avss.n1138 2.68978
R19716 avss.n9210 avss.n133 2.654
R19717 avss.n3355 avss.n141 2.654
R19718 avss.n9201 avss.n9200 2.654
R19719 avss.n6429 avss.n6428 2.6501
R19720 avss.n6419 avss.n6418 2.6501
R19721 avss.n6638 avss.n6637 2.5655
R19722 avss.n7261 avss.n552 2.4908
R19723 avss.n3371 avss.n561 2.4908
R19724 avss.n8776 avss.n7729 2.48881
R19725 avss.n8506 avss.n7733 2.48881
R19726 avss.n8770 avss.n7742 2.48881
R19727 avss.n8641 avss.n7746 2.48881
R19728 avss.n8764 avss.n7755 2.48881
R19729 avss.n3359 avss.n3358 2.4439
R19730 avss.n3361 avss.n3360 2.4439
R19731 avss.n6434 avss.n6433 2.4197
R19732 avss.n6440 avss.n6438 2.4197
R19733 avss.n6444 avss.n6443 2.4197
R19734 avss.n6414 avss.n6413 2.4197
R19735 avss.n6409 avss.n6408 2.4197
R19736 avss.n3329 avss.n1739 2.4197
R19737 avss.n3351 avss.n137 2.4005
R19738 avss.n9206 avss.n137 2.4005
R19739 avss.n9206 avss.n9205 2.4005
R19740 avss.n9205 avss.n138 2.4005
R19741 avss.n6609 avss.n138 2.4005
R19742 avss.n6609 avss.n6521 2.4005
R19743 avss.n6637 avss.n6521 2.4005
R19744 avss.n3357 avss.n134 2.4005
R19745 avss.n4646 avss.n3364 2.4005
R19746 avss.n4647 avss.n1686 2.4005
R19747 avss.n6478 avss.n1686 2.4005
R19748 avss.n6479 avss.n6478 2.4005
R19749 avss.n6479 avss.n1679 2.4005
R19750 avss.n5807 avss.n5802 2.3972
R19751 avss.n6816 avss.n6815 2.39097
R19752 avss.n7257 avss.n558 2.3054
R19753 avss.n4626 avss.n3323 2.3054
R19754 avss.n6399 avss.n6398 2.3054
R19755 avss.n7251 avss.n7250 2.3054
R19756 avss.n4622 avss.n4621 2.3054
R19757 avss.n3403 avss.n3340 2.3054
R19758 avss.n139 avss.n138 2.3005
R19759 avss.n9205 avss.n9204 2.3005
R19760 avss.n9207 avss.n9206 2.3005
R19761 avss.n137 avss.n135 2.3005
R19762 avss.n5730 avss.n1656 2.26231
R19763 avss.n5805 avss.n5734 2.26231
R19764 avss.n5761 avss.n5758 2.26231
R19765 avss.n5769 avss.n5768 2.26231
R19766 avss.n5812 avss.n5810 2.26231
R19767 avss.n6460 avss.n1699 2.26231
R19768 avss.n6464 avss.n1695 2.26231
R19769 avss.n6474 avss.n6472 2.26231
R19770 avss.n3388 avss.n3387 2.26231
R19771 avss.n3382 avss.n3381 2.26231
R19772 avss.n6468 avss.n1691 2.26231
R19773 avss.n5801 avss.n5736 2.25074
R19774 avss.n1705 avss.n1703 2.25074
R19775 avss.n3396 avss.n3366 2.25074
R19776 avss.n6659 avss.n1658 2.2479
R19777 avss.n6666 avss.n1653 2.2479
R19778 avss.n5791 avss.n5790 2.2479
R19779 avss.n5786 avss.n1661 2.2479
R19780 avss.n5737 avss.n5736 2.2479
R19781 avss.n5802 avss.n5735 2.2479
R19782 avss.n5772 avss.n5745 2.2479
R19783 avss.n5780 avss.n5747 2.2479
R19784 avss.n5765 avss.n5754 2.2479
R19785 avss.n5795 avss.n5728 2.2479
R19786 avss.n6445 avss.n6444 2.2479
R19787 avss.n6449 avss.n1703 2.2479
R19788 avss.n6456 avss.n6455 2.2479
R19789 avss.n6452 avss.n6451 2.2479
R19790 avss.n6441 avss.n6440 2.2479
R19791 avss.n6408 avss.n1736 2.2479
R19792 avss.n1739 avss.n1738 2.2479
R19793 avss.n3335 avss.n3330 2.2479
R19794 avss.n6413 avss.n1732 2.2479
R19795 avss.n6438 avss.n1711 2.2479
R19796 avss.n4632 avss.n4631 2.2479
R19797 avss.n4627 avss.n4626 2.2479
R19798 avss.n6400 avss.n6399 2.2479
R19799 avss.n6320 avss.n6318 2.2479
R19800 avss.n7260 avss.n553 2.2479
R19801 avss.n6414 avss.n1731 2.2479
R19802 avss.n6433 avss.n1716 2.2479
R19803 avss.n3392 avss.n3366 2.2479
R19804 avss.n3397 avss.n3365 2.2479
R19805 avss.n4642 avss.n3348 2.2479
R19806 avss.n4653 avss.n3344 2.2479
R19807 avss.n4657 avss.n1687 2.2479
R19808 avss.n3378 avss.n552 2.2479
R19809 avss.n6420 avss.n6419 2.2479
R19810 avss.n6428 avss.n1721 2.2479
R19811 avss.n3372 avss.n3371 2.2479
R19812 avss.n7252 avss.n7251 2.2479
R19813 avss.n4636 avss.n4622 2.2479
R19814 avss.n3405 avss.n3403 2.2479
R19815 avss.n6243 avss.n6242 2.2479
R19816 avss.n6661 avss.n6660 2.24405
R19817 avss.n1660 avss.n1659 2.24405
R19818 avss.n6665 avss.n6664 2.24405
R19819 avss.n5731 avss.n5730 2.24405
R19820 avss.n5789 avss.n5788 2.24405
R19821 avss.n5744 avss.n5743 2.24405
R19822 avss.n5784 avss.n5783 2.24405
R19823 avss.n5785 avss.n5782 2.24405
R19824 avss.n5798 avss.n5797 2.24405
R19825 avss.n5808 avss.n5734 2.24405
R19826 avss.n5803 avss.n5733 2.24405
R19827 avss.n5764 avss.n5758 2.24405
R19828 avss.n5759 avss.n5757 2.24405
R19829 avss.n5775 avss.n5752 2.24405
R19830 avss.n5753 avss.n5751 2.24405
R19831 avss.n5779 avss.n5748 2.24405
R19832 avss.n5750 avss.n5749 2.24405
R19833 avss.n5770 avss.n5769 2.24405
R19834 avss.n5767 avss.n5766 2.24405
R19835 avss.n5793 avss.n5741 2.24405
R19836 avss.n5794 avss.n5740 2.24405
R19837 avss.n5810 avss.n5732 2.24405
R19838 avss.n5811 avss.n5729 2.24405
R19839 avss.n6448 avss.n1704 2.24405
R19840 avss.n6454 avss.n6453 2.24405
R19841 avss.n6457 avss.n1701 2.24405
R19842 avss.n6439 avss.n1707 2.24405
R19843 avss.n1710 avss.n1706 2.24405
R19844 avss.n6407 avss.n1708 2.24405
R19845 avss.n6405 avss.n6404 2.24405
R19846 avss.n3333 avss.n3332 2.24405
R19847 avss.n3334 avss.n3331 2.24405
R19848 avss.n6458 avss.n1699 2.24405
R19849 avss.n6459 avss.n1700 2.24405
R19850 avss.n6412 avss.n1715 2.24405
R19851 avss.n1734 avss.n1733 2.24405
R19852 avss.n6437 avss.n1712 2.24405
R19853 avss.n1714 avss.n1713 2.24405
R19854 avss.n4630 avss.n1735 2.24405
R19855 avss.n4633 avss.n4625 2.24405
R19856 avss.n6403 avss.n1741 2.24405
R19857 avss.n3324 avss.n1740 2.24405
R19858 avss.n6317 avss.n3337 2.24405
R19859 avss.n6319 avss.n3327 2.24405
R19860 avss.n6462 avss.n1695 2.24405
R19861 avss.n6463 avss.n1696 2.24405
R19862 avss.n7259 avss.n7258 2.24405
R19863 avss.n557 avss.n555 2.24405
R19864 avss.n6415 avss.n1720 2.24405
R19865 avss.n6417 avss.n1730 2.24405
R19866 avss.n6432 avss.n1717 2.24405
R19867 avss.n1719 avss.n1718 2.24405
R19868 avss.n3393 avss.n563 2.24405
R19869 avss.n4639 avss.n4638 2.24405
R19870 avss.n4641 avss.n3398 2.24405
R19871 avss.n4652 avss.n3345 2.24405
R19872 avss.n3347 avss.n3346 2.24405
R19873 avss.n4660 avss.n3343 2.24405
R19874 avss.n4655 avss.n3342 2.24405
R19875 avss.n6472 avss.n6470 2.24405
R19876 avss.n6473 avss.n1688 2.24405
R19877 avss.n3387 avss.n3384 2.24405
R19878 avss.n3386 avss.n3367 2.24405
R19879 avss.n3373 avss.n1728 2.24405
R19880 avss.n3377 avss.n3376 2.24405
R19881 avss.n6423 avss.n1726 2.24405
R19882 avss.n1727 avss.n1725 2.24405
R19883 avss.n6427 avss.n1722 2.24405
R19884 avss.n1724 avss.n1723 2.24405
R19885 avss.n3381 avss.n3380 2.24405
R19886 avss.n3383 avss.n3368 2.24405
R19887 avss.n7255 avss.n560 2.24405
R19888 avss.n562 avss.n559 2.24405
R19889 avss.n4634 avss.n4624 2.24405
R19890 avss.n4635 avss.n4623 2.24405
R19891 avss.n3402 avss.n3325 2.24405
R19892 avss.n3404 avss.n3400 2.24405
R19893 avss.n6246 avss.n3339 2.24405
R19894 avss.n3341 avss.n3338 2.24405
R19895 avss.n6466 avss.n1691 2.24405
R19896 avss.n6467 avss.n1692 2.24405
R19897 avss.n6747 avss.t171 2.24157
R19898 avss.n6748 avss.t61 2.24157
R19899 avss.n8063 avss.n7720 2.13334
R19900 avss avss.n0 2.0943
R19901 avss.n7033 avss.n953 2.09217
R19902 avss.n6619 avss.n6521 2.0605
R19903 avss.n6610 avss.n6609 2.0605
R19904 avss.n6637 avss.n6636 2.0605
R19905 avss.n3352 avss.n3351 2.0605
R19906 avss.n6658 avss.n6657 2.023
R19907 avss.n6466 avss.n6465 1.9957
R19908 avss.n6462 avss.n6461 1.9957
R19909 avss.n6321 avss.n6246 1.9957
R19910 avss.n3337 avss.n3336 1.9957
R19911 avss.n6401 avss.n3325 1.9957
R19912 avss.n6404 avss.n6403 1.9957
R19913 avss.n4634 avss.n4633 1.9957
R19914 avss.n6410 avss.n1735 1.9957
R19915 avss.n7256 avss.n7255 1.9957
R19916 avss.n7258 avss.n556 1.9957
R19917 avss.n3380 avss.n3379 1.9957
R19918 avss.n6421 avss.n1728 1.9957
R19919 avss.n6667 avss.n1652 1.9607
R19920 avss.n5815 avss.n5728 1.9607
R19921 avss.n4648 avss.n3348 1.9373
R19922 avss.n623 avss.n613 1.87503
R19923 avss.n3275 avss.n2012 1.87503
R19924 avss.n9203 avss.n9202 1.84883
R19925 avss.n3356 avss.n136 1.84883
R19926 avss.n9209 avss.n9208 1.84883
R19927 avss.n9200 avss.n144 1.84325
R19928 avss.n162 avss.n153 1.83631
R19929 avss.n9186 avss.n9185 1.83631
R19930 avss.t38 avss.n183 1.83631
R19931 avss.n6117 avss.n6116 1.83011
R19932 avss.n6024 avss.n6018 1.83011
R19933 avss.t189 avss.n6035 1.83011
R19934 avss.n1640 avss.n1639 1.83011
R19935 avss.n1648 avss.n1249 1.83011
R19936 avss.n1621 avss.t88 1.83011
R19937 avss.n3362 avss.n3353 1.78688
R19938 avss avss.n1 1.7567
R19939 avss.n3391 avss.n3390 1.7177
R19940 avss.n6501 avss.n1679 1.6797
R19941 avss.n6482 avss.n6479 1.6797
R19942 avss.n6478 avss.n6477 1.667
R19943 avss.n4654 avss.n1686 1.667
R19944 avss.n4648 avss.n4647 1.667
R19945 avss.n4646 avss.n4645 1.667
R19946 avss.n3391 avss.n3364 1.667
R19947 avss.n6641 avss.n6640 1.628
R19948 avss.n6643 avss.n6520 1.628
R19949 avss.n6519 avss.n1669 1.628
R19950 avss.n6518 avss.n6517 1.628
R19951 avss.n6515 avss.n1670 1.628
R19952 avss.n1678 avss.n1672 1.628
R19953 avss.n5071 avss.n5070 1.6079
R19954 avss.n6395 avss.n6324 1.6079
R19955 avss.n3320 avss.n1742 1.6079
R19956 avss.n2113 avss.n2110 1.6079
R19957 avss.n706 avss.n703 1.6079
R19958 avss.n7247 avss.n566 1.6079
R19959 avss.n4618 avss.n582 1.6079
R19960 avss.n7264 avss.n551 1.6079
R19961 avss.n4645 avss.n4644 1.6079
R19962 avss.n142 avss.n139 1.6055
R19963 avss.n6620 avss.n6528 1.6005
R19964 avss.n6620 avss.n6619 1.6005
R19965 avss.n6608 avss.n6607 1.6005
R19966 avss.n6610 avss.n6608 1.6005
R19967 avss.n6657 avss.n1662 1.6005
R19968 avss.n6636 avss.n1662 1.6005
R19969 avss.n3353 avss.n3352 1.6005
R19970 avss.n6501 avss.n6500 1.6005
R19971 avss.n6482 avss.n6481 1.6005
R19972 avss.n6455 avss.n6449 1.5197
R19973 avss.n3330 avss.n1698 1.5197
R19974 avss.n9200 avss.n9199 1.5175
R19975 avss.n7864 avss.n141 1.5175
R19976 avss.n8733 avss.n133 1.5175
R19977 avss.n9212 avss.n9211 1.5175
R19978 avss.n6611 avss.n6610 1.4171
R19979 avss.n6608 avss.n6530 1.4171
R19980 avss.n5069 avss.n3340 1.4126
R19981 avss.n705 avss.n561 1.4126
R19982 avss.n7250 avss.n7249 1.4126
R19983 avss.n4621 avss.n4620 1.4126
R19984 avss.n9208 avss.n9207 1.3925
R19985 avss.n9204 avss.n136 1.3925
R19986 avss.n9203 avss.n139 1.3925
R19987 avss.n3358 avss.n3357 1.3925
R19988 avss.n3354 avss.n140 1.3925
R19989 avss.n6398 avss.n6397 1.3726
R19990 avss.n3323 avss.n3322 1.3726
R19991 avss.n2112 avss.n558 1.3726
R19992 avss.n7263 avss.n7261 1.3726
R19993 avss.n6658 avss.n1661 1.3676
R19994 avss.n5070 avss.n5068 1.2947
R19995 avss.n6324 avss.n6323 1.2947
R19996 avss.n2683 avss.n1742 1.2947
R19997 avss.n3002 avss.n2113 1.2947
R19998 avss.n7138 avss.n706 1.2947
R19999 avss.n4172 avss.n566 1.2947
R20000 avss.n4618 avss.n4617 1.2947
R20001 avss.n7265 avss.n7264 1.2947
R20002 avss.n5732 avss.n5731 1.2757
R20003 avss.n5793 avss.n5792 1.2757
R20004 avss.n5773 avss.n5770 1.2757
R20005 avss.n6318 avss.n6316 1.2704
R20006 avss.n6242 avss.n6241 1.2704
R20007 avss.n4654 avss.n4653 1.2623
R20008 avss.n8782 avss.n7720 1.24466
R20009 avss.n6606 avss 1.2287
R20010 avss avss.n5069 1.1961
R20011 avss.n6397 avss 1.1961
R20012 avss.n3322 avss 1.1961
R20013 avss avss.n2112 1.1961
R20014 avss avss.n705 1.1961
R20015 avss.n7249 avss 1.1961
R20016 avss.n4620 avss 1.1961
R20017 avss avss.n7263 1.1961
R20018 avss.n4659 avss.n4654 1.1579
R20019 avss.n5813 avss.n5808 1.1369
R20020 avss.n5797 avss.n5796 1.1369
R20021 avss.n5767 avss.n5764 1.1369
R20022 avss.n6621 avss.n6620 1.1255
R20023 avss.n6619 avss.n6618 1.1255
R20024 avss.n6532 avss.n6528 1.1255
R20025 avss.n6657 avss.n6656 1.1255
R20026 avss.n1666 avss.n1662 1.1255
R20027 avss.n6636 avss.n6635 1.1255
R20028 avss.n9210 avss.n9209 1.1255
R20029 avss.n3356 avss.n3355 1.1255
R20030 avss.n9202 avss.n9201 1.1255
R20031 avss.n6500 avss.n1676 1.1255
R20032 avss.n6481 avss.n1684 1.1255
R20033 avss.n6483 avss.n6482 1.1255
R20034 avss.n6502 avss.n6501 1.1255
R20035 avss.n3363 avss.n3349 1.06717
R20036 avss.n3350 avss.n3349 1.06717
R20037 avss.n1678 avss.n1670 1.06717
R20038 avss.n6518 avss.n1670 1.06717
R20039 avss.n6520 avss.n6519 1.06717
R20040 avss.n6640 avss.n6520 1.06717
R20041 avss.n6668 avss.n6667 1.043
R20042 avss.n2973 avss.n2972 1.04278
R20043 avss.n2972 avss.n2140 1.04278
R20044 avss.n2972 avss.n2141 1.04278
R20045 avss.n2972 avss.n2142 1.04278
R20046 avss.n2950 avss.n2928 1.04278
R20047 avss.n2950 avss.n2929 1.04278
R20048 avss.n2950 avss.n2930 1.04278
R20049 avss.n2950 avss.n2949 1.04278
R20050 avss.n3259 avss.n2021 1.04278
R20051 avss.n2030 avss.n2021 1.04278
R20052 avss.n3266 avss.n2021 1.04278
R20053 avss.n3269 avss.n2021 1.04278
R20054 avss.n2212 avss.n2139 1.04278
R20055 avss.n2182 avss.n2139 1.04278
R20056 avss.n2219 avss.n2139 1.04278
R20057 avss.n2175 avss.n2139 1.04278
R20058 avss.n2773 avss.n2232 1.04278
R20059 avss.n2773 avss.n2233 1.04278
R20060 avss.n2773 avss.n2234 1.04278
R20061 avss.n2773 avss.n2235 1.04278
R20062 avss.n2716 avss.n2715 1.04278
R20063 avss.n2715 avss.n2690 1.04278
R20064 avss.n2715 avss.n2691 1.04278
R20065 avss.n2715 avss.n2692 1.04278
R20066 avss.n2580 avss.n2227 1.04278
R20067 avss.n2503 avss.n2227 1.04278
R20068 avss.n2569 avss.n2227 1.04278
R20069 avss.n2507 avss.n2227 1.04278
R20070 avss.n2774 avss.n2231 1.04278
R20071 avss.n2774 avss.n2230 1.04278
R20072 avss.n2774 avss.n2229 1.04278
R20073 avss.n2774 avss.n2228 1.04278
R20074 avss.n2924 avss.n2849 1.04278
R20075 avss.n2924 avss.n2850 1.04278
R20076 avss.n2924 avss.n2851 1.04278
R20077 avss.n2924 avss.n2852 1.04278
R20078 avss.n2892 avss.n2858 1.04278
R20079 avss.n2892 avss.n2859 1.04278
R20080 avss.n2892 avss.n2860 1.04278
R20081 avss.n2892 avss.n2891 1.04278
R20082 avss.n2805 avss.n2804 1.04278
R20083 avss.n2805 avss.n2777 1.04278
R20084 avss.n2805 avss.n2776 1.04278
R20085 avss.n2805 avss.n2775 1.04278
R20086 avss.n2925 avss.n2848 1.04278
R20087 avss.n2925 avss.n2808 1.04278
R20088 avss.n2925 avss.n2807 1.04278
R20089 avss.n2925 avss.n2806 1.04278
R20090 avss.n7196 avss.n636 1.04278
R20091 avss.n643 avss.n636 1.04278
R20092 avss.n7203 avss.n636 1.04278
R20093 avss.n636 avss.n635 1.04278
R20094 avss.n3554 avss.n3475 1.04278
R20095 avss.n3554 avss.n3436 1.04278
R20096 avss.n3554 avss.n3435 1.04278
R20097 avss.n3554 avss.n3434 1.04278
R20098 avss.n3553 avss.n3479 1.04278
R20099 avss.n3553 avss.n3478 1.04278
R20100 avss.n3553 avss.n3477 1.04278
R20101 avss.n3553 avss.n3476 1.04278
R20102 avss.n3503 avss.n3491 1.04278
R20103 avss.n3498 avss.n3491 1.04278
R20104 avss.n3495 avss.n3491 1.04278
R20105 avss.n3529 avss.n3491 1.04278
R20106 avss.n4017 avss.n4016 1.04278
R20107 avss.n4016 avss.n4002 1.04278
R20108 avss.n4016 avss.n4015 1.04278
R20109 avss.n4016 avss.n4003 1.04278
R20110 avss.n4118 avss.n4117 1.04278
R20111 avss.n4118 avss.n4073 1.04278
R20112 avss.n4118 avss.n4072 1.04278
R20113 avss.n4118 avss.n4071 1.04278
R20114 avss.n4123 avss.n4122 1.04278
R20115 avss.n4123 avss.n4121 1.04278
R20116 avss.n4123 avss.n4119 1.04278
R20117 avss.n4123 avss.n4058 1.04278
R20118 avss.n4158 avss.n4157 1.04278
R20119 avss.n4158 avss.n4049 1.04278
R20120 avss.n4158 avss.n4048 1.04278
R20121 avss.n4158 avss.n4047 1.04278
R20122 avss.n4588 avss.n4587 1.04278
R20123 avss.n4587 avss.n4534 1.04278
R20124 avss.n4587 avss.n4535 1.04278
R20125 avss.n4587 avss.n4536 1.04278
R20126 avss.n4565 avss.n4543 1.04278
R20127 avss.n4565 avss.n4544 1.04278
R20128 avss.n4565 avss.n4545 1.04278
R20129 avss.n4565 avss.n4564 1.04278
R20130 avss.n3645 avss.n3644 1.04278
R20131 avss.n3644 avss.n3643 1.04278
R20132 avss.n3644 avss.n3577 1.04278
R20133 avss.n3644 avss.n3576 1.04278
R20134 avss.n4533 avss.n4532 1.04278
R20135 avss.n4533 avss.n3557 1.04278
R20136 avss.n4533 avss.n3556 1.04278
R20137 avss.n4533 avss.n3555 1.04278
R20138 avss.n5681 avss.n5616 1.04278
R20139 avss.n6134 avss.n5616 1.04278
R20140 avss.n5674 avss.n5616 1.04278
R20141 avss.n6141 avss.n5616 1.04278
R20142 avss.n5667 avss.n5616 1.04278
R20143 avss.n6148 avss.n5616 1.04278
R20144 avss.n5660 avss.n5616 1.04278
R20145 avss.n6155 avss.n5616 1.04278
R20146 avss.n5653 avss.n5616 1.04278
R20147 avss.n6162 avss.n5616 1.04278
R20148 avss.n5646 avss.n5616 1.04278
R20149 avss.n6169 avss.n5616 1.04278
R20150 avss.n5639 avss.n5616 1.04278
R20151 avss.n6176 avss.n5616 1.04278
R20152 avss.n5632 avss.n5616 1.04278
R20153 avss.n6183 avss.n5616 1.04278
R20154 avss.n5625 avss.n5616 1.04278
R20155 avss.n6190 avss.n5616 1.04278
R20156 avss.n6193 avss.n5616 1.04278
R20157 avss.n6003 avss.n6002 1.04278
R20158 avss.n6002 avss.n6001 1.04278
R20159 avss.n6002 avss.n5890 1.04278
R20160 avss.n6002 avss.n5889 1.04278
R20161 avss.n6002 avss.n5888 1.04278
R20162 avss.n6002 avss.n5887 1.04278
R20163 avss.n6002 avss.n5886 1.04278
R20164 avss.n6002 avss.n5885 1.04278
R20165 avss.n6002 avss.n5884 1.04278
R20166 avss.n6002 avss.n5883 1.04278
R20167 avss.n6002 avss.n5882 1.04278
R20168 avss.n6002 avss.n5881 1.04278
R20169 avss.n6002 avss.n5880 1.04278
R20170 avss.n6002 avss.n5879 1.04278
R20171 avss.n6002 avss.n5878 1.04278
R20172 avss.n6002 avss.n5877 1.04278
R20173 avss.n6002 avss.n5876 1.04278
R20174 avss.n6002 avss.n5875 1.04278
R20175 avss.n6002 avss.n5874 1.04278
R20176 avss.n6316 avss 1.0398
R20177 avss.n6241 avss 1.0398
R20178 avss.n6659 avss.n6658 1.0301
R20179 avss.n9208 avss.n135 1.0085
R20180 avss.n9207 avss.n136 1.0085
R20181 avss.n9204 avss.n9203 1.0085
R20182 avss.n3360 avss.n134 1.0085
R20183 avss.n3358 avss.n140 1.0085
R20184 avss.n3392 avss.n3391 0.9329
R20185 avss.n6477 avss.n6476 0.9329
R20186 avss.n6532 avss.n6524 0.9257
R20187 avss.n5816 avss.n5815 0.923
R20188 avss.n144 avss.n143 0.879167
R20189 avss.n6640 avss.n6639 0.873833
R20190 avss.n4645 avss.n3397 0.8123
R20191 avss.n6549 avss.n6533 0.795826
R20192 avss.n6604 avss.n6534 0.795826
R20193 avss.n7775 avss.n7772 0.743357
R20194 avss.n7772 avss.n7768 0.743357
R20195 avss.n8750 avss.n8749 0.743357
R20196 avss.n8749 avss.n8748 0.743357
R20197 avss.n8739 avss.n8738 0.743357
R20198 avss.n8740 avss.n8739 0.743357
R20199 avss.n7829 avss.n7796 0.743357
R20200 avss.n7829 avss.n7822 0.743357
R20201 avss.n7804 avss.n7800 0.743357
R20202 avss.n7816 avss.n7804 0.743357
R20203 avss.n7802 avss.n7799 0.743357
R20204 avss.n8711 avss.n7802 0.743357
R20205 avss.n8633 avss.n8632 0.743357
R20206 avss.n8634 avss.n8633 0.743357
R20207 avss.n7867 avss.n7863 0.743357
R20208 avss.n7870 avss.n7867 0.743357
R20209 avss.n8612 avss.n8611 0.743357
R20210 avss.n8613 avss.n8612 0.743357
R20211 avss.n7919 avss.n7886 0.743357
R20212 avss.n7919 avss.n7912 0.743357
R20213 avss.n7894 avss.n7890 0.743357
R20214 avss.n7906 avss.n7894 0.743357
R20215 avss.n7892 avss.n7889 0.743357
R20216 avss.n8587 avss.n7892 0.743357
R20217 avss.n2265 avss.n2261 0.743357
R20218 avss.n2286 avss.n2265 0.743357
R20219 avss.n2354 avss.n2353 0.743357
R20220 avss.n2367 avss.n2354 0.743357
R20221 avss.n2326 avss.n2321 0.743357
R20222 avss.n2321 avss.n372 0.743357
R20223 avss.n2659 avss.n2282 0.743357
R20224 avss.n2282 avss.n2267 0.743357
R20225 avss.n2365 avss.n2364 0.743357
R20226 avss.n2366 avss.n2365 0.743357
R20227 avss.n2364 avss.n2291 0.743357
R20228 avss.n2350 avss.n2291 0.743357
R20229 avss.n2430 avss.n2429 0.743357
R20230 avss.n2431 avss.n2430 0.743357
R20231 avss.n2429 avss.n2428 0.743357
R20232 avss.n2428 avss.n2427 0.743357
R20233 avss.n2333 avss.n2323 0.743357
R20234 avss.n2323 avss.n372 0.743357
R20235 avss.n3202 avss.n3201 0.743357
R20236 avss.n3203 avss.n3202 0.743357
R20237 avss.n3080 avss.n3079 0.743357
R20238 avss.n3081 avss.n3080 0.743357
R20239 avss.n3007 avss.n3003 0.743357
R20240 avss.n3007 avss.n374 0.743357
R20241 avss.n3216 avss.n2091 0.743357
R20242 avss.n3204 avss.n2091 0.743357
R20243 avss.n3098 avss.n3062 0.743357
R20244 avss.n3082 avss.n3062 0.743357
R20245 avss.n3099 avss.n3098 0.743357
R20246 avss.n3100 avss.n3099 0.743357
R20247 avss.n3150 avss.n3019 0.743357
R20248 avss.n3117 avss.n3019 0.743357
R20249 avss.n3150 avss.n3149 0.743357
R20250 avss.n3149 avss.n3148 0.743357
R20251 avss.n3156 avss.n3012 0.743357
R20252 avss.n3156 avss.n374 0.743357
R20253 avss.n2118 avss.n2114 0.743357
R20254 avss.n2118 avss.n2039 0.743357
R20255 avss.n2064 avss.n2053 0.743357
R20256 avss.n2053 avss.n2049 0.743357
R20257 avss.n2188 avss.n2187 0.743357
R20258 avss.n2187 avss.n2186 0.743357
R20259 avss.n2188 avss.n2037 0.743357
R20260 avss.n2120 avss.n2037 0.743357
R20261 avss.n2197 avss.n2048 0.743357
R20262 avss.n2052 avss.n2048 0.743357
R20263 avss.n2197 avss.n2087 0.743357
R20264 avss.n2087 avss.n2074 0.743357
R20265 avss.n3216 avss.n3215 0.743357
R20266 avss.n3215 avss.n3214 0.743357
R20267 avss.n2744 avss.n2743 0.743357
R20268 avss.n2745 avss.n2744 0.743357
R20269 avss.n2609 avss.n2608 0.743357
R20270 avss.n2608 avss.n2607 0.743357
R20271 avss.n2749 avss.n2748 0.743357
R20272 avss.n2750 avss.n2749 0.743357
R20273 avss.n2748 avss.n2747 0.743357
R20274 avss.n2747 avss.n2746 0.743357
R20275 avss.n2600 avss.n2489 0.743357
R20276 avss.n2489 avss.n2481 0.743357
R20277 avss.n2600 avss.n2278 0.743357
R20278 avss.n2467 avss.n2278 0.743357
R20279 avss.n2659 avss.n2658 0.743357
R20280 avss.n2658 avss.n2657 0.743357
R20281 avss.n7019 avss.n7018 0.743357
R20282 avss.n7018 avss.n7017 0.743357
R20283 avss.n7005 avss.n7004 0.743357
R20284 avss.n7006 avss.n7005 0.743357
R20285 avss.n6768 avss.n6760 0.743357
R20286 avss.n6760 avss.n1166 0.743357
R20287 avss.n1148 avss.n1094 0.743357
R20288 avss.n1094 avss.n1091 0.743357
R20289 avss.n6851 avss.n1123 0.743357
R20290 avss.n6860 avss.n1123 0.743357
R20291 avss.n6975 avss.n6974 0.743357
R20292 avss.n6974 avss.n964 0.743357
R20293 avss.n6975 avss.n977 0.743357
R20294 avss.n977 avss.n974 0.743357
R20295 avss.n6989 avss.n1015 0.743357
R20296 avss.n1015 avss.n1014 0.743357
R20297 avss.n6990 avss.n6989 0.743357
R20298 avss.n6991 avss.n6990 0.743357
R20299 avss.n6795 avss.n1170 0.743357
R20300 avss.n6726 avss.n1170 0.743357
R20301 avss.n6795 avss.n1168 0.743357
R20302 avss.n6762 avss.n1168 0.743357
R20303 avss.n6808 avss.n6807 0.743357
R20304 avss.n6807 avss.n6806 0.743357
R20305 avss.n6808 avss.n1106 0.743357
R20306 avss.n1106 avss.n1105 0.743357
R20307 avss.n6870 avss.n1110 0.743357
R20308 avss.n6815 avss.n1110 0.743357
R20309 avss.n6870 avss.n6869 0.743357
R20310 avss.n6869 avss.n6868 0.743357
R20311 avss.n6859 avss.n6858 0.743357
R20312 avss.n6860 avss.n6859 0.743357
R20313 avss.n9195 avss.n9194 0.743357
R20314 avss.n9194 avss.n9193 0.743357
R20315 avss.n9179 avss.n146 0.743357
R20316 avss.n9179 avss.n9178 0.743357
R20317 avss.n9169 avss.n9168 0.743357
R20318 avss.n9170 avss.n9169 0.743357
R20319 avss.n182 avss.n181 0.743357
R20320 avss.n194 avss.n182 0.743357
R20321 avss.n216 avss.n215 0.743357
R20322 avss.n216 avss.n199 0.743357
R20323 avss.n9137 avss.n212 0.743357
R20324 avss.n9131 avss.n212 0.743357
R20325 avss.n8062 avss.n8061 0.743357
R20326 avss.n8063 avss.n8062 0.743357
R20327 avss.n7332 avss.n7328 0.743357
R20328 avss.n7332 avss.n7331 0.743357
R20329 avss.n471 avss.n470 0.743357
R20330 avss.n472 avss.n471 0.743357
R20331 avss.n7458 avss.n402 0.743357
R20332 avss.n402 avss.n379 0.743357
R20333 avss.n7405 avss.n476 0.743357
R20334 avss.n7329 avss.n476 0.743357
R20335 avss.n7417 avss.n428 0.743357
R20336 avss.n473 avss.n428 0.743357
R20337 avss.n7417 avss.n425 0.743357
R20338 avss.n451 avss.n425 0.743357
R20339 avss.n7432 avss.n7431 0.743357
R20340 avss.n7433 avss.n7432 0.743357
R20341 avss.n7431 avss.n396 0.743357
R20342 avss.n396 avss.n392 0.743357
R20343 avss.n7467 avss.n7466 0.743357
R20344 avss.n7466 avss.n379 0.743357
R20345 avss.n550 avss.n546 0.743357
R20346 avss.n546 avss.n529 0.743357
R20347 avss.n7365 avss.n7308 0.743357
R20348 avss.n7308 avss.n517 0.743357
R20349 avss.n7281 avss.n7280 0.743357
R20350 avss.n7280 avss.n7279 0.743357
R20351 avss.n7281 avss.n528 0.743357
R20352 avss.n7270 avss.n528 0.743357
R20353 avss.n516 avss.n512 0.743357
R20354 avss.n7307 avss.n516 0.743357
R20355 avss.n512 avss.n511 0.743357
R20356 avss.n511 avss.n506 0.743357
R20357 avss.n7405 avss.n7404 0.743357
R20358 avss.n7404 avss.n7403 0.743357
R20359 avss.n3618 avss.n3617 0.743357
R20360 avss.n3617 avss.n577 0.743357
R20361 avss.n5213 avss.n5111 0.743357
R20362 avss.n5344 avss.n5111 0.743357
R20363 avss.n571 avss.n567 0.743357
R20364 avss.n7223 avss.n571 0.743357
R20365 avss.n4139 avss.n4057 0.743357
R20366 avss.n4139 avss.n623 0.743357
R20367 avss.n4086 avss.n4085 0.743357
R20368 avss.n4085 avss.n577 0.743357
R20369 avss.n5343 avss.n5342 0.743357
R20370 avss.n5344 avss.n5343 0.743357
R20371 avss.n7225 avss.n7224 0.743357
R20372 avss.n7224 avss.n7223 0.743357
R20373 avss.n3532 avss.n3531 0.743357
R20374 avss.n3531 avss.n623 0.743357
R20375 avss.n3445 avss.n603 0.743357
R20376 avss.n603 avss.n577 0.743357
R20377 avss.n5275 avss.n5113 0.743357
R20378 avss.n5344 avss.n5113 0.743357
R20379 avss.n7238 avss.n579 0.743357
R20380 avss.n7223 avss.n579 0.743357
R20381 avss.n4569 avss.n4537 0.743357
R20382 avss.n4537 avss.n623 0.743357
R20383 avss.n3413 avss.n3409 0.743357
R20384 avss.n3569 avss.n3413 0.743357
R20385 avss.n4512 avss.n4511 0.743357
R20386 avss.n4513 avss.n4512 0.743357
R20387 avss.n4526 avss.n3565 0.743357
R20388 avss.n3565 avss.n3564 0.743357
R20389 avss.n4526 avss.n4525 0.743357
R20390 avss.n4525 avss.n3415 0.743357
R20391 avss.n4496 avss.n3686 0.743357
R20392 avss.n3686 avss.n3685 0.743357
R20393 avss.n4497 avss.n4496 0.743357
R20394 avss.n4498 avss.n4497 0.743357
R20395 avss.n3702 avss.n3688 0.743357
R20396 avss.n3781 avss.n3688 0.743357
R20397 avss.n4170 avss.n4040 0.743357
R20398 avss.n4040 avss.n3996 0.743357
R20399 avss.n3964 avss.n3957 0.743357
R20400 avss.n3957 avss.n3954 0.743357
R20401 avss.n4188 avss.n4187 0.743357
R20402 avss.n4187 avss.n4186 0.743357
R20403 avss.n4188 avss.n3995 0.743357
R20404 avss.n4177 avss.n3995 0.743357
R20405 avss.n4214 avss.n3947 0.743357
R20406 avss.n3956 avss.n3947 0.743357
R20407 avss.n4215 avss.n4214 0.743357
R20408 avss.n4216 avss.n4215 0.743357
R20409 avss.n4256 avss.n4255 0.743357
R20410 avss.n4255 avss.n4254 0.743357
R20411 avss.n702 avss.n698 0.743357
R20412 avss.n698 avss.n652 0.743357
R20413 avss.n742 avss.n666 0.743357
R20414 avss.n666 avss.n662 0.743357
R20415 avss.n7154 avss.n7153 0.743357
R20416 avss.n7153 avss.n7152 0.743357
R20417 avss.n7154 avss.n650 0.743357
R20418 avss.n7143 avss.n650 0.743357
R20419 avss.n7166 avss.n661 0.743357
R20420 avss.n665 avss.n661 0.743357
R20421 avss.n7167 avss.n7166 0.743357
R20422 avss.n7168 avss.n7167 0.743357
R20423 avss.n7112 avss.n7111 0.743357
R20424 avss.n7113 avss.n7112 0.743357
R20425 avss.n712 avss.n708 0.743357
R20426 avss.n782 avss.n712 0.743357
R20427 avss.n902 avss.n840 0.743357
R20428 avss.n840 avss.n838 0.743357
R20429 avss.n7076 avss.n7075 0.743357
R20430 avss.n7075 avss.n7074 0.743357
R20431 avss.n7111 avss.n7110 0.743357
R20432 avss.n7110 avss.n714 0.743357
R20433 avss.n7101 avss.n784 0.743357
R20434 avss.n784 avss.n783 0.743357
R20435 avss.n7101 avss.n7100 0.743357
R20436 avss.n7100 avss.n7099 0.743357
R20437 avss.n816 avss.n814 0.743357
R20438 avss.n849 avss.n814 0.743357
R20439 avss.n819 avss.n816 0.743357
R20440 avss.n873 avss.n819 0.743357
R20441 avss.n7073 avss.n7072 0.743357
R20442 avss.n7074 avss.n7073 0.743357
R20443 avss.n4367 avss.n4366 0.743357
R20444 avss.n4366 avss.n4365 0.743357
R20445 avss.n4267 avss.n3906 0.743357
R20446 avss.n4264 avss.n3906 0.743357
R20447 avss.n4332 avss.n4331 0.743357
R20448 avss.n4331 avss.n832 0.743357
R20449 avss.n4256 avss.n3848 0.743357
R20450 avss.n3848 avss.n3846 0.743357
R20451 avss.n4357 avss.n3852 0.743357
R20452 avss.n4263 avss.n3852 0.743357
R20453 avss.n4357 avss.n4356 0.743357
R20454 avss.n4356 avss.n4355 0.743357
R20455 avss.n3873 avss.n3871 0.743357
R20456 avss.n4283 avss.n3871 0.743357
R20457 avss.n3876 avss.n3873 0.743357
R20458 avss.n3892 avss.n3876 0.743357
R20459 avss.n4317 avss.n4316 0.743357
R20460 avss.n4317 avss.n832 0.743357
R20461 avss.n3821 avss.n3774 0.743357
R20462 avss.n3774 avss.n3697 0.743357
R20463 avss.n4378 avss.n3763 0.743357
R20464 avss.n3763 avss.n3700 0.743357
R20465 avss.n4443 avss.n4442 0.743357
R20466 avss.n4442 avss.n833 0.743357
R20467 avss.n3702 avss.n3695 0.743357
R20468 avss.n3826 avss.n3695 0.743357
R20469 avss.n4469 avss.n4468 0.743357
R20470 avss.n4470 avss.n4469 0.743357
R20471 avss.n4468 avss.n4467 0.743357
R20472 avss.n4467 avss.n4466 0.743357
R20473 avss.n3730 avss.n3726 0.743357
R20474 avss.n4394 avss.n3726 0.743357
R20475 avss.n3733 avss.n3730 0.743357
R20476 avss.n3749 avss.n3733 0.743357
R20477 avss.n4428 avss.n4427 0.743357
R20478 avss.n4428 avss.n833 0.743357
R20479 avss.n1890 avss.n1889 0.743357
R20480 avss.n1889 avss.n914 0.743357
R20481 avss.n1747 avss.n1743 0.743357
R20482 avss.n3285 avss.n1747 0.743357
R20483 avss.n2694 avss.n2236 0.743357
R20484 avss.n2236 avss.n2012 0.743357
R20485 avss.n2551 avss.n2550 0.743357
R20486 avss.n2550 avss.n1751 0.743357
R20487 avss.n1945 avss.n1944 0.743357
R20488 avss.n1944 avss.n914 0.743357
R20489 avss.n3287 avss.n3286 0.743357
R20490 avss.n3286 avss.n3285 0.743357
R20491 avss.n2954 avss.n2143 0.743357
R20492 avss.n2143 avss.n2012 0.743357
R20493 avss.n2162 avss.n2161 0.743357
R20494 avss.n2161 avss.n1751 0.743357
R20495 avss.n2896 avss.n2853 0.743357
R20496 avss.n2853 avss.n2012 0.743357
R20497 avss.n2816 avss.n2000 0.743357
R20498 avss.n2000 avss.n1751 0.743357
R20499 avss.n1827 avss.n1826 0.743357
R20500 avss.n1826 avss.n914 0.743357
R20501 avss.n3311 avss.n1755 0.743357
R20502 avss.n3285 avss.n1755 0.743357
R20503 avss.n5351 avss.n5350 0.743357
R20504 avss.n5352 avss.n5351 0.743357
R20505 avss.n4670 avss.n4666 0.743357
R20506 avss.n4672 avss.n4670 0.743357
R20507 avss.n5110 avss.n5109 0.743357
R20508 avss.n5354 avss.n5110 0.743357
R20509 avss.n5416 avss.n5415 0.743357
R20510 avss.n5417 avss.n5416 0.743357
R20511 avss.n5469 avss.n5468 0.743357
R20512 avss.n5468 avss.n5467 0.743357
R20513 avss.n5590 avss.n5589 0.743357
R20514 avss.n5589 avss.n5588 0.743357
R20515 avss.n5576 avss.n5575 0.743357
R20516 avss.n5577 avss.n5576 0.743357
R20517 avss.n4819 avss.n4815 0.743357
R20518 avss.n4867 avss.n4819 0.743357
R20519 avss.n4930 avss.n4929 0.743357
R20520 avss.n4931 avss.n4930 0.743357
R20521 avss.n4989 avss.n4913 0.743357
R20522 avss.n4998 avss.n4913 0.743357
R20523 avss.n4808 avss.n4807 0.743357
R20524 avss.n4809 avss.n4808 0.743357
R20525 avss.n5546 avss.n5545 0.743357
R20526 avss.n5545 avss.n5544 0.743357
R20527 avss.n5546 avss.n4704 0.743357
R20528 avss.n4704 avss.n4701 0.743357
R20529 avss.n5560 avss.n4741 0.743357
R20530 avss.n4741 avss.n4740 0.743357
R20531 avss.n5561 avss.n5560 0.743357
R20532 avss.n5562 avss.n5561 0.743357
R20533 avss.n5030 avss.n4856 0.743357
R20534 avss.n4856 avss.n4834 0.743357
R20535 avss.n5030 avss.n5029 0.743357
R20536 avss.n5029 avss.n4821 0.743357
R20537 avss.n4895 avss.n4869 0.743357
R20538 avss.n4869 avss.n4868 0.743357
R20539 avss.n4895 avss.n4874 0.743357
R20540 avss.n4926 avss.n4874 0.743357
R20541 avss.n5009 avss.n5008 0.743357
R20542 avss.n5010 avss.n5009 0.743357
R20543 avss.n5008 avss.n5007 0.743357
R20544 avss.n5007 avss.n5006 0.743357
R20545 avss.n4997 avss.n4996 0.743357
R20546 avss.n4998 avss.n4997 0.743357
R20547 avss.n6281 avss.n6280 0.743357
R20548 avss.n6280 avss.n6279 0.743357
R20549 avss.n6256 avss.n6252 0.743357
R20550 avss.n6258 avss.n6256 0.743357
R20551 avss.n7057 avss.n7056 0.743357
R20552 avss.n7058 avss.n7057 0.743357
R20553 avss.n6329 avss.n6325 0.743357
R20554 avss.n6331 avss.n6329 0.743357
R20555 avss.n6911 avss.n6910 0.743357
R20556 avss.n6912 avss.n6911 0.743357
R20557 avss.n6352 avss.n6351 0.743357
R20558 avss.n6353 avss.n6352 0.743357
R20559 avss.n5705 avss.n5702 0.743357
R20560 avss.n5702 avss.n5698 0.743357
R20561 avss.n6110 avss.n6109 0.743357
R20562 avss.n6109 avss.n6108 0.743357
R20563 avss.n6099 avss.n6098 0.743357
R20564 avss.n6100 avss.n6099 0.743357
R20565 avss.n5855 avss.n5726 0.743357
R20566 avss.n5855 avss.n5847 0.743357
R20567 avss.n5829 avss.n5828 0.743357
R20568 avss.n6071 avss.n5829 0.743357
R20569 avss.n6090 avss.n6089 0.743357
R20570 avss.n6091 avss.n6090 0.743357
R20571 avss.n1251 avss.n1246 0.743357
R20572 avss.n1272 avss.n1251 0.743357
R20573 avss.n1248 avss.n1245 0.743357
R20574 avss.n1263 avss.n1248 0.743357
R20575 avss.n1220 avss.n1217 0.743357
R20576 avss.n1217 avss.n1205 0.743357
R20577 avss.n6686 avss.n6685 0.743357
R20578 avss.n6685 avss.n6684 0.743357
R20579 avss.n6675 avss.n6674 0.743357
R20580 avss.n6676 avss.n6675 0.743357
R20581 avss.n1594 avss.n1242 0.743357
R20582 avss.n1595 avss.n1594 0.743357
R20583 avss.n8032 avss.n8031 0.743357
R20584 avss.n8033 avss.n8032 0.743357
R20585 avss.n8003 avss.n8001 0.743357
R20586 avss.n8004 avss.n8003 0.743357
R20587 avss.n9403 avss.n9402 0.743357
R20588 avss.n9402 avss.n9401 0.743357
R20589 avss.n9398 avss.n9397 0.743357
R20590 avss.n9399 avss.n9398 0.743357
R20591 avss.n9380 avss.n13 0.743357
R20592 avss.n9390 avss.n13 0.743357
R20593 avss.n9388 avss.n9387 0.743357
R20594 avss.n9389 avss.n9388 0.743357
R20595 avss.n9348 avss.n9347 0.743357
R20596 avss.n9349 avss.n9348 0.743357
R20597 avss.n9252 avss.n9251 0.743357
R20598 avss.n9253 avss.n9252 0.743357
R20599 avss.n9247 avss.n9241 0.743357
R20600 avss.n9247 avss.n89 0.743357
R20601 avss.n74 avss.n72 0.743357
R20602 avss.n9292 avss.n74 0.743357
R20603 avss.n71 avss.n65 0.743357
R20604 avss.n9320 avss.n65 0.743357
R20605 avss.n8379 avss.n130 0.743357
R20606 avss.n8380 avss.n8379 0.743357
R20607 avss.n9216 avss.n127 0.743357
R20608 avss.n127 avss.n116 0.743357
R20609 avss.n6470 avss.n6469 0.7153
R20610 avss.n6244 avss.n4660 0.7153
R20611 avss.n3406 avss.n3345 0.7153
R20612 avss.n4638 avss.n4637 0.7153
R20613 avss.n7253 avss.n563 0.7153
R20614 avss.n3384 avss.n3383 0.7153
R20615 avss.n6612 avss.n6611 0.7061
R20616 avss.n6612 avss.n6529 0.7061
R20617 avss.n6616 avss.n6529 0.7061
R20618 avss.n6617 avss.n6616 0.7061
R20619 avss.n6625 avss.n6525 0.7061
R20620 avss.n6626 avss.n6625 0.7061
R20621 avss.n6626 avss.n6522 0.7061
R20622 avss.n6634 avss.n6522 0.7061
R20623 avss.n6650 avss.n1665 0.7061
R20624 avss.n6650 avss.n6649 0.7061
R20625 avss.n6649 avss.n1668 0.7061
R20626 avss.n6641 avss.n1668 0.7061
R20627 avss.n6613 avss.n6530 0.7061
R20628 avss.n6614 avss.n6613 0.7061
R20629 avss.n6615 avss.n6614 0.7061
R20630 avss.n6615 avss.n6527 0.7061
R20631 avss.n6623 avss.n6622 0.7061
R20632 avss.n6623 avss.n6523 0.7061
R20633 avss.n6631 avss.n6523 0.7061
R20634 avss.n6632 avss.n6631 0.7061
R20635 avss.n6653 avss.n6652 0.7061
R20636 avss.n6652 avss.n1667 0.7061
R20637 avss.n6644 avss.n1667 0.7061
R20638 avss.n6644 avss.n6643 0.7061
R20639 avss.n6628 avss.n6524 0.7061
R20640 avss.n6629 avss.n6628 0.7061
R20641 avss.n6629 avss.n1663 0.7061
R20642 avss.n6655 avss.n1664 0.7061
R20643 avss.n6647 avss.n1664 0.7061
R20644 avss.n6647 avss.n6646 0.7061
R20645 avss.n6646 avss.n1669 0.7061
R20646 avss.n6489 avss.n1683 0.7061
R20647 avss.n6490 avss.n6489 0.7061
R20648 avss.n6490 avss.n1680 0.7061
R20649 avss.n6498 avss.n1680 0.7061
R20650 avss.n6508 avss.n1675 0.7061
R20651 avss.n6509 avss.n6508 0.7061
R20652 avss.n6509 avss.n1671 0.7061
R20653 avss.n6517 avss.n1671 0.7061
R20654 avss.n6487 avss.n6486 0.7061
R20655 avss.n6487 avss.n1681 0.7061
R20656 avss.n6495 avss.n1681 0.7061
R20657 avss.n6496 avss.n6495 0.7061
R20658 avss.n6506 avss.n6505 0.7061
R20659 avss.n6506 avss.n1673 0.7061
R20660 avss.n6514 avss.n1673 0.7061
R20661 avss.n6515 avss.n6514 0.7061
R20662 avss.n6484 avss.n1682 0.7061
R20663 avss.n6492 avss.n1682 0.7061
R20664 avss.n6493 avss.n6492 0.7061
R20665 avss.n6493 avss.n1677 0.7061
R20666 avss.n6503 avss.n1674 0.7061
R20667 avss.n6511 avss.n1674 0.7061
R20668 avss.n6512 avss.n6511 0.7061
R20669 avss.n6512 avss.n1672 0.7061
R20670 avss.n4995 avss.n4990 0.622674
R20671 avss.n7459 avss.n399 0.622674
R20672 avss.n6857 avss.n6852 0.622674
R20673 avss.n2332 avss.n2327 0.622674
R20674 avss.n3161 avss.n3160 0.622674
R20675 avss.n7077 avss.n828 0.622674
R20676 avss.n4333 avss.n3885 0.622674
R20677 avss.n4444 avss.n3742 0.622674
R20678 avss.n6606 avss.n6532 0.6143
R20679 avss.n1374 avss.n1200 0.610371
R20680 avss.n6860 avss.n378 0.598119
R20681 avss.n6477 avss.n1687 0.5873
R20682 avss.n6635 avss.n6634 0.5585
R20683 avss.n6632 avss.n1666 0.5585
R20684 avss.n6656 avss.n1663 0.5585
R20685 avss.n6499 avss.n6498 0.5585
R20686 avss.n6496 avss.n1676 0.5585
R20687 avss.n6502 avss.n1677 0.5585
R20688 avss.n9386 avss.n9385 0.5549
R20689 avss.n9404 avss.n3 0.5549
R20690 avss.n8030 avss.n8015 0.5549
R20691 avss.n5781 avss.n5780 0.554
R20692 avss.n5790 avss.n5745 0.554
R20693 avss.n5763 avss.n5737 0.554
R20694 avss.n5765 avss.n5739 0.554
R20695 avss.t56 avss.t83 0.50147
R20696 avss.t69 avss.t209 0.50147
R20697 avss.t76 avss.t13 0.50147
R20698 avss.t36 avss.t201 0.50147
R20699 avss.t92 avss.t109 0.50147
R20700 avss.t196 avss.t4 0.50147
R20701 avss.t46 avss.t65 0.50147
R20702 avss.t43 avss.t79 0.50147
R20703 avss.n6672 avss.n6671 0.5009
R20704 avss.n6671 avss.n6670 0.5009
R20705 avss.n6096 avss.n5818 0.5009
R20706 avss.n6096 avss.n6095 0.5009
R20707 avss.n9214 avss.n70 0.5009
R20708 avss.n9316 avss.n70 0.5009
R20709 avss.n9135 avss.n145 0.5009
R20710 avss.n9197 avss.n145 0.5009
R20711 avss.n8609 avss.n8608 0.5009
R20712 avss.n8609 avss.n7866 0.5009
R20713 avss.n8736 avss.n8732 0.5009
R20714 avss.n8736 avss.n8735 0.5009
R20715 avss.n143 avss.n142 0.5005
R20716 avss.n6639 avss.n6638 0.5005
R20717 avss.n6618 avss.n6617 0.4865
R20718 avss.n6621 avss.n6527 0.4865
R20719 avss.n4813 avss.t57 0.484646
R20720 avss.n6396 avss.t70 0.484646
R20721 avss.n3321 avss.t77 0.484646
R20722 avss.n2111 avss.t37 0.484646
R20723 avss.n704 avss.t93 0.484646
R20724 avss.n7248 avss.t197 0.484646
R20725 avss.n4619 avss.t47 0.484646
R20726 avss.n7262 avss.t44 0.484646
R20727 avss.n4649 avss.n4648 0.4829
R20728 avss.n8713 avss.n8712 0.473227
R20729 avss.n8712 avss.n8711 0.473227
R20730 avss.n8589 avss.n8588 0.473227
R20731 avss.n8588 avss.n8587 0.473227
R20732 avss.n369 avss.n368 0.473227
R20733 avss.n8900 avss.n369 0.473227
R20734 avss.n9133 avss.n9132 0.473227
R20735 avss.n9132 avss.n9131 0.473227
R20736 avss.n8182 avss.n7487 0.473227
R20737 avss.n8898 avss.n7487 0.473227
R20738 avss.n8421 avss.n7485 0.473227
R20739 avss.n8898 avss.n7485 0.473227
R20740 avss.n8897 avss.n8896 0.473227
R20741 avss.n8898 avss.n8897 0.473227
R20742 avss.n6206 avss.n6205 0.473227
R20743 avss.n6207 avss.n6206 0.473227
R20744 avss.n6093 avss.n6092 0.473227
R20745 avss.n6092 avss.n6091 0.473227
R20746 avss.n1385 avss.n1384 0.473227
R20747 avss.n1384 avss.n1383 0.473227
R20748 avss.n1597 avss.n1596 0.473227
R20749 avss.n1596 avss.n1595 0.473227
R20750 avss.n9319 avss.n9318 0.473227
R20751 avss.n9320 avss.n9319 0.473227
R20752 avss.n6664 avss.n6663 0.4657
R20753 avss.n5788 avss.n5787 0.4657
R20754 avss.n5777 avss.n5775 0.4657
R20755 avss.n6458 avss.n6457 0.4657
R20756 avss.n3333 avss.n1704 0.4657
R20757 avss.n6442 avss.n1708 0.4657
R20758 avss.n6435 avss.n1715 0.4657
R20759 avss.n6430 avss.n1720 0.4657
R20760 avss.n6425 avss.n6423 0.4657
R20761 avss.n6558 avss.n6543 0.465174
R20762 avss.n6579 avss.n6578 0.465174
R20763 avss.n4996 avss.n4995 0.454413
R20764 avss.n4990 avss.n4989 0.454413
R20765 avss.n4989 avss.n4814 0.454413
R20766 avss.n5066 avss.n4815 0.454413
R20767 avss.n5590 avss.n4699 0.454413
R20768 avss.n5415 avss.n5414 0.454413
R20769 avss.n7266 avss.n550 0.454413
R20770 avss.n7467 avss.n399 0.454413
R20771 avss.n7459 avss.n7458 0.454413
R20772 avss.n7458 avss.n7457 0.454413
R20773 avss.n7328 avss.n7327 0.454413
R20774 avss.n7019 avss.n972 0.454413
R20775 avss.n6858 avss.n6857 0.454413
R20776 avss.n6852 avss.n6851 0.454413
R20777 avss.n6851 avss.n6850 0.454413
R20778 avss.n6768 avss.n6767 0.454413
R20779 avss.n6394 avss.n6325 0.454413
R20780 avss.n2681 avss.n2261 0.454413
R20781 avss.n2333 avss.n2332 0.454413
R20782 avss.n2327 avss.n2326 0.454413
R20783 avss.n2326 avss.n2260 0.454413
R20784 avss.n2743 avss.n2742 0.454413
R20785 avss.n3319 avss.n1743 0.454413
R20786 avss.n3201 avss.n3200 0.454413
R20787 avss.n3160 avss.n3012 0.454413
R20788 avss.n3161 avss.n3003 0.454413
R20789 avss.n3169 avss.n3003 0.454413
R20790 avss.n3001 avss.n2114 0.454413
R20791 avss.n3287 avss.n1993 0.454413
R20792 avss.n4616 avss.n3409 0.454413
R20793 avss.n3822 avss.n3821 0.454413
R20794 avss.n7225 avss.n596 0.454413
R20795 avss.n7136 avss.n708 0.454413
R20796 avss.n7076 avss.n707 0.454413
R20797 avss.n7077 avss.n7076 0.454413
R20798 avss.n7072 avss.n828 0.454413
R20799 avss.n7139 avss.n702 0.454413
R20800 avss.n7246 avss.n567 0.454413
R20801 avss.n4367 avss.n3843 0.454413
R20802 avss.n4332 avss.n3886 0.454413
R20803 avss.n4333 avss.n4332 0.454413
R20804 avss.n4316 avss.n3885 0.454413
R20805 avss.n4173 avss.n4170 0.454413
R20806 avss.n4443 avss.n3743 0.454413
R20807 avss.n4444 avss.n4443 0.454413
R20808 avss.n4427 avss.n3742 0.454413
R20809 avss.n7238 avss.n7237 0.454413
R20810 avss.n3311 avss.n3310 0.454413
R20811 avss.n6667 avss.n6666 0.437
R20812 avss.n5815 avss.n5814 0.437
R20813 avss.n6315 avss.n6251 0.3821
R20814 avss.n6240 avss.n4665 0.3821
R20815 avss.n6578 avss.n6577 0.371929
R20816 avss.n6577 avss.n6576 0.371929
R20817 avss.n6538 avss.n6534 0.371929
R20818 avss.n6561 avss.n6538 0.371929
R20819 avss.n6559 avss.n6558 0.371929
R20820 avss.n6560 avss.n6559 0.371929
R20821 avss.n6549 avss.n6545 0.371929
R20822 avss.n6546 avss.n6545 0.371929
R20823 avss.n9211 avss.n9210 0.347
R20824 avss.n3355 avss.n133 0.347
R20825 avss.n9201 avss.n141 0.347
R20826 avss.n6093 avss.n5821 0.29887
R20827 avss.n1598 avss.n1597 0.29887
R20828 avss.n9318 avss.n68 0.29887
R20829 avss.n9133 avss.n221 0.29887
R20830 avss.n8590 avss.n8589 0.29887
R20831 avss.n8714 avss.n8713 0.29887
R20832 avss.n6314 avss.n6252 0.279304
R20833 avss.n6239 avss.n4666 0.279304
R20834 avss.n6316 avss.n1694 0.2498
R20835 avss.n6241 avss.n1690 0.2498
R20836 avss.n1579 avss.n1244 0.2255
R20837 avss.n6094 avss.n5820 0.2255
R20838 avss.n9317 avss.n69 0.2255
R20839 avss.n9134 avss.n219 0.2255
R20840 avss.n8584 avss.n7888 0.2255
R20841 avss.n8708 avss.n7798 0.2255
R20842 avss.n6618 avss.n6525 0.2201
R20843 avss.n6622 avss.n6621 0.2201
R20844 avss.n6480 avss.n1683 0.2201
R20845 avss.n6486 avss.n1684 0.2201
R20846 avss.n6484 avss.n6483 0.2201
R20847 avss.n6669 avss 0.193383
R20848 avss.n5817 avss 0.193383
R20849 avss.n9198 avss 0.193383
R20850 avss.n7865 avss 0.193383
R20851 avss.n8734 avss 0.193383
R20852 avss.n9213 avss 0.193383
R20853 avss.n6669 avss.n6668 0.172342
R20854 avss.n5817 avss.n5816 0.172342
R20855 avss.n9199 avss.n9198 0.172342
R20856 avss.n7865 avss.n7864 0.172342
R20857 avss.n8734 avss.n8733 0.172342
R20858 avss.n9213 avss.n9212 0.172342
R20859 avss.n7261 avss.n7260 0.1598
R20860 avss.n7254 avss.n561 0.1598
R20861 avss.n6635 avss.n1665 0.1481
R20862 avss.n6653 avss.n1666 0.1481
R20863 avss.n6656 avss.n6655 0.1481
R20864 avss.n6499 avss.n1675 0.1481
R20865 avss.n6505 avss.n1676 0.1481
R20866 avss.n6503 avss.n6502 0.1481
R20867 avss.n6203 avss.n6202 0.1445
R20868 avss.n6202 avss.n6201 0.1445
R20869 avss.n6201 avss.n5603 0.1445
R20870 avss.n5912 avss.n5603 0.1445
R20871 avss.n5915 avss.n5912 0.1445
R20872 avss.n5915 avss.n5908 0.1445
R20873 avss.n5919 avss.n5908 0.1445
R20874 avss.n5922 avss.n5919 0.1445
R20875 avss.n5925 avss.n5922 0.1445
R20876 avss.n5925 avss.n5906 0.1445
R20877 avss.n5929 avss.n5906 0.1445
R20878 avss.n5932 avss.n5929 0.1445
R20879 avss.n5935 avss.n5932 0.1445
R20880 avss.n5935 avss.n5904 0.1445
R20881 avss.n5939 avss.n5904 0.1445
R20882 avss.n5942 avss.n5939 0.1445
R20883 avss.n5945 avss.n5942 0.1445
R20884 avss.n5945 avss.n5902 0.1445
R20885 avss.n5949 avss.n5902 0.1445
R20886 avss.n5952 avss.n5949 0.1445
R20887 avss.n5955 avss.n5952 0.1445
R20888 avss.n5955 avss.n5900 0.1445
R20889 avss.n5959 avss.n5900 0.1445
R20890 avss.n5962 avss.n5959 0.1445
R20891 avss.n5965 avss.n5962 0.1445
R20892 avss.n5965 avss.n5898 0.1445
R20893 avss.n5969 avss.n5898 0.1445
R20894 avss.n5972 avss.n5969 0.1445
R20895 avss.n5975 avss.n5972 0.1445
R20896 avss.n5975 avss.n5896 0.1445
R20897 avss.n5979 avss.n5896 0.1445
R20898 avss.n5982 avss.n5979 0.1445
R20899 avss.n5985 avss.n5982 0.1445
R20900 avss.n5985 avss.n5894 0.1445
R20901 avss.n5989 avss.n5894 0.1445
R20902 avss.n5992 avss.n5989 0.1445
R20903 avss.n5994 avss.n5992 0.1445
R20904 avss.n5994 avss.n5892 0.1445
R20905 avss.n5999 avss.n5892 0.1445
R20906 avss.n5999 avss.n5872 0.1445
R20907 avss.n6005 avss.n5872 0.1445
R20908 avss.n6006 avss.n6005 0.1445
R20909 avss.n6006 avss.n5870 0.1445
R20910 avss.n6010 avss.n5870 0.1445
R20911 avss.n6012 avss.n6010 0.1445
R20912 avss.n6013 avss.n6012 0.1445
R20913 avss.n6013 avss.n5868 0.1445
R20914 avss.n6017 avss.n5868 0.1445
R20915 avss.n6027 avss.n6017 0.1445
R20916 avss.n6028 avss.n6027 0.1445
R20917 avss.n6028 avss.n5866 0.1445
R20918 avss.n6032 avss.n5866 0.1445
R20919 avss.n6033 avss.n6032 0.1445
R20920 avss.n6043 avss.n6033 0.1445
R20921 avss.n6043 avss.n5863 0.1445
R20922 avss.n6047 avss.n5863 0.1445
R20923 avss.n6047 avss.n5845 0.1445
R20924 avss.n6060 avss.n5845 0.1445
R20925 avss.n6060 avss.n5843 0.1445
R20926 avss.n6069 avss.n5843 0.1445
R20927 avss.n6069 avss.n6068 0.1445
R20928 avss.n6068 avss.n6067 0.1445
R20929 avss.n6067 avss.n6066 0.1445
R20930 avss.n6551 avss.n6547 0.1445
R20931 avss.n6556 avss.n6555 0.1445
R20932 avss.n6557 avss.n6544 0.1445
R20933 avss.n6550 avss.n6548 0.1445
R20934 avss.n6582 avss.n6575 0.1445
R20935 avss.n6582 avss.n6565 0.1445
R20936 avss.n6594 avss.n6565 0.1445
R20937 avss.n6594 avss.n6563 0.1445
R20938 avss.n6598 avss.n6563 0.1445
R20939 avss.n6586 avss.n6570 0.1445
R20940 avss.n6586 avss.n6568 0.1445
R20941 avss.n6590 avss.n6568 0.1445
R20942 avss.n6590 avss.n6536 0.1445
R20943 avss.n6602 avss.n6536 0.1445
R20944 avss.n6587 avss.n6569 0.1445
R20945 avss.n6588 avss.n6587 0.1445
R20946 avss.n6589 avss.n6588 0.1445
R20947 avss.n6589 avss.n6535 0.1445
R20948 avss.n6603 avss.n6535 0.1445
R20949 avss.n6581 avss.n6580 0.1445
R20950 avss.n6581 avss.n6564 0.1445
R20951 avss.n6595 avss.n6564 0.1445
R20952 avss.n6596 avss.n6595 0.1445
R20953 avss.n6597 avss.n6596 0.1445
R20954 avss.n1388 avss.n1382 0.1445
R20955 avss.n1388 avss.n1371 0.1445
R20956 avss.n1400 avss.n1371 0.1445
R20957 avss.n1400 avss.n1369 0.1445
R20958 avss.n1404 avss.n1369 0.1445
R20959 avss.n1404 avss.n1360 0.1445
R20960 avss.n1416 avss.n1360 0.1445
R20961 avss.n1416 avss.n1358 0.1445
R20962 avss.n1420 avss.n1358 0.1445
R20963 avss.n1420 avss.n1348 0.1445
R20964 avss.n1432 avss.n1348 0.1445
R20965 avss.n1432 avss.n1346 0.1445
R20966 avss.n1436 avss.n1346 0.1445
R20967 avss.n1436 avss.n1336 0.1445
R20968 avss.n1448 avss.n1336 0.1445
R20969 avss.n1448 avss.n1334 0.1445
R20970 avss.n1452 avss.n1334 0.1445
R20971 avss.n1452 avss.n1324 0.1445
R20972 avss.n1464 avss.n1324 0.1445
R20973 avss.n1464 avss.n1322 0.1445
R20974 avss.n1471 avss.n1322 0.1445
R20975 avss.n1471 avss.n1470 0.1445
R20976 avss.n1470 avss.n1312 0.1445
R20977 avss.n1485 avss.n1312 0.1445
R20978 avss.n1486 avss.n1485 0.1445
R20979 avss.n1486 avss.n1310 0.1445
R20980 avss.n1490 avss.n1310 0.1445
R20981 avss.n1491 avss.n1490 0.1445
R20982 avss.n1492 avss.n1491 0.1445
R20983 avss.n1492 avss.n1307 0.1445
R20984 avss.n1496 avss.n1307 0.1445
R20985 avss.n1497 avss.n1496 0.1445
R20986 avss.n1505 avss.n1497 0.1445
R20987 avss.n1505 avss.n1304 0.1445
R20988 avss.n1509 avss.n1304 0.1445
R20989 avss.n1509 avss.n1294 0.1445
R20990 avss.n1521 avss.n1294 0.1445
R20991 avss.n1521 avss.n1292 0.1445
R20992 avss.n1525 avss.n1292 0.1445
R20993 avss.n1525 avss.n1282 0.1445
R20994 avss.n1537 avss.n1282 0.1445
R20995 avss.n1537 avss.n1280 0.1445
R20996 avss.n1544 avss.n1280 0.1445
R20997 avss.n1544 avss.n1543 0.1445
R20998 avss.n1543 avss.n1268 0.1445
R20999 avss.n1558 avss.n1268 0.1445
R21000 avss.n1559 avss.n1558 0.1445
R21001 avss.n1561 avss.n1559 0.1445
R21002 avss.n1561 avss.n1266 0.1445
R21003 avss.n1629 avss.n1266 0.1445
R21004 avss.n1629 avss.n1628 0.1445
R21005 avss.n1628 avss.n1627 0.1445
R21006 avss.n1627 avss.n1626 0.1445
R21007 avss.n1626 avss.n1624 0.1445
R21008 avss.n1624 avss.n1623 0.1445
R21009 avss.n1623 avss.n1570 0.1445
R21010 avss.n1611 avss.n1570 0.1445
R21011 avss.n1611 avss.n1610 0.1445
R21012 avss.n1610 avss.n1609 0.1445
R21013 avss.n1609 avss.n1607 0.1445
R21014 avss.n1607 avss.n1606 0.1445
R21015 avss.n1606 avss.n1577 0.1445
R21016 avss.n1580 avss.n1577 0.1445
R21017 avss.n1392 avss.n1378 0.1445
R21018 avss.n1392 avss.n1376 0.1445
R21019 avss.n1396 avss.n1376 0.1445
R21020 avss.n1396 avss.n1366 0.1445
R21021 avss.n1408 avss.n1366 0.1445
R21022 avss.n1408 avss.n1364 0.1445
R21023 avss.n1412 avss.n1364 0.1445
R21024 avss.n1412 avss.n1354 0.1445
R21025 avss.n1424 avss.n1354 0.1445
R21026 avss.n1424 avss.n1352 0.1445
R21027 avss.n1428 avss.n1352 0.1445
R21028 avss.n1428 avss.n1342 0.1445
R21029 avss.n1440 avss.n1342 0.1445
R21030 avss.n1440 avss.n1340 0.1445
R21031 avss.n1444 avss.n1340 0.1445
R21032 avss.n1444 avss.n1330 0.1445
R21033 avss.n1456 avss.n1330 0.1445
R21034 avss.n1456 avss.n1328 0.1445
R21035 avss.n1460 avss.n1328 0.1445
R21036 avss.n1460 avss.n1318 0.1445
R21037 avss.n1475 avss.n1318 0.1445
R21038 avss.n1475 avss.n1316 0.1445
R21039 avss.n1480 avss.n1316 0.1445
R21040 avss.n1480 avss.n1182 0.1445
R21041 avss.n6714 avss.n1182 0.1445
R21042 avss.n6714 avss.n6713 0.1445
R21043 avss.n6713 avss.n6712 0.1445
R21044 avss.n6712 avss.n1186 0.1445
R21045 avss.n6706 avss.n1186 0.1445
R21046 avss.n6706 avss.n6705 0.1445
R21047 avss.n6705 avss.n6704 0.1445
R21048 avss.n6704 avss.n1197 0.1445
R21049 avss.n1501 avss.n1197 0.1445
R21050 avss.n1501 avss.n1300 0.1445
R21051 avss.n1513 avss.n1300 0.1445
R21052 avss.n1513 avss.n1298 0.1445
R21053 avss.n1517 avss.n1298 0.1445
R21054 avss.n1517 avss.n1288 0.1445
R21055 avss.n1529 avss.n1288 0.1445
R21056 avss.n1529 avss.n1286 0.1445
R21057 avss.n1533 avss.n1286 0.1445
R21058 avss.n1533 avss.n1276 0.1445
R21059 avss.n1548 avss.n1276 0.1445
R21060 avss.n1548 avss.n1274 0.1445
R21061 avss.n1553 avss.n1274 0.1445
R21062 avss.n1553 avss.n1256 0.1445
R21063 avss.n1637 avss.n1256 0.1445
R21064 avss.n1637 avss.n1636 0.1445
R21065 avss.n1636 avss.n1635 0.1445
R21066 avss.n1635 avss.n1262 0.1445
R21067 avss.n1262 avss.n1208 0.1445
R21068 avss.n6697 avss.n1208 0.1445
R21069 avss.n6697 avss.n6696 0.1445
R21070 avss.n6696 avss.n6695 0.1445
R21071 avss.n6695 avss.n1212 0.1445
R21072 avss.n1617 avss.n1212 0.1445
R21073 avss.n1617 avss.n1230 0.1445
R21074 avss.n6681 avss.n1230 0.1445
R21075 avss.n6681 avss.n6680 0.1445
R21076 avss.n6680 avss.n6679 0.1445
R21077 avss.n6679 avss.n1234 0.1445
R21078 avss.n1601 avss.n1234 0.1445
R21079 avss.n1601 avss.n1600 0.1445
R21080 avss.n1393 avss.n1377 0.1445
R21081 avss.n1394 avss.n1393 0.1445
R21082 avss.n1395 avss.n1394 0.1445
R21083 avss.n1395 avss.n1365 0.1445
R21084 avss.n1409 avss.n1365 0.1445
R21085 avss.n1410 avss.n1409 0.1445
R21086 avss.n1411 avss.n1410 0.1445
R21087 avss.n1411 avss.n1353 0.1445
R21088 avss.n1425 avss.n1353 0.1445
R21089 avss.n1426 avss.n1425 0.1445
R21090 avss.n1427 avss.n1426 0.1445
R21091 avss.n1427 avss.n1341 0.1445
R21092 avss.n1441 avss.n1341 0.1445
R21093 avss.n1442 avss.n1441 0.1445
R21094 avss.n1443 avss.n1442 0.1445
R21095 avss.n1443 avss.n1329 0.1445
R21096 avss.n1457 avss.n1329 0.1445
R21097 avss.n1458 avss.n1457 0.1445
R21098 avss.n1459 avss.n1458 0.1445
R21099 avss.n1459 avss.n1317 0.1445
R21100 avss.n1476 avss.n1317 0.1445
R21101 avss.n1477 avss.n1476 0.1445
R21102 avss.n1479 avss.n1477 0.1445
R21103 avss.n1479 avss.n1478 0.1445
R21104 avss.n1478 avss.n1183 0.1445
R21105 avss.n1184 avss.n1183 0.1445
R21106 avss.n1185 avss.n1184 0.1445
R21107 avss.n1193 avss.n1185 0.1445
R21108 avss.n1194 avss.n1193 0.1445
R21109 avss.n1195 avss.n1194 0.1445
R21110 avss.n1196 avss.n1195 0.1445
R21111 avss.n1499 avss.n1196 0.1445
R21112 avss.n1500 avss.n1499 0.1445
R21113 avss.n1500 avss.n1299 0.1445
R21114 avss.n1514 avss.n1299 0.1445
R21115 avss.n1515 avss.n1514 0.1445
R21116 avss.n1516 avss.n1515 0.1445
R21117 avss.n1516 avss.n1287 0.1445
R21118 avss.n1530 avss.n1287 0.1445
R21119 avss.n1531 avss.n1530 0.1445
R21120 avss.n1532 avss.n1531 0.1445
R21121 avss.n1532 avss.n1275 0.1445
R21122 avss.n1549 avss.n1275 0.1445
R21123 avss.n1550 avss.n1549 0.1445
R21124 avss.n1552 avss.n1550 0.1445
R21125 avss.n1552 avss.n1551 0.1445
R21126 avss.n1551 avss.n1257 0.1445
R21127 avss.n1258 avss.n1257 0.1445
R21128 avss.n1259 avss.n1258 0.1445
R21129 avss.n1261 avss.n1259 0.1445
R21130 avss.n1261 avss.n1260 0.1445
R21131 avss.n1260 avss.n1209 0.1445
R21132 avss.n1210 avss.n1209 0.1445
R21133 avss.n1211 avss.n1210 0.1445
R21134 avss.n1614 avss.n1211 0.1445
R21135 avss.n1616 avss.n1614 0.1445
R21136 avss.n1616 avss.n1615 0.1445
R21137 avss.n1615 avss.n1231 0.1445
R21138 avss.n1232 avss.n1231 0.1445
R21139 avss.n1233 avss.n1232 0.1445
R21140 avss.n1584 avss.n1233 0.1445
R21141 avss.n1585 avss.n1584 0.1445
R21142 avss.n1599 avss.n1585 0.1445
R21143 avss.n1387 avss.n1386 0.1445
R21144 avss.n1387 avss.n1370 0.1445
R21145 avss.n1401 avss.n1370 0.1445
R21146 avss.n1402 avss.n1401 0.1445
R21147 avss.n1403 avss.n1402 0.1445
R21148 avss.n1403 avss.n1359 0.1445
R21149 avss.n1417 avss.n1359 0.1445
R21150 avss.n1418 avss.n1417 0.1445
R21151 avss.n1419 avss.n1418 0.1445
R21152 avss.n1419 avss.n1347 0.1445
R21153 avss.n1433 avss.n1347 0.1445
R21154 avss.n1434 avss.n1433 0.1445
R21155 avss.n1435 avss.n1434 0.1445
R21156 avss.n1435 avss.n1335 0.1445
R21157 avss.n1449 avss.n1335 0.1445
R21158 avss.n1450 avss.n1449 0.1445
R21159 avss.n1451 avss.n1450 0.1445
R21160 avss.n1451 avss.n1323 0.1445
R21161 avss.n1465 avss.n1323 0.1445
R21162 avss.n1466 avss.n1465 0.1445
R21163 avss.n1467 avss.n1466 0.1445
R21164 avss.n1469 avss.n1467 0.1445
R21165 avss.n1469 avss.n1468 0.1445
R21166 avss.n1468 avss.n1311 0.1445
R21167 avss.n1487 avss.n1311 0.1445
R21168 avss.n1488 avss.n1487 0.1445
R21169 avss.n1489 avss.n1488 0.1445
R21170 avss.n1489 avss.n1308 0.1445
R21171 avss.n1493 avss.n1308 0.1445
R21172 avss.n1494 avss.n1493 0.1445
R21173 avss.n1495 avss.n1494 0.1445
R21174 avss.n1495 avss.n1305 0.1445
R21175 avss.n1506 avss.n1305 0.1445
R21176 avss.n1507 avss.n1506 0.1445
R21177 avss.n1508 avss.n1507 0.1445
R21178 avss.n1508 avss.n1293 0.1445
R21179 avss.n1522 avss.n1293 0.1445
R21180 avss.n1523 avss.n1522 0.1445
R21181 avss.n1524 avss.n1523 0.1445
R21182 avss.n1524 avss.n1281 0.1445
R21183 avss.n1538 avss.n1281 0.1445
R21184 avss.n1539 avss.n1538 0.1445
R21185 avss.n1540 avss.n1539 0.1445
R21186 avss.n1542 avss.n1540 0.1445
R21187 avss.n1542 avss.n1541 0.1445
R21188 avss.n1541 avss.n1269 0.1445
R21189 avss.n1269 avss.n1267 0.1445
R21190 avss.n1562 avss.n1267 0.1445
R21191 avss.n1563 avss.n1562 0.1445
R21192 avss.n1564 avss.n1563 0.1445
R21193 avss.n1565 avss.n1564 0.1445
R21194 avss.n1566 avss.n1565 0.1445
R21195 avss.n1567 avss.n1566 0.1445
R21196 avss.n1568 avss.n1567 0.1445
R21197 avss.n1569 avss.n1568 0.1445
R21198 avss.n1571 avss.n1569 0.1445
R21199 avss.n1572 avss.n1571 0.1445
R21200 avss.n1573 avss.n1572 0.1445
R21201 avss.n1574 avss.n1573 0.1445
R21202 avss.n1575 avss.n1574 0.1445
R21203 avss.n1576 avss.n1575 0.1445
R21204 avss.n1578 avss.n1576 0.1445
R21205 avss.n1579 avss.n1578 0.1445
R21206 avss.n1590 avss.n1587 0.1445
R21207 avss.n1589 avss.n1241 0.1445
R21208 avss.n6690 avss.n6689 0.1445
R21209 avss.n6688 avss.n1219 0.1445
R21210 avss.n1646 avss.n1642 0.1445
R21211 avss.n1645 avss.n1643 0.1445
R21212 avss.n6114 avss.n6113 0.1445
R21213 avss.n6112 avss.n5704 0.1445
R21214 avss.n5859 avss.n5856 0.1445
R21215 avss.n5858 avss.n5725 0.1445
R21216 avss.n6086 avss.n6085 0.1445
R21217 avss.n6087 avss.n5827 0.1445
R21218 avss.n6204 avss.n5600 0.1445
R21219 avss.n5602 avss.n5600 0.1445
R21220 avss.n5909 avss.n5602 0.1445
R21221 avss.n5910 avss.n5909 0.1445
R21222 avss.n5916 avss.n5910 0.1445
R21223 avss.n5917 avss.n5916 0.1445
R21224 avss.n5918 avss.n5917 0.1445
R21225 avss.n5918 avss.n5907 0.1445
R21226 avss.n5926 avss.n5907 0.1445
R21227 avss.n5927 avss.n5926 0.1445
R21228 avss.n5928 avss.n5927 0.1445
R21229 avss.n5928 avss.n5905 0.1445
R21230 avss.n5936 avss.n5905 0.1445
R21231 avss.n5937 avss.n5936 0.1445
R21232 avss.n5938 avss.n5937 0.1445
R21233 avss.n5938 avss.n5903 0.1445
R21234 avss.n5946 avss.n5903 0.1445
R21235 avss.n5947 avss.n5946 0.1445
R21236 avss.n5948 avss.n5947 0.1445
R21237 avss.n5948 avss.n5901 0.1445
R21238 avss.n5956 avss.n5901 0.1445
R21239 avss.n5957 avss.n5956 0.1445
R21240 avss.n5958 avss.n5957 0.1445
R21241 avss.n5958 avss.n5899 0.1445
R21242 avss.n5966 avss.n5899 0.1445
R21243 avss.n5967 avss.n5966 0.1445
R21244 avss.n5968 avss.n5967 0.1445
R21245 avss.n5968 avss.n5897 0.1445
R21246 avss.n5976 avss.n5897 0.1445
R21247 avss.n5977 avss.n5976 0.1445
R21248 avss.n5978 avss.n5977 0.1445
R21249 avss.n5978 avss.n5895 0.1445
R21250 avss.n5986 avss.n5895 0.1445
R21251 avss.n5987 avss.n5986 0.1445
R21252 avss.n5988 avss.n5987 0.1445
R21253 avss.n5988 avss.n5893 0.1445
R21254 avss.n5995 avss.n5893 0.1445
R21255 avss.n5996 avss.n5995 0.1445
R21256 avss.n5998 avss.n5996 0.1445
R21257 avss.n5998 avss.n5997 0.1445
R21258 avss.n5997 avss.n5871 0.1445
R21259 avss.n6007 avss.n5871 0.1445
R21260 avss.n6008 avss.n6007 0.1445
R21261 avss.n6009 avss.n6008 0.1445
R21262 avss.n6009 avss.n5869 0.1445
R21263 avss.n6014 avss.n5869 0.1445
R21264 avss.n6015 avss.n6014 0.1445
R21265 avss.n6016 avss.n6015 0.1445
R21266 avss.n6016 avss.n5867 0.1445
R21267 avss.n6029 avss.n5867 0.1445
R21268 avss.n6030 avss.n6029 0.1445
R21269 avss.n6031 avss.n6030 0.1445
R21270 avss.n6031 avss.n5864 0.1445
R21271 avss.n6044 avss.n5864 0.1445
R21272 avss.n6045 avss.n6044 0.1445
R21273 avss.n6046 avss.n6045 0.1445
R21274 avss.n6046 avss.n5844 0.1445
R21275 avss.n6061 avss.n5844 0.1445
R21276 avss.n6062 avss.n6061 0.1445
R21277 avss.n6063 avss.n6062 0.1445
R21278 avss.n6064 avss.n6063 0.1445
R21279 avss.n6065 avss.n6064 0.1445
R21280 avss.n6065 avss.n5820 0.1445
R21281 avss.n5611 avss.n5599 0.1445
R21282 avss.n5612 avss.n5611 0.1445
R21283 avss.n5613 avss.n5612 0.1445
R21284 avss.n5614 avss.n5613 0.1445
R21285 avss.n5619 avss.n5614 0.1445
R21286 avss.n5620 avss.n5619 0.1445
R21287 avss.n5621 avss.n5620 0.1445
R21288 avss.n5622 avss.n5621 0.1445
R21289 avss.n5623 avss.n5622 0.1445
R21290 avss.n5627 avss.n5623 0.1445
R21291 avss.n5628 avss.n5627 0.1445
R21292 avss.n5629 avss.n5628 0.1445
R21293 avss.n5630 avss.n5629 0.1445
R21294 avss.n5634 avss.n5630 0.1445
R21295 avss.n5635 avss.n5634 0.1445
R21296 avss.n5636 avss.n5635 0.1445
R21297 avss.n5637 avss.n5636 0.1445
R21298 avss.n5641 avss.n5637 0.1445
R21299 avss.n5642 avss.n5641 0.1445
R21300 avss.n5643 avss.n5642 0.1445
R21301 avss.n5644 avss.n5643 0.1445
R21302 avss.n5648 avss.n5644 0.1445
R21303 avss.n5649 avss.n5648 0.1445
R21304 avss.n5650 avss.n5649 0.1445
R21305 avss.n5651 avss.n5650 0.1445
R21306 avss.n5655 avss.n5651 0.1445
R21307 avss.n5656 avss.n5655 0.1445
R21308 avss.n5657 avss.n5656 0.1445
R21309 avss.n5658 avss.n5657 0.1445
R21310 avss.n5662 avss.n5658 0.1445
R21311 avss.n5663 avss.n5662 0.1445
R21312 avss.n5664 avss.n5663 0.1445
R21313 avss.n5665 avss.n5664 0.1445
R21314 avss.n5669 avss.n5665 0.1445
R21315 avss.n5670 avss.n5669 0.1445
R21316 avss.n5671 avss.n5670 0.1445
R21317 avss.n5672 avss.n5671 0.1445
R21318 avss.n5676 avss.n5672 0.1445
R21319 avss.n5677 avss.n5676 0.1445
R21320 avss.n5678 avss.n5677 0.1445
R21321 avss.n5679 avss.n5678 0.1445
R21322 avss.n5691 avss.n5679 0.1445
R21323 avss.n5692 avss.n5691 0.1445
R21324 avss.n5693 avss.n5692 0.1445
R21325 avss.n5694 avss.n5693 0.1445
R21326 avss.n5695 avss.n5694 0.1445
R21327 avss.n6019 avss.n5695 0.1445
R21328 avss.n6021 avss.n6019 0.1445
R21329 avss.n6021 avss.n6020 0.1445
R21330 avss.n6020 avss.n5715 0.1445
R21331 avss.n5716 avss.n5715 0.1445
R21332 avss.n5717 avss.n5716 0.1445
R21333 avss.n6037 avss.n5717 0.1445
R21334 avss.n6038 avss.n6037 0.1445
R21335 avss.n6038 avss.n5851 0.1445
R21336 avss.n6053 avss.n5851 0.1445
R21337 avss.n6054 avss.n6053 0.1445
R21338 avss.n6055 avss.n6054 0.1445
R21339 avss.n6055 avss.n5837 0.1445
R21340 avss.n6075 avss.n5837 0.1445
R21341 avss.n6076 avss.n6075 0.1445
R21342 avss.n6077 avss.n6076 0.1445
R21343 avss.n6078 avss.n6077 0.1445
R21344 avss.n5610 avss.n5609 0.1445
R21345 avss.n6197 avss.n5610 0.1445
R21346 avss.n6197 avss.n6196 0.1445
R21347 avss.n6196 avss.n6195 0.1445
R21348 avss.n6195 avss.n5615 0.1445
R21349 avss.n5617 avss.n5615 0.1445
R21350 avss.n6188 avss.n5617 0.1445
R21351 avss.n6188 avss.n6187 0.1445
R21352 avss.n6187 avss.n6186 0.1445
R21353 avss.n6186 avss.n5624 0.1445
R21354 avss.n6181 avss.n5624 0.1445
R21355 avss.n6181 avss.n6180 0.1445
R21356 avss.n6180 avss.n6179 0.1445
R21357 avss.n6179 avss.n5631 0.1445
R21358 avss.n6174 avss.n5631 0.1445
R21359 avss.n6174 avss.n6173 0.1445
R21360 avss.n6173 avss.n6172 0.1445
R21361 avss.n6172 avss.n5638 0.1445
R21362 avss.n6167 avss.n5638 0.1445
R21363 avss.n6167 avss.n6166 0.1445
R21364 avss.n6166 avss.n6165 0.1445
R21365 avss.n6165 avss.n5645 0.1445
R21366 avss.n6160 avss.n5645 0.1445
R21367 avss.n6160 avss.n6159 0.1445
R21368 avss.n6159 avss.n6158 0.1445
R21369 avss.n6158 avss.n5652 0.1445
R21370 avss.n6153 avss.n5652 0.1445
R21371 avss.n6153 avss.n6152 0.1445
R21372 avss.n6152 avss.n6151 0.1445
R21373 avss.n6151 avss.n5659 0.1445
R21374 avss.n6146 avss.n5659 0.1445
R21375 avss.n6146 avss.n6145 0.1445
R21376 avss.n6145 avss.n6144 0.1445
R21377 avss.n6144 avss.n5666 0.1445
R21378 avss.n6139 avss.n5666 0.1445
R21379 avss.n6139 avss.n6138 0.1445
R21380 avss.n6138 avss.n6137 0.1445
R21381 avss.n6137 avss.n5673 0.1445
R21382 avss.n6132 avss.n5673 0.1445
R21383 avss.n6132 avss.n6131 0.1445
R21384 avss.n6131 avss.n6130 0.1445
R21385 avss.n6130 avss.n5680 0.1445
R21386 avss.n5690 avss.n5680 0.1445
R21387 avss.n6122 avss.n5690 0.1445
R21388 avss.n6122 avss.n6121 0.1445
R21389 avss.n6121 avss.n6120 0.1445
R21390 avss.n6120 avss.n5696 0.1445
R21391 avss.n6022 avss.n5696 0.1445
R21392 avss.n6022 avss.n5714 0.1445
R21393 avss.n6105 avss.n5714 0.1445
R21394 avss.n6105 avss.n6104 0.1445
R21395 avss.n6104 avss.n6103 0.1445
R21396 avss.n6103 avss.n5718 0.1445
R21397 avss.n6039 avss.n5718 0.1445
R21398 avss.n6039 avss.n5852 0.1445
R21399 avss.n6052 avss.n5852 0.1445
R21400 avss.n6052 avss.n5850 0.1445
R21401 avss.n6056 avss.n5850 0.1445
R21402 avss.n6056 avss.n5838 0.1445
R21403 avss.n6074 avss.n5838 0.1445
R21404 avss.n6074 avss.n5836 0.1445
R21405 avss.n6080 avss.n5836 0.1445
R21406 avss.n6080 avss.n6079 0.1445
R21407 avss.n6213 avss.n4688 0.1445
R21408 avss.n6213 avss.n4686 0.1445
R21409 avss.n6217 avss.n4686 0.1445
R21410 avss.n6217 avss.n4676 0.1445
R21411 avss.n6229 avss.n4676 0.1445
R21412 avss.n6229 avss.n4674 0.1445
R21413 avss.n6233 avss.n4674 0.1445
R21414 avss.n4941 avss.n4928 0.1445
R21415 avss.n4946 avss.n4928 0.1445
R21416 avss.n4946 avss.n4882 0.1445
R21417 avss.n5015 avss.n4882 0.1445
R21418 avss.n5015 avss.n5014 0.1445
R21419 avss.n5014 avss.n5013 0.1445
R21420 avss.n5013 avss.n4886 0.1445
R21421 avss.n4966 avss.n4886 0.1445
R21422 avss.n4971 avss.n4966 0.1445
R21423 avss.n4971 avss.n4909 0.1445
R21424 avss.n5003 avss.n4909 0.1445
R21425 avss.n5003 avss.n5002 0.1445
R21426 avss.n5002 avss.n5001 0.1445
R21427 avss.n4936 avss.n4935 0.1445
R21428 avss.n4935 avss.n4923 0.1445
R21429 avss.n4951 avss.n4923 0.1445
R21430 avss.n4952 avss.n4951 0.1445
R21431 avss.n4954 avss.n4952 0.1445
R21432 avss.n4954 avss.n4921 0.1445
R21433 avss.n4961 avss.n4921 0.1445
R21434 avss.n4961 avss.n4960 0.1445
R21435 avss.n4960 avss.n4919 0.1445
R21436 avss.n4976 avss.n4919 0.1445
R21437 avss.n4977 avss.n4976 0.1445
R21438 avss.n4977 avss.n4917 0.1445
R21439 avss.n4981 avss.n4917 0.1445
R21440 avss.n4934 avss.n4932 0.1445
R21441 avss.n4934 avss.n4933 0.1445
R21442 avss.n4933 avss.n4924 0.1445
R21443 avss.n4924 avss.n4922 0.1445
R21444 avss.n4955 avss.n4922 0.1445
R21445 avss.n4956 avss.n4955 0.1445
R21446 avss.n4957 avss.n4956 0.1445
R21447 avss.n4959 avss.n4957 0.1445
R21448 avss.n4959 avss.n4958 0.1445
R21449 avss.n4958 avss.n4918 0.1445
R21450 avss.n4978 avss.n4918 0.1445
R21451 avss.n4979 avss.n4978 0.1445
R21452 avss.n4980 avss.n4979 0.1445
R21453 avss.n4943 avss.n4942 0.1445
R21454 avss.n4945 avss.n4943 0.1445
R21455 avss.n4945 avss.n4944 0.1445
R21456 avss.n4944 avss.n4883 0.1445
R21457 avss.n4884 avss.n4883 0.1445
R21458 avss.n4885 avss.n4884 0.1445
R21459 avss.n4967 avss.n4885 0.1445
R21460 avss.n4968 avss.n4967 0.1445
R21461 avss.n4970 avss.n4968 0.1445
R21462 avss.n4970 avss.n4969 0.1445
R21463 avss.n4969 avss.n4910 0.1445
R21464 avss.n4911 avss.n4910 0.1445
R21465 avss.n4912 avss.n4911 0.1445
R21466 avss.n4987 avss.n4986 0.1445
R21467 avss.n4899 avss.n4898 0.1445
R21468 avss.n5020 avss.n4873 0.1445
R21469 avss.n5021 avss.n4872 0.1445
R21470 avss.n5024 avss.n4870 0.1445
R21471 avss.n4861 avss.n4860 0.1445
R21472 avss.n5034 avss.n4857 0.1445
R21473 avss.n5033 avss.n4858 0.1445
R21474 avss.n5585 avss.n5584 0.1445
R21475 avss.n5584 avss.n4707 0.1445
R21476 avss.n5580 avss.n4707 0.1445
R21477 avss.n5580 avss.n4709 0.1445
R21478 avss.n5423 avss.n4806 0.1445
R21479 avss.n5454 avss.n4806 0.1445
R21480 avss.n5454 avss.n5453 0.1445
R21481 avss.n5453 avss.n5452 0.1445
R21482 avss.n5452 avss.n5451 0.1445
R21483 avss.n5451 avss.n5448 0.1445
R21484 avss.n5448 avss.n5447 0.1445
R21485 avss.n5447 avss.n5446 0.1445
R21486 avss.n5446 avss.n5444 0.1445
R21487 avss.n5444 avss.n5443 0.1445
R21488 avss.n5443 avss.n5435 0.1445
R21489 avss.n5439 avss.n5435 0.1445
R21490 avss.n5439 avss.n5438 0.1445
R21491 avss.n5419 avss.n4801 0.1445
R21492 avss.n5458 avss.n4801 0.1445
R21493 avss.n5458 avss.n4799 0.1445
R21494 avss.n5464 avss.n4799 0.1445
R21495 avss.n5464 avss.n5463 0.1445
R21496 avss.n5463 avss.n4779 0.1445
R21497 avss.n5488 avss.n4779 0.1445
R21498 avss.n5488 avss.n4777 0.1445
R21499 avss.n5503 avss.n4777 0.1445
R21500 avss.n5503 avss.n5502 0.1445
R21501 avss.n5502 avss.n5501 0.1445
R21502 avss.n5501 avss.n5498 0.1445
R21503 avss.n5498 avss.n5497 0.1445
R21504 avss.n5418 avss.n4800 0.1445
R21505 avss.n5459 avss.n4800 0.1445
R21506 avss.n5460 avss.n5459 0.1445
R21507 avss.n5461 avss.n5460 0.1445
R21508 avss.n5462 avss.n5461 0.1445
R21509 avss.n5462 avss.n4778 0.1445
R21510 avss.n5489 avss.n4778 0.1445
R21511 avss.n5490 avss.n5489 0.1445
R21512 avss.n5491 avss.n5490 0.1445
R21513 avss.n5492 avss.n5491 0.1445
R21514 avss.n5493 avss.n5492 0.1445
R21515 avss.n5494 avss.n5493 0.1445
R21516 avss.n5496 avss.n5494 0.1445
R21517 avss.n5425 avss.n5424 0.1445
R21518 avss.n5426 avss.n5425 0.1445
R21519 avss.n5427 avss.n5426 0.1445
R21520 avss.n5428 avss.n5427 0.1445
R21521 avss.n5429 avss.n5428 0.1445
R21522 avss.n5430 avss.n5429 0.1445
R21523 avss.n5431 avss.n5430 0.1445
R21524 avss.n5432 avss.n5431 0.1445
R21525 avss.n5433 avss.n5432 0.1445
R21526 avss.n5434 avss.n5433 0.1445
R21527 avss.n5436 avss.n5434 0.1445
R21528 avss.n5437 avss.n5436 0.1445
R21529 avss.n5437 avss.n4745 0.1445
R21530 avss.n5548 avss.n4744 0.1445
R21531 avss.n5554 avss.n4744 0.1445
R21532 avss.n5555 avss.n5554 0.1445
R21533 avss.n5557 avss.n5555 0.1445
R21534 avss.n5550 avss.n5549 0.1445
R21535 avss.n5551 avss.n5550 0.1445
R21536 avss.n5551 avss.n4743 0.1445
R21537 avss.n5558 avss.n4743 0.1445
R21538 avss.n5583 avss.n4706 0.1445
R21539 avss.n5583 avss.n5582 0.1445
R21540 avss.n5582 avss.n5581 0.1445
R21541 avss.n5581 avss.n4708 0.1445
R21542 avss.n4862 avss.n4742 0.1445
R21543 avss.n4893 avss.n4866 0.1445
R21544 avss.n4894 avss.n4892 0.1445
R21545 avss.n5023 avss.n4859 0.1445
R21546 avss.n4900 avss.n4897 0.1445
R21547 avss.n4993 avss.n4992 0.1445
R21548 avss.n4994 avss.n4991 0.1445
R21549 avss.n4988 avss.n4985 0.1445
R21550 avss.n4727 avss.n4726 0.1445
R21551 avss.n5567 avss.n4727 0.1445
R21552 avss.n5567 avss.n5566 0.1445
R21553 avss.n5566 avss.n5565 0.1445
R21554 avss.n5565 avss.n4732 0.1445
R21555 avss.n4839 avss.n4732 0.1445
R21556 avss.n5039 avss.n4839 0.1445
R21557 avss.n5039 avss.n4836 0.1445
R21558 avss.n5043 avss.n4836 0.1445
R21559 avss.n5043 avss.n4825 0.1445
R21560 avss.n5056 avss.n4825 0.1445
R21561 avss.n5056 avss.n4823 0.1445
R21562 avss.n5060 avss.n4823 0.1445
R21563 avss.n5573 avss.n5572 0.1445
R21564 avss.n5572 avss.n5571 0.1445
R21565 avss.n5571 avss.n4720 0.1445
R21566 avss.n4847 avss.n4720 0.1445
R21567 avss.n4849 avss.n4847 0.1445
R21568 avss.n4849 avss.n4844 0.1445
R21569 avss.n4853 avss.n4844 0.1445
R21570 avss.n4853 avss.n4831 0.1445
R21571 avss.n5047 avss.n4831 0.1445
R21572 avss.n5047 avss.n4829 0.1445
R21573 avss.n5051 avss.n4829 0.1445
R21574 avss.n5051 avss.n4817 0.1445
R21575 avss.n5064 avss.n4817 0.1445
R21576 avss.n5574 avss.n4717 0.1445
R21577 avss.n4719 avss.n4717 0.1445
R21578 avss.n4845 avss.n4719 0.1445
R21579 avss.n4846 avss.n4845 0.1445
R21580 avss.n4850 avss.n4846 0.1445
R21581 avss.n4851 avss.n4850 0.1445
R21582 avss.n4852 avss.n4851 0.1445
R21583 avss.n4852 avss.n4830 0.1445
R21584 avss.n5048 avss.n4830 0.1445
R21585 avss.n5049 avss.n5048 0.1445
R21586 avss.n5050 avss.n5049 0.1445
R21587 avss.n5050 avss.n4816 0.1445
R21588 avss.n5065 avss.n4816 0.1445
R21589 avss.n4728 avss.n4716 0.1445
R21590 avss.n4729 avss.n4728 0.1445
R21591 avss.n4730 avss.n4729 0.1445
R21592 avss.n4731 avss.n4730 0.1445
R21593 avss.n4837 avss.n4731 0.1445
R21594 avss.n4838 avss.n4837 0.1445
R21595 avss.n5040 avss.n4838 0.1445
R21596 avss.n5041 avss.n5040 0.1445
R21597 avss.n5042 avss.n5041 0.1445
R21598 avss.n5042 avss.n4824 0.1445
R21599 avss.n5057 avss.n4824 0.1445
R21600 avss.n5058 avss.n5057 0.1445
R21601 avss.n5059 avss.n5058 0.1445
R21602 avss.n5473 avss.n4792 0.1445
R21603 avss.n5473 avss.n4793 0.1445
R21604 avss.n4793 avss.n4769 0.1445
R21605 avss.n5508 avss.n4769 0.1445
R21606 avss.n5508 avss.n4767 0.1445
R21607 avss.n5512 avss.n4767 0.1445
R21608 avss.n5512 avss.n4754 0.1445
R21609 avss.n5536 avss.n4754 0.1445
R21610 avss.n5536 avss.n4752 0.1445
R21611 avss.n5541 avss.n4752 0.1445
R21612 avss.n5541 avss.n4697 0.1445
R21613 avss.n5593 avss.n4697 0.1445
R21614 avss.n5593 avss.n5592 0.1445
R21615 avss.n5477 avss.n4786 0.1445
R21616 avss.n5477 avss.n4784 0.1445
R21617 avss.n5483 avss.n4784 0.1445
R21618 avss.n5483 avss.n5482 0.1445
R21619 avss.n5482 avss.n4761 0.1445
R21620 avss.n5516 avss.n4761 0.1445
R21621 avss.n5516 avss.n4759 0.1445
R21622 avss.n5531 avss.n4759 0.1445
R21623 avss.n5531 avss.n5530 0.1445
R21624 avss.n5530 avss.n5529 0.1445
R21625 avss.n5529 avss.n5528 0.1445
R21626 avss.n5528 avss.n5526 0.1445
R21627 avss.n5526 avss.n5525 0.1445
R21628 avss.n5478 avss.n4785 0.1445
R21629 avss.n5479 avss.n5478 0.1445
R21630 avss.n5480 avss.n5479 0.1445
R21631 avss.n5481 avss.n5480 0.1445
R21632 avss.n5481 avss.n4760 0.1445
R21633 avss.n5517 avss.n4760 0.1445
R21634 avss.n5518 avss.n5517 0.1445
R21635 avss.n5519 avss.n5518 0.1445
R21636 avss.n5520 avss.n5519 0.1445
R21637 avss.n5521 avss.n5520 0.1445
R21638 avss.n5522 avss.n5521 0.1445
R21639 avss.n5523 avss.n5522 0.1445
R21640 avss.n5524 avss.n5523 0.1445
R21641 avss.n5472 avss.n5470 0.1445
R21642 avss.n5472 avss.n5471 0.1445
R21643 avss.n5471 avss.n4768 0.1445
R21644 avss.n5509 avss.n4768 0.1445
R21645 avss.n5510 avss.n5509 0.1445
R21646 avss.n5511 avss.n5510 0.1445
R21647 avss.n5511 avss.n4753 0.1445
R21648 avss.n5537 avss.n4753 0.1445
R21649 avss.n5538 avss.n5537 0.1445
R21650 avss.n5540 avss.n5538 0.1445
R21651 avss.n5540 avss.n5539 0.1445
R21652 avss.n5539 avss.n4698 0.1445
R21653 avss.n5591 avss.n4698 0.1445
R21654 avss.n5357 avss.n5104 0.1445
R21655 avss.n5369 avss.n5104 0.1445
R21656 avss.n5369 avss.n5102 0.1445
R21657 avss.n5373 avss.n5102 0.1445
R21658 avss.n5373 avss.n5092 0.1445
R21659 avss.n5385 avss.n5092 0.1445
R21660 avss.n5385 avss.n5090 0.1445
R21661 avss.n5389 avss.n5090 0.1445
R21662 avss.n5389 avss.n5080 0.1445
R21663 avss.n5402 avss.n5080 0.1445
R21664 avss.n5402 avss.n5078 0.1445
R21665 avss.n5407 avss.n5078 0.1445
R21666 avss.n5407 avss.n5406 0.1445
R21667 avss.n5361 avss.n5108 0.1445
R21668 avss.n5365 avss.n5108 0.1445
R21669 avss.n5365 avss.n5098 0.1445
R21670 avss.n5377 avss.n5098 0.1445
R21671 avss.n5377 avss.n5096 0.1445
R21672 avss.n5381 avss.n5096 0.1445
R21673 avss.n5381 avss.n5086 0.1445
R21674 avss.n5393 avss.n5086 0.1445
R21675 avss.n5393 avss.n5084 0.1445
R21676 avss.n5398 avss.n5084 0.1445
R21677 avss.n5398 avss.n5073 0.1445
R21678 avss.n5411 avss.n5073 0.1445
R21679 avss.n5412 avss.n5411 0.1445
R21680 avss.n5363 avss.n5362 0.1445
R21681 avss.n5364 avss.n5363 0.1445
R21682 avss.n5364 avss.n5097 0.1445
R21683 avss.n5378 avss.n5097 0.1445
R21684 avss.n5379 avss.n5378 0.1445
R21685 avss.n5380 avss.n5379 0.1445
R21686 avss.n5380 avss.n5085 0.1445
R21687 avss.n5394 avss.n5085 0.1445
R21688 avss.n5395 avss.n5394 0.1445
R21689 avss.n5397 avss.n5395 0.1445
R21690 avss.n5397 avss.n5396 0.1445
R21691 avss.n5396 avss.n5072 0.1445
R21692 avss.n5413 avss.n5072 0.1445
R21693 avss.n5356 avss.n5103 0.1445
R21694 avss.n5370 avss.n5103 0.1445
R21695 avss.n5371 avss.n5370 0.1445
R21696 avss.n5372 avss.n5371 0.1445
R21697 avss.n5372 avss.n5091 0.1445
R21698 avss.n5386 avss.n5091 0.1445
R21699 avss.n5387 avss.n5386 0.1445
R21700 avss.n5388 avss.n5387 0.1445
R21701 avss.n5388 avss.n5079 0.1445
R21702 avss.n5403 avss.n5079 0.1445
R21703 avss.n5404 avss.n5403 0.1445
R21704 avss.n5405 avss.n5404 0.1445
R21705 avss.n5405 avss.n4812 0.1445
R21706 avss.n6288 avss.n6274 0.1445
R21707 avss.n6288 avss.n6272 0.1445
R21708 avss.n6292 avss.n6272 0.1445
R21709 avss.n6292 avss.n6262 0.1445
R21710 avss.n6304 avss.n6262 0.1445
R21711 avss.n6304 avss.n6260 0.1445
R21712 avss.n6308 avss.n6260 0.1445
R21713 avss.n6284 avss.n6278 0.1445
R21714 avss.n6284 avss.n6268 0.1445
R21715 avss.n6296 avss.n6268 0.1445
R21716 avss.n6296 avss.n6266 0.1445
R21717 avss.n6300 avss.n6266 0.1445
R21718 avss.n6300 avss.n6254 0.1445
R21719 avss.n6312 avss.n6254 0.1445
R21720 avss.n6283 avss.n6282 0.1445
R21721 avss.n6283 avss.n6267 0.1445
R21722 avss.n6297 avss.n6267 0.1445
R21723 avss.n6298 avss.n6297 0.1445
R21724 avss.n6299 avss.n6298 0.1445
R21725 avss.n6299 avss.n6253 0.1445
R21726 avss.n6313 avss.n6253 0.1445
R21727 avss.n6289 avss.n6273 0.1445
R21728 avss.n6290 avss.n6289 0.1445
R21729 avss.n6291 avss.n6290 0.1445
R21730 avss.n6291 avss.n6261 0.1445
R21731 avss.n6305 avss.n6261 0.1445
R21732 avss.n6306 avss.n6305 0.1445
R21733 avss.n6307 avss.n6306 0.1445
R21734 avss.n2894 avss.n2856 0.1445
R21735 avss.n2889 avss.n2856 0.1445
R21736 avss.n2889 avss.n2888 0.1445
R21737 avss.n2888 avss.n2887 0.1445
R21738 avss.n2887 avss.n2884 0.1445
R21739 avss.n2884 avss.n2883 0.1445
R21740 avss.n2883 avss.n2880 0.1445
R21741 avss.n2880 avss.n2879 0.1445
R21742 avss.n2879 avss.n2875 0.1445
R21743 avss.n2875 avss.n2874 0.1445
R21744 avss.n2874 avss.n2873 0.1445
R21745 avss.n2873 avss.n547 0.1445
R21746 avss.n7268 avss.n547 0.1445
R21747 avss.n2895 avss.n2855 0.1445
R21748 avss.n2862 avss.n2855 0.1445
R21749 avss.n2863 avss.n2862 0.1445
R21750 avss.n2864 avss.n2863 0.1445
R21751 avss.n2865 avss.n2864 0.1445
R21752 avss.n2866 avss.n2865 0.1445
R21753 avss.n2867 avss.n2866 0.1445
R21754 avss.n2868 avss.n2867 0.1445
R21755 avss.n2869 avss.n2868 0.1445
R21756 avss.n2870 avss.n2869 0.1445
R21757 avss.n2871 avss.n2870 0.1445
R21758 avss.n2871 avss.n548 0.1445
R21759 avss.n7267 avss.n548 0.1445
R21760 avss.n2898 avss.n2897 0.1445
R21761 avss.n2899 avss.n2898 0.1445
R21762 avss.n2900 avss.n2899 0.1445
R21763 avss.n2901 avss.n2900 0.1445
R21764 avss.n2902 avss.n2901 0.1445
R21765 avss.n2903 avss.n2902 0.1445
R21766 avss.n2904 avss.n2903 0.1445
R21767 avss.n2906 avss.n2904 0.1445
R21768 avss.n2906 avss.n2905 0.1445
R21769 avss.n2905 avss.n540 0.1445
R21770 avss.n541 avss.n540 0.1445
R21771 avss.n542 avss.n541 0.1445
R21772 avss.n549 avss.n542 0.1445
R21773 avss.n2922 avss.n2921 0.1445
R21774 avss.n2921 avss.n2920 0.1445
R21775 avss.n2920 avss.n2917 0.1445
R21776 avss.n2917 avss.n2916 0.1445
R21777 avss.n2916 avss.n2913 0.1445
R21778 avss.n2913 avss.n2912 0.1445
R21779 avss.n2912 avss.n2909 0.1445
R21780 avss.n2909 avss.n2908 0.1445
R21781 avss.n2908 avss.n539 0.1445
R21782 avss.n7276 avss.n539 0.1445
R21783 avss.n7276 avss.n7275 0.1445
R21784 avss.n7275 avss.n7274 0.1445
R21785 avss.n7274 avss.n543 0.1445
R21786 avss.n468 avss.n467 0.1445
R21787 avss.n467 avss.n466 0.1445
R21788 avss.n466 avss.n439 0.1445
R21789 avss.n447 avss.n439 0.1445
R21790 avss.n447 avss.n446 0.1445
R21791 avss.n446 avss.n445 0.1445
R21792 avss.n445 avss.n409 0.1445
R21793 avss.n7447 avss.n409 0.1445
R21794 avss.n7448 avss.n7447 0.1445
R21795 avss.n7448 avss.n407 0.1445
R21796 avss.n7452 avss.n407 0.1445
R21797 avss.n7454 avss.n7452 0.1445
R21798 avss.n7455 avss.n7454 0.1445
R21799 avss.n7470 avss.n7469 0.1445
R21800 avss.n7428 avss.n7427 0.1445
R21801 avss.n7423 avss.n7422 0.1445
R21802 avss.n7421 avss.n7420 0.1445
R21803 avss.n7410 avss.n7409 0.1445
R21804 avss.n7300 avss.n7299 0.1445
R21805 avss.n7380 avss.n7379 0.1445
R21806 avss.n7378 avss.n475 0.1445
R21807 avss.n7288 avss.n526 0.1445
R21808 avss.n7292 avss.n526 0.1445
R21809 avss.n7292 avss.n514 0.1445
R21810 avss.n7375 avss.n514 0.1445
R21811 avss.n2819 avss.n2818 0.1445
R21812 avss.n2822 avss.n2819 0.1445
R21813 avss.n2822 avss.n2814 0.1445
R21814 avss.n2826 avss.n2814 0.1445
R21815 avss.n2829 avss.n2826 0.1445
R21816 avss.n2832 avss.n2829 0.1445
R21817 avss.n2832 avss.n2812 0.1445
R21818 avss.n2836 avss.n2812 0.1445
R21819 avss.n2839 avss.n2836 0.1445
R21820 avss.n2841 avss.n2839 0.1445
R21821 avss.n2841 avss.n2810 0.1445
R21822 avss.n2846 avss.n2810 0.1445
R21823 avss.n2846 avss.n2845 0.1445
R21824 avss.n3282 avss.n3281 0.1445
R21825 avss.n3281 avss.n2003 0.1445
R21826 avss.n3277 avss.n2003 0.1445
R21827 avss.n3277 avss.n2005 0.1445
R21828 avss.n2784 avss.n2005 0.1445
R21829 avss.n2787 avss.n2784 0.1445
R21830 avss.n2787 avss.n2781 0.1445
R21831 avss.n2791 avss.n2781 0.1445
R21832 avss.n2794 avss.n2791 0.1445
R21833 avss.n2796 avss.n2794 0.1445
R21834 avss.n2796 avss.n2779 0.1445
R21835 avss.n2802 avss.n2779 0.1445
R21836 avss.n2802 avss.n2801 0.1445
R21837 avss.n3280 avss.n2002 0.1445
R21838 avss.n3280 avss.n3279 0.1445
R21839 avss.n3279 avss.n3278 0.1445
R21840 avss.n3278 avss.n2004 0.1445
R21841 avss.n2782 avss.n2004 0.1445
R21842 avss.n2788 avss.n2782 0.1445
R21843 avss.n2789 avss.n2788 0.1445
R21844 avss.n2790 avss.n2789 0.1445
R21845 avss.n2790 avss.n2780 0.1445
R21846 avss.n2797 avss.n2780 0.1445
R21847 avss.n2798 avss.n2797 0.1445
R21848 avss.n2799 avss.n2798 0.1445
R21849 avss.n2800 avss.n2799 0.1445
R21850 avss.n2817 avss.n2815 0.1445
R21851 avss.n2823 avss.n2815 0.1445
R21852 avss.n2824 avss.n2823 0.1445
R21853 avss.n2825 avss.n2824 0.1445
R21854 avss.n2825 avss.n2813 0.1445
R21855 avss.n2833 avss.n2813 0.1445
R21856 avss.n2834 avss.n2833 0.1445
R21857 avss.n2835 avss.n2834 0.1445
R21858 avss.n2835 avss.n2811 0.1445
R21859 avss.n2842 avss.n2811 0.1445
R21860 avss.n2843 avss.n2842 0.1445
R21861 avss.n2844 avss.n2843 0.1445
R21862 avss.n2844 avss.n530 0.1445
R21863 avss.n7284 avss.n521 0.1445
R21864 avss.n7295 avss.n521 0.1445
R21865 avss.n7295 avss.n519 0.1445
R21866 avss.n7304 avss.n519 0.1445
R21867 avss.n7283 avss.n520 0.1445
R21868 avss.n7296 avss.n520 0.1445
R21869 avss.n7297 avss.n7296 0.1445
R21870 avss.n7303 avss.n7297 0.1445
R21871 avss.n7290 avss.n7289 0.1445
R21872 avss.n7291 avss.n7290 0.1445
R21873 avss.n7291 avss.n513 0.1445
R21874 avss.n7376 avss.n513 0.1445
R21875 avss.n7301 avss.n7298 0.1445
R21876 avss.n7414 avss.n430 0.1445
R21877 avss.n7415 avss.n429 0.1445
R21878 avss.n7408 avss.n427 0.1445
R21879 avss.n7429 avss.n424 0.1445
R21880 avss.n422 avss.n400 0.1445
R21881 avss.n423 avss.n421 0.1445
R21882 avss.n7468 avss.n398 0.1445
R21883 avss.n469 avss.n436 0.1445
R21884 avss.n438 avss.n436 0.1445
R21885 avss.n440 avss.n438 0.1445
R21886 avss.n441 avss.n440 0.1445
R21887 avss.n442 avss.n441 0.1445
R21888 avss.n444 avss.n442 0.1445
R21889 avss.n444 avss.n443 0.1445
R21890 avss.n443 avss.n408 0.1445
R21891 avss.n7449 avss.n408 0.1445
R21892 avss.n7450 avss.n7449 0.1445
R21893 avss.n7451 avss.n7450 0.1445
R21894 avss.n7451 avss.n405 0.1445
R21895 avss.n7456 avss.n405 0.1445
R21896 avss.n458 avss.n435 0.1445
R21897 avss.n459 avss.n458 0.1445
R21898 avss.n460 avss.n459 0.1445
R21899 avss.n460 avss.n413 0.1445
R21900 avss.n7438 avss.n413 0.1445
R21901 avss.n7439 avss.n7438 0.1445
R21902 avss.n7441 avss.n7439 0.1445
R21903 avss.n7441 avss.n7440 0.1445
R21904 avss.n7440 avss.n387 0.1445
R21905 avss.n388 avss.n387 0.1445
R21906 avss.n389 avss.n388 0.1445
R21907 avss.n403 avss.n389 0.1445
R21908 avss.n7460 avss.n403 0.1445
R21909 avss.n457 avss.n456 0.1445
R21910 avss.n462 avss.n457 0.1445
R21911 avss.n462 avss.n461 0.1445
R21912 avss.n461 avss.n414 0.1445
R21913 avss.n7437 avss.n414 0.1445
R21914 avss.n7437 avss.n412 0.1445
R21915 avss.n7442 avss.n412 0.1445
R21916 avss.n7442 avss.n386 0.1445
R21917 avss.n7477 avss.n386 0.1445
R21918 avss.n7477 avss.n7476 0.1445
R21919 avss.n7476 avss.n7475 0.1445
R21920 avss.n7475 avss.n390 0.1445
R21921 avss.n7461 avss.n390 0.1445
R21922 avss.n7363 avss.n7362 0.1445
R21923 avss.n7362 avss.n7361 0.1445
R21924 avss.n7361 avss.n7359 0.1445
R21925 avss.n7359 avss.n7358 0.1445
R21926 avss.n7358 avss.n7356 0.1445
R21927 avss.n7356 avss.n7355 0.1445
R21928 avss.n7355 avss.n7354 0.1445
R21929 avss.n7354 avss.n7319 0.1445
R21930 avss.n7340 avss.n7319 0.1445
R21931 avss.n7340 avss.n7339 0.1445
R21932 avss.n7339 avss.n7338 0.1445
R21933 avss.n7338 avss.n7335 0.1445
R21934 avss.n7335 avss.n7334 0.1445
R21935 avss.n7364 avss.n7310 0.1445
R21936 avss.n7313 avss.n7310 0.1445
R21937 avss.n7314 avss.n7313 0.1445
R21938 avss.n7315 avss.n7314 0.1445
R21939 avss.n7316 avss.n7315 0.1445
R21940 avss.n7317 avss.n7316 0.1445
R21941 avss.n7318 avss.n7317 0.1445
R21942 avss.n7320 avss.n7318 0.1445
R21943 avss.n7321 avss.n7320 0.1445
R21944 avss.n7322 avss.n7321 0.1445
R21945 avss.n7323 avss.n7322 0.1445
R21946 avss.n7324 avss.n7323 0.1445
R21947 avss.n7325 avss.n7324 0.1445
R21948 avss.n7368 avss.n7366 0.1445
R21949 avss.n7368 avss.n7367 0.1445
R21950 avss.n7367 avss.n501 0.1445
R21951 avss.n502 avss.n501 0.1445
R21952 avss.n503 avss.n502 0.1445
R21953 avss.n7345 avss.n503 0.1445
R21954 avss.n7346 avss.n7345 0.1445
R21955 avss.n7348 avss.n7346 0.1445
R21956 avss.n7348 avss.n7347 0.1445
R21957 avss.n7347 avss.n486 0.1445
R21958 avss.n487 avss.n486 0.1445
R21959 avss.n488 avss.n487 0.1445
R21960 avss.n7326 avss.n488 0.1445
R21961 avss.n7370 avss.n7369 0.1445
R21962 avss.n7369 avss.n500 0.1445
R21963 avss.n7388 avss.n500 0.1445
R21964 avss.n7388 avss.n7387 0.1445
R21965 avss.n7387 avss.n7386 0.1445
R21966 avss.n7386 avss.n504 0.1445
R21967 avss.n7344 avss.n504 0.1445
R21968 avss.n7349 avss.n7344 0.1445
R21969 avss.n7349 avss.n485 0.1445
R21970 avss.n7400 avss.n485 0.1445
R21971 avss.n7400 avss.n7399 0.1445
R21972 avss.n7399 avss.n7398 0.1445
R21973 avss.n7398 avss.n489 0.1445
R21974 avss.n8059 avss.n8058 0.1445
R21975 avss.n8058 avss.n8057 0.1445
R21976 avss.n8057 avss.n7950 0.1445
R21977 avss.n8053 avss.n7950 0.1445
R21978 avss.n8053 avss.n8052 0.1445
R21979 avss.n8052 avss.n8051 0.1445
R21980 avss.n8051 avss.n7956 0.1445
R21981 avss.n8020 avss.n7956 0.1445
R21982 avss.n8021 avss.n8020 0.1445
R21983 avss.n8021 avss.n8017 0.1445
R21984 avss.n8026 avss.n8017 0.1445
R21985 avss.n8027 avss.n8026 0.1445
R21986 avss.n8028 avss.n8027 0.1445
R21987 avss.n8013 avss.n8002 0.1445
R21988 avss.n8009 avss.n8008 0.1445
R21989 avss.n8007 avss.n4 0.1445
R21990 avss.n9383 avss.n9382 0.1445
R21991 avss.n9394 avss.n9393 0.1445
R21992 avss.n9395 avss.n12 0.1445
R21993 avss.n9378 avss.n9377 0.1445
R21994 avss.n9377 avss.n9376 0.1445
R21995 avss.n9376 avss.n22 0.1445
R21996 avss.n9330 avss.n22 0.1445
R21997 avss.n9331 avss.n9330 0.1445
R21998 avss.n9331 avss.n9327 0.1445
R21999 avss.n9336 avss.n9327 0.1445
R22000 avss.n9337 avss.n9336 0.1445
R22001 avss.n9338 avss.n9337 0.1445
R22002 avss.n9338 avss.n9325 0.1445
R22003 avss.n9343 avss.n9325 0.1445
R22004 avss.n9344 avss.n9343 0.1445
R22005 avss.n9345 avss.n9344 0.1445
R22006 avss.n30 avss.n29 0.1445
R22007 avss.n9372 avss.n30 0.1445
R22008 avss.n9372 avss.n9371 0.1445
R22009 avss.n9371 avss.n9370 0.1445
R22010 avss.n9370 avss.n35 0.1445
R22011 avss.n9364 avss.n35 0.1445
R22012 avss.n9364 avss.n9363 0.1445
R22013 avss.n9363 avss.n9362 0.1445
R22014 avss.n9362 avss.n45 0.1445
R22015 avss.n9355 avss.n45 0.1445
R22016 avss.n9355 avss.n9354 0.1445
R22017 avss.n9354 avss.n9353 0.1445
R22018 avss.n9353 avss.n59 0.1445
R22019 avss.n31 avss.n18 0.1445
R22020 avss.n32 avss.n31 0.1445
R22021 avss.n33 avss.n32 0.1445
R22022 avss.n34 avss.n33 0.1445
R22023 avss.n41 avss.n34 0.1445
R22024 avss.n42 avss.n41 0.1445
R22025 avss.n43 avss.n42 0.1445
R22026 avss.n44 avss.n43 0.1445
R22027 avss.n55 avss.n44 0.1445
R22028 avss.n56 avss.n55 0.1445
R22029 avss.n57 avss.n56 0.1445
R22030 avss.n58 avss.n57 0.1445
R22031 avss.n9323 avss.n58 0.1445
R22032 avss.n7967 avss.n7946 0.1445
R22033 avss.n7968 avss.n7967 0.1445
R22034 avss.n7968 avss.n7962 0.1445
R22035 avss.n7974 avss.n7962 0.1445
R22036 avss.n7975 avss.n7974 0.1445
R22037 avss.n7976 avss.n7975 0.1445
R22038 avss.n7977 avss.n7976 0.1445
R22039 avss.n7978 avss.n7977 0.1445
R22040 avss.n7990 avss.n7978 0.1445
R22041 avss.n7991 avss.n7990 0.1445
R22042 avss.n7992 avss.n7991 0.1445
R22043 avss.n7993 avss.n7992 0.1445
R22044 avss.n8000 avss.n7993 0.1445
R22045 avss.n7966 avss.n7965 0.1445
R22046 avss.n7969 avss.n7966 0.1445
R22047 avss.n7969 avss.n7963 0.1445
R22048 avss.n7973 avss.n7963 0.1445
R22049 avss.n7973 avss.n7961 0.1445
R22050 avss.n8047 avss.n7961 0.1445
R22051 avss.n8047 avss.n8046 0.1445
R22052 avss.n8046 avss.n8045 0.1445
R22053 avss.n8045 avss.n7979 0.1445
R22054 avss.n8039 avss.n7979 0.1445
R22055 avss.n8039 avss.n8038 0.1445
R22056 avss.n8038 avss.n8037 0.1445
R22057 avss.n8037 avss.n7994 0.1445
R22058 avss.n8894 avss.n8893 0.1445
R22059 avss.n8893 avss.n8892 0.1445
R22060 avss.n8892 avss.n7494 0.1445
R22061 avss.n8284 avss.n7494 0.1445
R22062 avss.n8289 avss.n8284 0.1445
R22063 avss.n8290 avss.n8289 0.1445
R22064 avss.n8292 avss.n8290 0.1445
R22065 avss.n8292 avss.n8282 0.1445
R22066 avss.n8297 avss.n8282 0.1445
R22067 avss.n8298 avss.n8297 0.1445
R22068 avss.n8300 avss.n8298 0.1445
R22069 avss.n8300 avss.n8280 0.1445
R22070 avss.n8305 avss.n8280 0.1445
R22071 avss.n8306 avss.n8305 0.1445
R22072 avss.n8308 avss.n8306 0.1445
R22073 avss.n8308 avss.n8278 0.1445
R22074 avss.n8313 avss.n8278 0.1445
R22075 avss.n8314 avss.n8313 0.1445
R22076 avss.n8316 avss.n8314 0.1445
R22077 avss.n8316 avss.n8276 0.1445
R22078 avss.n8321 avss.n8276 0.1445
R22079 avss.n8322 avss.n8321 0.1445
R22080 avss.n8324 avss.n8322 0.1445
R22081 avss.n8324 avss.n8274 0.1445
R22082 avss.n8329 avss.n8274 0.1445
R22083 avss.n8330 avss.n8329 0.1445
R22084 avss.n8332 avss.n8330 0.1445
R22085 avss.n8332 avss.n8272 0.1445
R22086 avss.n8337 avss.n8272 0.1445
R22087 avss.n8338 avss.n8337 0.1445
R22088 avss.n8340 avss.n8338 0.1445
R22089 avss.n8340 avss.n8270 0.1445
R22090 avss.n8345 avss.n8270 0.1445
R22091 avss.n8346 avss.n8345 0.1445
R22092 avss.n8348 avss.n8346 0.1445
R22093 avss.n8348 avss.n8268 0.1445
R22094 avss.n8353 avss.n8268 0.1445
R22095 avss.n8354 avss.n8353 0.1445
R22096 avss.n8355 avss.n8354 0.1445
R22097 avss.n8355 avss.n8266 0.1445
R22098 avss.n8387 avss.n8266 0.1445
R22099 avss.n8387 avss.n8386 0.1445
R22100 avss.n8386 avss.n8385 0.1445
R22101 avss.n8385 avss.n8384 0.1445
R22102 avss.n8384 avss.n8383 0.1445
R22103 avss.n8383 avss.n8363 0.1445
R22104 avss.n8374 avss.n8363 0.1445
R22105 avss.n8374 avss.n8373 0.1445
R22106 avss.n8373 avss.n114 0.1445
R22107 avss.n9232 avss.n114 0.1445
R22108 avss.n9232 avss.n112 0.1445
R22109 avss.n9236 avss.n112 0.1445
R22110 avss.n9236 avss.n100 0.1445
R22111 avss.n9264 avss.n100 0.1445
R22112 avss.n9264 avss.n98 0.1445
R22113 avss.n9268 avss.n98 0.1445
R22114 avss.n9268 avss.n87 0.1445
R22115 avss.n9281 avss.n87 0.1445
R22116 avss.n9281 avss.n85 0.1445
R22117 avss.n9290 avss.n85 0.1445
R22118 avss.n9290 avss.n9289 0.1445
R22119 avss.n9289 avss.n9288 0.1445
R22120 avss.n9288 avss.n9287 0.1445
R22121 avss.n9245 avss.n9242 0.1445
R22122 avss.n9244 avss.n9240 0.1445
R22123 avss.n9310 avss.n9306 0.1445
R22124 avss.n9309 avss.n9307 0.1445
R22125 avss.n8895 avss.n7491 0.1445
R22126 avss.n7493 avss.n7491 0.1445
R22127 avss.n8285 avss.n7493 0.1445
R22128 avss.n8286 avss.n8285 0.1445
R22129 avss.n8287 avss.n8286 0.1445
R22130 avss.n8287 avss.n8283 0.1445
R22131 avss.n8293 avss.n8283 0.1445
R22132 avss.n8294 avss.n8293 0.1445
R22133 avss.n8295 avss.n8294 0.1445
R22134 avss.n8295 avss.n8281 0.1445
R22135 avss.n8301 avss.n8281 0.1445
R22136 avss.n8302 avss.n8301 0.1445
R22137 avss.n8303 avss.n8302 0.1445
R22138 avss.n8303 avss.n8279 0.1445
R22139 avss.n8309 avss.n8279 0.1445
R22140 avss.n8310 avss.n8309 0.1445
R22141 avss.n8311 avss.n8310 0.1445
R22142 avss.n8311 avss.n8277 0.1445
R22143 avss.n8317 avss.n8277 0.1445
R22144 avss.n8318 avss.n8317 0.1445
R22145 avss.n8319 avss.n8318 0.1445
R22146 avss.n8319 avss.n8275 0.1445
R22147 avss.n8325 avss.n8275 0.1445
R22148 avss.n8326 avss.n8325 0.1445
R22149 avss.n8327 avss.n8326 0.1445
R22150 avss.n8327 avss.n8273 0.1445
R22151 avss.n8333 avss.n8273 0.1445
R22152 avss.n8334 avss.n8333 0.1445
R22153 avss.n8335 avss.n8334 0.1445
R22154 avss.n8335 avss.n8271 0.1445
R22155 avss.n8341 avss.n8271 0.1445
R22156 avss.n8342 avss.n8341 0.1445
R22157 avss.n8343 avss.n8342 0.1445
R22158 avss.n8343 avss.n8269 0.1445
R22159 avss.n8349 avss.n8269 0.1445
R22160 avss.n8350 avss.n8349 0.1445
R22161 avss.n8351 avss.n8350 0.1445
R22162 avss.n8351 avss.n8267 0.1445
R22163 avss.n8356 avss.n8267 0.1445
R22164 avss.n8357 avss.n8356 0.1445
R22165 avss.n8358 avss.n8357 0.1445
R22166 avss.n8359 avss.n8358 0.1445
R22167 avss.n8360 avss.n8359 0.1445
R22168 avss.n8361 avss.n8360 0.1445
R22169 avss.n8362 avss.n8361 0.1445
R22170 avss.n8370 avss.n8362 0.1445
R22171 avss.n8371 avss.n8370 0.1445
R22172 avss.n8372 avss.n8371 0.1445
R22173 avss.n8372 avss.n113 0.1445
R22174 avss.n9233 avss.n113 0.1445
R22175 avss.n9234 avss.n9233 0.1445
R22176 avss.n9235 avss.n9234 0.1445
R22177 avss.n9235 avss.n99 0.1445
R22178 avss.n9265 avss.n99 0.1445
R22179 avss.n9266 avss.n9265 0.1445
R22180 avss.n9267 avss.n9266 0.1445
R22181 avss.n9267 avss.n86 0.1445
R22182 avss.n9282 avss.n86 0.1445
R22183 avss.n9283 avss.n9282 0.1445
R22184 avss.n9284 avss.n9283 0.1445
R22185 avss.n9285 avss.n9284 0.1445
R22186 avss.n9286 avss.n9285 0.1445
R22187 avss.n9286 avss.n69 0.1445
R22188 avss.n7506 avss.n7490 0.1445
R22189 avss.n7507 avss.n7506 0.1445
R22190 avss.n7508 avss.n7507 0.1445
R22191 avss.n7509 avss.n7508 0.1445
R22192 avss.n7531 avss.n7509 0.1445
R22193 avss.n7532 avss.n7531 0.1445
R22194 avss.n7533 avss.n7532 0.1445
R22195 avss.n7534 avss.n7533 0.1445
R22196 avss.n7555 avss.n7534 0.1445
R22197 avss.n7556 avss.n7555 0.1445
R22198 avss.n7557 avss.n7556 0.1445
R22199 avss.n7558 avss.n7557 0.1445
R22200 avss.n7579 avss.n7558 0.1445
R22201 avss.n7580 avss.n7579 0.1445
R22202 avss.n7581 avss.n7580 0.1445
R22203 avss.n7582 avss.n7581 0.1445
R22204 avss.n7603 avss.n7582 0.1445
R22205 avss.n7604 avss.n7603 0.1445
R22206 avss.n7605 avss.n7604 0.1445
R22207 avss.n7606 avss.n7605 0.1445
R22208 avss.n7627 avss.n7606 0.1445
R22209 avss.n7628 avss.n7627 0.1445
R22210 avss.n7629 avss.n7628 0.1445
R22211 avss.n7630 avss.n7629 0.1445
R22212 avss.n7651 avss.n7630 0.1445
R22213 avss.n7652 avss.n7651 0.1445
R22214 avss.n7653 avss.n7652 0.1445
R22215 avss.n7654 avss.n7653 0.1445
R22216 avss.n7675 avss.n7654 0.1445
R22217 avss.n7676 avss.n7675 0.1445
R22218 avss.n7677 avss.n7676 0.1445
R22219 avss.n7678 avss.n7677 0.1445
R22220 avss.n7699 avss.n7678 0.1445
R22221 avss.n7700 avss.n7699 0.1445
R22222 avss.n7701 avss.n7700 0.1445
R22223 avss.n7702 avss.n7701 0.1445
R22224 avss.n7723 avss.n7702 0.1445
R22225 avss.n7724 avss.n7723 0.1445
R22226 avss.n7725 avss.n7724 0.1445
R22227 avss.n7726 avss.n7725 0.1445
R22228 avss.n7749 avss.n7726 0.1445
R22229 avss.n7750 avss.n7749 0.1445
R22230 avss.n7751 avss.n7750 0.1445
R22231 avss.n7752 avss.n7751 0.1445
R22232 avss.n8365 avss.n7752 0.1445
R22233 avss.n8366 avss.n8365 0.1445
R22234 avss.n8366 avss.n120 0.1445
R22235 avss.n9225 avss.n120 0.1445
R22236 avss.n9226 avss.n9225 0.1445
R22237 avss.n9227 avss.n9226 0.1445
R22238 avss.n9227 avss.n107 0.1445
R22239 avss.n9257 avss.n107 0.1445
R22240 avss.n9258 avss.n9257 0.1445
R22241 avss.n9259 avss.n9258 0.1445
R22242 avss.n9259 avss.n93 0.1445
R22243 avss.n9274 avss.n93 0.1445
R22244 avss.n9275 avss.n9274 0.1445
R22245 avss.n9276 avss.n9275 0.1445
R22246 avss.n9276 avss.n79 0.1445
R22247 avss.n9296 avss.n79 0.1445
R22248 avss.n9297 avss.n9296 0.1445
R22249 avss.n9298 avss.n9297 0.1445
R22250 avss.n9299 avss.n9298 0.1445
R22251 avss.n7505 avss.n7504 0.1445
R22252 avss.n8888 avss.n7505 0.1445
R22253 avss.n8888 avss.n8887 0.1445
R22254 avss.n8887 avss.n8886 0.1445
R22255 avss.n8886 avss.n7510 0.1445
R22256 avss.n8876 avss.n7510 0.1445
R22257 avss.n8876 avss.n8875 0.1445
R22258 avss.n8875 avss.n8874 0.1445
R22259 avss.n8874 avss.n7535 0.1445
R22260 avss.n8864 avss.n7535 0.1445
R22261 avss.n8864 avss.n8863 0.1445
R22262 avss.n8863 avss.n8862 0.1445
R22263 avss.n8862 avss.n7559 0.1445
R22264 avss.n8852 avss.n7559 0.1445
R22265 avss.n8852 avss.n8851 0.1445
R22266 avss.n8851 avss.n8850 0.1445
R22267 avss.n8850 avss.n7583 0.1445
R22268 avss.n8840 avss.n7583 0.1445
R22269 avss.n8840 avss.n8839 0.1445
R22270 avss.n8839 avss.n8838 0.1445
R22271 avss.n8838 avss.n7607 0.1445
R22272 avss.n8828 avss.n7607 0.1445
R22273 avss.n8828 avss.n8827 0.1445
R22274 avss.n8827 avss.n8826 0.1445
R22275 avss.n8826 avss.n7631 0.1445
R22276 avss.n8816 avss.n7631 0.1445
R22277 avss.n8816 avss.n8815 0.1445
R22278 avss.n8815 avss.n8814 0.1445
R22279 avss.n8814 avss.n7655 0.1445
R22280 avss.n8804 avss.n7655 0.1445
R22281 avss.n8804 avss.n8803 0.1445
R22282 avss.n8803 avss.n8802 0.1445
R22283 avss.n8802 avss.n7679 0.1445
R22284 avss.n8792 avss.n7679 0.1445
R22285 avss.n8792 avss.n8791 0.1445
R22286 avss.n8791 avss.n8790 0.1445
R22287 avss.n8790 avss.n7703 0.1445
R22288 avss.n8780 avss.n7703 0.1445
R22289 avss.n8780 avss.n8779 0.1445
R22290 avss.n8779 avss.n8778 0.1445
R22291 avss.n8778 avss.n7727 0.1445
R22292 avss.n8768 avss.n7727 0.1445
R22293 avss.n8768 avss.n8767 0.1445
R22294 avss.n8767 avss.n8766 0.1445
R22295 avss.n8766 avss.n7753 0.1445
R22296 avss.n8367 avss.n7753 0.1445
R22297 avss.n8367 avss.n121 0.1445
R22298 avss.n9224 avss.n121 0.1445
R22299 avss.n9224 avss.n119 0.1445
R22300 avss.n9228 avss.n119 0.1445
R22301 avss.n9228 avss.n108 0.1445
R22302 avss.n9256 avss.n108 0.1445
R22303 avss.n9256 avss.n106 0.1445
R22304 avss.n9260 avss.n106 0.1445
R22305 avss.n9260 avss.n94 0.1445
R22306 avss.n9273 avss.n94 0.1445
R22307 avss.n9273 avss.n92 0.1445
R22308 avss.n9277 avss.n92 0.1445
R22309 avss.n9277 avss.n80 0.1445
R22310 avss.n9295 avss.n80 0.1445
R22311 avss.n9295 avss.n78 0.1445
R22312 avss.n9301 avss.n78 0.1445
R22313 avss.n9301 avss.n9300 0.1445
R22314 avss.n8906 avss.n367 0.1445
R22315 avss.n8910 avss.n367 0.1445
R22316 avss.n8910 avss.n357 0.1445
R22317 avss.n8922 avss.n357 0.1445
R22318 avss.n8922 avss.n355 0.1445
R22319 avss.n8926 avss.n355 0.1445
R22320 avss.n8926 avss.n345 0.1445
R22321 avss.n8938 avss.n345 0.1445
R22322 avss.n8938 avss.n343 0.1445
R22323 avss.n8942 avss.n343 0.1445
R22324 avss.n8942 avss.n333 0.1445
R22325 avss.n8954 avss.n333 0.1445
R22326 avss.n8954 avss.n331 0.1445
R22327 avss.n8958 avss.n331 0.1445
R22328 avss.n8958 avss.n321 0.1445
R22329 avss.n8970 avss.n321 0.1445
R22330 avss.n8970 avss.n319 0.1445
R22331 avss.n8977 avss.n319 0.1445
R22332 avss.n8977 avss.n8976 0.1445
R22333 avss.n8976 avss.n309 0.1445
R22334 avss.n8991 avss.n309 0.1445
R22335 avss.n8992 avss.n8991 0.1445
R22336 avss.n8992 avss.n307 0.1445
R22337 avss.n8996 avss.n307 0.1445
R22338 avss.n8997 avss.n8996 0.1445
R22339 avss.n8998 avss.n8997 0.1445
R22340 avss.n8998 avss.n304 0.1445
R22341 avss.n9002 avss.n304 0.1445
R22342 avss.n9003 avss.n9002 0.1445
R22343 avss.n9004 avss.n9003 0.1445
R22344 avss.n9004 avss.n301 0.1445
R22345 avss.n9008 avss.n301 0.1445
R22346 avss.n9009 avss.n9008 0.1445
R22347 avss.n9010 avss.n9009 0.1445
R22348 avss.n9010 avss.n298 0.1445
R22349 avss.n9014 avss.n298 0.1445
R22350 avss.n9015 avss.n9014 0.1445
R22351 avss.n9016 avss.n9015 0.1445
R22352 avss.n9016 avss.n295 0.1445
R22353 avss.n9020 avss.n295 0.1445
R22354 avss.n9021 avss.n9020 0.1445
R22355 avss.n9022 avss.n9021 0.1445
R22356 avss.n9022 avss.n292 0.1445
R22357 avss.n9079 avss.n292 0.1445
R22358 avss.n9079 avss.n9078 0.1445
R22359 avss.n9078 avss.n9077 0.1445
R22360 avss.n9077 avss.n9076 0.1445
R22361 avss.n9076 avss.n9074 0.1445
R22362 avss.n9074 avss.n9073 0.1445
R22363 avss.n9073 avss.n9071 0.1445
R22364 avss.n9071 avss.n9070 0.1445
R22365 avss.n9070 avss.n9068 0.1445
R22366 avss.n9068 avss.n9067 0.1445
R22367 avss.n9067 avss.n9035 0.1445
R22368 avss.n9056 avss.n9035 0.1445
R22369 avss.n9056 avss.n9055 0.1445
R22370 avss.n9055 avss.n9054 0.1445
R22371 avss.n9054 avss.n9052 0.1445
R22372 avss.n9052 avss.n9051 0.1445
R22373 avss.n9051 avss.n9050 0.1445
R22374 avss.n9050 avss.n9049 0.1445
R22375 avss.n9049 avss.n9046 0.1445
R22376 avss.n9046 avss.n9045 0.1445
R22377 avss.n8902 avss.n363 0.1445
R22378 avss.n8914 avss.n363 0.1445
R22379 avss.n8914 avss.n361 0.1445
R22380 avss.n8918 avss.n361 0.1445
R22381 avss.n8918 avss.n351 0.1445
R22382 avss.n8930 avss.n351 0.1445
R22383 avss.n8930 avss.n349 0.1445
R22384 avss.n8934 avss.n349 0.1445
R22385 avss.n8934 avss.n339 0.1445
R22386 avss.n8946 avss.n339 0.1445
R22387 avss.n8946 avss.n337 0.1445
R22388 avss.n8950 avss.n337 0.1445
R22389 avss.n8950 avss.n327 0.1445
R22390 avss.n8962 avss.n327 0.1445
R22391 avss.n8962 avss.n325 0.1445
R22392 avss.n8966 avss.n325 0.1445
R22393 avss.n8966 avss.n315 0.1445
R22394 avss.n8981 avss.n315 0.1445
R22395 avss.n8981 avss.n313 0.1445
R22396 avss.n8986 avss.n313 0.1445
R22397 avss.n8986 avss.n230 0.1445
R22398 avss.n9125 avss.n230 0.1445
R22399 avss.n9125 avss.n9124 0.1445
R22400 avss.n9124 avss.n9123 0.1445
R22401 avss.n9123 avss.n234 0.1445
R22402 avss.n9117 avss.n234 0.1445
R22403 avss.n9117 avss.n9116 0.1445
R22404 avss.n9116 avss.n9115 0.1445
R22405 avss.n9115 avss.n245 0.1445
R22406 avss.n9109 avss.n245 0.1445
R22407 avss.n9109 avss.n9108 0.1445
R22408 avss.n9108 avss.n9107 0.1445
R22409 avss.n9107 avss.n256 0.1445
R22410 avss.n9101 avss.n256 0.1445
R22411 avss.n9101 avss.n9100 0.1445
R22412 avss.n9100 avss.n9099 0.1445
R22413 avss.n9099 avss.n267 0.1445
R22414 avss.n9093 avss.n267 0.1445
R22415 avss.n9093 avss.n9092 0.1445
R22416 avss.n9092 avss.n9091 0.1445
R22417 avss.n9091 avss.n278 0.1445
R22418 avss.n9085 avss.n278 0.1445
R22419 avss.n9085 avss.n9084 0.1445
R22420 avss.n9084 avss.n9083 0.1445
R22421 avss.n9083 avss.n156 0.1445
R22422 avss.n9190 avss.n156 0.1445
R22423 avss.n9190 avss.n9189 0.1445
R22424 avss.n9189 avss.n9188 0.1445
R22425 avss.n9188 avss.n160 0.1445
R22426 avss.n9175 avss.n160 0.1445
R22427 avss.n9175 avss.n9174 0.1445
R22428 avss.n9174 avss.n9173 0.1445
R22429 avss.n9173 avss.n173 0.1445
R22430 avss.n9062 avss.n173 0.1445
R22431 avss.n9062 avss.n188 0.1445
R22432 avss.n9156 avss.n188 0.1445
R22433 avss.n9156 avss.n9155 0.1445
R22434 avss.n9155 avss.n9154 0.1445
R22435 avss.n9154 avss.n192 0.1445
R22436 avss.n9147 avss.n192 0.1445
R22437 avss.n9147 avss.n9146 0.1445
R22438 avss.n9146 avss.n9145 0.1445
R22439 avss.n9145 avss.n205 0.1445
R22440 avss.n8901 avss.n362 0.1445
R22441 avss.n8915 avss.n362 0.1445
R22442 avss.n8916 avss.n8915 0.1445
R22443 avss.n8917 avss.n8916 0.1445
R22444 avss.n8917 avss.n350 0.1445
R22445 avss.n8931 avss.n350 0.1445
R22446 avss.n8932 avss.n8931 0.1445
R22447 avss.n8933 avss.n8932 0.1445
R22448 avss.n8933 avss.n338 0.1445
R22449 avss.n8947 avss.n338 0.1445
R22450 avss.n8948 avss.n8947 0.1445
R22451 avss.n8949 avss.n8948 0.1445
R22452 avss.n8949 avss.n326 0.1445
R22453 avss.n8963 avss.n326 0.1445
R22454 avss.n8964 avss.n8963 0.1445
R22455 avss.n8965 avss.n8964 0.1445
R22456 avss.n8965 avss.n314 0.1445
R22457 avss.n8982 avss.n314 0.1445
R22458 avss.n8983 avss.n8982 0.1445
R22459 avss.n8985 avss.n8983 0.1445
R22460 avss.n8985 avss.n8984 0.1445
R22461 avss.n8984 avss.n231 0.1445
R22462 avss.n232 avss.n231 0.1445
R22463 avss.n233 avss.n232 0.1445
R22464 avss.n241 avss.n233 0.1445
R22465 avss.n242 avss.n241 0.1445
R22466 avss.n243 avss.n242 0.1445
R22467 avss.n244 avss.n243 0.1445
R22468 avss.n252 avss.n244 0.1445
R22469 avss.n253 avss.n252 0.1445
R22470 avss.n254 avss.n253 0.1445
R22471 avss.n255 avss.n254 0.1445
R22472 avss.n263 avss.n255 0.1445
R22473 avss.n264 avss.n263 0.1445
R22474 avss.n265 avss.n264 0.1445
R22475 avss.n266 avss.n265 0.1445
R22476 avss.n274 avss.n266 0.1445
R22477 avss.n275 avss.n274 0.1445
R22478 avss.n276 avss.n275 0.1445
R22479 avss.n277 avss.n276 0.1445
R22480 avss.n285 avss.n277 0.1445
R22481 avss.n286 avss.n285 0.1445
R22482 avss.n287 avss.n286 0.1445
R22483 avss.n289 avss.n287 0.1445
R22484 avss.n289 avss.n288 0.1445
R22485 avss.n288 avss.n157 0.1445
R22486 avss.n158 avss.n157 0.1445
R22487 avss.n159 avss.n158 0.1445
R22488 avss.n169 avss.n159 0.1445
R22489 avss.n170 avss.n169 0.1445
R22490 avss.n171 avss.n170 0.1445
R22491 avss.n172 avss.n171 0.1445
R22492 avss.n9059 avss.n172 0.1445
R22493 avss.n9061 avss.n9059 0.1445
R22494 avss.n9061 avss.n9060 0.1445
R22495 avss.n9060 avss.n189 0.1445
R22496 avss.n190 avss.n189 0.1445
R22497 avss.n191 avss.n190 0.1445
R22498 avss.n201 avss.n191 0.1445
R22499 avss.n202 avss.n201 0.1445
R22500 avss.n203 avss.n202 0.1445
R22501 avss.n204 avss.n203 0.1445
R22502 avss.n220 avss.n204 0.1445
R22503 avss.n8908 avss.n8907 0.1445
R22504 avss.n8909 avss.n8908 0.1445
R22505 avss.n8909 avss.n356 0.1445
R22506 avss.n8923 avss.n356 0.1445
R22507 avss.n8924 avss.n8923 0.1445
R22508 avss.n8925 avss.n8924 0.1445
R22509 avss.n8925 avss.n344 0.1445
R22510 avss.n8939 avss.n344 0.1445
R22511 avss.n8940 avss.n8939 0.1445
R22512 avss.n8941 avss.n8940 0.1445
R22513 avss.n8941 avss.n332 0.1445
R22514 avss.n8955 avss.n332 0.1445
R22515 avss.n8956 avss.n8955 0.1445
R22516 avss.n8957 avss.n8956 0.1445
R22517 avss.n8957 avss.n320 0.1445
R22518 avss.n8971 avss.n320 0.1445
R22519 avss.n8972 avss.n8971 0.1445
R22520 avss.n8973 avss.n8972 0.1445
R22521 avss.n8975 avss.n8973 0.1445
R22522 avss.n8975 avss.n8974 0.1445
R22523 avss.n8974 avss.n308 0.1445
R22524 avss.n8993 avss.n308 0.1445
R22525 avss.n8994 avss.n8993 0.1445
R22526 avss.n8995 avss.n8994 0.1445
R22527 avss.n8995 avss.n305 0.1445
R22528 avss.n8999 avss.n305 0.1445
R22529 avss.n9000 avss.n8999 0.1445
R22530 avss.n9001 avss.n9000 0.1445
R22531 avss.n9001 avss.n302 0.1445
R22532 avss.n9005 avss.n302 0.1445
R22533 avss.n9006 avss.n9005 0.1445
R22534 avss.n9007 avss.n9006 0.1445
R22535 avss.n9007 avss.n299 0.1445
R22536 avss.n9011 avss.n299 0.1445
R22537 avss.n9012 avss.n9011 0.1445
R22538 avss.n9013 avss.n9012 0.1445
R22539 avss.n9013 avss.n296 0.1445
R22540 avss.n9017 avss.n296 0.1445
R22541 avss.n9018 avss.n9017 0.1445
R22542 avss.n9019 avss.n9018 0.1445
R22543 avss.n9019 avss.n293 0.1445
R22544 avss.n9023 avss.n293 0.1445
R22545 avss.n9024 avss.n9023 0.1445
R22546 avss.n9025 avss.n9024 0.1445
R22547 avss.n9026 avss.n9025 0.1445
R22548 avss.n9027 avss.n9026 0.1445
R22549 avss.n9028 avss.n9027 0.1445
R22550 avss.n9029 avss.n9028 0.1445
R22551 avss.n9030 avss.n9029 0.1445
R22552 avss.n9031 avss.n9030 0.1445
R22553 avss.n9032 avss.n9031 0.1445
R22554 avss.n9033 avss.n9032 0.1445
R22555 avss.n9034 avss.n9033 0.1445
R22556 avss.n9036 avss.n9034 0.1445
R22557 avss.n9037 avss.n9036 0.1445
R22558 avss.n9038 avss.n9037 0.1445
R22559 avss.n9039 avss.n9038 0.1445
R22560 avss.n9040 avss.n9039 0.1445
R22561 avss.n9041 avss.n9040 0.1445
R22562 avss.n9042 avss.n9041 0.1445
R22563 avss.n9043 avss.n9042 0.1445
R22564 avss.n9044 avss.n9043 0.1445
R22565 avss.n9044 avss.n219 0.1445
R22566 avss.n9140 avss.n213 0.1445
R22567 avss.n9139 avss.n214 0.1445
R22568 avss.n9162 avss.n9159 0.1445
R22569 avss.n9161 avss.n180 0.1445
R22570 avss.n9182 avss.n148 0.1445
R22571 avss.n9183 avss.n9180 0.1445
R22572 avss.n8180 avss.n8177 0.1445
R22573 avss.n8177 avss.n8176 0.1445
R22574 avss.n8176 avss.n8175 0.1445
R22575 avss.n8175 avss.n8173 0.1445
R22576 avss.n8173 avss.n8172 0.1445
R22577 avss.n8172 avss.n8170 0.1445
R22578 avss.n8170 avss.n8169 0.1445
R22579 avss.n8169 avss.n8167 0.1445
R22580 avss.n8167 avss.n8166 0.1445
R22581 avss.n8166 avss.n8164 0.1445
R22582 avss.n8164 avss.n8163 0.1445
R22583 avss.n8163 avss.n8161 0.1445
R22584 avss.n8161 avss.n8160 0.1445
R22585 avss.n8160 avss.n8158 0.1445
R22586 avss.n8158 avss.n8157 0.1445
R22587 avss.n8157 avss.n8155 0.1445
R22588 avss.n8155 avss.n8154 0.1445
R22589 avss.n8154 avss.n8152 0.1445
R22590 avss.n8152 avss.n8151 0.1445
R22591 avss.n8151 avss.n8149 0.1445
R22592 avss.n8149 avss.n8148 0.1445
R22593 avss.n8148 avss.n8146 0.1445
R22594 avss.n8146 avss.n8145 0.1445
R22595 avss.n8145 avss.n8143 0.1445
R22596 avss.n8143 avss.n8142 0.1445
R22597 avss.n8142 avss.n8140 0.1445
R22598 avss.n8140 avss.n8139 0.1445
R22599 avss.n8139 avss.n8137 0.1445
R22600 avss.n8137 avss.n8136 0.1445
R22601 avss.n8136 avss.n8134 0.1445
R22602 avss.n8134 avss.n8133 0.1445
R22603 avss.n8133 avss.n8131 0.1445
R22604 avss.n8131 avss.n8130 0.1445
R22605 avss.n8130 avss.n8128 0.1445
R22606 avss.n8128 avss.n8127 0.1445
R22607 avss.n8127 avss.n8125 0.1445
R22608 avss.n8125 avss.n8124 0.1445
R22609 avss.n8124 avss.n7943 0.1445
R22610 avss.n8514 avss.n7943 0.1445
R22611 avss.n8515 avss.n8514 0.1445
R22612 avss.n8515 avss.n7941 0.1445
R22613 avss.n8519 avss.n7941 0.1445
R22614 avss.n8520 avss.n8519 0.1445
R22615 avss.n8521 avss.n8520 0.1445
R22616 avss.n8521 avss.n7939 0.1445
R22617 avss.n8525 avss.n7939 0.1445
R22618 avss.n8525 avss.n7938 0.1445
R22619 avss.n8536 avss.n7938 0.1445
R22620 avss.n8536 avss.n7936 0.1445
R22621 avss.n8541 avss.n7936 0.1445
R22622 avss.n8542 avss.n8541 0.1445
R22623 avss.n8543 avss.n8542 0.1445
R22624 avss.n8543 avss.n7934 0.1445
R22625 avss.n8547 avss.n7934 0.1445
R22626 avss.n8547 avss.n7916 0.1445
R22627 avss.n8561 avss.n7916 0.1445
R22628 avss.n8561 avss.n7914 0.1445
R22629 avss.n8567 avss.n7914 0.1445
R22630 avss.n8567 avss.n8566 0.1445
R22631 avss.n8566 avss.n7903 0.1445
R22632 avss.n8581 avss.n7903 0.1445
R22633 avss.n8581 avss.n7901 0.1445
R22634 avss.n8585 avss.n7901 0.1445
R22635 avss.n8187 avss.n8184 0.1445
R22636 avss.n8187 avss.n8084 0.1445
R22637 avss.n8192 avss.n8084 0.1445
R22638 avss.n8193 avss.n8192 0.1445
R22639 avss.n8195 avss.n8193 0.1445
R22640 avss.n8195 avss.n8082 0.1445
R22641 avss.n8200 avss.n8082 0.1445
R22642 avss.n8201 avss.n8200 0.1445
R22643 avss.n8203 avss.n8201 0.1445
R22644 avss.n8203 avss.n8080 0.1445
R22645 avss.n8208 avss.n8080 0.1445
R22646 avss.n8209 avss.n8208 0.1445
R22647 avss.n8211 avss.n8209 0.1445
R22648 avss.n8211 avss.n8078 0.1445
R22649 avss.n8216 avss.n8078 0.1445
R22650 avss.n8217 avss.n8216 0.1445
R22651 avss.n8219 avss.n8217 0.1445
R22652 avss.n8219 avss.n8076 0.1445
R22653 avss.n8224 avss.n8076 0.1445
R22654 avss.n8225 avss.n8224 0.1445
R22655 avss.n8227 avss.n8225 0.1445
R22656 avss.n8227 avss.n8074 0.1445
R22657 avss.n8232 avss.n8074 0.1445
R22658 avss.n8233 avss.n8232 0.1445
R22659 avss.n8235 avss.n8233 0.1445
R22660 avss.n8235 avss.n8072 0.1445
R22661 avss.n8240 avss.n8072 0.1445
R22662 avss.n8241 avss.n8240 0.1445
R22663 avss.n8243 avss.n8241 0.1445
R22664 avss.n8243 avss.n8070 0.1445
R22665 avss.n8248 avss.n8070 0.1445
R22666 avss.n8249 avss.n8248 0.1445
R22667 avss.n8251 avss.n8249 0.1445
R22668 avss.n8251 avss.n8068 0.1445
R22669 avss.n8256 avss.n8068 0.1445
R22670 avss.n8257 avss.n8256 0.1445
R22671 avss.n8259 avss.n8257 0.1445
R22672 avss.n8259 avss.n8066 0.1445
R22673 avss.n8510 avss.n8066 0.1445
R22674 avss.n8510 avss.n8509 0.1445
R22675 avss.n8509 avss.n8508 0.1445
R22676 avss.n8508 avss.n7852 0.1445
R22677 avss.n8639 avss.n7852 0.1445
R22678 avss.n8639 avss.n8638 0.1445
R22679 avss.n8638 avss.n8637 0.1445
R22680 avss.n8637 avss.n7856 0.1445
R22681 avss.n8531 avss.n7856 0.1445
R22682 avss.n8531 avss.n7873 0.1445
R22683 avss.n8620 avss.n7873 0.1445
R22684 avss.n8620 avss.n8619 0.1445
R22685 avss.n8619 avss.n8618 0.1445
R22686 avss.n8618 avss.n7877 0.1445
R22687 avss.n7931 avss.n7877 0.1445
R22688 avss.n8553 avss.n7931 0.1445
R22689 avss.n8553 avss.n7928 0.1445
R22690 avss.n8557 avss.n7928 0.1445
R22691 avss.n8557 avss.n7910 0.1445
R22692 avss.n8571 avss.n7910 0.1445
R22693 avss.n8571 avss.n7908 0.1445
R22694 avss.n8576 avss.n7908 0.1445
R22695 avss.n8576 avss.n7899 0.1445
R22696 avss.n8593 avss.n7899 0.1445
R22697 avss.n8593 avss.n8592 0.1445
R22698 avss.n8188 avss.n8183 0.1445
R22699 avss.n8189 avss.n8188 0.1445
R22700 avss.n8190 avss.n8189 0.1445
R22701 avss.n8190 avss.n8083 0.1445
R22702 avss.n8196 avss.n8083 0.1445
R22703 avss.n8197 avss.n8196 0.1445
R22704 avss.n8198 avss.n8197 0.1445
R22705 avss.n8198 avss.n8081 0.1445
R22706 avss.n8204 avss.n8081 0.1445
R22707 avss.n8205 avss.n8204 0.1445
R22708 avss.n8206 avss.n8205 0.1445
R22709 avss.n8206 avss.n8079 0.1445
R22710 avss.n8212 avss.n8079 0.1445
R22711 avss.n8213 avss.n8212 0.1445
R22712 avss.n8214 avss.n8213 0.1445
R22713 avss.n8214 avss.n8077 0.1445
R22714 avss.n8220 avss.n8077 0.1445
R22715 avss.n8221 avss.n8220 0.1445
R22716 avss.n8222 avss.n8221 0.1445
R22717 avss.n8222 avss.n8075 0.1445
R22718 avss.n8228 avss.n8075 0.1445
R22719 avss.n8229 avss.n8228 0.1445
R22720 avss.n8230 avss.n8229 0.1445
R22721 avss.n8230 avss.n8073 0.1445
R22722 avss.n8236 avss.n8073 0.1445
R22723 avss.n8237 avss.n8236 0.1445
R22724 avss.n8238 avss.n8237 0.1445
R22725 avss.n8238 avss.n8071 0.1445
R22726 avss.n8244 avss.n8071 0.1445
R22727 avss.n8245 avss.n8244 0.1445
R22728 avss.n8246 avss.n8245 0.1445
R22729 avss.n8246 avss.n8069 0.1445
R22730 avss.n8252 avss.n8069 0.1445
R22731 avss.n8253 avss.n8252 0.1445
R22732 avss.n8254 avss.n8253 0.1445
R22733 avss.n8254 avss.n8067 0.1445
R22734 avss.n8260 avss.n8067 0.1445
R22735 avss.n8261 avss.n8260 0.1445
R22736 avss.n8262 avss.n8261 0.1445
R22737 avss.n8263 avss.n8262 0.1445
R22738 avss.n8265 avss.n8263 0.1445
R22739 avss.n8265 avss.n8264 0.1445
R22740 avss.n8264 avss.n7853 0.1445
R22741 avss.n7854 avss.n7853 0.1445
R22742 avss.n7855 avss.n7854 0.1445
R22743 avss.n8528 avss.n7855 0.1445
R22744 avss.n8530 avss.n8528 0.1445
R22745 avss.n8530 avss.n8529 0.1445
R22746 avss.n8529 avss.n7874 0.1445
R22747 avss.n7875 avss.n7874 0.1445
R22748 avss.n7876 avss.n7875 0.1445
R22749 avss.n7929 avss.n7876 0.1445
R22750 avss.n7930 avss.n7929 0.1445
R22751 avss.n8554 avss.n7930 0.1445
R22752 avss.n8555 avss.n8554 0.1445
R22753 avss.n8556 avss.n8555 0.1445
R22754 avss.n8556 avss.n7909 0.1445
R22755 avss.n8572 avss.n7909 0.1445
R22756 avss.n8573 avss.n8572 0.1445
R22757 avss.n8575 avss.n8573 0.1445
R22758 avss.n8575 avss.n8574 0.1445
R22759 avss.n8574 avss.n7900 0.1445
R22760 avss.n8591 avss.n7900 0.1445
R22761 avss.n8181 avss.n8085 0.1445
R22762 avss.n8086 avss.n8085 0.1445
R22763 avss.n8087 avss.n8086 0.1445
R22764 avss.n8088 avss.n8087 0.1445
R22765 avss.n8089 avss.n8088 0.1445
R22766 avss.n8090 avss.n8089 0.1445
R22767 avss.n8091 avss.n8090 0.1445
R22768 avss.n8092 avss.n8091 0.1445
R22769 avss.n8093 avss.n8092 0.1445
R22770 avss.n8094 avss.n8093 0.1445
R22771 avss.n8095 avss.n8094 0.1445
R22772 avss.n8096 avss.n8095 0.1445
R22773 avss.n8097 avss.n8096 0.1445
R22774 avss.n8098 avss.n8097 0.1445
R22775 avss.n8099 avss.n8098 0.1445
R22776 avss.n8100 avss.n8099 0.1445
R22777 avss.n8101 avss.n8100 0.1445
R22778 avss.n8102 avss.n8101 0.1445
R22779 avss.n8103 avss.n8102 0.1445
R22780 avss.n8104 avss.n8103 0.1445
R22781 avss.n8105 avss.n8104 0.1445
R22782 avss.n8106 avss.n8105 0.1445
R22783 avss.n8107 avss.n8106 0.1445
R22784 avss.n8108 avss.n8107 0.1445
R22785 avss.n8109 avss.n8108 0.1445
R22786 avss.n8110 avss.n8109 0.1445
R22787 avss.n8111 avss.n8110 0.1445
R22788 avss.n8112 avss.n8111 0.1445
R22789 avss.n8113 avss.n8112 0.1445
R22790 avss.n8114 avss.n8113 0.1445
R22791 avss.n8115 avss.n8114 0.1445
R22792 avss.n8116 avss.n8115 0.1445
R22793 avss.n8117 avss.n8116 0.1445
R22794 avss.n8118 avss.n8117 0.1445
R22795 avss.n8119 avss.n8118 0.1445
R22796 avss.n8120 avss.n8119 0.1445
R22797 avss.n8122 avss.n8120 0.1445
R22798 avss.n8122 avss.n8121 0.1445
R22799 avss.n8121 avss.n7942 0.1445
R22800 avss.n8516 avss.n7942 0.1445
R22801 avss.n8517 avss.n8516 0.1445
R22802 avss.n8518 avss.n8517 0.1445
R22803 avss.n8518 avss.n7940 0.1445
R22804 avss.n8522 avss.n7940 0.1445
R22805 avss.n8523 avss.n8522 0.1445
R22806 avss.n8524 avss.n8523 0.1445
R22807 avss.n8524 avss.n7937 0.1445
R22808 avss.n8537 avss.n7937 0.1445
R22809 avss.n8538 avss.n8537 0.1445
R22810 avss.n8539 avss.n8538 0.1445
R22811 avss.n8539 avss.n7935 0.1445
R22812 avss.n8544 avss.n7935 0.1445
R22813 avss.n8545 avss.n8544 0.1445
R22814 avss.n8546 avss.n8545 0.1445
R22815 avss.n8546 avss.n7915 0.1445
R22816 avss.n8562 avss.n7915 0.1445
R22817 avss.n8563 avss.n8562 0.1445
R22818 avss.n8564 avss.n8563 0.1445
R22819 avss.n8565 avss.n8564 0.1445
R22820 avss.n8565 avss.n7902 0.1445
R22821 avss.n8582 avss.n7902 0.1445
R22822 avss.n8583 avss.n8582 0.1445
R22823 avss.n8584 avss.n8583 0.1445
R22824 avss.n8602 avss.n8598 0.1445
R22825 avss.n8601 avss.n8599 0.1445
R22826 avss.n7923 avss.n7920 0.1445
R22827 avss.n7922 avss.n7885 0.1445
R22828 avss.n8625 avss.n7862 0.1445
R22829 avss.n8626 avss.n8623 0.1445
R22830 avss.n8424 avss.n8409 0.1445
R22831 avss.n8425 avss.n8424 0.1445
R22832 avss.n8427 avss.n8425 0.1445
R22833 avss.n8427 avss.n8407 0.1445
R22834 avss.n8432 avss.n8407 0.1445
R22835 avss.n8433 avss.n8432 0.1445
R22836 avss.n8435 avss.n8433 0.1445
R22837 avss.n8435 avss.n8405 0.1445
R22838 avss.n8440 avss.n8405 0.1445
R22839 avss.n8441 avss.n8440 0.1445
R22840 avss.n8443 avss.n8441 0.1445
R22841 avss.n8443 avss.n8403 0.1445
R22842 avss.n8448 avss.n8403 0.1445
R22843 avss.n8449 avss.n8448 0.1445
R22844 avss.n8451 avss.n8449 0.1445
R22845 avss.n8451 avss.n8401 0.1445
R22846 avss.n8456 avss.n8401 0.1445
R22847 avss.n8457 avss.n8456 0.1445
R22848 avss.n8459 avss.n8457 0.1445
R22849 avss.n8459 avss.n8399 0.1445
R22850 avss.n8464 avss.n8399 0.1445
R22851 avss.n8465 avss.n8464 0.1445
R22852 avss.n8467 avss.n8465 0.1445
R22853 avss.n8467 avss.n8397 0.1445
R22854 avss.n8472 avss.n8397 0.1445
R22855 avss.n8473 avss.n8472 0.1445
R22856 avss.n8475 avss.n8473 0.1445
R22857 avss.n8475 avss.n8395 0.1445
R22858 avss.n8480 avss.n8395 0.1445
R22859 avss.n8481 avss.n8480 0.1445
R22860 avss.n8483 avss.n8481 0.1445
R22861 avss.n8483 avss.n8393 0.1445
R22862 avss.n8488 avss.n8393 0.1445
R22863 avss.n8489 avss.n8488 0.1445
R22864 avss.n8491 avss.n8489 0.1445
R22865 avss.n8491 avss.n8391 0.1445
R22866 avss.n8496 avss.n8391 0.1445
R22867 avss.n8497 avss.n8496 0.1445
R22868 avss.n8498 avss.n8497 0.1445
R22869 avss.n8498 avss.n8389 0.1445
R22870 avss.n8503 avss.n8389 0.1445
R22871 avss.n8503 avss.n7849 0.1445
R22872 avss.n8643 avss.n7849 0.1445
R22873 avss.n8644 avss.n8643 0.1445
R22874 avss.n8644 avss.n7847 0.1445
R22875 avss.n8648 avss.n7847 0.1445
R22876 avss.n8649 avss.n8648 0.1445
R22877 avss.n8659 avss.n8649 0.1445
R22878 avss.n8659 avss.n7843 0.1445
R22879 avss.n8663 avss.n7843 0.1445
R22880 avss.n8665 avss.n8663 0.1445
R22881 avss.n8666 avss.n8665 0.1445
R22882 avss.n8666 avss.n7841 0.1445
R22883 avss.n8670 avss.n7841 0.1445
R22884 avss.n8670 avss.n7826 0.1445
R22885 avss.n8684 avss.n7826 0.1445
R22886 avss.n8684 avss.n7824 0.1445
R22887 avss.n8690 avss.n7824 0.1445
R22888 avss.n8690 avss.n8689 0.1445
R22889 avss.n8689 avss.n7813 0.1445
R22890 avss.n8705 avss.n7813 0.1445
R22891 avss.n8705 avss.n7811 0.1445
R22892 avss.n8709 avss.n7811 0.1445
R22893 avss.n8419 avss.n8416 0.1445
R22894 avss.n8416 avss.n8415 0.1445
R22895 avss.n8415 avss.n7519 0.1445
R22896 avss.n8882 avss.n7519 0.1445
R22897 avss.n8882 avss.n8881 0.1445
R22898 avss.n8881 avss.n8880 0.1445
R22899 avss.n8880 avss.n7523 0.1445
R22900 avss.n8870 avss.n7523 0.1445
R22901 avss.n8870 avss.n8869 0.1445
R22902 avss.n8869 avss.n8868 0.1445
R22903 avss.n8868 avss.n7547 0.1445
R22904 avss.n8858 avss.n7547 0.1445
R22905 avss.n8858 avss.n8857 0.1445
R22906 avss.n8857 avss.n8856 0.1445
R22907 avss.n8856 avss.n7571 0.1445
R22908 avss.n8846 avss.n7571 0.1445
R22909 avss.n8846 avss.n8845 0.1445
R22910 avss.n8845 avss.n8844 0.1445
R22911 avss.n8844 avss.n7595 0.1445
R22912 avss.n8834 avss.n7595 0.1445
R22913 avss.n8834 avss.n8833 0.1445
R22914 avss.n8833 avss.n8832 0.1445
R22915 avss.n8832 avss.n7619 0.1445
R22916 avss.n8822 avss.n7619 0.1445
R22917 avss.n8822 avss.n8821 0.1445
R22918 avss.n8821 avss.n8820 0.1445
R22919 avss.n8820 avss.n7643 0.1445
R22920 avss.n8810 avss.n7643 0.1445
R22921 avss.n8810 avss.n8809 0.1445
R22922 avss.n8809 avss.n8808 0.1445
R22923 avss.n8808 avss.n7667 0.1445
R22924 avss.n8798 avss.n7667 0.1445
R22925 avss.n8798 avss.n8797 0.1445
R22926 avss.n8797 avss.n8796 0.1445
R22927 avss.n8796 avss.n7691 0.1445
R22928 avss.n8786 avss.n7691 0.1445
R22929 avss.n8786 avss.n8785 0.1445
R22930 avss.n8785 avss.n8784 0.1445
R22931 avss.n8784 avss.n7715 0.1445
R22932 avss.n8774 avss.n7715 0.1445
R22933 avss.n8774 avss.n8773 0.1445
R22934 avss.n8773 avss.n8772 0.1445
R22935 avss.n8772 avss.n7740 0.1445
R22936 avss.n8762 avss.n7740 0.1445
R22937 avss.n8762 avss.n8761 0.1445
R22938 avss.n8761 avss.n8760 0.1445
R22939 avss.n8760 avss.n7766 0.1445
R22940 avss.n8655 avss.n7766 0.1445
R22941 avss.n8655 avss.n7784 0.1445
R22942 avss.n8745 avss.n7784 0.1445
R22943 avss.n8745 avss.n8744 0.1445
R22944 avss.n8744 avss.n8743 0.1445
R22945 avss.n8743 avss.n7788 0.1445
R22946 avss.n8676 avss.n7788 0.1445
R22947 avss.n8676 avss.n7838 0.1445
R22948 avss.n8680 avss.n7838 0.1445
R22949 avss.n8680 avss.n7820 0.1445
R22950 avss.n8695 avss.n7820 0.1445
R22951 avss.n8695 avss.n7818 0.1445
R22952 avss.n8700 avss.n7818 0.1445
R22953 avss.n8700 avss.n7809 0.1445
R22954 avss.n8717 avss.n7809 0.1445
R22955 avss.n8717 avss.n8716 0.1445
R22956 avss.n8420 avss.n8412 0.1445
R22957 avss.n8414 avss.n8412 0.1445
R22958 avss.n8414 avss.n8413 0.1445
R22959 avss.n8413 avss.n7520 0.1445
R22960 avss.n7521 avss.n7520 0.1445
R22961 avss.n7522 avss.n7521 0.1445
R22962 avss.n7543 avss.n7522 0.1445
R22963 avss.n7544 avss.n7543 0.1445
R22964 avss.n7545 avss.n7544 0.1445
R22965 avss.n7546 avss.n7545 0.1445
R22966 avss.n7567 avss.n7546 0.1445
R22967 avss.n7568 avss.n7567 0.1445
R22968 avss.n7569 avss.n7568 0.1445
R22969 avss.n7570 avss.n7569 0.1445
R22970 avss.n7591 avss.n7570 0.1445
R22971 avss.n7592 avss.n7591 0.1445
R22972 avss.n7593 avss.n7592 0.1445
R22973 avss.n7594 avss.n7593 0.1445
R22974 avss.n7615 avss.n7594 0.1445
R22975 avss.n7616 avss.n7615 0.1445
R22976 avss.n7617 avss.n7616 0.1445
R22977 avss.n7618 avss.n7617 0.1445
R22978 avss.n7639 avss.n7618 0.1445
R22979 avss.n7640 avss.n7639 0.1445
R22980 avss.n7641 avss.n7640 0.1445
R22981 avss.n7642 avss.n7641 0.1445
R22982 avss.n7663 avss.n7642 0.1445
R22983 avss.n7664 avss.n7663 0.1445
R22984 avss.n7665 avss.n7664 0.1445
R22985 avss.n7666 avss.n7665 0.1445
R22986 avss.n7687 avss.n7666 0.1445
R22987 avss.n7688 avss.n7687 0.1445
R22988 avss.n7689 avss.n7688 0.1445
R22989 avss.n7690 avss.n7689 0.1445
R22990 avss.n7711 avss.n7690 0.1445
R22991 avss.n7712 avss.n7711 0.1445
R22992 avss.n7713 avss.n7712 0.1445
R22993 avss.n7714 avss.n7713 0.1445
R22994 avss.n7736 avss.n7714 0.1445
R22995 avss.n7737 avss.n7736 0.1445
R22996 avss.n7738 avss.n7737 0.1445
R22997 avss.n7739 avss.n7738 0.1445
R22998 avss.n7762 avss.n7739 0.1445
R22999 avss.n7763 avss.n7762 0.1445
R23000 avss.n7764 avss.n7763 0.1445
R23001 avss.n7765 avss.n7764 0.1445
R23002 avss.n8652 avss.n7765 0.1445
R23003 avss.n8654 avss.n8652 0.1445
R23004 avss.n8654 avss.n8653 0.1445
R23005 avss.n8653 avss.n7785 0.1445
R23006 avss.n7786 avss.n7785 0.1445
R23007 avss.n7787 avss.n7786 0.1445
R23008 avss.n7839 avss.n7787 0.1445
R23009 avss.n8677 avss.n7839 0.1445
R23010 avss.n8678 avss.n8677 0.1445
R23011 avss.n8679 avss.n8678 0.1445
R23012 avss.n8679 avss.n7819 0.1445
R23013 avss.n8696 avss.n7819 0.1445
R23014 avss.n8697 avss.n8696 0.1445
R23015 avss.n8699 avss.n8697 0.1445
R23016 avss.n8699 avss.n8698 0.1445
R23017 avss.n8698 avss.n7810 0.1445
R23018 avss.n8715 avss.n7810 0.1445
R23019 avss.n8423 avss.n8422 0.1445
R23020 avss.n8423 avss.n8408 0.1445
R23021 avss.n8428 avss.n8408 0.1445
R23022 avss.n8429 avss.n8428 0.1445
R23023 avss.n8430 avss.n8429 0.1445
R23024 avss.n8430 avss.n8406 0.1445
R23025 avss.n8436 avss.n8406 0.1445
R23026 avss.n8437 avss.n8436 0.1445
R23027 avss.n8438 avss.n8437 0.1445
R23028 avss.n8438 avss.n8404 0.1445
R23029 avss.n8444 avss.n8404 0.1445
R23030 avss.n8445 avss.n8444 0.1445
R23031 avss.n8446 avss.n8445 0.1445
R23032 avss.n8446 avss.n8402 0.1445
R23033 avss.n8452 avss.n8402 0.1445
R23034 avss.n8453 avss.n8452 0.1445
R23035 avss.n8454 avss.n8453 0.1445
R23036 avss.n8454 avss.n8400 0.1445
R23037 avss.n8460 avss.n8400 0.1445
R23038 avss.n8461 avss.n8460 0.1445
R23039 avss.n8462 avss.n8461 0.1445
R23040 avss.n8462 avss.n8398 0.1445
R23041 avss.n8468 avss.n8398 0.1445
R23042 avss.n8469 avss.n8468 0.1445
R23043 avss.n8470 avss.n8469 0.1445
R23044 avss.n8470 avss.n8396 0.1445
R23045 avss.n8476 avss.n8396 0.1445
R23046 avss.n8477 avss.n8476 0.1445
R23047 avss.n8478 avss.n8477 0.1445
R23048 avss.n8478 avss.n8394 0.1445
R23049 avss.n8484 avss.n8394 0.1445
R23050 avss.n8485 avss.n8484 0.1445
R23051 avss.n8486 avss.n8485 0.1445
R23052 avss.n8486 avss.n8392 0.1445
R23053 avss.n8492 avss.n8392 0.1445
R23054 avss.n8493 avss.n8492 0.1445
R23055 avss.n8494 avss.n8493 0.1445
R23056 avss.n8494 avss.n8390 0.1445
R23057 avss.n8499 avss.n8390 0.1445
R23058 avss.n8500 avss.n8499 0.1445
R23059 avss.n8502 avss.n8500 0.1445
R23060 avss.n8502 avss.n8501 0.1445
R23061 avss.n8501 avss.n7848 0.1445
R23062 avss.n8645 avss.n7848 0.1445
R23063 avss.n8646 avss.n8645 0.1445
R23064 avss.n8647 avss.n8646 0.1445
R23065 avss.n8647 avss.n7844 0.1445
R23066 avss.n8660 avss.n7844 0.1445
R23067 avss.n8661 avss.n8660 0.1445
R23068 avss.n8662 avss.n8661 0.1445
R23069 avss.n8662 avss.n7842 0.1445
R23070 avss.n8667 avss.n7842 0.1445
R23071 avss.n8668 avss.n8667 0.1445
R23072 avss.n8669 avss.n8668 0.1445
R23073 avss.n8669 avss.n7825 0.1445
R23074 avss.n8685 avss.n7825 0.1445
R23075 avss.n8686 avss.n8685 0.1445
R23076 avss.n8687 avss.n8686 0.1445
R23077 avss.n8688 avss.n8687 0.1445
R23078 avss.n8688 avss.n7812 0.1445
R23079 avss.n8706 avss.n7812 0.1445
R23080 avss.n8707 avss.n8706 0.1445
R23081 avss.n8708 avss.n8707 0.1445
R23082 avss.n8726 avss.n8722 0.1445
R23083 avss.n8725 avss.n8723 0.1445
R23084 avss.n7833 avss.n7830 0.1445
R23085 avss.n7832 avss.n7795 0.1445
R23086 avss.n8752 avss.n7774 0.1445
R23087 avss.n8754 avss.n8753 0.1445
R23088 avss.n6908 avss.n6907 0.1445
R23089 avss.n6907 avss.n6906 0.1445
R23090 avss.n6906 avss.n6905 0.1445
R23091 avss.n6905 avss.n6903 0.1445
R23092 avss.n6903 avss.n6902 0.1445
R23093 avss.n6902 avss.n1075 0.1445
R23094 avss.n6897 avss.n1075 0.1445
R23095 avss.n6897 avss.n6896 0.1445
R23096 avss.n6896 avss.n6895 0.1445
R23097 avss.n6895 avss.n1087 0.1445
R23098 avss.n1087 avss.n1086 0.1445
R23099 avss.n1086 avss.n1085 0.1445
R23100 avss.n1085 avss.n1084 0.1445
R23101 avss.n6884 avss.n6883 0.1445
R23102 avss.n6883 avss.n1097 0.1445
R23103 avss.n6879 avss.n1097 0.1445
R23104 avss.n6879 avss.n1099 0.1445
R23105 avss.n6818 avss.n1099 0.1445
R23106 avss.n6818 avss.n1142 0.1445
R23107 avss.n6831 avss.n1142 0.1445
R23108 avss.n6831 avss.n1140 0.1445
R23109 avss.n6836 avss.n1140 0.1445
R23110 avss.n6836 avss.n1119 0.1445
R23111 avss.n6865 avss.n1119 0.1445
R23112 avss.n6865 avss.n6864 0.1445
R23113 avss.n6864 avss.n6863 0.1445
R23114 avss.n1153 avss.n1150 0.1445
R23115 avss.n1153 avss.n1147 0.1445
R23116 avss.n1157 avss.n1147 0.1445
R23117 avss.n1158 avss.n1157 0.1445
R23118 avss.n6822 avss.n1158 0.1445
R23119 avss.n6822 avss.n1145 0.1445
R23120 avss.n6826 avss.n1145 0.1445
R23121 avss.n6826 avss.n1135 0.1445
R23122 avss.n6840 avss.n1135 0.1445
R23123 avss.n6840 avss.n1133 0.1445
R23124 avss.n6844 avss.n1133 0.1445
R23125 avss.n6847 avss.n6844 0.1445
R23126 avss.n6848 avss.n6847 0.1445
R23127 avss.n1154 avss.n1149 0.1445
R23128 avss.n1155 avss.n1154 0.1445
R23129 avss.n1156 avss.n1155 0.1445
R23130 avss.n1156 avss.n1146 0.1445
R23131 avss.n6823 avss.n1146 0.1445
R23132 avss.n6824 avss.n6823 0.1445
R23133 avss.n6825 avss.n6824 0.1445
R23134 avss.n6825 avss.n1134 0.1445
R23135 avss.n6841 avss.n1134 0.1445
R23136 avss.n6842 avss.n6841 0.1445
R23137 avss.n6843 avss.n6842 0.1445
R23138 avss.n6843 avss.n1132 0.1445
R23139 avss.n6849 avss.n1132 0.1445
R23140 avss.n6882 avss.n1096 0.1445
R23141 avss.n6882 avss.n6881 0.1445
R23142 avss.n6881 avss.n6880 0.1445
R23143 avss.n6880 avss.n1098 0.1445
R23144 avss.n6817 avss.n1098 0.1445
R23145 avss.n6817 avss.n1141 0.1445
R23146 avss.n6832 avss.n1141 0.1445
R23147 avss.n6833 avss.n6832 0.1445
R23148 avss.n6835 avss.n6833 0.1445
R23149 avss.n6835 avss.n6834 0.1445
R23150 avss.n6834 avss.n1120 0.1445
R23151 avss.n1121 avss.n1120 0.1445
R23152 avss.n1122 avss.n1121 0.1445
R23153 avss.n1129 avss.n1128 0.1445
R23154 avss.n6812 avss.n1161 0.1445
R23155 avss.n6874 avss.n6873 0.1445
R23156 avss.n6872 avss.n1108 0.1445
R23157 avss.n6802 avss.n6801 0.1445
R23158 avss.n6792 avss.n1174 0.1445
R23159 avss.n6788 avss.n6787 0.1445
R23160 avss.n6786 avss.n1169 0.1445
R23161 avss.n7014 avss.n7013 0.1445
R23162 avss.n7013 avss.n980 0.1445
R23163 avss.n7009 avss.n980 0.1445
R23164 avss.n7009 avss.n982 0.1445
R23165 avss.n6349 avss.n6348 0.1445
R23166 avss.n6348 avss.n6347 0.1445
R23167 avss.n6347 avss.n6345 0.1445
R23168 avss.n6345 avss.n1051 0.1445
R23169 avss.n6925 avss.n1051 0.1445
R23170 avss.n6925 avss.n1049 0.1445
R23171 avss.n6931 avss.n1049 0.1445
R23172 avss.n6931 avss.n6930 0.1445
R23173 avss.n6930 avss.n1025 0.1445
R23174 avss.n6967 avss.n1025 0.1445
R23175 avss.n6967 avss.n1023 0.1445
R23176 avss.n6971 avss.n1023 0.1445
R23177 avss.n6972 avss.n6971 0.1445
R23178 avss.n6339 avss.n6337 0.1445
R23179 avss.n6339 avss.n1060 0.1445
R23180 avss.n6915 avss.n1060 0.1445
R23181 avss.n6915 avss.n1058 0.1445
R23182 avss.n6921 avss.n1058 0.1445
R23183 avss.n6921 avss.n6920 0.1445
R23184 avss.n6920 avss.n1035 0.1445
R23185 avss.n6951 avss.n1035 0.1445
R23186 avss.n6951 avss.n1033 0.1445
R23187 avss.n6963 avss.n1033 0.1445
R23188 avss.n6963 avss.n6962 0.1445
R23189 avss.n6962 avss.n6961 0.1445
R23190 avss.n6961 avss.n6959 0.1445
R23191 avss.n6338 avss.n6334 0.1445
R23192 avss.n6338 avss.n1059 0.1445
R23193 avss.n6916 avss.n1059 0.1445
R23194 avss.n6917 avss.n6916 0.1445
R23195 avss.n6918 avss.n6917 0.1445
R23196 avss.n6919 avss.n6918 0.1445
R23197 avss.n6919 avss.n1034 0.1445
R23198 avss.n6952 avss.n1034 0.1445
R23199 avss.n6953 avss.n6952 0.1445
R23200 avss.n6954 avss.n6953 0.1445
R23201 avss.n6955 avss.n6954 0.1445
R23202 avss.n6956 avss.n6955 0.1445
R23203 avss.n6958 avss.n6956 0.1445
R23204 avss.n6350 avss.n6335 0.1445
R23205 avss.n6343 avss.n6335 0.1445
R23206 avss.n6344 avss.n6343 0.1445
R23207 avss.n6344 avss.n1050 0.1445
R23208 avss.n6926 avss.n1050 0.1445
R23209 avss.n6927 avss.n6926 0.1445
R23210 avss.n6928 avss.n6927 0.1445
R23211 avss.n6929 avss.n6928 0.1445
R23212 avss.n6929 avss.n1024 0.1445
R23213 avss.n6968 avss.n1024 0.1445
R23214 avss.n6969 avss.n6968 0.1445
R23215 avss.n6970 avss.n6969 0.1445
R23216 avss.n6970 avss.n1019 0.1445
R23217 avss.n6977 avss.n1018 0.1445
R23218 avss.n6983 avss.n1018 0.1445
R23219 avss.n6984 avss.n6983 0.1445
R23220 avss.n6986 avss.n6984 0.1445
R23221 avss.n6979 avss.n6978 0.1445
R23222 avss.n6980 avss.n6979 0.1445
R23223 avss.n6980 avss.n1017 0.1445
R23224 avss.n6987 avss.n1017 0.1445
R23225 avss.n7012 avss.n979 0.1445
R23226 avss.n7012 avss.n7011 0.1445
R23227 avss.n7011 avss.n7010 0.1445
R23228 avss.n7010 avss.n981 0.1445
R23229 avss.n6793 avss.n1016 0.1445
R23230 avss.n1172 avss.n1171 0.1445
R23231 avss.n1173 avss.n1162 0.1445
R23232 avss.n6800 avss.n6798 0.1445
R23233 avss.n6811 avss.n6810 0.1445
R23234 avss.n6855 avss.n6854 0.1445
R23235 avss.n6856 avss.n6853 0.1445
R23236 avss.n1130 avss.n1109 0.1445
R23237 avss.n1000 avss.n999 0.1445
R23238 avss.n6996 avss.n1000 0.1445
R23239 avss.n6996 avss.n6995 0.1445
R23240 avss.n6995 avss.n6994 0.1445
R23241 avss.n6994 avss.n1005 0.1445
R23242 avss.n6744 avss.n1005 0.1445
R23243 avss.n6744 avss.n6720 0.1445
R23244 avss.n6783 avss.n6720 0.1445
R23245 avss.n6783 avss.n6782 0.1445
R23246 avss.n6782 avss.n6781 0.1445
R23247 avss.n6781 avss.n6724 0.1445
R23248 avss.n6764 avss.n6724 0.1445
R23249 avss.n6770 avss.n6764 0.1445
R23250 avss.n7002 avss.n7001 0.1445
R23251 avss.n7001 avss.n7000 0.1445
R23252 avss.n7000 avss.n993 0.1445
R23253 avss.n6733 avss.n993 0.1445
R23254 avss.n6738 avss.n6733 0.1445
R23255 avss.n6738 avss.n6731 0.1445
R23256 avss.n6750 avss.n6731 0.1445
R23257 avss.n6751 avss.n6750 0.1445
R23258 avss.n6754 avss.n6751 0.1445
R23259 avss.n6754 avss.n6729 0.1445
R23260 avss.n6776 avss.n6729 0.1445
R23261 avss.n6776 avss.n6775 0.1445
R23262 avss.n6775 avss.n6774 0.1445
R23263 avss.n7003 avss.n990 0.1445
R23264 avss.n992 avss.n990 0.1445
R23265 avss.n6734 avss.n992 0.1445
R23266 avss.n6735 avss.n6734 0.1445
R23267 avss.n6737 avss.n6735 0.1445
R23268 avss.n6737 avss.n6736 0.1445
R23269 avss.n6736 avss.n6732 0.1445
R23270 avss.n6732 avss.n6730 0.1445
R23271 avss.n6755 avss.n6730 0.1445
R23272 avss.n6756 avss.n6755 0.1445
R23273 avss.n6757 avss.n6756 0.1445
R23274 avss.n6758 avss.n6757 0.1445
R23275 avss.n6759 avss.n6758 0.1445
R23276 avss.n1001 avss.n989 0.1445
R23277 avss.n1002 avss.n1001 0.1445
R23278 avss.n1003 avss.n1002 0.1445
R23279 avss.n1004 avss.n1003 0.1445
R23280 avss.n6741 avss.n1004 0.1445
R23281 avss.n6743 avss.n6741 0.1445
R23282 avss.n6743 avss.n6742 0.1445
R23283 avss.n6742 avss.n6721 0.1445
R23284 avss.n6722 avss.n6721 0.1445
R23285 avss.n6723 avss.n6722 0.1445
R23286 avss.n6765 avss.n6723 0.1445
R23287 avss.n6766 avss.n6765 0.1445
R23288 avss.n6769 avss.n6766 0.1445
R23289 avss.n930 avss.n929 0.1445
R23290 avss.n7048 avss.n929 0.1445
R23291 avss.n7048 avss.n7047 0.1445
R23292 avss.n7047 avss.n7046 0.1445
R23293 avss.n7046 avss.n936 0.1445
R23294 avss.n7040 avss.n936 0.1445
R23295 avss.n7040 avss.n7039 0.1445
R23296 avss.n7039 avss.n7038 0.1445
R23297 avss.n7038 avss.n946 0.1445
R23298 avss.n6358 avss.n946 0.1445
R23299 avss.n6384 avss.n6358 0.1445
R23300 avss.n6384 avss.n6355 0.1445
R23301 avss.n6388 avss.n6355 0.1445
R23302 avss.n7054 avss.n7053 0.1445
R23303 avss.n7053 avss.n7052 0.1445
R23304 avss.n7052 avss.n923 0.1445
R23305 avss.n6367 avss.n923 0.1445
R23306 avss.n6368 avss.n6367 0.1445
R23307 avss.n6368 avss.n6364 0.1445
R23308 avss.n6373 avss.n6364 0.1445
R23309 avss.n6374 avss.n6373 0.1445
R23310 avss.n6376 avss.n6374 0.1445
R23311 avss.n6376 avss.n6362 0.1445
R23312 avss.n6380 avss.n6362 0.1445
R23313 avss.n6380 avss.n6327 0.1445
R23314 avss.n6392 avss.n6327 0.1445
R23315 avss.n7055 avss.n920 0.1445
R23316 avss.n922 avss.n920 0.1445
R23317 avss.n6365 avss.n922 0.1445
R23318 avss.n6366 avss.n6365 0.1445
R23319 avss.n6369 avss.n6366 0.1445
R23320 avss.n6370 avss.n6369 0.1445
R23321 avss.n6371 avss.n6370 0.1445
R23322 avss.n6371 avss.n6363 0.1445
R23323 avss.n6377 avss.n6363 0.1445
R23324 avss.n6378 avss.n6377 0.1445
R23325 avss.n6379 avss.n6378 0.1445
R23326 avss.n6379 avss.n6326 0.1445
R23327 avss.n6393 avss.n6326 0.1445
R23328 avss.n932 avss.n931 0.1445
R23329 avss.n933 avss.n932 0.1445
R23330 avss.n934 avss.n933 0.1445
R23331 avss.n935 avss.n934 0.1445
R23332 avss.n942 avss.n935 0.1445
R23333 avss.n943 avss.n942 0.1445
R23334 avss.n944 avss.n943 0.1445
R23335 avss.n945 avss.n944 0.1445
R23336 avss.n6356 avss.n945 0.1445
R23337 avss.n6357 avss.n6356 0.1445
R23338 avss.n6385 avss.n6357 0.1445
R23339 avss.n6386 avss.n6385 0.1445
R23340 avss.n6387 avss.n6386 0.1445
R23341 avss.n6909 avss.n1069 0.1445
R23342 avss.n1071 avss.n1069 0.1445
R23343 avss.n1072 avss.n1071 0.1445
R23344 avss.n1073 avss.n1072 0.1445
R23345 avss.n1074 avss.n1073 0.1445
R23346 avss.n1076 avss.n1074 0.1445
R23347 avss.n1077 avss.n1076 0.1445
R23348 avss.n1078 avss.n1077 0.1445
R23349 avss.n1079 avss.n1078 0.1445
R23350 avss.n1080 avss.n1079 0.1445
R23351 avss.n1081 avss.n1080 0.1445
R23352 avss.n1082 avss.n1081 0.1445
R23353 avss.n1083 avss.n1082 0.1445
R23354 avss.n1068 avss.n1044 0.1445
R23355 avss.n6937 avss.n1044 0.1445
R23356 avss.n6938 avss.n6937 0.1445
R23357 avss.n6939 avss.n6938 0.1445
R23358 avss.n6940 avss.n6939 0.1445
R23359 avss.n6942 avss.n6940 0.1445
R23360 avss.n6942 avss.n6941 0.1445
R23361 avss.n6941 avss.n959 0.1445
R23362 avss.n960 avss.n959 0.1445
R23363 avss.n961 avss.n960 0.1445
R23364 avss.n970 avss.n961 0.1445
R23365 avss.n971 avss.n970 0.1445
R23366 avss.n7020 avss.n971 0.1445
R23367 avss.n1067 avss.n1045 0.1445
R23368 avss.n6936 avss.n1045 0.1445
R23369 avss.n6936 avss.n1043 0.1445
R23370 avss.n6946 avss.n1043 0.1445
R23371 avss.n6946 avss.n6945 0.1445
R23372 avss.n6945 avss.n6944 0.1445
R23373 avss.n6944 avss.n958 0.1445
R23374 avss.n7030 avss.n958 0.1445
R23375 avss.n7030 avss.n7029 0.1445
R23376 avss.n7029 avss.n7028 0.1445
R23377 avss.n7028 avss.n962 0.1445
R23378 avss.n7022 avss.n962 0.1445
R23379 avss.n7022 avss.n7021 0.1445
R23380 avss.n2612 avss.n2483 0.1445
R23381 avss.n2612 avss.n2472 0.1445
R23382 avss.n2627 avss.n2472 0.1445
R23383 avss.n2627 avss.n2470 0.1445
R23384 avss.n2633 avss.n2470 0.1445
R23385 avss.n2633 avss.n2632 0.1445
R23386 avss.n2632 avss.n2458 0.1445
R23387 avss.n2648 avss.n2458 0.1445
R23388 avss.n2648 avss.n2456 0.1445
R23389 avss.n2654 avss.n2456 0.1445
R23390 avss.n2654 avss.n2653 0.1445
R23391 avss.n2653 avss.n2263 0.1445
R23392 avss.n2679 avss.n2263 0.1445
R23393 avss.n2378 avss.n2352 0.1445
R23394 avss.n2383 avss.n2352 0.1445
R23395 avss.n2383 avss.n2299 0.1445
R23396 avss.n2436 avss.n2299 0.1445
R23397 avss.n2436 avss.n2435 0.1445
R23398 avss.n2435 avss.n2434 0.1445
R23399 avss.n2434 avss.n2303 0.1445
R23400 avss.n2403 avss.n2303 0.1445
R23401 avss.n2408 avss.n2403 0.1445
R23402 avss.n2408 avss.n2317 0.1445
R23403 avss.n2424 avss.n2317 0.1445
R23404 avss.n2424 avss.n2423 0.1445
R23405 avss.n2423 avss.n2422 0.1445
R23406 avss.n2373 avss.n2372 0.1445
R23407 avss.n2372 avss.n2347 0.1445
R23408 avss.n2388 avss.n2347 0.1445
R23409 avss.n2389 avss.n2388 0.1445
R23410 avss.n2391 avss.n2389 0.1445
R23411 avss.n2391 avss.n2345 0.1445
R23412 avss.n2398 avss.n2345 0.1445
R23413 avss.n2398 avss.n2397 0.1445
R23414 avss.n2397 avss.n2342 0.1445
R23415 avss.n2413 avss.n2342 0.1445
R23416 avss.n2414 avss.n2413 0.1445
R23417 avss.n2414 avss.n2340 0.1445
R23418 avss.n2418 avss.n2340 0.1445
R23419 avss.n2371 avss.n2369 0.1445
R23420 avss.n2371 avss.n2370 0.1445
R23421 avss.n2370 avss.n2348 0.1445
R23422 avss.n2348 avss.n2346 0.1445
R23423 avss.n2392 avss.n2346 0.1445
R23424 avss.n2393 avss.n2392 0.1445
R23425 avss.n2394 avss.n2393 0.1445
R23426 avss.n2396 avss.n2394 0.1445
R23427 avss.n2396 avss.n2395 0.1445
R23428 avss.n2395 avss.n2341 0.1445
R23429 avss.n2415 avss.n2341 0.1445
R23430 avss.n2416 avss.n2415 0.1445
R23431 avss.n2417 avss.n2416 0.1445
R23432 avss.n2380 avss.n2379 0.1445
R23433 avss.n2382 avss.n2380 0.1445
R23434 avss.n2382 avss.n2381 0.1445
R23435 avss.n2381 avss.n2300 0.1445
R23436 avss.n2301 avss.n2300 0.1445
R23437 avss.n2302 avss.n2301 0.1445
R23438 avss.n2404 avss.n2302 0.1445
R23439 avss.n2405 avss.n2404 0.1445
R23440 avss.n2407 avss.n2405 0.1445
R23441 avss.n2407 avss.n2406 0.1445
R23442 avss.n2406 avss.n2318 0.1445
R23443 avss.n2319 avss.n2318 0.1445
R23444 avss.n2320 avss.n2319 0.1445
R23445 avss.n2335 avss.n2324 0.1445
R23446 avss.n2361 avss.n2360 0.1445
R23447 avss.n2441 avss.n2290 0.1445
R23448 avss.n2442 avss.n2289 0.1445
R23449 avss.n2446 avss.n2445 0.1445
R23450 avss.n2492 avss.n2491 0.1445
R23451 avss.n2664 avss.n2663 0.1445
R23452 avss.n2662 avss.n2280 0.1445
R23453 avss.n2589 avss.n2500 0.1445
R23454 avss.n2589 avss.n2487 0.1445
R23455 avss.n2604 avss.n2487 0.1445
R23456 avss.n2604 avss.n2603 0.1445
R23457 avss.n2548 avss.n2547 0.1445
R23458 avss.n2547 avss.n2546 0.1445
R23459 avss.n2546 avss.n2544 0.1445
R23460 avss.n2544 avss.n2543 0.1445
R23461 avss.n2543 avss.n2540 0.1445
R23462 avss.n2540 avss.n2539 0.1445
R23463 avss.n2539 avss.n2536 0.1445
R23464 avss.n2536 avss.n2535 0.1445
R23465 avss.n2535 avss.n2532 0.1445
R23466 avss.n2532 avss.n2531 0.1445
R23467 avss.n2531 avss.n2528 0.1445
R23468 avss.n2528 avss.n2527 0.1445
R23469 avss.n2527 avss.n2525 0.1445
R23470 avss.n2552 avss.n2510 0.1445
R23471 avss.n2558 avss.n2510 0.1445
R23472 avss.n2559 avss.n2558 0.1445
R23473 avss.n2562 avss.n2559 0.1445
R23474 avss.n2562 avss.n2508 0.1445
R23475 avss.n2566 avss.n2508 0.1445
R23476 avss.n2566 avss.n2506 0.1445
R23477 avss.n2572 avss.n2506 0.1445
R23478 avss.n2572 avss.n2504 0.1445
R23479 avss.n2577 avss.n2504 0.1445
R23480 avss.n2577 avss.n2502 0.1445
R23481 avss.n2582 avss.n2502 0.1445
R23482 avss.n2583 avss.n2582 0.1445
R23483 avss.n2554 avss.n2553 0.1445
R23484 avss.n2555 avss.n2554 0.1445
R23485 avss.n2555 avss.n2509 0.1445
R23486 avss.n2563 avss.n2509 0.1445
R23487 avss.n2564 avss.n2563 0.1445
R23488 avss.n2565 avss.n2564 0.1445
R23489 avss.n2565 avss.n2505 0.1445
R23490 avss.n2573 avss.n2505 0.1445
R23491 avss.n2574 avss.n2573 0.1445
R23492 avss.n2576 avss.n2574 0.1445
R23493 avss.n2576 avss.n2575 0.1445
R23494 avss.n2575 avss.n2501 0.1445
R23495 avss.n2584 avss.n2501 0.1445
R23496 avss.n2549 avss.n2511 0.1445
R23497 avss.n2513 avss.n2511 0.1445
R23498 avss.n2514 avss.n2513 0.1445
R23499 avss.n2515 avss.n2514 0.1445
R23500 avss.n2516 avss.n2515 0.1445
R23501 avss.n2517 avss.n2516 0.1445
R23502 avss.n2518 avss.n2517 0.1445
R23503 avss.n2519 avss.n2518 0.1445
R23504 avss.n2520 avss.n2519 0.1445
R23505 avss.n2521 avss.n2520 0.1445
R23506 avss.n2522 avss.n2521 0.1445
R23507 avss.n2523 avss.n2522 0.1445
R23508 avss.n2524 avss.n2523 0.1445
R23509 avss.n2496 avss.n2495 0.1445
R23510 avss.n2594 avss.n2495 0.1445
R23511 avss.n2595 avss.n2594 0.1445
R23512 avss.n2597 avss.n2595 0.1445
R23513 avss.n2498 avss.n2497 0.1445
R23514 avss.n2499 avss.n2498 0.1445
R23515 avss.n2499 avss.n2494 0.1445
R23516 avss.n2598 avss.n2494 0.1445
R23517 avss.n2588 avss.n2586 0.1445
R23518 avss.n2588 avss.n2587 0.1445
R23519 avss.n2587 avss.n2488 0.1445
R23520 avss.n2602 avss.n2488 0.1445
R23521 avss.n2493 avss.n2490 0.1445
R23522 avss.n2450 avss.n2284 0.1445
R23523 avss.n2451 avss.n2283 0.1445
R23524 avss.n2444 avss.n2281 0.1445
R23525 avss.n2362 avss.n2359 0.1445
R23526 avss.n2330 avss.n2329 0.1445
R23527 avss.n2331 avss.n2328 0.1445
R23528 avss.n2334 avss.n2325 0.1445
R23529 avss.n2771 avss.n2770 0.1445
R23530 avss.n2770 avss.n2239 0.1445
R23531 avss.n2766 avss.n2239 0.1445
R23532 avss.n2766 avss.n2763 0.1445
R23533 avss.n2763 avss.n2760 0.1445
R23534 avss.n2760 avss.n2759 0.1445
R23535 avss.n2759 avss.n2756 0.1445
R23536 avss.n2756 avss.n2755 0.1445
R23537 avss.n2755 avss.n2245 0.1445
R23538 avss.n2730 avss.n2245 0.1445
R23539 avss.n2730 avss.n2728 0.1445
R23540 avss.n2735 avss.n2728 0.1445
R23541 avss.n2735 avss.n2734 0.1445
R23542 avss.n2713 avss.n2712 0.1445
R23543 avss.n2712 avss.n2696 0.1445
R23544 avss.n2708 avss.n2696 0.1445
R23545 avss.n2708 avss.n2705 0.1445
R23546 avss.n2705 avss.n2702 0.1445
R23547 avss.n2702 avss.n2701 0.1445
R23548 avss.n2701 avss.n2688 0.1445
R23549 avss.n2718 avss.n2688 0.1445
R23550 avss.n2718 avss.n2686 0.1445
R23551 avss.n2723 avss.n2686 0.1445
R23552 avss.n2723 avss.n2685 0.1445
R23553 avss.n2739 avss.n2685 0.1445
R23554 avss.n2740 avss.n2739 0.1445
R23555 avss.n2711 avss.n2695 0.1445
R23556 avss.n2711 avss.n2710 0.1445
R23557 avss.n2710 avss.n2709 0.1445
R23558 avss.n2709 avss.n2697 0.1445
R23559 avss.n2698 avss.n2697 0.1445
R23560 avss.n2699 avss.n2698 0.1445
R23561 avss.n2699 avss.n2687 0.1445
R23562 avss.n2719 avss.n2687 0.1445
R23563 avss.n2720 avss.n2719 0.1445
R23564 avss.n2722 avss.n2720 0.1445
R23565 avss.n2722 avss.n2721 0.1445
R23566 avss.n2721 avss.n2684 0.1445
R23567 avss.n2741 avss.n2684 0.1445
R23568 avss.n2769 avss.n2238 0.1445
R23569 avss.n2769 avss.n2768 0.1445
R23570 avss.n2768 avss.n2767 0.1445
R23571 avss.n2767 avss.n2240 0.1445
R23572 avss.n2241 avss.n2240 0.1445
R23573 avss.n2242 avss.n2241 0.1445
R23574 avss.n2243 avss.n2242 0.1445
R23575 avss.n2244 avss.n2243 0.1445
R23576 avss.n2729 avss.n2244 0.1445
R23577 avss.n2731 avss.n2729 0.1445
R23578 avss.n2732 avss.n2731 0.1445
R23579 avss.n2733 avss.n2732 0.1445
R23580 avss.n2733 avss.n2259 0.1445
R23581 avss.n1922 avss.n1857 0.1445
R23582 avss.n1922 avss.n1858 0.1445
R23583 avss.n1918 avss.n1858 0.1445
R23584 avss.n1918 avss.n1917 0.1445
R23585 avss.n1917 avss.n1915 0.1445
R23586 avss.n1915 avss.n1914 0.1445
R23587 avss.n1914 avss.n1912 0.1445
R23588 avss.n1912 avss.n1911 0.1445
R23589 avss.n1911 avss.n1909 0.1445
R23590 avss.n1909 avss.n1908 0.1445
R23591 avss.n1908 avss.n1906 0.1445
R23592 avss.n1906 avss.n1905 0.1445
R23593 avss.n1905 avss.n1903 0.1445
R23594 avss.n1887 avss.n1886 0.1445
R23595 avss.n1886 avss.n1861 0.1445
R23596 avss.n1882 avss.n1861 0.1445
R23597 avss.n1882 avss.n1881 0.1445
R23598 avss.n1881 avss.n1879 0.1445
R23599 avss.n1879 avss.n1878 0.1445
R23600 avss.n1878 avss.n1876 0.1445
R23601 avss.n1876 avss.n1875 0.1445
R23602 avss.n1875 avss.n1873 0.1445
R23603 avss.n1873 avss.n1872 0.1445
R23604 avss.n1872 avss.n1870 0.1445
R23605 avss.n1870 avss.n1745 0.1445
R23606 avss.n3317 avss.n1745 0.1445
R23607 avss.n1885 avss.n1859 0.1445
R23608 avss.n1885 avss.n1884 0.1445
R23609 avss.n1884 avss.n1883 0.1445
R23610 avss.n1883 avss.n1862 0.1445
R23611 avss.n1863 avss.n1862 0.1445
R23612 avss.n1864 avss.n1863 0.1445
R23613 avss.n1865 avss.n1864 0.1445
R23614 avss.n1866 avss.n1865 0.1445
R23615 avss.n1867 avss.n1866 0.1445
R23616 avss.n1868 avss.n1867 0.1445
R23617 avss.n1869 avss.n1868 0.1445
R23618 avss.n1869 avss.n1744 0.1445
R23619 avss.n3318 avss.n1744 0.1445
R23620 avss.n1921 avss.n1892 0.1445
R23621 avss.n1921 avss.n1920 0.1445
R23622 avss.n1920 avss.n1919 0.1445
R23623 avss.n1919 avss.n1893 0.1445
R23624 avss.n1894 avss.n1893 0.1445
R23625 avss.n1895 avss.n1894 0.1445
R23626 avss.n1896 avss.n1895 0.1445
R23627 avss.n1897 avss.n1896 0.1445
R23628 avss.n1898 avss.n1897 0.1445
R23629 avss.n1899 avss.n1898 0.1445
R23630 avss.n1900 avss.n1899 0.1445
R23631 avss.n1901 avss.n1900 0.1445
R23632 avss.n1902 avss.n1901 0.1445
R23633 avss.n2611 avss.n2610 0.1445
R23634 avss.n2611 avss.n2471 0.1445
R23635 avss.n2628 avss.n2471 0.1445
R23636 avss.n2629 avss.n2628 0.1445
R23637 avss.n2630 avss.n2629 0.1445
R23638 avss.n2631 avss.n2630 0.1445
R23639 avss.n2631 avss.n2457 0.1445
R23640 avss.n2649 avss.n2457 0.1445
R23641 avss.n2650 avss.n2649 0.1445
R23642 avss.n2651 avss.n2650 0.1445
R23643 avss.n2652 avss.n2651 0.1445
R23644 avss.n2652 avss.n2262 0.1445
R23645 avss.n2680 avss.n2262 0.1445
R23646 avss.n2618 avss.n2478 0.1445
R23647 avss.n2619 avss.n2618 0.1445
R23648 avss.n2620 avss.n2619 0.1445
R23649 avss.n2621 avss.n2620 0.1445
R23650 avss.n2621 avss.n2464 0.1445
R23651 avss.n2639 avss.n2464 0.1445
R23652 avss.n2640 avss.n2639 0.1445
R23653 avss.n2641 avss.n2640 0.1445
R23654 avss.n2642 avss.n2641 0.1445
R23655 avss.n2642 avss.n2270 0.1445
R23656 avss.n2672 avss.n2270 0.1445
R23657 avss.n2673 avss.n2672 0.1445
R23658 avss.n2674 avss.n2673 0.1445
R23659 avss.n2617 avss.n2479 0.1445
R23660 avss.n2617 avss.n2477 0.1445
R23661 avss.n2623 avss.n2477 0.1445
R23662 avss.n2623 avss.n2622 0.1445
R23663 avss.n2622 avss.n2465 0.1445
R23664 avss.n2638 avss.n2465 0.1445
R23665 avss.n2638 avss.n2463 0.1445
R23666 avss.n2644 avss.n2463 0.1445
R23667 avss.n2644 avss.n2643 0.1445
R23668 avss.n2643 avss.n2271 0.1445
R23669 avss.n2671 avss.n2271 0.1445
R23670 avss.n2671 avss.n2269 0.1445
R23671 avss.n2675 avss.n2269 0.1445
R23672 avss.n2065 avss.n2063 0.1445
R23673 avss.n3234 avss.n2063 0.1445
R23674 avss.n3234 avss.n3233 0.1445
R23675 avss.n3233 avss.n3232 0.1445
R23676 avss.n3232 avss.n2071 0.1445
R23677 avss.n3175 avss.n2071 0.1445
R23678 avss.n3179 avss.n3175 0.1445
R23679 avss.n3179 avss.n3174 0.1445
R23680 avss.n3190 avss.n3174 0.1445
R23681 avss.n3190 avss.n3172 0.1445
R23682 avss.n3196 avss.n3172 0.1445
R23683 avss.n3197 avss.n3196 0.1445
R23684 avss.n3198 avss.n3197 0.1445
R23685 avss.n3103 avss.n3055 0.1445
R23686 avss.n3103 avss.n3053 0.1445
R23687 avss.n3107 avss.n3053 0.1445
R23688 avss.n3107 avss.n3041 0.1445
R23689 avss.n3121 avss.n3041 0.1445
R23690 avss.n3121 avss.n3039 0.1445
R23691 avss.n3125 avss.n3039 0.1445
R23692 avss.n3125 avss.n3028 0.1445
R23693 avss.n3141 avss.n3028 0.1445
R23694 avss.n3141 avss.n3026 0.1445
R23695 avss.n3145 avss.n3026 0.1445
R23696 avss.n3145 avss.n3010 0.1445
R23697 avss.n3163 avss.n3010 0.1445
R23698 avss.n3077 avss.n3076 0.1445
R23699 avss.n3076 avss.n3047 0.1445
R23700 avss.n3111 avss.n3047 0.1445
R23701 avss.n3111 avss.n3045 0.1445
R23702 avss.n3115 avss.n3045 0.1445
R23703 avss.n3115 avss.n3035 0.1445
R23704 avss.n3129 avss.n3035 0.1445
R23705 avss.n3129 avss.n3033 0.1445
R23706 avss.n3137 avss.n3033 0.1445
R23707 avss.n3137 avss.n3136 0.1445
R23708 avss.n3136 avss.n3135 0.1445
R23709 avss.n3135 avss.n3005 0.1445
R23710 avss.n3167 avss.n3005 0.1445
R23711 avss.n3078 avss.n3075 0.1445
R23712 avss.n3075 avss.n3046 0.1445
R23713 avss.n3112 avss.n3046 0.1445
R23714 avss.n3113 avss.n3112 0.1445
R23715 avss.n3114 avss.n3113 0.1445
R23716 avss.n3114 avss.n3034 0.1445
R23717 avss.n3130 avss.n3034 0.1445
R23718 avss.n3131 avss.n3130 0.1445
R23719 avss.n3132 avss.n3131 0.1445
R23720 avss.n3133 avss.n3132 0.1445
R23721 avss.n3134 avss.n3133 0.1445
R23722 avss.n3134 avss.n3004 0.1445
R23723 avss.n3168 avss.n3004 0.1445
R23724 avss.n3104 avss.n3054 0.1445
R23725 avss.n3105 avss.n3104 0.1445
R23726 avss.n3106 avss.n3105 0.1445
R23727 avss.n3106 avss.n3040 0.1445
R23728 avss.n3122 avss.n3040 0.1445
R23729 avss.n3123 avss.n3122 0.1445
R23730 avss.n3124 avss.n3123 0.1445
R23731 avss.n3124 avss.n3027 0.1445
R23732 avss.n3142 avss.n3027 0.1445
R23733 avss.n3143 avss.n3142 0.1445
R23734 avss.n3144 avss.n3143 0.1445
R23735 avss.n3144 avss.n3011 0.1445
R23736 avss.n3162 avss.n3011 0.1445
R23737 avss.n3154 avss.n3017 0.1445
R23738 avss.n3066 avss.n3065 0.1445
R23739 avss.n3087 avss.n3086 0.1445
R23740 avss.n3088 avss.n3018 0.1445
R23741 avss.n3091 avss.n3084 0.1445
R23742 avss.n2194 avss.n2193 0.1445
R23743 avss.n3221 avss.n3220 0.1445
R23744 avss.n3219 avss.n2089 0.1445
R23745 avss.n3252 avss.n2036 0.1445
R23746 avss.n3247 avss.n2036 0.1445
R23747 avss.n3247 avss.n3246 0.1445
R23748 avss.n3246 avss.n3245 0.1445
R23749 avss.n2165 avss.n2164 0.1445
R23750 avss.n2168 avss.n2165 0.1445
R23751 avss.n2168 avss.n2153 0.1445
R23752 avss.n2224 avss.n2153 0.1445
R23753 avss.n2224 avss.n2223 0.1445
R23754 avss.n2223 avss.n2222 0.1445
R23755 avss.n2222 avss.n2174 0.1445
R23756 avss.n2217 avss.n2174 0.1445
R23757 avss.n2217 avss.n2216 0.1445
R23758 avss.n2216 avss.n2215 0.1445
R23759 avss.n2215 avss.n2181 0.1445
R23760 avss.n2210 avss.n2181 0.1445
R23761 avss.n2210 avss.n2209 0.1445
R23762 avss.n2159 avss.n2158 0.1445
R23763 avss.n2158 avss.n2016 0.1445
R23764 avss.n3273 avss.n2016 0.1445
R23765 avss.n3273 avss.n3272 0.1445
R23766 avss.n3272 avss.n3271 0.1445
R23767 avss.n3271 avss.n2020 0.1445
R23768 avss.n2022 avss.n2020 0.1445
R23769 avss.n3264 avss.n2022 0.1445
R23770 avss.n3264 avss.n3263 0.1445
R23771 avss.n3263 avss.n3262 0.1445
R23772 avss.n3262 avss.n2029 0.1445
R23773 avss.n3257 avss.n2029 0.1445
R23774 avss.n3257 avss.n3256 0.1445
R23775 avss.n2160 avss.n2156 0.1445
R23776 avss.n2156 avss.n2155 0.1445
R23777 avss.n2155 avss.n2017 0.1445
R23778 avss.n2018 avss.n2017 0.1445
R23779 avss.n2019 avss.n2018 0.1445
R23780 avss.n2024 avss.n2019 0.1445
R23781 avss.n2025 avss.n2024 0.1445
R23782 avss.n2026 avss.n2025 0.1445
R23783 avss.n2027 avss.n2026 0.1445
R23784 avss.n2028 avss.n2027 0.1445
R23785 avss.n2032 avss.n2028 0.1445
R23786 avss.n2033 avss.n2032 0.1445
R23787 avss.n3255 avss.n2033 0.1445
R23788 avss.n2163 avss.n2154 0.1445
R23789 avss.n2169 avss.n2154 0.1445
R23790 avss.n2170 avss.n2169 0.1445
R23791 avss.n2171 avss.n2170 0.1445
R23792 avss.n2172 avss.n2171 0.1445
R23793 avss.n2173 avss.n2172 0.1445
R23794 avss.n2177 avss.n2173 0.1445
R23795 avss.n2178 avss.n2177 0.1445
R23796 avss.n2179 avss.n2178 0.1445
R23797 avss.n2180 avss.n2179 0.1445
R23798 avss.n2184 avss.n2180 0.1445
R23799 avss.n2185 avss.n2184 0.1445
R23800 avss.n2208 avss.n2185 0.1445
R23801 avss.n2205 avss.n2204 0.1445
R23802 avss.n2204 avss.n2203 0.1445
R23803 avss.n2203 avss.n2202 0.1445
R23804 avss.n2202 avss.n2200 0.1445
R23805 avss.n2206 avss.n2189 0.1445
R23806 avss.n2190 avss.n2189 0.1445
R23807 avss.n2191 avss.n2190 0.1445
R23808 avss.n2199 avss.n2191 0.1445
R23809 avss.n3253 avss.n2035 0.1445
R23810 avss.n2045 avss.n2035 0.1445
R23811 avss.n2046 avss.n2045 0.1445
R23812 avss.n2047 avss.n2046 0.1445
R23813 avss.n2195 avss.n2192 0.1445
R23814 avss.n3095 avss.n3069 0.1445
R23815 avss.n3096 avss.n3068 0.1445
R23816 avss.n3090 avss.n2090 0.1445
R23817 avss.n3067 avss.n3063 0.1445
R23818 avss.n3158 avss.n3014 0.1445
R23819 avss.n3159 avss.n3013 0.1445
R23820 avss.n3153 avss.n3152 0.1445
R23821 avss.n2970 avss.n2969 0.1445
R23822 avss.n2969 avss.n2956 0.1445
R23823 avss.n2965 avss.n2956 0.1445
R23824 avss.n2965 avss.n2962 0.1445
R23825 avss.n2962 avss.n2959 0.1445
R23826 avss.n2959 avss.n2137 0.1445
R23827 avss.n2975 avss.n2137 0.1445
R23828 avss.n2975 avss.n2135 0.1445
R23829 avss.n2979 avss.n2135 0.1445
R23830 avss.n2979 avss.n2124 0.1445
R23831 avss.n2991 avss.n2124 0.1445
R23832 avss.n2991 avss.n2122 0.1445
R23833 avss.n2995 avss.n2122 0.1445
R23834 avss.n2952 avss.n2146 0.1445
R23835 avss.n2947 avss.n2146 0.1445
R23836 avss.n2947 avss.n2946 0.1445
R23837 avss.n2946 avss.n2945 0.1445
R23838 avss.n2945 avss.n2942 0.1445
R23839 avss.n2942 avss.n2941 0.1445
R23840 avss.n2941 avss.n2938 0.1445
R23841 avss.n2938 avss.n2130 0.1445
R23842 avss.n2983 avss.n2130 0.1445
R23843 avss.n2983 avss.n2128 0.1445
R23844 avss.n2987 avss.n2128 0.1445
R23845 avss.n2987 avss.n2116 0.1445
R23846 avss.n2999 avss.n2116 0.1445
R23847 avss.n2953 avss.n2145 0.1445
R23848 avss.n2932 avss.n2145 0.1445
R23849 avss.n2933 avss.n2932 0.1445
R23850 avss.n2934 avss.n2933 0.1445
R23851 avss.n2935 avss.n2934 0.1445
R23852 avss.n2936 avss.n2935 0.1445
R23853 avss.n2937 avss.n2936 0.1445
R23854 avss.n2937 avss.n2129 0.1445
R23855 avss.n2984 avss.n2129 0.1445
R23856 avss.n2985 avss.n2984 0.1445
R23857 avss.n2986 avss.n2985 0.1445
R23858 avss.n2986 avss.n2115 0.1445
R23859 avss.n3000 avss.n2115 0.1445
R23860 avss.n2968 avss.n2955 0.1445
R23861 avss.n2968 avss.n2967 0.1445
R23862 avss.n2967 avss.n2966 0.1445
R23863 avss.n2966 avss.n2957 0.1445
R23864 avss.n2958 avss.n2957 0.1445
R23865 avss.n2958 avss.n2136 0.1445
R23866 avss.n2976 avss.n2136 0.1445
R23867 avss.n2977 avss.n2976 0.1445
R23868 avss.n2978 avss.n2977 0.1445
R23869 avss.n2978 avss.n2123 0.1445
R23870 avss.n2992 avss.n2123 0.1445
R23871 avss.n2993 avss.n2992 0.1445
R23872 avss.n2994 avss.n2993 0.1445
R23873 avss.n1949 avss.n1925 0.1445
R23874 avss.n1949 avss.n1808 0.1445
R23875 avss.n1961 avss.n1808 0.1445
R23876 avss.n1961 avss.n1806 0.1445
R23877 avss.n1970 avss.n1806 0.1445
R23878 avss.n1970 avss.n1969 0.1445
R23879 avss.n1969 avss.n1968 0.1445
R23880 avss.n1968 avss.n1778 0.1445
R23881 avss.n3294 avss.n1778 0.1445
R23882 avss.n3294 avss.n3293 0.1445
R23883 avss.n3293 avss.n3292 0.1445
R23884 avss.n3292 avss.n3291 0.1445
R23885 avss.n3291 avss.n3289 0.1445
R23886 avss.n1942 avss.n1941 0.1445
R23887 avss.n1941 avss.n1928 0.1445
R23888 avss.n1937 avss.n1928 0.1445
R23889 avss.n1937 avss.n1936 0.1445
R23890 avss.n1936 avss.n1934 0.1445
R23891 avss.n1934 avss.n1933 0.1445
R23892 avss.n1933 avss.n1787 0.1445
R23893 avss.n1983 avss.n1787 0.1445
R23894 avss.n1984 avss.n1983 0.1445
R23895 avss.n1984 avss.n1785 0.1445
R23896 avss.n1988 avss.n1785 0.1445
R23897 avss.n1990 avss.n1988 0.1445
R23898 avss.n1991 avss.n1990 0.1445
R23899 avss.n1940 avss.n1926 0.1445
R23900 avss.n1940 avss.n1939 0.1445
R23901 avss.n1939 avss.n1938 0.1445
R23902 avss.n1938 avss.n1929 0.1445
R23903 avss.n1930 avss.n1929 0.1445
R23904 avss.n1932 avss.n1930 0.1445
R23905 avss.n1932 avss.n1931 0.1445
R23906 avss.n1931 avss.n1786 0.1445
R23907 avss.n1985 avss.n1786 0.1445
R23908 avss.n1986 avss.n1985 0.1445
R23909 avss.n1987 avss.n1986 0.1445
R23910 avss.n1987 avss.n1783 0.1445
R23911 avss.n1992 avss.n1783 0.1445
R23912 avss.n1948 avss.n1947 0.1445
R23913 avss.n1948 avss.n1807 0.1445
R23914 avss.n1962 avss.n1807 0.1445
R23915 avss.n1963 avss.n1962 0.1445
R23916 avss.n1964 avss.n1963 0.1445
R23917 avss.n1965 avss.n1964 0.1445
R23918 avss.n1967 avss.n1965 0.1445
R23919 avss.n1967 avss.n1966 0.1445
R23920 avss.n1966 avss.n1779 0.1445
R23921 avss.n1780 avss.n1779 0.1445
R23922 avss.n1781 avss.n1780 0.1445
R23923 avss.n1782 avss.n1781 0.1445
R23924 avss.n3288 avss.n1782 0.1445
R23925 avss.n2067 avss.n2066 0.1445
R23926 avss.n2068 avss.n2067 0.1445
R23927 avss.n2069 avss.n2068 0.1445
R23928 avss.n2070 avss.n2069 0.1445
R23929 avss.n3176 avss.n2070 0.1445
R23930 avss.n3177 avss.n3176 0.1445
R23931 avss.n3178 avss.n3177 0.1445
R23932 avss.n3178 avss.n3173 0.1445
R23933 avss.n3191 avss.n3173 0.1445
R23934 avss.n3192 avss.n3191 0.1445
R23935 avss.n3193 avss.n3192 0.1445
R23936 avss.n3193 avss.n3171 0.1445
R23937 avss.n3199 avss.n3171 0.1445
R23938 avss.n2056 avss.n2055 0.1445
R23939 avss.n2057 avss.n2056 0.1445
R23940 avss.n2076 avss.n2057 0.1445
R23941 avss.n2077 avss.n2076 0.1445
R23942 avss.n2078 avss.n2077 0.1445
R23943 avss.n2079 avss.n2078 0.1445
R23944 avss.n3182 avss.n2079 0.1445
R23945 avss.n3184 avss.n3182 0.1445
R23946 avss.n3184 avss.n3183 0.1445
R23947 avss.n3183 avss.n2100 0.1445
R23948 avss.n2101 avss.n2100 0.1445
R23949 avss.n2102 avss.n2101 0.1445
R23950 avss.n2109 avss.n2102 0.1445
R23951 avss.n3240 avss.n3239 0.1445
R23952 avss.n3239 avss.n3238 0.1445
R23953 avss.n3238 avss.n2058 0.1445
R23954 avss.n3228 avss.n2058 0.1445
R23955 avss.n3228 avss.n3227 0.1445
R23956 avss.n3227 avss.n3226 0.1445
R23957 avss.n3226 avss.n2080 0.1445
R23958 avss.n3185 avss.n2080 0.1445
R23959 avss.n3185 avss.n2099 0.1445
R23960 avss.n3211 avss.n2099 0.1445
R23961 avss.n3211 avss.n3210 0.1445
R23962 avss.n3210 avss.n3209 0.1445
R23963 avss.n3209 avss.n2103 0.1445
R23964 avss.n4567 avss.n4540 0.1445
R23965 avss.n4562 avss.n4540 0.1445
R23966 avss.n4562 avss.n4561 0.1445
R23967 avss.n4561 avss.n4560 0.1445
R23968 avss.n4560 avss.n4557 0.1445
R23969 avss.n4557 avss.n4556 0.1445
R23970 avss.n4556 avss.n4553 0.1445
R23971 avss.n4553 avss.n3425 0.1445
R23972 avss.n4598 avss.n3425 0.1445
R23973 avss.n4598 avss.n3423 0.1445
R23974 avss.n4602 avss.n3423 0.1445
R23975 avss.n4602 avss.n3411 0.1445
R23976 avss.n4614 avss.n3411 0.1445
R23977 avss.n3670 avss.n3669 0.1445
R23978 avss.n4503 avss.n3670 0.1445
R23979 avss.n4503 avss.n4502 0.1445
R23980 avss.n4502 avss.n4501 0.1445
R23981 avss.n4501 avss.n3675 0.1445
R23982 avss.n3786 avss.n3675 0.1445
R23983 avss.n3807 avss.n3786 0.1445
R23984 avss.n3807 avss.n3783 0.1445
R23985 avss.n3812 avss.n3783 0.1445
R23986 avss.n3812 avss.n3770 0.1445
R23987 avss.n3831 avss.n3770 0.1445
R23988 avss.n3831 avss.n3830 0.1445
R23989 avss.n3830 avss.n3829 0.1445
R23990 avss.n4509 avss.n4508 0.1445
R23991 avss.n4508 avss.n4507 0.1445
R23992 avss.n4507 avss.n3663 0.1445
R23993 avss.n3794 avss.n3663 0.1445
R23994 avss.n3796 avss.n3794 0.1445
R23995 avss.n3796 avss.n3791 0.1445
R23996 avss.n3803 avss.n3791 0.1445
R23997 avss.n3803 avss.n3802 0.1445
R23998 avss.n3802 avss.n3779 0.1445
R23999 avss.n3817 avss.n3779 0.1445
R24000 avss.n3818 avss.n3817 0.1445
R24001 avss.n3818 avss.n3777 0.1445
R24002 avss.n3824 avss.n3777 0.1445
R24003 avss.n4510 avss.n3660 0.1445
R24004 avss.n3662 avss.n3660 0.1445
R24005 avss.n3792 avss.n3662 0.1445
R24006 avss.n3793 avss.n3792 0.1445
R24007 avss.n3797 avss.n3793 0.1445
R24008 avss.n3798 avss.n3797 0.1445
R24009 avss.n3799 avss.n3798 0.1445
R24010 avss.n3801 avss.n3799 0.1445
R24011 avss.n3801 avss.n3800 0.1445
R24012 avss.n3800 avss.n3778 0.1445
R24013 avss.n3819 avss.n3778 0.1445
R24014 avss.n3820 avss.n3819 0.1445
R24015 avss.n3823 avss.n3820 0.1445
R24016 avss.n3671 avss.n3659 0.1445
R24017 avss.n3672 avss.n3671 0.1445
R24018 avss.n3673 avss.n3672 0.1445
R24019 avss.n3674 avss.n3673 0.1445
R24020 avss.n3784 avss.n3674 0.1445
R24021 avss.n3785 avss.n3784 0.1445
R24022 avss.n3808 avss.n3785 0.1445
R24023 avss.n3809 avss.n3808 0.1445
R24024 avss.n3811 avss.n3809 0.1445
R24025 avss.n3811 avss.n3810 0.1445
R24026 avss.n3810 avss.n3771 0.1445
R24027 avss.n3772 avss.n3771 0.1445
R24028 avss.n3773 avss.n3772 0.1445
R24029 avss.n5340 avss.n5339 0.1445
R24030 avss.n5339 avss.n5338 0.1445
R24031 avss.n5338 avss.n5120 0.1445
R24032 avss.n5172 avss.n5120 0.1445
R24033 avss.n5177 avss.n5172 0.1445
R24034 avss.n5178 avss.n5177 0.1445
R24035 avss.n5180 avss.n5178 0.1445
R24036 avss.n5180 avss.n5170 0.1445
R24037 avss.n5193 avss.n5170 0.1445
R24038 avss.n5193 avss.n5192 0.1445
R24039 avss.n5192 avss.n5191 0.1445
R24040 avss.n5191 avss.n5190 0.1445
R24041 avss.n5190 avss.n5188 0.1445
R24042 avss.n7177 avss.n7176 0.1445
R24043 avss.n7176 avss.n669 0.1445
R24044 avss.n7172 avss.n669 0.1445
R24045 avss.n7172 avss.n671 0.1445
R24046 avss.n729 avss.n671 0.1445
R24047 avss.n729 avss.n727 0.1445
R24048 avss.n7118 avss.n727 0.1445
R24049 avss.n7118 avss.n7117 0.1445
R24050 avss.n7117 avss.n7116 0.1445
R24051 avss.n7116 avss.n718 0.1445
R24052 avss.n7126 avss.n718 0.1445
R24053 avss.n7126 avss.n716 0.1445
R24054 avss.n7130 avss.n716 0.1445
R24055 avss.n743 avss.n741 0.1445
R24056 avss.n751 avss.n741 0.1445
R24057 avss.n752 avss.n751 0.1445
R24058 avss.n753 avss.n752 0.1445
R24059 avss.n753 avss.n739 0.1445
R24060 avss.n759 avss.n739 0.1445
R24061 avss.n760 avss.n759 0.1445
R24062 avss.n762 avss.n760 0.1445
R24063 avss.n762 avss.n737 0.1445
R24064 avss.n768 avss.n737 0.1445
R24065 avss.n768 avss.n767 0.1445
R24066 avss.n767 avss.n710 0.1445
R24067 avss.n7134 avss.n710 0.1445
R24068 avss.n745 avss.n744 0.1445
R24069 avss.n746 avss.n745 0.1445
R24070 avss.n746 avss.n740 0.1445
R24071 avss.n754 avss.n740 0.1445
R24072 avss.n755 avss.n754 0.1445
R24073 avss.n756 avss.n755 0.1445
R24074 avss.n756 avss.n738 0.1445
R24075 avss.n763 avss.n738 0.1445
R24076 avss.n764 avss.n763 0.1445
R24077 avss.n765 avss.n764 0.1445
R24078 avss.n766 avss.n765 0.1445
R24079 avss.n766 avss.n709 0.1445
R24080 avss.n7135 avss.n709 0.1445
R24081 avss.n7175 avss.n668 0.1445
R24082 avss.n7175 avss.n7174 0.1445
R24083 avss.n7174 avss.n7173 0.1445
R24084 avss.n7173 avss.n670 0.1445
R24085 avss.n730 avss.n670 0.1445
R24086 avss.n731 avss.n730 0.1445
R24087 avss.n732 avss.n731 0.1445
R24088 avss.n733 avss.n732 0.1445
R24089 avss.n734 avss.n733 0.1445
R24090 avss.n734 avss.n717 0.1445
R24091 avss.n7127 avss.n717 0.1445
R24092 avss.n7128 avss.n7127 0.1445
R24093 avss.n7129 avss.n7128 0.1445
R24094 avss.n3449 avss.n3447 0.1445
R24095 avss.n3450 avss.n3449 0.1445
R24096 avss.n3450 avss.n3443 0.1445
R24097 avss.n3454 avss.n3443 0.1445
R24098 avss.n3456 avss.n3454 0.1445
R24099 avss.n3459 avss.n3456 0.1445
R24100 avss.n3459 avss.n3440 0.1445
R24101 avss.n3463 avss.n3440 0.1445
R24102 avss.n3466 avss.n3463 0.1445
R24103 avss.n3468 avss.n3466 0.1445
R24104 avss.n3468 avss.n3438 0.1445
R24105 avss.n3473 avss.n3438 0.1445
R24106 avss.n3473 avss.n3472 0.1445
R24107 avss.n7189 avss.n649 0.1445
R24108 avss.n7184 avss.n649 0.1445
R24109 avss.n7184 avss.n7183 0.1445
R24110 avss.n7183 avss.n7182 0.1445
R24111 avss.n7156 avss.n683 0.1445
R24112 avss.n7160 avss.n683 0.1445
R24113 avss.n7162 avss.n7160 0.1445
R24114 avss.n7163 avss.n7162 0.1445
R24115 avss.n7158 avss.n7157 0.1445
R24116 avss.n7159 avss.n7158 0.1445
R24117 avss.n7159 avss.n682 0.1445
R24118 avss.n7164 avss.n682 0.1445
R24119 avss.n776 avss.n775 0.1445
R24120 avss.n7105 avss.n785 0.1445
R24121 avss.n794 avss.n781 0.1445
R24122 avss.n795 avss.n793 0.1445
R24123 avss.n7064 avss.n7063 0.1445
R24124 avss.n7085 avss.n818 0.1445
R24125 avss.n7069 avss.n7061 0.1445
R24126 avss.n7068 avss.n7067 0.1445
R24127 avss.n900 avss.n899 0.1445
R24128 avss.n899 avss.n898 0.1445
R24129 avss.n898 avss.n897 0.1445
R24130 avss.n897 avss.n895 0.1445
R24131 avss.n895 avss.n894 0.1445
R24132 avss.n894 avss.n847 0.1445
R24133 avss.n859 avss.n847 0.1445
R24134 avss.n883 avss.n859 0.1445
R24135 avss.n883 avss.n882 0.1445
R24136 avss.n882 avss.n881 0.1445
R24137 avss.n881 avss.n870 0.1445
R24138 avss.n870 avss.n869 0.1445
R24139 avss.n869 avss.n868 0.1445
R24140 avss.n905 avss.n804 0.1445
R24141 avss.n7096 avss.n804 0.1445
R24142 avss.n7096 avss.n7095 0.1445
R24143 avss.n7095 avss.n7094 0.1445
R24144 avss.n7094 avss.n808 0.1445
R24145 avss.n889 avss.n808 0.1445
R24146 avss.n889 avss.n888 0.1445
R24147 avss.n888 avss.n887 0.1445
R24148 avss.n887 avss.n855 0.1445
R24149 avss.n877 avss.n855 0.1445
R24150 avss.n877 avss.n826 0.1445
R24151 avss.n7080 avss.n826 0.1445
R24152 avss.n7080 avss.n7079 0.1445
R24153 avss.n904 avss.n903 0.1445
R24154 avss.n903 avss.n805 0.1445
R24155 avss.n806 avss.n805 0.1445
R24156 avss.n807 avss.n806 0.1445
R24157 avss.n851 avss.n807 0.1445
R24158 avss.n852 avss.n851 0.1445
R24159 avss.n853 avss.n852 0.1445
R24160 avss.n854 avss.n853 0.1445
R24161 avss.n874 avss.n854 0.1445
R24162 avss.n876 avss.n874 0.1445
R24163 avss.n876 avss.n875 0.1445
R24164 avss.n875 avss.n827 0.1445
R24165 avss.n7078 avss.n827 0.1445
R24166 avss.n901 avss.n841 0.1445
R24167 avss.n843 avss.n841 0.1445
R24168 avss.n844 avss.n843 0.1445
R24169 avss.n845 avss.n844 0.1445
R24170 avss.n846 avss.n845 0.1445
R24171 avss.n860 avss.n846 0.1445
R24172 avss.n861 avss.n860 0.1445
R24173 avss.n862 avss.n861 0.1445
R24174 avss.n863 avss.n862 0.1445
R24175 avss.n864 avss.n863 0.1445
R24176 avss.n865 avss.n864 0.1445
R24177 avss.n866 avss.n865 0.1445
R24178 avss.n867 avss.n866 0.1445
R24179 avss.n7086 avss.n817 0.1445
R24180 avss.n7089 avss.n815 0.1445
R24181 avss.n7088 avss.n792 0.1445
R24182 avss.n7065 avss.n7062 0.1445
R24183 avss.n7104 avss.n791 0.1445
R24184 avss.n788 avss.n787 0.1445
R24185 avss.n789 avss.n786 0.1445
R24186 avss.n777 avss.n681 0.1445
R24187 avss.n7190 avss.n648 0.1445
R24188 avss.n658 avss.n648 0.1445
R24189 avss.n659 avss.n658 0.1445
R24190 avss.n660 avss.n659 0.1445
R24191 avss.n3446 avss.n3444 0.1445
R24192 avss.n3451 avss.n3444 0.1445
R24193 avss.n3452 avss.n3451 0.1445
R24194 avss.n3453 avss.n3452 0.1445
R24195 avss.n3453 avss.n3441 0.1445
R24196 avss.n3460 avss.n3441 0.1445
R24197 avss.n3461 avss.n3460 0.1445
R24198 avss.n3462 avss.n3461 0.1445
R24199 avss.n3462 avss.n3439 0.1445
R24200 avss.n3469 avss.n3439 0.1445
R24201 avss.n3470 avss.n3469 0.1445
R24202 avss.n3471 avss.n3470 0.1445
R24203 avss.n3471 avss.n684 0.1445
R24204 avss.n606 avss.n605 0.1445
R24205 avss.n607 avss.n606 0.1445
R24206 avss.n630 avss.n607 0.1445
R24207 avss.n631 avss.n630 0.1445
R24208 avss.n632 avss.n631 0.1445
R24209 avss.n633 avss.n632 0.1445
R24210 avss.n638 avss.n633 0.1445
R24211 avss.n639 avss.n638 0.1445
R24212 avss.n640 avss.n639 0.1445
R24213 avss.n641 avss.n640 0.1445
R24214 avss.n645 avss.n641 0.1445
R24215 avss.n646 avss.n645 0.1445
R24216 avss.n7192 avss.n646 0.1445
R24217 avss.n7220 avss.n7219 0.1445
R24218 avss.n7219 avss.n7218 0.1445
R24219 avss.n7218 avss.n608 0.1445
R24220 avss.n7208 avss.n608 0.1445
R24221 avss.n7208 avss.n7207 0.1445
R24222 avss.n7207 avss.n7206 0.1445
R24223 avss.n7206 avss.n634 0.1445
R24224 avss.n7201 avss.n634 0.1445
R24225 avss.n7201 avss.n7200 0.1445
R24226 avss.n7200 avss.n7199 0.1445
R24227 avss.n7199 avss.n642 0.1445
R24228 avss.n7194 avss.n642 0.1445
R24229 avss.n7194 avss.n7193 0.1445
R24230 avss.n3535 avss.n3534 0.1445
R24231 avss.n3538 avss.n3535 0.1445
R24232 avss.n3538 avss.n3483 0.1445
R24233 avss.n3542 avss.n3483 0.1445
R24234 avss.n3543 avss.n3542 0.1445
R24235 avss.n3546 avss.n3543 0.1445
R24236 avss.n3546 avss.n3481 0.1445
R24237 avss.n3551 avss.n3481 0.1445
R24238 avss.n3551 avss.n691 0.1445
R24239 avss.n7149 avss.n691 0.1445
R24240 avss.n7149 avss.n7148 0.1445
R24241 avss.n7148 avss.n7147 0.1445
R24242 avss.n7147 avss.n695 0.1445
R24243 avss.n3527 avss.n3489 0.1445
R24244 avss.n3527 avss.n3493 0.1445
R24245 avss.n3523 avss.n3493 0.1445
R24246 avss.n3523 avss.n3522 0.1445
R24247 avss.n3522 avss.n3521 0.1445
R24248 avss.n3521 avss.n3500 0.1445
R24249 avss.n3517 avss.n3500 0.1445
R24250 avss.n3517 avss.n3516 0.1445
R24251 avss.n3516 avss.n3515 0.1445
R24252 avss.n3515 avss.n3511 0.1445
R24253 avss.n3511 avss.n3510 0.1445
R24254 avss.n3510 avss.n699 0.1445
R24255 avss.n7141 avss.n699 0.1445
R24256 avss.n3526 avss.n3488 0.1445
R24257 avss.n3526 avss.n3525 0.1445
R24258 avss.n3525 avss.n3524 0.1445
R24259 avss.n3524 avss.n3494 0.1445
R24260 avss.n3520 avss.n3494 0.1445
R24261 avss.n3520 avss.n3519 0.1445
R24262 avss.n3519 avss.n3518 0.1445
R24263 avss.n3518 avss.n3501 0.1445
R24264 avss.n3506 avss.n3501 0.1445
R24265 avss.n3507 avss.n3506 0.1445
R24266 avss.n3508 avss.n3507 0.1445
R24267 avss.n3508 avss.n700 0.1445
R24268 avss.n7140 avss.n700 0.1445
R24269 avss.n3533 avss.n3486 0.1445
R24270 avss.n3539 avss.n3486 0.1445
R24271 avss.n3540 avss.n3539 0.1445
R24272 avss.n3541 avss.n3540 0.1445
R24273 avss.n3541 avss.n3482 0.1445
R24274 avss.n3547 avss.n3482 0.1445
R24275 avss.n3548 avss.n3547 0.1445
R24276 avss.n3550 avss.n3548 0.1445
R24277 avss.n3550 avss.n3549 0.1445
R24278 avss.n3549 avss.n692 0.1445
R24279 avss.n693 avss.n692 0.1445
R24280 avss.n694 avss.n693 0.1445
R24281 avss.n701 avss.n694 0.1445
R24282 avss.n5341 avss.n5117 0.1445
R24283 avss.n5119 avss.n5117 0.1445
R24284 avss.n5173 avss.n5119 0.1445
R24285 avss.n5174 avss.n5173 0.1445
R24286 avss.n5175 avss.n5174 0.1445
R24287 avss.n5175 avss.n5171 0.1445
R24288 avss.n5181 avss.n5171 0.1445
R24289 avss.n5182 avss.n5181 0.1445
R24290 avss.n5183 avss.n5182 0.1445
R24291 avss.n5184 avss.n5183 0.1445
R24292 avss.n5185 avss.n5184 0.1445
R24293 avss.n5186 avss.n5185 0.1445
R24294 avss.n5187 avss.n5186 0.1445
R24295 avss.n5133 avss.n5132 0.1445
R24296 avss.n5134 avss.n5133 0.1445
R24297 avss.n5135 avss.n5134 0.1445
R24298 avss.n5136 avss.n5135 0.1445
R24299 avss.n5157 avss.n5136 0.1445
R24300 avss.n5158 avss.n5157 0.1445
R24301 avss.n5159 avss.n5158 0.1445
R24302 avss.n5160 avss.n5159 0.1445
R24303 avss.n5162 avss.n5160 0.1445
R24304 avss.n5162 avss.n5161 0.1445
R24305 avss.n5161 avss.n594 0.1445
R24306 avss.n595 avss.n594 0.1445
R24307 avss.n7226 avss.n595 0.1445
R24308 avss.n5131 avss.n5130 0.1445
R24309 avss.n5334 avss.n5130 0.1445
R24310 avss.n5334 avss.n5333 0.1445
R24311 avss.n5333 avss.n5332 0.1445
R24312 avss.n5332 avss.n5137 0.1445
R24313 avss.n5322 avss.n5137 0.1445
R24314 avss.n5322 avss.n5321 0.1445
R24315 avss.n5321 avss.n5320 0.1445
R24316 avss.n5320 avss.n5163 0.1445
R24317 avss.n5163 avss.n593 0.1445
R24318 avss.n7229 avss.n593 0.1445
R24319 avss.n7229 avss.n7228 0.1445
R24320 avss.n7228 avss.n7227 0.1445
R24321 avss.n5216 avss.n5200 0.1445
R24322 avss.n5217 avss.n5216 0.1445
R24323 avss.n5219 avss.n5217 0.1445
R24324 avss.n5219 avss.n5198 0.1445
R24325 avss.n5224 avss.n5198 0.1445
R24326 avss.n5225 avss.n5224 0.1445
R24327 avss.n5227 avss.n5225 0.1445
R24328 avss.n5227 avss.n5196 0.1445
R24329 avss.n5235 avss.n5196 0.1445
R24330 avss.n5235 avss.n5234 0.1445
R24331 avss.n5234 avss.n5233 0.1445
R24332 avss.n5233 avss.n569 0.1445
R24333 avss.n7244 avss.n569 0.1445
R24334 avss.n3982 avss.n3981 0.1445
R24335 avss.n3981 avss.n3978 0.1445
R24336 avss.n3978 avss.n3933 0.1445
R24337 avss.n4219 avss.n3933 0.1445
R24338 avss.n4219 avss.n3931 0.1445
R24339 avss.n4223 avss.n3931 0.1445
R24340 avss.n4223 avss.n3920 0.1445
R24341 avss.n4246 avss.n3920 0.1445
R24342 avss.n4246 avss.n3918 0.1445
R24343 avss.n4251 avss.n3918 0.1445
R24344 avss.n4251 avss.n3841 0.1445
R24345 avss.n4370 avss.n3841 0.1445
R24346 avss.n4370 avss.n4369 0.1445
R24347 avss.n3965 avss.n3963 0.1445
R24348 avss.n3973 avss.n3963 0.1445
R24349 avss.n3973 avss.n3972 0.1445
R24350 avss.n3972 avss.n3971 0.1445
R24351 avss.n3971 avss.n3927 0.1445
R24352 avss.n4227 avss.n3927 0.1445
R24353 avss.n4227 avss.n3925 0.1445
R24354 avss.n4242 avss.n3925 0.1445
R24355 avss.n4242 avss.n4241 0.1445
R24356 avss.n4241 avss.n4240 0.1445
R24357 avss.n4240 avss.n4239 0.1445
R24358 avss.n4239 avss.n4237 0.1445
R24359 avss.n4237 avss.n4236 0.1445
R24360 avss.n3967 avss.n3966 0.1445
R24361 avss.n3968 avss.n3967 0.1445
R24362 avss.n3969 avss.n3968 0.1445
R24363 avss.n3970 avss.n3969 0.1445
R24364 avss.n3970 avss.n3926 0.1445
R24365 avss.n4228 avss.n3926 0.1445
R24366 avss.n4229 avss.n4228 0.1445
R24367 avss.n4230 avss.n4229 0.1445
R24368 avss.n4231 avss.n4230 0.1445
R24369 avss.n4232 avss.n4231 0.1445
R24370 avss.n4233 avss.n4232 0.1445
R24371 avss.n4234 avss.n4233 0.1445
R24372 avss.n4235 avss.n4234 0.1445
R24373 avss.n3980 avss.n3959 0.1445
R24374 avss.n3980 avss.n3979 0.1445
R24375 avss.n3979 avss.n3932 0.1445
R24376 avss.n4220 avss.n3932 0.1445
R24377 avss.n4221 avss.n4220 0.1445
R24378 avss.n4222 avss.n4221 0.1445
R24379 avss.n4222 avss.n3919 0.1445
R24380 avss.n4247 avss.n3919 0.1445
R24381 avss.n4248 avss.n4247 0.1445
R24382 avss.n4250 avss.n4248 0.1445
R24383 avss.n4250 avss.n4249 0.1445
R24384 avss.n4249 avss.n3842 0.1445
R24385 avss.n4368 avss.n3842 0.1445
R24386 avss.n4090 avss.n4088 0.1445
R24387 avss.n4091 avss.n4090 0.1445
R24388 avss.n4091 avss.n4080 0.1445
R24389 avss.n4095 avss.n4080 0.1445
R24390 avss.n4097 avss.n4095 0.1445
R24391 avss.n4100 avss.n4097 0.1445
R24392 avss.n4100 avss.n4077 0.1445
R24393 avss.n4104 avss.n4077 0.1445
R24394 avss.n4107 avss.n4104 0.1445
R24395 avss.n4109 avss.n4107 0.1445
R24396 avss.n4109 avss.n4075 0.1445
R24397 avss.n4115 avss.n4075 0.1445
R24398 avss.n4115 avss.n4114 0.1445
R24399 avss.n4192 avss.n3988 0.1445
R24400 avss.n4203 avss.n3988 0.1445
R24401 avss.n4203 avss.n3986 0.1445
R24402 avss.n4207 avss.n3986 0.1445
R24403 avss.n4196 avss.n3993 0.1445
R24404 avss.n4200 avss.n3993 0.1445
R24405 avss.n4200 avss.n3952 0.1445
R24406 avss.n4211 avss.n3952 0.1445
R24407 avss.n4198 avss.n4197 0.1445
R24408 avss.n4199 avss.n4198 0.1445
R24409 avss.n4199 avss.n3951 0.1445
R24410 avss.n4212 avss.n3951 0.1445
R24411 avss.n3949 avss.n3948 0.1445
R24412 avss.n4362 avss.n4361 0.1445
R24413 avss.n4260 avss.n3908 0.1445
R24414 avss.n4259 avss.n4258 0.1445
R24415 avss.n4321 avss.n4320 0.1445
R24416 avss.n4341 avss.n3875 0.1445
R24417 avss.n4326 avss.n4318 0.1445
R24418 avss.n4325 avss.n4324 0.1445
R24419 avss.n4275 avss.n3905 0.1445
R24420 avss.n4276 avss.n4275 0.1445
R24421 avss.n4276 avss.n3903 0.1445
R24422 avss.n4280 avss.n3903 0.1445
R24423 avss.n4281 avss.n4280 0.1445
R24424 avss.n4290 avss.n4281 0.1445
R24425 avss.n4290 avss.n3900 0.1445
R24426 avss.n4296 avss.n3900 0.1445
R24427 avss.n4296 avss.n4295 0.1445
R24428 avss.n4295 avss.n3889 0.1445
R24429 avss.n4311 avss.n3889 0.1445
R24430 avss.n4311 avss.n3887 0.1445
R24431 avss.n4315 avss.n3887 0.1445
R24432 avss.n4270 avss.n3861 0.1445
R24433 avss.n4352 avss.n3861 0.1445
R24434 avss.n4352 avss.n4351 0.1445
R24435 avss.n4351 avss.n4350 0.1445
R24436 avss.n4350 avss.n3865 0.1445
R24437 avss.n4286 avss.n3865 0.1445
R24438 avss.n4286 avss.n3896 0.1445
R24439 avss.n4301 avss.n3896 0.1445
R24440 avss.n4301 avss.n3894 0.1445
R24441 avss.n4306 avss.n3894 0.1445
R24442 avss.n4306 avss.n3883 0.1445
R24443 avss.n4336 avss.n3883 0.1445
R24444 avss.n4336 avss.n4335 0.1445
R24445 avss.n4269 avss.n4268 0.1445
R24446 avss.n4268 avss.n3862 0.1445
R24447 avss.n3863 avss.n3862 0.1445
R24448 avss.n3864 avss.n3863 0.1445
R24449 avss.n4284 avss.n3864 0.1445
R24450 avss.n4285 avss.n4284 0.1445
R24451 avss.n4285 avss.n3895 0.1445
R24452 avss.n4302 avss.n3895 0.1445
R24453 avss.n4303 avss.n4302 0.1445
R24454 avss.n4305 avss.n4303 0.1445
R24455 avss.n4305 avss.n4304 0.1445
R24456 avss.n4304 avss.n3884 0.1445
R24457 avss.n4334 avss.n3884 0.1445
R24458 avss.n4266 avss.n3904 0.1445
R24459 avss.n4277 avss.n3904 0.1445
R24460 avss.n4278 avss.n4277 0.1445
R24461 avss.n4279 avss.n4278 0.1445
R24462 avss.n4279 avss.n3901 0.1445
R24463 avss.n4291 avss.n3901 0.1445
R24464 avss.n4292 avss.n4291 0.1445
R24465 avss.n4293 avss.n4292 0.1445
R24466 avss.n4294 avss.n4293 0.1445
R24467 avss.n4294 avss.n3888 0.1445
R24468 avss.n4312 avss.n3888 0.1445
R24469 avss.n4313 avss.n4312 0.1445
R24470 avss.n4314 avss.n4313 0.1445
R24471 avss.n4342 avss.n3874 0.1445
R24472 avss.n4345 avss.n3872 0.1445
R24473 avss.n4344 avss.n3851 0.1445
R24474 avss.n4322 avss.n4319 0.1445
R24475 avss.n4360 avss.n3850 0.1445
R24476 avss.n3944 avss.n3943 0.1445
R24477 avss.n3945 avss.n3942 0.1445
R24478 avss.n3950 avss.n3909 0.1445
R24479 avss.n4191 avss.n3987 0.1445
R24480 avss.n4204 avss.n3987 0.1445
R24481 avss.n4205 avss.n4204 0.1445
R24482 avss.n4206 avss.n4205 0.1445
R24483 avss.n4087 avss.n4081 0.1445
R24484 avss.n4092 avss.n4081 0.1445
R24485 avss.n4093 avss.n4092 0.1445
R24486 avss.n4094 avss.n4093 0.1445
R24487 avss.n4094 avss.n4078 0.1445
R24488 avss.n4101 avss.n4078 0.1445
R24489 avss.n4102 avss.n4101 0.1445
R24490 avss.n4103 avss.n4102 0.1445
R24491 avss.n4103 avss.n4076 0.1445
R24492 avss.n4110 avss.n4076 0.1445
R24493 avss.n4111 avss.n4110 0.1445
R24494 avss.n4112 avss.n4111 0.1445
R24495 avss.n4113 avss.n4112 0.1445
R24496 avss.n4084 avss.n4082 0.1445
R24497 avss.n4082 avss.n618 0.1445
R24498 avss.n619 avss.n618 0.1445
R24499 avss.n620 avss.n619 0.1445
R24500 avss.n4007 avss.n620 0.1445
R24501 avss.n4010 avss.n4007 0.1445
R24502 avss.n4011 avss.n4010 0.1445
R24503 avss.n4012 avss.n4011 0.1445
R24504 avss.n4012 avss.n4000 0.1445
R24505 avss.n4021 avss.n4000 0.1445
R24506 avss.n4022 avss.n4021 0.1445
R24507 avss.n4023 avss.n4022 0.1445
R24508 avss.n4023 avss.n3997 0.1445
R24509 avss.n4083 avss.n617 0.1445
R24510 avss.n7214 avss.n617 0.1445
R24511 avss.n7214 avss.n7213 0.1445
R24512 avss.n7213 avss.n7212 0.1445
R24513 avss.n7212 avss.n621 0.1445
R24514 avss.n4009 avss.n621 0.1445
R24515 avss.n4009 avss.n4006 0.1445
R24516 avss.n4013 avss.n4006 0.1445
R24517 avss.n4013 avss.n4001 0.1445
R24518 avss.n4020 avss.n4001 0.1445
R24519 avss.n4020 avss.n3999 0.1445
R24520 avss.n4024 avss.n3999 0.1445
R24521 avss.n4025 avss.n4024 0.1445
R24522 avss.n4137 avss.n4059 0.1445
R24523 avss.n4133 avss.n4059 0.1445
R24524 avss.n4133 avss.n4132 0.1445
R24525 avss.n4132 avss.n4131 0.1445
R24526 avss.n4131 avss.n4065 0.1445
R24527 avss.n4127 avss.n4065 0.1445
R24528 avss.n4127 avss.n4126 0.1445
R24529 avss.n4126 avss.n4125 0.1445
R24530 avss.n4125 avss.n4033 0.1445
R24531 avss.n4183 avss.n4033 0.1445
R24532 avss.n4183 avss.n4182 0.1445
R24533 avss.n4182 avss.n4181 0.1445
R24534 avss.n4181 avss.n4037 0.1445
R24535 avss.n4141 avss.n4054 0.1445
R24536 avss.n4145 avss.n4054 0.1445
R24537 avss.n4146 avss.n4145 0.1445
R24538 avss.n4149 avss.n4146 0.1445
R24539 avss.n4149 avss.n4051 0.1445
R24540 avss.n4155 avss.n4051 0.1445
R24541 avss.n4155 avss.n4052 0.1445
R24542 avss.n4052 avss.n4043 0.1445
R24543 avss.n4163 avss.n4043 0.1445
R24544 avss.n4164 avss.n4163 0.1445
R24545 avss.n4166 avss.n4164 0.1445
R24546 avss.n4166 avss.n4041 0.1445
R24547 avss.n4175 avss.n4041 0.1445
R24548 avss.n4143 avss.n4142 0.1445
R24549 avss.n4144 avss.n4143 0.1445
R24550 avss.n4144 avss.n4053 0.1445
R24551 avss.n4150 avss.n4053 0.1445
R24552 avss.n4151 avss.n4150 0.1445
R24553 avss.n4154 avss.n4151 0.1445
R24554 avss.n4154 avss.n4153 0.1445
R24555 avss.n4153 avss.n4152 0.1445
R24556 avss.n4152 avss.n4044 0.1445
R24557 avss.n4044 avss.n4042 0.1445
R24558 avss.n4167 avss.n4042 0.1445
R24559 avss.n4168 avss.n4167 0.1445
R24560 avss.n4174 avss.n4168 0.1445
R24561 avss.n4136 avss.n4135 0.1445
R24562 avss.n4135 avss.n4134 0.1445
R24563 avss.n4134 avss.n4060 0.1445
R24564 avss.n4130 avss.n4060 0.1445
R24565 avss.n4130 avss.n4129 0.1445
R24566 avss.n4129 avss.n4128 0.1445
R24567 avss.n4128 avss.n4066 0.1445
R24568 avss.n4070 avss.n4066 0.1445
R24569 avss.n4070 avss.n4069 0.1445
R24570 avss.n4069 avss.n4034 0.1445
R24571 avss.n4035 avss.n4034 0.1445
R24572 avss.n4036 avss.n4035 0.1445
R24573 avss.n4169 avss.n4036 0.1445
R24574 avss.n5215 avss.n5214 0.1445
R24575 avss.n5215 avss.n5199 0.1445
R24576 avss.n5220 avss.n5199 0.1445
R24577 avss.n5221 avss.n5220 0.1445
R24578 avss.n5222 avss.n5221 0.1445
R24579 avss.n5222 avss.n5197 0.1445
R24580 avss.n5228 avss.n5197 0.1445
R24581 avss.n5229 avss.n5228 0.1445
R24582 avss.n5230 avss.n5229 0.1445
R24583 avss.n5231 avss.n5230 0.1445
R24584 avss.n5232 avss.n5231 0.1445
R24585 avss.n5232 avss.n568 0.1445
R24586 avss.n7245 avss.n568 0.1445
R24587 avss.n5211 avss.n5203 0.1445
R24588 avss.n5205 avss.n5203 0.1445
R24589 avss.n5205 avss.n5204 0.1445
R24590 avss.n5204 avss.n5147 0.1445
R24591 avss.n5148 avss.n5147 0.1445
R24592 avss.n5149 avss.n5148 0.1445
R24593 avss.n5302 avss.n5149 0.1445
R24594 avss.n5303 avss.n5302 0.1445
R24595 avss.n5304 avss.n5303 0.1445
R24596 avss.n5305 avss.n5304 0.1445
R24597 avss.n5306 avss.n5305 0.1445
R24598 avss.n5307 avss.n5306 0.1445
R24599 avss.n5308 avss.n5307 0.1445
R24600 avss.n5210 avss.n5207 0.1445
R24601 avss.n5207 avss.n5206 0.1445
R24602 avss.n5206 avss.n5146 0.1445
R24603 avss.n5328 avss.n5146 0.1445
R24604 avss.n5328 avss.n5327 0.1445
R24605 avss.n5327 avss.n5326 0.1445
R24606 avss.n5326 avss.n5150 0.1445
R24607 avss.n5316 avss.n5150 0.1445
R24608 avss.n5316 avss.n5315 0.1445
R24609 avss.n5315 avss.n5314 0.1445
R24610 avss.n5314 avss.n5312 0.1445
R24611 avss.n5312 avss.n5311 0.1445
R24612 avss.n5311 avss.n5309 0.1445
R24613 avss.n3615 avss.n3614 0.1445
R24614 avss.n3614 avss.n3613 0.1445
R24615 avss.n3613 avss.n3612 0.1445
R24616 avss.n3612 avss.n3610 0.1445
R24617 avss.n3610 avss.n3609 0.1445
R24618 avss.n3609 avss.n3607 0.1445
R24619 avss.n3607 avss.n3604 0.1445
R24620 avss.n3604 avss.n3603 0.1445
R24621 avss.n3603 avss.n3600 0.1445
R24622 avss.n3600 avss.n3599 0.1445
R24623 avss.n3599 avss.n3560 0.1445
R24624 avss.n4530 avss.n3560 0.1445
R24625 avss.n4530 avss.n4529 0.1445
R24626 avss.n4520 avss.n3571 0.1445
R24627 avss.n4520 avss.n3572 0.1445
R24628 avss.n4516 avss.n3572 0.1445
R24629 avss.n4516 avss.n3653 0.1445
R24630 avss.n4486 avss.n3568 0.1445
R24631 avss.n4490 avss.n4486 0.1445
R24632 avss.n4491 avss.n4490 0.1445
R24633 avss.n4493 avss.n4491 0.1445
R24634 avss.n4487 avss.n3562 0.1445
R24635 avss.n4488 avss.n4487 0.1445
R24636 avss.n4488 avss.n4485 0.1445
R24637 avss.n4494 avss.n4485 0.1445
R24638 avss.n4483 avss.n4482 0.1445
R24639 avss.n4474 avss.n3694 0.1445
R24640 avss.n3706 avss.n3705 0.1445
R24641 avss.n3707 avss.n3704 0.1445
R24642 avss.n4432 avss.n4431 0.1445
R24643 avss.n4452 avss.n3732 0.1445
R24644 avss.n4437 avss.n4429 0.1445
R24645 avss.n4436 avss.n4435 0.1445
R24646 avss.n4386 avss.n3762 0.1445
R24647 avss.n4387 avss.n4386 0.1445
R24648 avss.n4387 avss.n3760 0.1445
R24649 avss.n4391 avss.n3760 0.1445
R24650 avss.n4392 avss.n4391 0.1445
R24651 avss.n4401 avss.n4392 0.1445
R24652 avss.n4401 avss.n3757 0.1445
R24653 avss.n4407 avss.n3757 0.1445
R24654 avss.n4407 avss.n4406 0.1445
R24655 avss.n4406 avss.n3746 0.1445
R24656 avss.n4422 avss.n3746 0.1445
R24657 avss.n4422 avss.n3744 0.1445
R24658 avss.n4426 avss.n3744 0.1445
R24659 avss.n4381 avss.n3716 0.1445
R24660 avss.n4463 avss.n3716 0.1445
R24661 avss.n4463 avss.n4462 0.1445
R24662 avss.n4462 avss.n4461 0.1445
R24663 avss.n4461 avss.n3720 0.1445
R24664 avss.n4397 avss.n3720 0.1445
R24665 avss.n4397 avss.n3753 0.1445
R24666 avss.n4412 avss.n3753 0.1445
R24667 avss.n4412 avss.n3751 0.1445
R24668 avss.n4417 avss.n3751 0.1445
R24669 avss.n4417 avss.n3740 0.1445
R24670 avss.n4447 avss.n3740 0.1445
R24671 avss.n4447 avss.n4446 0.1445
R24672 avss.n4380 avss.n4379 0.1445
R24673 avss.n4379 avss.n3717 0.1445
R24674 avss.n3718 avss.n3717 0.1445
R24675 avss.n3719 avss.n3718 0.1445
R24676 avss.n4395 avss.n3719 0.1445
R24677 avss.n4396 avss.n4395 0.1445
R24678 avss.n4396 avss.n3752 0.1445
R24679 avss.n4413 avss.n3752 0.1445
R24680 avss.n4414 avss.n4413 0.1445
R24681 avss.n4416 avss.n4414 0.1445
R24682 avss.n4416 avss.n4415 0.1445
R24683 avss.n4415 avss.n3741 0.1445
R24684 avss.n4445 avss.n3741 0.1445
R24685 avss.n4377 avss.n3761 0.1445
R24686 avss.n4388 avss.n3761 0.1445
R24687 avss.n4389 avss.n4388 0.1445
R24688 avss.n4390 avss.n4389 0.1445
R24689 avss.n4390 avss.n3758 0.1445
R24690 avss.n4402 avss.n3758 0.1445
R24691 avss.n4403 avss.n4402 0.1445
R24692 avss.n4404 avss.n4403 0.1445
R24693 avss.n4405 avss.n4404 0.1445
R24694 avss.n4405 avss.n3745 0.1445
R24695 avss.n4423 avss.n3745 0.1445
R24696 avss.n4424 avss.n4423 0.1445
R24697 avss.n4425 avss.n4424 0.1445
R24698 avss.n4453 avss.n3731 0.1445
R24699 avss.n4456 avss.n3727 0.1445
R24700 avss.n4455 avss.n3729 0.1445
R24701 avss.n4433 avss.n4430 0.1445
R24702 avss.n4475 avss.n3693 0.1445
R24703 avss.n4478 avss.n3690 0.1445
R24704 avss.n4477 avss.n3691 0.1445
R24705 avss.n4484 avss.n3687 0.1445
R24706 avss.n4519 avss.n3651 0.1445
R24707 avss.n4519 avss.n4518 0.1445
R24708 avss.n4518 avss.n4517 0.1445
R24709 avss.n4517 avss.n3652 0.1445
R24710 avss.n3616 avss.n3586 0.1445
R24711 avss.n3588 avss.n3586 0.1445
R24712 avss.n3589 avss.n3588 0.1445
R24713 avss.n3590 avss.n3589 0.1445
R24714 avss.n3591 avss.n3590 0.1445
R24715 avss.n3592 avss.n3591 0.1445
R24716 avss.n3593 avss.n3592 0.1445
R24717 avss.n3594 avss.n3593 0.1445
R24718 avss.n3595 avss.n3594 0.1445
R24719 avss.n3597 avss.n3595 0.1445
R24720 avss.n3597 avss.n3596 0.1445
R24721 avss.n3596 avss.n3561 0.1445
R24722 avss.n4528 avss.n3561 0.1445
R24723 avss.n3621 avss.n3620 0.1445
R24724 avss.n3622 avss.n3621 0.1445
R24725 avss.n3622 avss.n3583 0.1445
R24726 avss.n3627 avss.n3583 0.1445
R24727 avss.n3628 avss.n3627 0.1445
R24728 avss.n3629 avss.n3628 0.1445
R24729 avss.n3629 avss.n3580 0.1445
R24730 avss.n3636 avss.n3580 0.1445
R24731 avss.n3637 avss.n3636 0.1445
R24732 avss.n3638 avss.n3637 0.1445
R24733 avss.n3639 avss.n3638 0.1445
R24734 avss.n3639 avss.n3573 0.1445
R24735 avss.n3649 avss.n3573 0.1445
R24736 avss.n3619 avss.n3585 0.1445
R24737 avss.n3623 avss.n3585 0.1445
R24738 avss.n3625 avss.n3623 0.1445
R24739 avss.n3626 avss.n3625 0.1445
R24740 avss.n3626 avss.n3582 0.1445
R24741 avss.n3630 avss.n3582 0.1445
R24742 avss.n3633 avss.n3630 0.1445
R24743 avss.n3635 avss.n3633 0.1445
R24744 avss.n3635 avss.n3579 0.1445
R24745 avss.n3641 avss.n3579 0.1445
R24746 avss.n3641 avss.n3640 0.1445
R24747 avss.n3640 avss.n3574 0.1445
R24748 avss.n3648 avss.n3574 0.1445
R24749 avss.n5281 avss.n5278 0.1445
R24750 avss.n5282 avss.n5281 0.1445
R24751 avss.n5282 avss.n5244 0.1445
R24752 avss.n5286 avss.n5244 0.1445
R24753 avss.n5288 avss.n5286 0.1445
R24754 avss.n5289 avss.n5288 0.1445
R24755 avss.n5289 avss.n5240 0.1445
R24756 avss.n5299 avss.n5240 0.1445
R24757 avss.n5299 avss.n5241 0.1445
R24758 avss.n5295 avss.n5241 0.1445
R24759 avss.n5295 avss.n5294 0.1445
R24760 avss.n5294 avss.n580 0.1445
R24761 avss.n7240 avss.n580 0.1445
R24762 avss.n5273 avss.n5272 0.1445
R24763 avss.n5272 avss.n5271 0.1445
R24764 avss.n5271 avss.n5250 0.1445
R24765 avss.n5267 avss.n5250 0.1445
R24766 avss.n5267 avss.n5266 0.1445
R24767 avss.n5266 avss.n5265 0.1445
R24768 avss.n5265 avss.n5254 0.1445
R24769 avss.n5261 avss.n5254 0.1445
R24770 avss.n5261 avss.n5260 0.1445
R24771 avss.n5260 avss.n5259 0.1445
R24772 avss.n5259 avss.n584 0.1445
R24773 avss.n7234 avss.n584 0.1445
R24774 avss.n7235 avss.n7234 0.1445
R24775 avss.n5274 avss.n5246 0.1445
R24776 avss.n5270 avss.n5246 0.1445
R24777 avss.n5270 avss.n5269 0.1445
R24778 avss.n5269 avss.n5268 0.1445
R24779 avss.n5268 avss.n5251 0.1445
R24780 avss.n5264 avss.n5251 0.1445
R24781 avss.n5264 avss.n5263 0.1445
R24782 avss.n5263 avss.n5262 0.1445
R24783 avss.n5262 avss.n5255 0.1445
R24784 avss.n5258 avss.n5255 0.1445
R24785 avss.n5258 avss.n5257 0.1445
R24786 avss.n5257 avss.n583 0.1445
R24787 avss.n7236 avss.n583 0.1445
R24788 avss.n5277 avss.n5245 0.1445
R24789 avss.n5283 avss.n5245 0.1445
R24790 avss.n5284 avss.n5283 0.1445
R24791 avss.n5285 avss.n5284 0.1445
R24792 avss.n5285 avss.n5242 0.1445
R24793 avss.n5290 avss.n5242 0.1445
R24794 avss.n5291 avss.n5290 0.1445
R24795 avss.n5298 avss.n5291 0.1445
R24796 avss.n5298 avss.n5297 0.1445
R24797 avss.n5297 avss.n5296 0.1445
R24798 avss.n5296 avss.n5292 0.1445
R24799 avss.n5292 avss.n581 0.1445
R24800 avss.n7239 avss.n581 0.1445
R24801 avss.n4568 avss.n4539 0.1445
R24802 avss.n4547 avss.n4539 0.1445
R24803 avss.n4548 avss.n4547 0.1445
R24804 avss.n4549 avss.n4548 0.1445
R24805 avss.n4550 avss.n4549 0.1445
R24806 avss.n4551 avss.n4550 0.1445
R24807 avss.n4552 avss.n4551 0.1445
R24808 avss.n4552 avss.n3424 0.1445
R24809 avss.n4599 avss.n3424 0.1445
R24810 avss.n4600 avss.n4599 0.1445
R24811 avss.n4601 avss.n4600 0.1445
R24812 avss.n4601 avss.n3410 0.1445
R24813 avss.n4615 avss.n3410 0.1445
R24814 avss.n4571 avss.n4570 0.1445
R24815 avss.n4572 avss.n4571 0.1445
R24816 avss.n4573 avss.n4572 0.1445
R24817 avss.n4574 avss.n4573 0.1445
R24818 avss.n4575 avss.n4574 0.1445
R24819 avss.n4575 avss.n3431 0.1445
R24820 avss.n4591 avss.n3431 0.1445
R24821 avss.n4592 avss.n4591 0.1445
R24822 avss.n4593 avss.n4592 0.1445
R24823 avss.n4593 avss.n3418 0.1445
R24824 avss.n4607 avss.n3418 0.1445
R24825 avss.n4608 avss.n4607 0.1445
R24826 avss.n4609 avss.n4608 0.1445
R24827 avss.n4585 avss.n4584 0.1445
R24828 avss.n4584 avss.n4583 0.1445
R24829 avss.n4583 avss.n4580 0.1445
R24830 avss.n4580 avss.n4579 0.1445
R24831 avss.n4579 avss.n4576 0.1445
R24832 avss.n4576 avss.n3432 0.1445
R24833 avss.n4590 avss.n3432 0.1445
R24834 avss.n4590 avss.n3430 0.1445
R24835 avss.n4594 avss.n3430 0.1445
R24836 avss.n4594 avss.n3419 0.1445
R24837 avss.n4606 avss.n3419 0.1445
R24838 avss.n4606 avss.n3417 0.1445
R24839 avss.n4610 avss.n3417 0.1445
R24840 avss.n1953 avss.n1818 0.1445
R24841 avss.n1953 avss.n1816 0.1445
R24842 avss.n1957 avss.n1816 0.1445
R24843 avss.n1957 avss.n1796 0.1445
R24844 avss.n1974 avss.n1796 0.1445
R24845 avss.n1974 avss.n1794 0.1445
R24846 avss.n1978 avss.n1794 0.1445
R24847 avss.n1978 avss.n1769 0.1445
R24848 avss.n3298 avss.n1769 0.1445
R24849 avss.n3298 avss.n1767 0.1445
R24850 avss.n3302 avss.n1767 0.1445
R24851 avss.n3302 avss.n1756 0.1445
R24852 avss.n3313 avss.n1756 0.1445
R24853 avss.n1851 avss.n1823 0.1445
R24854 avss.n1851 avss.n1824 0.1445
R24855 avss.n1847 avss.n1824 0.1445
R24856 avss.n1847 avss.n1846 0.1445
R24857 avss.n1846 avss.n1845 0.1445
R24858 avss.n1845 avss.n1832 0.1445
R24859 avss.n1841 avss.n1832 0.1445
R24860 avss.n1841 avss.n1840 0.1445
R24861 avss.n1840 avss.n1839 0.1445
R24862 avss.n1839 avss.n1835 0.1445
R24863 avss.n1835 avss.n1759 0.1445
R24864 avss.n3307 avss.n1759 0.1445
R24865 avss.n3308 avss.n3307 0.1445
R24866 avss.n1850 avss.n1828 0.1445
R24867 avss.n1850 avss.n1849 0.1445
R24868 avss.n1849 avss.n1848 0.1445
R24869 avss.n1848 avss.n1829 0.1445
R24870 avss.n1844 avss.n1829 0.1445
R24871 avss.n1844 avss.n1843 0.1445
R24872 avss.n1843 avss.n1842 0.1445
R24873 avss.n1842 avss.n1833 0.1445
R24874 avss.n1838 avss.n1833 0.1445
R24875 avss.n1838 avss.n1837 0.1445
R24876 avss.n1837 avss.n1836 0.1445
R24877 avss.n1836 avss.n1758 0.1445
R24878 avss.n3309 avss.n1758 0.1445
R24879 avss.n1954 avss.n1817 0.1445
R24880 avss.n1955 avss.n1954 0.1445
R24881 avss.n1956 avss.n1955 0.1445
R24882 avss.n1956 avss.n1795 0.1445
R24883 avss.n1975 avss.n1795 0.1445
R24884 avss.n1976 avss.n1975 0.1445
R24885 avss.n1977 avss.n1976 0.1445
R24886 avss.n1977 avss.n1768 0.1445
R24887 avss.n3299 avss.n1768 0.1445
R24888 avss.n3300 avss.n3299 0.1445
R24889 avss.n3301 avss.n3300 0.1445
R24890 avss.n3301 avss.n1757 0.1445
R24891 avss.n3312 avss.n1757 0.1445
R24892 avss.n5348 avss.n5347 0.1445
R24893 avss.n5347 avss.n4682 0.1445
R24894 avss.n6221 avss.n4682 0.1445
R24895 avss.n6221 avss.n4680 0.1445
R24896 avss.n6225 avss.n4680 0.1445
R24897 avss.n6225 avss.n4668 0.1445
R24898 avss.n6237 avss.n4668 0.1445
R24899 avss.n5349 avss.n5346 0.1445
R24900 avss.n5346 avss.n4681 0.1445
R24901 avss.n6222 avss.n4681 0.1445
R24902 avss.n6223 avss.n6222 0.1445
R24903 avss.n6224 avss.n6223 0.1445
R24904 avss.n6224 avss.n4667 0.1445
R24905 avss.n6238 avss.n4667 0.1445
R24906 avss.n6214 avss.n4687 0.1445
R24907 avss.n6215 avss.n6214 0.1445
R24908 avss.n6216 avss.n6215 0.1445
R24909 avss.n6216 avss.n4675 0.1445
R24910 avss.n6230 avss.n4675 0.1445
R24911 avss.n6231 avss.n6230 0.1445
R24912 avss.n6232 avss.n6231 0.1445
R24913 avss.n9219 avss.n128 0.1445
R24914 avss.n9218 avss.n129 0.1445
R24915 avss.n1588 avss.n1242 0.122783
R24916 avss.n6687 avss.n6686 0.122783
R24917 avss.n1644 avss.n1245 0.122783
R24918 avss.n6111 avss.n6110 0.122783
R24919 avss.n5857 avss.n5726 0.122783
R24920 avss.n6089 avss.n6088 0.122783
R24921 avss.n5355 avss.n5109 0.122783
R24922 avss.n8006 avss.n8001 0.122783
R24923 avss.n9397 avss.n9396 0.122783
R24924 avss.n9243 avss.n9241 0.122783
R24925 avss.n9308 avss.n71 0.122783
R24926 avss.n9181 avss.n146 0.122783
R24927 avss.n9138 avss.n9137 0.122783
R24928 avss.n9160 avss.n181 0.122783
R24929 avss.n8624 avss.n7863 0.122783
R24930 avss.n8600 avss.n7889 0.122783
R24931 avss.n7921 avss.n7886 0.122783
R24932 avss.n8751 avss.n8750 0.122783
R24933 avss.n8724 avss.n7799 0.122783
R24934 avss.n7831 avss.n7796 0.122783
R24935 avss.n7056 avss.n919 0.122783
R24936 avss.n1891 avss.n1890 0.122783
R24937 avss.n1946 avss.n1945 0.122783
R24938 avss.n5342 avss.n5116 0.122783
R24939 avss.n5213 avss.n5212 0.122783
R24940 avss.n5276 avss.n5275 0.122783
R24941 avss.n1827 avss.n1825 0.122783
R24942 avss.n9217 avss.n9216 0.122783
R24943 avss.n4631 avss.n558 0.1148
R24944 avss.n6402 avss.n3323 0.1148
R24945 avss.n6398 avss.n6322 0.1148
R24946 avss.n7250 avss.n565 0.1148
R24947 avss.n4621 avss.n3407 0.1148
R24948 avss.n6245 avss.n3340 0.1148
R24949 avss.n4665 avss.n4664 0.0995
R24950 avss.n6251 avss.n6250 0.0995
R24951 avss.n6673 avss.n6672 0.0933481
R24952 avss.n6671 avss.n1221 0.0933481
R24953 avss.n6670 avss.n1651 0.0933481
R24954 avss.n5818 avss.n5706 0.0933481
R24955 avss.n6097 avss.n6096 0.0933481
R24956 avss.n6095 avss.n5819 0.0933481
R24957 avss.n9250 avss.n70 0.0933481
R24958 avss.n9316 avss.n9315 0.0933481
R24959 avss.n9136 avss.n9135 0.0933481
R24960 avss.n9167 avss.n145 0.0933481
R24961 avss.n9197 avss.n9196 0.0933481
R24962 avss.n8608 avss.n8607 0.0933481
R24963 avss.n8610 avss.n8609 0.0933481
R24964 avss.n8631 avss.n7866 0.0933481
R24965 avss.n8732 avss.n8731 0.0933481
R24966 avss.n8737 avss.n8736 0.0933481
R24967 avss.n8735 avss.n7776 0.0933481
R24968 avss.n9215 avss.n9214 0.0933481
R24969 avss.n4664 avss.n4663 0.0577854
R24970 avss.n6250 avss.n6249 0.0577854
R24971 avss.n5547 avss.n5546 0.0556412
R24972 avss.n7282 avss.n7281 0.0556412
R24973 avss.n6976 avss.n6975 0.0556412
R24974 avss.n2748 avss.n2252 0.0556412
R24975 avss.n2207 avss.n2188 0.0556412
R24976 avss.n7155 avss.n7154 0.0556412
R24977 avss.n4188 avss.n3994 0.0556412
R24978 avss.n4527 avss.n4526 0.0556412
R24979 avss.n5008 avss.n4891 0.0543057
R24980 avss.n4896 avss.n4895 0.0543057
R24981 avss.n5030 avss.n4863 0.0543057
R24982 avss.n5008 avss.n4901 0.0543057
R24983 avss.n7431 avss.n420 0.0543057
R24984 avss.n7417 avss.n7416 0.0543057
R24985 avss.n7405 avss.n477 0.0543057
R24986 avss.n7431 avss.n7430 0.0543057
R24987 avss.n6871 avss.n6870 0.0543057
R24988 avss.n6809 avss.n6808 0.0543057
R24989 avss.n6795 avss.n6794 0.0543057
R24990 avss.n6870 avss.n1111 0.0543057
R24991 avss.n2429 avss.n2308 0.0543057
R24992 avss.n2364 avss.n2363 0.0543057
R24993 avss.n2659 avss.n2452 0.0543057
R24994 avss.n2429 avss.n2309 0.0543057
R24995 avss.n3151 avss.n3150 0.0543057
R24996 avss.n3098 avss.n3097 0.0543057
R24997 avss.n3216 avss.n2092 0.0543057
R24998 avss.n3150 avss.n3020 0.0543057
R24999 avss.n7111 avss.n778 0.0543057
R25000 avss.n7066 avss.n816 0.0543057
R25001 avss.n7087 avss.n816 0.0543057
R25002 avss.n7101 avss.n796 0.0543057
R25003 avss.n4257 avss.n4256 0.0543057
R25004 avss.n4323 avss.n3873 0.0543057
R25005 avss.n4343 avss.n3873 0.0543057
R25006 avss.n4357 avss.n3853 0.0543057
R25007 avss.n3703 avss.n3702 0.0543057
R25008 avss.n4434 avss.n3730 0.0543057
R25009 avss.n4454 avss.n3730 0.0543057
R25010 avss.n4468 avss.n3708 0.0543057
R25011 avss.n5560 avss.n5559 0.0543036
R25012 avss.n7302 avss.n512 0.0543036
R25013 avss.n6989 avss.n6988 0.0543036
R25014 avss.n2600 avss.n2599 0.0543036
R25015 avss.n2198 avss.n2197 0.0543036
R25016 avss.n7166 avss.n7165 0.0543036
R25017 avss.n4214 avss.n4213 0.0543036
R25018 avss.n4496 avss.n4495 0.0543036
R25019 avss.n5560 avss.n4738 0.0542944
R25020 avss.n7377 avss.n512 0.0542944
R25021 avss.n6989 avss.n1012 0.0542944
R25022 avss.n2601 avss.n2600 0.0542944
R25023 avss.n2197 avss.n2196 0.0542944
R25024 avss.n7166 avss.n680 0.0542944
R25025 avss.n4214 avss.n3946 0.0542944
R25026 avss.n4496 avss.n3682 0.0542944
R25027 avss.n142 avss 0.0455
R25028 avss.n6638 avss 0.0455
R25029 avss.n5022 avss.n4871 0.0385313
R25030 avss.n5032 avss.n5031 0.0385313
R25031 avss.n7419 avss.n7418 0.0385313
R25032 avss.n7407 avss.n7406 0.0385313
R25033 avss.n6799 avss.n1163 0.0385313
R25034 avss.n6797 avss.n6796 0.0385313
R25035 avss.n2443 avss.n2288 0.0385313
R25036 avss.n2661 avss.n2660 0.0385313
R25037 avss.n3089 avss.n3061 0.0385313
R25038 avss.n3218 avss.n3217 0.0385313
R25039 avss.n7103 avss.n7102 0.0385313
R25040 avss.n790 avss.n774 0.0385313
R25041 avss.n4359 avss.n4358 0.0385313
R25042 avss.n3941 avss.n3910 0.0385313
R25043 avss.n3728 avss.n3701 0.0385313
R25044 avss.n4476 avss.n3692 0.0385313
R25045 avss.n5495 avss.n4746 0.0383975
R25046 avss.n531 avss.n527 0.0383975
R25047 avss.n6957 avss.n1020 0.0383975
R25048 avss.n2585 avss.n2251 0.0383975
R25049 avss.n3254 avss.n2034 0.0383975
R25050 avss.n7191 avss.n647 0.0383975
R25051 avss.n4190 avss.n4189 0.0383975
R25052 avss.n3650 avss.n3563 0.0383975
R25053 avss.t83 avss.t82 0.0313571
R25054 avss.t209 avss.t208 0.0313571
R25055 avss.t13 avss.t12 0.0313571
R25056 avss.t201 avss.t200 0.0313571
R25057 avss.t109 avss.t108 0.0313571
R25058 avss.t4 avss.t3 0.0313571
R25059 avss.t65 avss.t64 0.0313571
R25060 avss.t79 avss.t78 0.0313571
R25061 avss.n9381 avss.n3 0.0311936
R25062 avss.n9385 avss.n9384 0.0311936
R25063 avss.n8015 avss.n8014 0.0311936
R25064 avss.n9386 avss.n9379 0.0288526
R25065 avss.n8030 avss.n8029 0.0288526
R25066 avss.n9405 avss.n9404 0.0254711
R25067 avss.n9379 avss.n19 0.0213092
R25068 avss.n21 avss.n19 0.0213092
R25069 avss.n9328 avss.n21 0.0213092
R25070 avss.n9329 avss.n9328 0.0213092
R25071 avss.n9332 avss.n9329 0.0213092
R25072 avss.n9333 avss.n9332 0.0213092
R25073 avss.n9334 avss.n9333 0.0213092
R25074 avss.n9334 avss.n9326 0.0213092
R25075 avss.n9339 avss.n9326 0.0213092
R25076 avss.n9340 avss.n9339 0.0213092
R25077 avss.n9341 avss.n9340 0.0213092
R25078 avss.n9341 avss.n9324 0.0213092
R25079 avss.n9346 avss.n9324 0.0213092
R25080 avss.n9384 avss.n9381 0.0213092
R25081 avss.n8014 avss.n2 0.0213092
R25082 avss.n8060 avss.n7947 0.0213092
R25083 avss.n7949 avss.n7947 0.0213092
R25084 avss.n7952 avss.n7949 0.0213092
R25085 avss.n7953 avss.n7952 0.0213092
R25086 avss.n7954 avss.n7953 0.0213092
R25087 avss.n7955 avss.n7954 0.0213092
R25088 avss.n8018 avss.n7955 0.0213092
R25089 avss.n8019 avss.n8018 0.0213092
R25090 avss.n8022 avss.n8019 0.0213092
R25091 avss.n8023 avss.n8022 0.0213092
R25092 avss.n8024 avss.n8023 0.0213092
R25093 avss.n8024 avss.n8016 0.0213092
R25094 avss.n8029 avss.n8016 0.0213092
R25095 avss.n143 avss 0.0205
R25096 avss.n6639 avss 0.0205
R25097 avss.n5546 avss.n4746 0.0177418
R25098 avss.n7281 avss.n531 0.0177418
R25099 avss.n6975 avss.n1020 0.0177418
R25100 avss.n2748 avss.n2251 0.0177418
R25101 avss.n2188 avss.n2034 0.0177418
R25102 avss.n7154 avss.n647 0.0177418
R25103 avss.n4189 avss.n4188 0.0177418
R25104 avss.n4526 avss.n3563 0.0177418
R25105 avss.n6662 avss 0.0176
R25106 avss.n6451 avss 0.0176
R25107 avss.n5031 avss.n5030 0.0162745
R25108 avss.n4895 avss.n4871 0.0162745
R25109 avss.n7406 avss.n7405 0.0162745
R25110 avss.n7418 avss.n7417 0.0162745
R25111 avss.n6796 avss.n6795 0.0162745
R25112 avss.n6808 avss.n1163 0.0162745
R25113 avss.n2660 avss.n2659 0.0162745
R25114 avss.n2364 avss.n2288 0.0162745
R25115 avss.n3217 avss.n3216 0.0162745
R25116 avss.n3098 avss.n3061 0.0162745
R25117 avss.n7102 avss.n7101 0.0162745
R25118 avss.n7111 avss.n774 0.0162745
R25119 avss.n4358 avss.n4357 0.0162745
R25120 avss.n4256 avss.n3910 0.0162745
R25121 avss.n4468 avss.n3701 0.0162745
R25122 avss.n3702 avss.n3692 0.0162745
R25123 avss.t56 avss.t55 0.0155
R25124 avss.t57 avss.t56 0.0155
R25125 avss.t69 avss.t68 0.0155
R25126 avss.t70 avss.t69 0.0155
R25127 avss.t76 avss.t75 0.0155
R25128 avss.t77 avss.t76 0.0155
R25129 avss.t36 avss.t35 0.0155
R25130 avss.t37 avss.t36 0.0155
R25131 avss.t92 avss.t91 0.0155
R25132 avss.t93 avss.t92 0.0155
R25133 avss.t196 avss.t195 0.0155
R25134 avss.t197 avss.t196 0.0155
R25135 avss.t46 avss.t45 0.0155
R25136 avss.t47 avss.t46 0.0155
R25137 avss.t43 avss.t42 0.0155
R25138 avss.t44 avss.t43 0.0155
R25139 avss.n5778 avss.n5750 0.0149069
R25140 avss.n5779 avss.n5778 0.0149069
R25141 avss.n5782 avss.n5746 0.0149069
R25142 avss.n5783 avss.n5746 0.0149069
R25143 avss.n6660 avss.n6659 0.0149069
R25144 avss.n6662 avss.n1659 0.0149069
R25145 avss.n6660 avss.n1657 0.0149069
R25146 avss.n1659 avss.n1657 0.0149069
R25147 avss.n5771 avss.n5753 0.0149069
R25148 avss.n5771 avss.n5752 0.0149069
R25149 avss.n5790 avss.n5789 0.0149069
R25150 avss.n5743 avss.n1652 0.0149069
R25151 avss.n6665 avss.n1654 0.0149069
R25152 avss.n5730 avss.n1654 0.0149069
R25153 avss.n6666 avss.n6665 0.0149069
R25154 avss.n5789 avss.n5742 0.0149069
R25155 avss.n5743 avss.n5742 0.0149069
R25156 avss.n5782 avss.n5781 0.0149069
R25157 avss.n5783 avss.n1661 0.0149069
R25158 avss.n5763 avss.n5759 0.0149069
R25159 avss.n5800 avss.n5798 0.0149069
R25160 avss.n5801 avss.n5800 0.0149069
R25161 avss.n5804 avss.n5803 0.0149069
R25162 avss.n5804 avss.n5734 0.0149069
R25163 avss.n5798 avss.n5737 0.0149069
R25164 avss.n5802 avss.n5801 0.0149069
R25165 avss.n5807 avss.n5803 0.0149069
R25166 avss.n5760 avss.n5758 0.0149069
R25167 avss.n5760 avss.n5759 0.0149069
R25168 avss.n5774 avss.n5753 0.0149069
R25169 avss.n5752 avss.n5745 0.0149069
R25170 avss.n5776 avss.n5750 0.0149069
R25171 avss.n5780 avss.n5779 0.0149069
R25172 avss.n5769 avss.n5755 0.0149069
R25173 avss.n5766 avss.n5755 0.0149069
R25174 avss.n5740 avss.n5738 0.0149069
R25175 avss.n5741 avss.n5738 0.0149069
R25176 avss.n5809 avss.n5729 0.0149069
R25177 avss.n5810 avss.n5809 0.0149069
R25178 avss.n5766 avss.n5765 0.0149069
R25179 avss.n5740 avss.n5739 0.0149069
R25180 avss.n5741 avss.n5728 0.0149069
R25181 avss.n5814 avss.n5729 0.0149069
R25182 avss.n6426 avss.n1724 0.0149069
R25183 avss.n6427 avss.n6426 0.0149069
R25184 avss.n6431 avss.n1719 0.0149069
R25185 avss.n6432 avss.n6431 0.0149069
R25186 avss.n6436 avss.n1714 0.0149069
R25187 avss.n6437 avss.n6436 0.0149069
R25188 avss.n6440 avss.n6439 0.0149069
R25189 avss.n6443 avss.n1706 0.0149069
R25190 avss.n6447 avss.n1705 0.0149069
R25191 avss.n6448 avss.n6447 0.0149069
R25192 avss.n6454 avss.n6450 0.0149069
R25193 avss.n6450 avss.n1701 0.0149069
R25194 avss.n6444 avss.n1705 0.0149069
R25195 avss.n6449 avss.n6448 0.0149069
R25196 avss.n6455 avss.n6454 0.0149069
R25197 avss.n6451 avss.n1701 0.0149069
R25198 avss.n6439 avss.n1709 0.0149069
R25199 avss.n1709 avss.n1706 0.0149069
R25200 avss.n1729 avss.n1727 0.0149069
R25201 avss.n1729 avss.n1726 0.0149069
R25202 avss.n6417 avss.n6416 0.0149069
R25203 avss.n6416 avss.n6415 0.0149069
R25204 avss.n6413 avss.n6412 0.0149069
R25205 avss.n6409 avss.n1734 0.0149069
R25206 avss.n6407 avss.n6406 0.0149069
R25207 avss.n6406 avss.n6405 0.0149069
R25208 avss.n3331 avss.n3328 0.0149069
R25209 avss.n3332 avss.n3328 0.0149069
R25210 avss.n1700 avss.n1697 0.0149069
R25211 avss.n1699 avss.n1697 0.0149069
R25212 avss.n6408 avss.n6407 0.0149069
R25213 avss.n6405 avss.n1739 0.0149069
R25214 avss.n3331 avss.n3329 0.0149069
R25215 avss.n3332 avss.n3330 0.0149069
R25216 avss.n1700 avss.n1698 0.0149069
R25217 avss.n6412 avss.n6411 0.0149069
R25218 avss.n6411 avss.n1734 0.0149069
R25219 avss.n6434 avss.n1714 0.0149069
R25220 avss.n6438 avss.n6437 0.0149069
R25221 avss.n3376 avss.n3374 0.0149069
R25222 avss.n3374 avss.n3373 0.0149069
R25223 avss.n7260 avss.n7259 0.0149069
R25224 avss.n7257 avss.n557 0.0149069
R25225 avss.n4630 avss.n4629 0.0149069
R25226 avss.n4629 avss.n4625 0.0149069
R25227 avss.n3326 avss.n3324 0.0149069
R25228 avss.n3326 avss.n1741 0.0149069
R25229 avss.n6247 avss.n3327 0.0149069
R25230 avss.n6317 avss.n6247 0.0149069
R25231 avss.n1696 avss.n1693 0.0149069
R25232 avss.n1695 avss.n1693 0.0149069
R25233 avss.n4631 avss.n4630 0.0149069
R25234 avss.n4626 avss.n4625 0.0149069
R25235 avss.n6402 avss.n3324 0.0149069
R25236 avss.n6399 avss.n1741 0.0149069
R25237 avss.n6322 avss.n3327 0.0149069
R25238 avss.n6318 avss.n6317 0.0149069
R25239 avss.n1696 avss.n1694 0.0149069
R25240 avss.n7259 avss.n554 0.0149069
R25241 avss.n557 avss.n554 0.0149069
R25242 avss.n6418 avss.n6417 0.0149069
R25243 avss.n6415 avss.n6414 0.0149069
R25244 avss.n6429 avss.n1719 0.0149069
R25245 avss.n6433 avss.n6432 0.0149069
R25246 avss.n3390 avss.n3367 0.0149069
R25247 avss.n3395 avss.n3393 0.0149069
R25248 avss.n3396 avss.n3395 0.0149069
R25249 avss.n4640 avss.n3398 0.0149069
R25250 avss.n4640 avss.n4639 0.0149069
R25251 avss.n4651 avss.n3347 0.0149069
R25252 avss.n4652 avss.n4651 0.0149069
R25253 avss.n4656 avss.n4655 0.0149069
R25254 avss.n4656 avss.n3343 0.0149069
R25255 avss.n6471 avss.n1688 0.0149069
R25256 avss.n6472 avss.n6471 0.0149069
R25257 avss.n3393 avss.n3392 0.0149069
R25258 avss.n3397 avss.n3396 0.0149069
R25259 avss.n4644 avss.n3398 0.0149069
R25260 avss.n4639 avss.n3348 0.0149069
R25261 avss.n4649 avss.n3347 0.0149069
R25262 avss.n4653 avss.n4652 0.0149069
R25263 avss.n4659 avss.n4655 0.0149069
R25264 avss.n3343 avss.n1687 0.0149069
R25265 avss.n6476 avss.n1688 0.0149069
R25266 avss.n3387 avss.n3385 0.0149069
R25267 avss.n3385 avss.n3367 0.0149069
R25268 avss.n3376 avss.n3375 0.0149069
R25269 avss.n3373 avss.n552 0.0149069
R25270 avss.n6422 avss.n1727 0.0149069
R25271 avss.n6419 avss.n1726 0.0149069
R25272 avss.n6424 avss.n1724 0.0149069
R25273 avss.n6428 avss.n6427 0.0149069
R25274 avss.n3381 avss.n3370 0.0149069
R25275 avss.n3370 avss.n3368 0.0149069
R25276 avss.n564 avss.n562 0.0149069
R25277 avss.n564 avss.n560 0.0149069
R25278 avss.n4623 avss.n3399 0.0149069
R25279 avss.n4624 avss.n3399 0.0149069
R25280 avss.n3401 avss.n3400 0.0149069
R25281 avss.n3402 avss.n3401 0.0149069
R25282 avss.n4661 avss.n3341 0.0149069
R25283 avss.n4661 avss.n3339 0.0149069
R25284 avss.n1692 avss.n1689 0.0149069
R25285 avss.n1691 avss.n1689 0.0149069
R25286 avss.n3371 avss.n3368 0.0149069
R25287 avss.n7254 avss.n562 0.0149069
R25288 avss.n7251 avss.n560 0.0149069
R25289 avss.n4623 avss.n565 0.0149069
R25290 avss.n4624 avss.n4622 0.0149069
R25291 avss.n3407 avss.n3400 0.0149069
R25292 avss.n3403 avss.n3402 0.0149069
R25293 avss.n6245 avss.n3341 0.0149069
R25294 avss.n6242 avss.n3339 0.0149069
R25295 avss.n1692 avss.n1690 0.0149069
R25296 avss.n5808 avss.n5733 0.0129
R25297 avss.n5811 avss.n5732 0.0129
R25298 avss.n6661 avss.n1660 0.0129
R25299 avss.n5794 avss.n5793 0.0129
R25300 avss.n5788 avss.n5744 0.0129
R25301 avss.n5785 avss.n5784 0.0129
R25302 avss.n5764 avss.n5757 0.0129
R25303 avss.n5775 avss.n5751 0.0129
R25304 avss.n5749 avss.n5748 0.0129
R25305 avss.n6473 avss.n6470 0.0129
R25306 avss.n6467 avss.n6466 0.0129
R25307 avss.n6463 avss.n6462 0.0129
R25308 avss.n6459 avss.n6458 0.0129
R25309 avss.n4660 avss.n3342 0.0129
R25310 avss.n6246 avss.n3338 0.0129
R25311 avss.n6319 avss.n3337 0.0129
R25312 avss.n3334 avss.n3333 0.0129
R25313 avss.n3346 avss.n3345 0.0129
R25314 avss.n3404 avss.n3325 0.0129
R25315 avss.n6403 avss.n1740 0.0129
R25316 avss.n1710 avss.n1707 0.0129
R25317 avss.n4641 avss.n4638 0.0129
R25318 avss.n4635 avss.n4634 0.0129
R25319 avss.n1733 avss.n1715 0.0129
R25320 avss.n1713 avss.n1712 0.0129
R25321 avss.n7255 avss.n559 0.0129
R25322 avss.n7258 avss.n555 0.0129
R25323 avss.n1730 avss.n1720 0.0129
R25324 avss.n1718 avss.n1717 0.0129
R25325 avss.n3386 avss.n3384 0.0129
R25326 avss.n3377 avss.n1728 0.0129
R25327 avss.n6423 avss.n1725 0.0129
R25328 avss.n1723 avss.n1722 0.0129
R25329 avss.n6661 avss 0.0081
R25330 avss.n6453 avss 0.0081
R25331 avss.n5805 avss.n5733 0.00719147
R25332 avss.n5812 avss.n5811 0.00719147
R25333 avss.n1655 avss.n1653 0.00719147
R25334 avss.n6664 avss.n1656 0.00719147
R25335 avss.n6663 avss.n1658 0.00719147
R25336 avss.n1660 avss.n1658 0.00719147
R25337 avss.n5731 avss.n1653 0.00719147
R25338 avss.n1656 avss.n1655 0.00719147
R25339 avss.n5799 avss.n5736 0.00719147
R25340 avss.n5797 avss.n5735 0.00719147
R25341 avss.n5795 avss.n5794 0.00719147
R25342 avss.n5792 avss.n5791 0.00719147
R25343 avss.n5786 avss.n5785 0.00719147
R25344 avss.n5791 avss.n5744 0.00719147
R25345 avss.n5787 avss.n5786 0.00719147
R25346 avss.n5799 avss.n5735 0.00719147
R25347 avss.n5806 avss.n5805 0.00719147
R25348 avss.n5762 avss.n5761 0.00719147
R25349 avss.n5768 avss.n5756 0.00719147
R25350 avss.n5770 avss.n5754 0.00719147
R25351 avss.n5772 avss.n5751 0.00719147
R25352 avss.n5749 avss.n5747 0.00719147
R25353 avss.n5761 avss.n5757 0.00719147
R25354 avss.n5773 avss.n5772 0.00719147
R25355 avss.n5777 avss.n5747 0.00719147
R25356 avss.n5768 avss.n5767 0.00719147
R25357 avss.n5756 avss.n5754 0.00719147
R25358 avss.n5796 avss.n5795 0.00719147
R25359 avss.n5813 avss.n5812 0.00719147
R25360 avss.n6474 avss.n6473 0.00719147
R25361 avss.n6468 avss.n6467 0.00719147
R25362 avss.n6464 avss.n6463 0.00719147
R25363 avss.n6460 avss.n6459 0.00719147
R25364 avss.n6456 avss.n1702 0.00719147
R25365 avss.n6453 avss.n6452 0.00719147
R25366 avss.n4657 avss.n3342 0.00719147
R25367 avss.n6243 avss.n3338 0.00719147
R25368 avss.n6320 avss.n6319 0.00719147
R25369 avss.n3335 avss.n3334 0.00719147
R25370 avss.n6446 avss.n6445 0.00719147
R25371 avss.n6445 avss.n1704 0.00719147
R25372 avss.n6446 avss.n1703 0.00719147
R25373 avss.n6457 avss.n6456 0.00719147
R25374 avss.n6452 avss.n1702 0.00719147
R25375 avss.n3346 avss.n3344 0.00719147
R25376 avss.n3405 avss.n3404 0.00719147
R25377 avss.n6400 avss.n1740 0.00719147
R25378 avss.n1737 avss.n1736 0.00719147
R25379 avss.n1738 avss.n1708 0.00719147
R25380 avss.n6442 avss.n6441 0.00719147
R25381 avss.n6441 avss.n1710 0.00719147
R25382 avss.n6404 avss.n1736 0.00719147
R25383 avss.n1738 avss.n1737 0.00719147
R25384 avss.n3336 avss.n3335 0.00719147
R25385 avss.n6461 avss.n6460 0.00719147
R25386 avss.n4642 avss.n4641 0.00719147
R25387 avss.n4636 avss.n4635 0.00719147
R25388 avss.n4632 avss.n4628 0.00719147
R25389 avss.n4627 avss.n1735 0.00719147
R25390 avss.n6410 avss.n1732 0.00719147
R25391 avss.n1713 avss.n1711 0.00719147
R25392 avss.n1733 avss.n1732 0.00719147
R25393 avss.n6435 avss.n1711 0.00719147
R25394 avss.n4633 avss.n4632 0.00719147
R25395 avss.n4628 avss.n4627 0.00719147
R25396 avss.n6401 avss.n6400 0.00719147
R25397 avss.n6321 avss.n6320 0.00719147
R25398 avss.n6465 avss.n6464 0.00719147
R25399 avss.n3394 avss.n3366 0.00719147
R25400 avss.n3365 avss.n563 0.00719147
R25401 avss.n7252 avss.n559 0.00719147
R25402 avss.n7256 avss.n553 0.00719147
R25403 avss.n1731 avss.n1730 0.00719147
R25404 avss.n1718 avss.n1716 0.00719147
R25405 avss.n555 avss.n553 0.00719147
R25406 avss.n1731 avss.n556 0.00719147
R25407 avss.n6430 avss.n1716 0.00719147
R25408 avss.n3394 avss.n3365 0.00719147
R25409 avss.n4643 avss.n4642 0.00719147
R25410 avss.n4650 avss.n3344 0.00719147
R25411 avss.n4658 avss.n4657 0.00719147
R25412 avss.n6475 avss.n6474 0.00719147
R25413 avss.n3389 avss.n3388 0.00719147
R25414 avss.n3382 avss.n3369 0.00719147
R25415 avss.n3380 avss.n3372 0.00719147
R25416 avss.n3378 avss.n3377 0.00719147
R25417 avss.n6420 avss.n1725 0.00719147
R25418 avss.n1723 avss.n1721 0.00719147
R25419 avss.n3388 avss.n3386 0.00719147
R25420 avss.n3379 avss.n3378 0.00719147
R25421 avss.n6421 avss.n6420 0.00719147
R25422 avss.n6425 avss.n1721 0.00719147
R25423 avss.n3383 avss.n3382 0.00719147
R25424 avss.n3372 avss.n3369 0.00719147
R25425 avss.n7253 avss.n7252 0.00719147
R25426 avss.n4637 avss.n4636 0.00719147
R25427 avss.n3406 avss.n3405 0.00719147
R25428 avss.n6244 avss.n6243 0.00719147
R25429 avss.n6469 avss.n6468 0.00719147
R25430 avss.n9405 avss.n2 0.00622254
C0 current_mirror_0.B a_57586_30169# 0.00346f
C1 layer_input_0.nvout_2 vpost1 0.08559f
C2 current_mirror_0.A a_55466_64949# 0
C3 layer_output_0.nvout_2 a_58428_33960# 0.09075f
C4 layer_output_0.nvout_1 a_35712_33960# 0.23052f
C5 layer_input_0.vout_4 a_37586_30169# 0.21613f
C6 stdp_4x2_0.stdp_6.vw a_35712_44960# 0.82148f
C7 stdp_4x2_0.Current_limit_0.i_SUM a_58428_55960# 0.00171f
C8 a_35712_44960# avdd 2.01475f
C9 layer_output_0.nvout_1 a_35586_55752# 0.03888f
C10 a_38698_41169# vpost1 0.03096f
C11 a_35712_67160# a_35466_64949# 0.014f
C12 a_55466_30169# a_61930_30169# 0.0045f
C13 a_35586_66952# a_36944_64741# 0.00193f
C14 layer_input_0.nvout_1 layer_output_0.nvout_2 0.18957f
C15 stdp_4x2_0.stdp_3.vw a_55586_44752# 1.34914f
C16 stdp_4x2_0.stdp_6.vw a_35466_42749# 0.36212f
C17 a_35466_42749# avdd 0.00114f
C18 layer_output_0.nvout_1 layer_input_0.nvout_3 0.07335f
C19 a_57586_52169# vpre2 0.00161f
C20 a_10290_71650# layer_input_0.Iext4 0.18158f
C21 a_55466_63369# vpost2 0.03764f
C22 a_4794_71649# layer_input_0.Iext2 0.34461f
C23 a_38302_31541# vpost1 0.16485f
C24 a_55466_63369# a_58698_63369# 1.05124f
C25 avdd vpost2 6.40292f
C26 current_mirror_0.A a_37586_63369# 0.73756f
C27 a_58302_64741# a_57586_63369# 0.01443f
C28 layer_output_0.nvout_2 a_58302_33752# 0.00708f
C29 a_38428_55960# vpost1 0.04829f
C30 current_mirror_0.B a_56944_31541# 0.13317f
C31 a_38428_55960# a_35466_52169# 0
C32 layer_output_0.nvout_1 a_35586_33752# 0.03721f
C33 current_mirror_0.A vpost1 0.6529f
C34 current_mirror_0.A a_35466_52169# 0.62773f
C35 stdp_4x2_0.stdp_6.vw a_35586_44752# 1.34914f
C36 a_61930_30169# vw42 0.00597f
C37 a_35586_44752# avdd 6.78464f
C38 layer_input_0.vout_4 a_36944_31541# 0.30758f
C39 layer_output_0.nvout_1 layer_output_0.Iext2 0.37663f
C40 layer_output_0.nvout_1 stdp_4x2_0.stdp_2.vw 0.16303f
C41 a_55466_30169# a_58698_30169# 1.05124f
C42 a_35466_41169# vpost1 0.03435f
C43 a_56944_53541# vpre2 0.02582f
C44 layer_output_0.nvout_1 a_38428_44960# 0.10136f
C45 layer_input_0.Iext1 layer_input_0.Iext3 1.43042f
C46 a_7926_70021# layer_input_0.Iext4 0.04505f
C47 layer_input_0.Iext4 a_4666_70229# 0.06465f
C48 layer_input_0.Iext2 a_4666_70229# 0.01964f
C49 a_38428_33960# vpost1 0.04811f
C50 layer_output_0.nvout_2 a_55466_41169# 0.03161f
C51 layer_output_0.nvout_1 a_37586_41169# 0.05387f
C52 a_58302_64741# a_56944_64741# 1.39736f
C53 layer_output_0.nvout_2 a_55712_33960# 0.16275f
C54 layer_input_0.Iext3 avdd 5.84034f
C55 layer_input_0.Iext1 avdd 4.00222f
C56 a_58428_67160# a_57586_63369# 0.02759f
C57 a_36944_64741# a_37586_63369# 1.08975f
C58 current_mirror_0.B a_55466_31749# 0.01209f
C59 a_38302_55752# vpost1 0.13479f
C60 layer_input_0.nvout_2 a_56944_53541# 0.01679f
C61 stdp_4x2_0.stdp_2.vw a_41930_52169# 0.00571f
C62 layer_output_0.nvout_1 stdp_4x2_0.stdp_0.vw 0.26091f
C63 a_36944_64741# vpost1 0.11205f
C64 current_mirror_0.A a_57586_52169# 0.78649f
C65 layer_input_0.vout_4 a_35466_31749# 0.15995f
C66 stdp_4x2_0.Current_limit_0.i_SUM a_55712_55960# 0.03719f
C67 stdp_4x2_0.stdp_6.vw avdd 11.7834f
C68 layer_input_0.nvout_1 a_55586_66952# 0.09565f
C69 current_mirror_0.B stdp_4x2_0.Current_limit_0.i_SUM 0.05007f
C70 a_55466_53749# vpre2 0.09917f
C71 stdp_4x2_0.Current_limit_1.i_SUM a_38302_42541# 0.04324f
C72 layer_output_0.nvout_1 a_38302_44752# 0.00639f
C73 a_10290_71650# a_4666_70229# 1.44905f
C74 a_7926_70021# a_10290_71650# 0.03121f
C75 a_4794_71649# a_7926_70021# 0.02036f
C76 a_4794_71649# a_4666_70229# 1.04636f
C77 a_38302_33752# vpost1 0.13479f
C78 stdp_4x2_0.stdp_3.vw vw42 0.51198f
C79 layer_output_0.nvout_1 a_36944_42541# 0.10989f
C80 a_58698_52169# vpost2 0.03659f
C81 layer_output_0.nvout_2 a_55586_33752# 0.04055f
C82 a_58302_64741# a_55466_64949# 0.0096f
C83 a_58428_67160# a_56944_64741# 0.17308f
C84 a_35466_64949# a_37586_63369# 0.00297f
C85 layer_input_0.nvout_4 layer_input_0.vout_4 1.14962f
C86 current_mirror_0.B a_37586_30169# 0.11766f
C87 layer_input_0.nvout_2 a_55466_53749# 0.00327f
C88 current_mirror_0.A a_56944_53541# 0.29644f
C89 stdp_4x2_0.Current_limit_0.i_SUM a_55586_55752# 0.07252f
C90 layer_output_0.nvout_2 layer_input_0.nvout_2 0.11217f
C91 stdp_4x2_0.Current_limit_0.i_SUM a_58302_42541# 0.29688f
C92 a_37586_52169# vpre2 0.18448f
C93 layer_output_0.nvout_1 a_35712_44960# 0.20927f
C94 a_7926_70021# a_4666_70229# 0.24848f
C95 layer_output_0.nvout_1 a_35466_42749# 0.02724f
C96 a_57586_63369# a_61930_63369# 0.07064f
C97 a_55466_52169# vpost2 0.03713f
C98 a_58302_66952# a_56944_64741# 0
C99 layer_input_0.nvout_4 a_8786_33529# 1.4855f
C100 current_mirror_0.B a_36944_31541# 0.47647f
C101 a_35586_55752# vpost1 0.05233f
C102 layer_input_0.nvout_3 vpost1 0.08025f
C103 current_mirror_0.A a_55466_53749# 0
C104 layer_output_0.nvout_1 vpost2 3.39333f
C105 Vin vpre1 0.04404f
C106 stdp_4x2_0.Current_limit_0.i_SUM stdp_4x2_0.stdp_4.vw 0.37652f
C107 layer_output_0.nvout_2 current_mirror_0.A 0.22193f
C108 current_mirror_0.B a_38302_64741# 0.89586f
C109 stdp_4x2_0.Current_limit_0.i_SUM a_58428_44960# 0.18388f
C110 a_57586_30169# a_61930_30169# 0.07064f
C111 layer_output_0.nvout_1 a_35586_44752# 0.04255f
C112 a_36944_53541# vpre2 0.27186f
C113 a_57586_63369# vpost2 0.05255f
C114 a_35586_33752# vpost1 0.05279f
C115 a_38698_63369# a_41930_63369# 1.05124f
C116 a_57586_63369# a_58698_63369# 0.07349f
C117 a_56944_64741# a_61930_63369# 0
C118 stdp_4x2_0.Current_limit_0.i_SUM a_69620_23589# 1.26353f
C119 layer_output_0.Iext2 vpost1 0
C120 stdp_4x2_0.stdp_2.vw vpost1 0.0582f
C121 stdp_4x2_0.Current_limit_1.i_SUM a_35466_30169# 0.03185f
C122 a_38428_55960# a_37586_52169# 0.02759f
C123 layer_input_0.nvout_2 a_36944_53541# 0.51957f
C124 stdp_4x2_0.Current_limit_0.i_SUM vpre1 0.00341f
C125 current_mirror_0.A a_37586_52169# 0.75752f
C126 a_38428_44960# vpost1 0.04839f
C127 a_58698_52169# a_61930_52169# 1.05124f
C128 a_38698_30169# a_41930_30169# 1.05124f
C129 a_57586_30169# a_58698_30169# 0.07349f
C130 stdp_4x2_0.Current_limit_0.i_SUM a_58302_44752# 0.01081f
C131 a_56944_31541# a_61930_30169# 0
C132 a_37586_41169# vpost1 0.04053f
C133 layer_output_0.nvout_1 stdp_4x2_0.stdp_6.vw 0.26223f
C134 layer_output_0.nvout_1 avdd 11.8022f
C135 a_35466_53749# vpre2 0.15533f
C136 stdp_4x2_0.stdp_0.vw vpost1 0.06068f
C137 a_56944_64741# vpost2 0.11203f
C138 layer_output_0.nvout_2 a_57586_41169# 0.06269f
C139 current_mirror_0.B layer_input_0.nvout_4 3.08987f
C140 a_35466_63369# a_41930_63369# 0.0045f
C141 a_57586_63369# a_55466_63369# 1.12049f
C142 current_mirror_0.B a_58302_31541# 1.07322f
C143 layer_input_0.nvout_2 a_35466_53749# 0.01053f
C144 a_38428_55960# a_36944_53541# 0.17308f
C145 stdp_4x2_0.stdp_5.vw vpre1 0.0719f
C146 current_mirror_0.A a_36944_53541# 0.34596f
C147 a_38302_44752# vpost1 0.13479f
C148 a_55466_52169# a_61930_52169# 0.0045f
C149 layer_input_0.vout_4 a_55712_33960# 0.00545f
C150 a_57586_30169# a_55466_30169# 1.12049f
C151 stdp_4x2_0.Current_limit_0.i_SUM a_55712_44960# 0
C152 a_56944_31541# a_58698_30169# 0
C153 a_35466_30169# a_41930_30169# 0.0045f
C154 a_36944_42541# vpost1 0.27042f
C155 a_35712_67160# avdd 2.01701f
C156 layer_input_0.Iext2 Vin 0.14875f
C157 layer_output_0.nvout_2 a_56944_42541# 0.06797f
C158 current_mirror_0.B a_61930_41169# 0.01291f
C159 a_56944_64741# a_55466_63369# 0
C160 a_35466_63369# a_38698_63369# 1.05124f
C161 current_mirror_0.B a_58428_33960# 0.12373f
C162 layer_input_0.nvout_2 a_58302_53541# 0.04995f
C163 a_56944_64741# avdd 0.46248f
C164 a_38302_55752# a_36944_53541# 0
C165 a_38302_64741# vpre1 0.05534f
C166 current_mirror_0.A a_35466_53749# 0
C167 a_55466_52169# a_58698_52169# 1.05124f
C168 layer_output_0.nvout_2 a_58302_64741# 0.07425f
C169 layer_output_0.nvout_1 a_38698_63369# 0.00202f
C170 a_35466_30169# a_38698_30169# 1.05124f
C171 stdp_4x2_0.Current_limit_0.i_SUM a_55586_44752# 0.07139f
C172 layer_output_0.nvout_2 layer_input_0.nvout_3 0.0919f
C173 a_56944_31541# a_55466_30169# 0
C174 layer_input_0.nvout_1 current_mirror_0.B 0.12775f
C175 a_4794_71649# Vin 0.07519f
C176 a_35586_66952# avdd 6.7835f
C177 current_mirror_0.B a_58698_41169# 0.04033f
C178 layer_input_0.vout_3 a_55466_41169# 0.00193f
C179 layer_output_0.nvout_2 a_55466_42749# 0.02994f
C180 a_55466_64949# a_55466_63369# 0
C181 stdp_4x2_0.Current_limit_0.i_SUM a_58698_30169# 0.00404f
C182 current_mirror_0.B a_58302_33752# 0.00634f
C183 layer_input_0.nvout_2 a_58428_55960# 0.08496f
C184 a_35712_55960# a_36944_53541# 0
C185 a_55466_64949# avdd 0.00114f
C186 current_mirror_0.A a_58302_53541# 0.0506f
C187 a_35586_44752# vpost1 0.05202f
C188 Vin_neg vpre1 0.04942f
C189 layer_output_0.nvout_2 layer_output_0.Iext2 1.17414f
C190 a_56944_31541# vw42 0.92323f
C191 a_8786_49529# avdd 1.33172f
C192 layer_input_0.vout_4 a_38302_31541# 0.11816f
C193 layer_output_0.nvout_1 a_35466_63369# 0.03326f
C194 layer_output_0.nvout_2 a_58428_67160# 0.08496f
C195 a_55466_31749# a_55466_30169# 0
C196 stdp_4x2_0.Current_limit_0.i_SUM stdp_4x2_0.stdp_3.vw 0.34539f
C197 a_38428_67160# current_mirror_0.B 0.04582f
C198 a_4666_70229# Vin 0.47815f
C199 a_7926_70021# Vin 0.00641f
C200 current_mirror_0.A layer_input_0.vout_4 1.40555f
C201 layer_input_0.vout_3 a_41930_41169# 0.0297f
C202 current_mirror_0.B a_55466_41169# 0
C203 a_57586_52169# vpost2 0.04728f
C204 stdp_4x2_0.Current_limit_0.i_SUM a_55466_30169# 0.03906f
C205 a_35466_41169# layer_input_0.vout_4 0.00178f
C206 current_mirror_0.B a_55712_33960# 0.03734f
C207 stdp_4x2_0.Current_limit_1.i_SUM a_37586_30169# 0.05895f
C208 a_35586_55752# a_36944_53541# 0.00193f
C209 a_35712_55960# a_35466_53749# 0.014f
C210 layer_input_0.nvout_2 a_58302_55752# 0.14803f
C211 current_mirror_0.A a_58428_55960# 0.10129f
C212 stdp_4x2_0.stdp_6.vw vpost1 0.05658f
C213 avdd vpost1 5.05555f
C214 layer_input_0.vout_4 a_38428_33960# 0.05077f
C215 layer_input_0.nvout_2 layer_input_0.vout_3 0.25548f
C216 a_55466_31749# vw42 0.36212f
C217 layer_output_0.nvout_2 a_58302_66952# 0.00639f
C218 a_55586_66952# a_58302_64741# 0.07669f
C219 a_55712_67160# a_58428_67160# 0.03272f
C220 a_38302_66952# current_mirror_0.B 0
C221 a_55712_55960# vpre2 0.00476f
C222 stdp_4x2_0.Current_limit_0.i_SUM vw42 0.3136f
C223 layer_input_0.vout_3 a_38698_41169# 0.04367f
C224 a_58302_42541# a_55466_41169# 0.00311f
C225 a_58428_44960# a_58698_41169# 0
C226 current_mirror_0.B a_41930_41169# 0.00473f
C227 current_mirror_0.B vpre2 0.07785f
C228 a_35712_67160# layer_output_0.nvout_1 0.16084f
C229 a_56944_53541# vpost2 0.27264f
C230 a_37586_63369# a_41930_63369# 0.06712f
C231 current_mirror_0.B a_55586_33752# 0.18858f
C232 stdp_4x2_0.Current_limit_1.i_SUM a_36944_31541# 0.05238f
C233 layer_input_0.nvout_2 a_55712_55960# 0.09373f
C234 stdp_4x2_0.stdp_2.vw a_36944_53541# 0.92323f
C235 layer_input_0.nvout_1 vpre1 5.56066f
C236 current_mirror_0.B layer_input_0.nvout_2 0.36503f
C237 current_mirror_0.A layer_input_0.vout_3 1.13542f
C238 a_55586_66952# a_58428_67160# 0.00852f
C239 a_37586_30169# a_41930_30169# 0.07064f
C240 stdp_4x2_0.Current_limit_1.i_SUM a_38302_64741# 0.00566f
C241 layer_input_0.Iext4 Vin_neg 0.52577f
C242 layer_output_0.nvout_1 a_38698_52169# 0.00172f
C243 layer_input_0.Iext2 Vin_neg 0.04129f
C244 a_58428_44960# a_55466_41169# 0
C245 layer_input_0.vout_3 a_35466_41169# 0.04272f
C246 current_mirror_0.B a_38698_41169# 0.05543f
C247 layer_input_0.Iext4 layer_input_0.nvout_4 0.9664f
C248 a_35586_66952# layer_output_0.nvout_1 0.00639f
C249 a_37586_63369# a_38698_63369# 0.0718f
C250 a_56944_64741# a_57586_63369# 1.08975f
C251 a_38698_63369# vpost1 0.03096f
C252 current_mirror_0.B a_38302_31541# 0.94502f
C253 stdp_4x2_0.Current_limit_1.i_SUM a_35466_31749# 0.02015f
C254 stdp_4x2_0.stdp_2.vw a_35466_53749# 0.36212f
C255 layer_input_0.nvout_2 a_55586_55752# 0.12938f
C256 layer_output_0.nvout_2 vpost2 3.93626f
C257 a_38428_67160# vpre1 0.00644f
C258 a_38698_52169# a_41930_52169# 1.05124f
C259 layer_input_0.vout_4 a_35712_33960# 0.078f
C260 a_56944_53541# avdd 0.4642f
C261 layer_output_0.nvout_2 a_58698_63369# 0.0017f
C262 a_57586_52169# a_61930_52169# 0.07064f
C263 current_mirror_0.B a_38428_55960# 0.04582f
C264 a_55586_66952# a_58302_66952# 0.37123f
C265 current_mirror_0.B current_mirror_0.A 9.53675f
C266 a_56944_31541# a_57586_30169# 1.09114f
C267 a_36944_31541# a_41930_30169# 0
C268 a_37586_30169# a_38698_30169# 0.07349f
C269 a_10290_71650# Vin_neg 0.07353f
C270 stdp_4x2_0.stdp_4.vw vpre2 0.08815f
C271 current_mirror_0.B a_35466_41169# 0.01567f
C272 layer_input_0.nvout_3 layer_input_0.vout_4 0.05165f
C273 layer_input_0.vout_3 a_57586_41169# 0.00161f
C274 stdp_4x2_0.Current_limit_1.i_SUM layer_input_0.nvout_4 0.06681f
C275 a_37586_63369# a_35466_63369# 1.12049f
C276 a_55466_64949# a_57586_63369# 0.00297f
C277 a_35586_66952# a_35712_67160# 0.30951f
C278 current_mirror_0.B a_38428_33960# 0.03786f
C279 a_35466_63369# vpost1 0.03357f
C280 layer_input_0.nvout_2 stdp_4x2_0.stdp_4.vw 0.07022f
C281 vw11 vpre1 1.04247f
C282 current_mirror_0.A a_55586_55752# 0.06372f
C283 a_57586_52169# a_58698_52169# 0.07349f
C284 layer_input_0.vout_4 a_35586_33752# 0.34688f
C285 layer_output_0.nvout_2 a_55466_63369# 0.03133f
C286 a_56944_53541# a_61930_52169# 0
C287 current_mirror_0.B a_38302_55752# 0.00181f
C288 a_55466_53749# avdd 0.00114f
C289 layer_output_0.nvout_1 a_37586_63369# 0.05734f
C290 current_mirror_0.A a_58302_42541# 0.03762f
C291 current_mirror_0.B a_36944_64741# 0.1547f
C292 a_58302_31541# a_55466_30169# 0.00323f
C293 vpre1 vpre2 0.1187f
C294 a_55466_31749# a_57586_30169# 0.00332f
C295 a_58428_33960# a_58698_30169# 0
C296 a_37586_30169# a_35466_30169# 1.12049f
C297 layer_output_0.nvout_2 avdd 13.1523f
C298 layer_output_0.nvout_1 vpost1 4.62795f
C299 a_38302_53541# vpre2 0.11053f
C300 layer_output_0.nvout_1 a_35466_52169# 0.03163f
C301 a_7926_70021# Vin_neg 0.0203f
C302 a_4666_70229# Vin_neg 0.4836f
C303 layer_input_0.vout_3 a_56944_42541# 0.02582f
C304 stdp_4x2_0.stdp_3.vw a_61930_41169# 0.00597f
C305 current_mirror_0.B a_57586_41169# 0.03723f
C306 a_55466_64949# a_56944_64741# 0.13503f
C307 stdp_4x2_0.Current_limit_0.i_SUM a_57586_30169# 0.03782f
C308 a_37586_41169# layer_input_0.vout_4 0
C309 layer_input_0.nvout_4 vw42 0.06401f
C310 current_mirror_0.B a_38302_33752# 0.00181f
C311 layer_input_0.nvout_2 a_38302_53541# 0.20924f
C312 current_mirror_0.A stdp_4x2_0.stdp_4.vw 0.06432f
C313 layer_input_0.vout_4 stdp_4x2_0.stdp_0.vw 1.07484f
C314 a_58302_31541# vw42 0
C315 a_35466_52169# a_41930_52169# 0.0045f
C316 a_56944_53541# a_58698_52169# 0
C317 a_57586_52169# a_55466_52169# 1.12049f
C318 current_mirror_0.A a_58428_44960# 0.09318f
C319 a_55712_67160# avdd 2.01807f
C320 a_55466_31749# a_56944_31541# 0.1349f
C321 a_36944_31541# a_35466_30169# 0
C322 layer_input_0.nvout_3 layer_input_0.vout_3 1.78626f
C323 a_58428_33960# a_55466_30169# 0
C324 stdp_4x2_0.Current_limit_1.i_SUM layer_input_0.nvout_1 0.04096f
C325 a_58302_42541# a_57586_41169# 0.01547f
C326 layer_input_0.vout_3 a_55466_42749# 0.09414f
C327 current_mirror_0.B a_56944_42541# 0.13692f
C328 stdp_4x2_0.Current_limit_0.i_SUM a_56944_31541# 0.01885f
C329 current_mirror_0.A vpre1 0.7473f
C330 a_38428_55960# a_38302_53541# 0.72125f
C331 current_mirror_0.A a_38302_53541# 0.00108f
C332 a_38698_52169# vpost1 0.03292f
C333 current_mirror_0.B a_35586_55752# 0.23429f
C334 a_35466_52169# a_38698_52169# 1.05124f
C335 a_56944_53541# a_55466_52169# 0
C336 a_58428_33960# vw42 0.022f
C337 a_36944_53541# avdd 0.46403f
C338 current_mirror_0.B a_58302_64741# 0.94081f
C339 layer_output_0.nvout_2 a_58698_52169# 0.00189f
C340 a_35466_31749# a_35466_30169# 0
C341 a_55586_66952# avdd 6.7835f
C342 stdp_4x2_0.Current_limit_1.i_SUM a_38428_67160# 0.01354f
C343 a_38428_44960# layer_input_0.vout_3 0.01012f
C344 layer_input_0.nvout_3 a_8786_41529# 1.4855f
C345 current_mirror_0.B layer_input_0.nvout_3 0.34005f
C346 a_58428_44960# a_57586_41169# 0.02754f
C347 a_58302_42541# a_56944_42541# 1.39736f
C348 layer_input_0.vout_3 a_37586_41169# 0.74223f
C349 layer_input_0.Iext4 vpre2 0.05051f
C350 layer_input_0.Iext2 vpre2 0.18433f
C351 a_58302_53541# vpost2 0.17086f
C352 current_mirror_0.B a_35586_33752# 0.24638f
C353 a_36944_64741# vpre1 0.1375f
C354 a_38302_55752# a_38302_53541# 0.00102f
C355 a_55466_53749# a_55466_52169# 0
C356 a_35466_53749# avdd 0.00114f
C357 current_mirror_0.B stdp_4x2_0.stdp_2.vw 0.03849f
C358 a_58302_33752# vw42 0
C359 current_mirror_0.B a_58428_67160# 0.07018f
C360 layer_input_0.Iext2 layer_input_0.nvout_2 0.97028f
C361 layer_output_0.nvout_2 a_55466_52169# 0.03152f
C362 layer_input_0.nvout_3 a_58302_42541# 0.04529f
C363 current_mirror_0.B a_38428_44960# 0.07067f
C364 stdp_4x2_0.Current_limit_1.i_SUM a_38302_66952# 0.00194f
C365 stdp_4x2_0.Current_limit_1.i_SUM vw11 0.33739f
C366 a_58428_44960# a_56944_42541# 0.17308f
C367 a_58302_42541# a_55466_42749# 0.0096f
C368 layer_input_0.vout_3 a_36944_42541# 0.15705f
C369 layer_output_0.nvout_1 layer_output_0.nvout_2 0.89276f
C370 current_mirror_0.B a_37586_41169# 0.04f
C371 stdp_4x2_0.Current_limit_1.i_SUM vpre2 0.40305f
C372 current_mirror_0.A a_61930_30169# 0.72251f
C373 a_58428_55960# vpost2 0.0531f
C374 current_mirror_0.B stdp_4x2_0.stdp_0.vw 0.85196f
C375 a_37586_63369# vpost1 0.04109f
C376 a_35466_64949# vpre1 0.11982f
C377 a_35466_52169# vpost1 0.03656f
C378 layer_output_0.nvout_2 a_57586_63369# 0.05594f
C379 stdp_4x2_0.Current_limit_1.i_SUM layer_input_0.nvout_2 0.17166f
C380 a_58302_53541# avdd 2.97787f
C381 a_55712_33960# vw42 0.82227f
C382 stdp_4x2_0.stdp_5.vw stdp_4x2_0.Current_limit_0.i_SUM 0.34034f
C383 current_mirror_0.B a_58302_66952# 0
C384 current_mirror_0.A a_55586_44752# 0.14126f
C385 a_58302_31541# a_57586_30169# 0.01567f
C386 layer_input_0.nvout_3 a_58428_44960# 0.08292f
C387 current_mirror_0.B a_38302_44752# 0.00181f
C388 a_35712_44960# layer_input_0.vout_3 0.0393f
C389 layer_output_0.nvout_1 a_37586_52169# 0.05477f
C390 layer_output_0.Iext1 layer_output_0.Iext2 0
C391 current_mirror_0.B a_36944_42541# 0.13566f
C392 layer_input_0.vout_4 avdd 5.05531f
C393 a_58302_44752# a_56944_42541# 0
C394 layer_input_0.vout_3 a_35466_42749# 0.1259f
C395 stdp_4x2_0.Current_limit_1.i_SUM a_38698_41169# 0.00125f
C396 current_mirror_0.A a_58698_30169# 0.67791f
C397 a_58302_55752# vpost2 0.12075f
C398 layer_output_0.Iext2 a_45786_9329# 1.52483f
C399 stdp_4x2_0.Current_limit_1.i_SUM a_38302_31541# 0.00649f
C400 a_35586_55752# a_38302_53541# 0.07669f
C401 layer_input_0.nvout_4 a_56944_31541# 0.00446f
C402 layer_output_0.nvout_2 a_56944_64741# 0.04401f
C403 a_37586_52169# a_41930_52169# 0.07064f
C404 a_55586_33752# vw42 1.34914f
C405 a_58428_55960# avdd 1.61883f
C406 stdp_4x2_0.Current_limit_1.i_SUM a_38428_55960# 0.00203f
C407 current_mirror_0.B a_61930_63369# 0
C408 current_mirror_0.A stdp_4x2_0.stdp_3.vw 0.06224f
C409 stdp_4x2_0.Current_limit_1.i_SUM current_mirror_0.A 0.2816f
C410 a_58302_31541# a_56944_31541# 1.39736f
C411 a_58428_33960# a_57586_30169# 0.02754f
C412 a_36944_31541# a_37586_30169# 1.08975f
C413 layer_input_0.nvout_3 a_58302_44752# 0.163f
C414 a_35586_44752# layer_input_0.vout_3 0.02389f
C415 Vin Vin_neg 0.26083f
C416 layer_output_0.nvout_1 a_36944_53541# 0.04193f
C417 a_69620_23589# layer_output_0.Iext2 0.92752f
C418 a_55712_44960# a_56944_42541# 0
C419 stdp_4x2_0.Current_limit_1.i_SUM a_35466_41169# 0.02745f
C420 a_8786_33529# avdd 1.33081f
C421 current_mirror_0.A a_55466_30169# 0.66352f
C422 stdp_4x2_0.Current_limit_1.i_SUM a_38428_33960# 0.02713f
C423 stdp_4x2_0.stdp_2.vw a_38302_53541# 0
C424 current_mirror_0.B vpost2 0.14435f
C425 layer_input_0.Iext3 layer_input_0.vout_3 0.14329f
C426 layer_input_0.nvout_4 a_55466_31749# 0
C427 a_37586_52169# a_38698_52169# 0.07349f
C428 a_55712_67160# a_56944_64741# 0
C429 layer_output_0.nvout_2 a_55466_64949# 0.00823f
C430 current_mirror_0.B a_58698_63369# 0.05786f
C431 a_36944_53541# a_41930_52169# 0
C432 a_58302_55752# avdd 1.839f
C433 current_mirror_0.A a_38302_42541# 0
C434 stdp_4x2_0.Current_limit_1.i_SUM a_36944_64741# 0.11079f
C435 a_58428_33960# a_56944_31541# 0.17308f
C436 layer_input_0.nvout_3 a_55712_44960# 0.09383f
C437 a_58302_31541# a_55466_31749# 0.0096f
C438 stdp_4x2_0.stdp_6.vw layer_input_0.vout_3 1.69724f
C439 a_35466_31749# a_37586_30169# 0.00297f
C440 current_mirror_0.B a_35586_44752# 0.23443f
C441 layer_input_0.vout_3 avdd 5.54781f
C442 layer_output_0.nvout_1 a_35466_53749# 0.00676f
C443 current_mirror_0.A vw42 0.06645f
C444 stdp_4x2_0.Current_limit_0.i_SUM layer_input_0.nvout_4 0.05408f
C445 a_55712_44960# a_55466_42749# 0.014f
C446 a_55586_44752# a_56944_42541# 0.00193f
C447 a_38302_42541# a_35466_41169# 0
C448 current_mirror_0.A a_41930_30169# 0.72308f
C449 a_55586_55752# vpost2 0.05444f
C450 stdp_4x2_0.Current_limit_0.i_SUM a_58302_31541# 0.29688f
C451 a_8786_57529# vpre1 0.23235f
C452 stdp_4x2_0.Current_limit_1.i_SUM a_38302_33752# 0.00415f
C453 a_58302_42541# vpost2 0.14065f
C454 layer_input_0.Iext3 a_8786_41529# 1.53083f
C455 a_55586_66952# a_56944_64741# 0.00193f
C456 a_55712_67160# a_55466_64949# 0.014f
C457 a_55712_55960# avdd 2.01786f
C458 current_mirror_0.B a_55466_63369# 0.00909f
C459 a_58302_53541# a_55466_52169# 0.00311f
C460 a_58428_55960# a_58698_52169# 0
C461 a_56944_53541# a_57586_52169# 1.09114f
C462 stdp_4x2_0.Current_limit_1.i_SUM a_35712_55960# 0.02694f
C463 layer_output_0.nvout_2 vpost1 0.00467f
C464 stdp_4x2_0.Current_limit_1.i_SUM a_35466_64949# 0.02661f
C465 current_mirror_0.B stdp_4x2_0.stdp_6.vw 0.03849f
C466 a_58302_33752# a_56944_31541# 0
C467 a_35466_31749# a_36944_31541# 0.13503f
C468 layer_input_0.nvout_3 a_55586_44752# 0.13398f
C469 a_8786_41529# avdd 1.33081f
C470 current_mirror_0.B avdd 47.6846f
C471 stdp_4x2_0.stdp_3.vw a_56944_42541# 0.92323f
C472 a_45786_9329# vpost2 0.25559f
C473 current_mirror_0.A a_38698_30169# 0.68804f
C474 stdp_4x2_0.stdp_4.vw vpost2 0.05808f
C475 stdp_4x2_0.Current_limit_0.i_SUM a_58428_33960# 0.18041f
C476 stdp_4x2_0.Current_limit_1.i_SUM a_35712_33960# 0.01723f
C477 layer_output_0.nvout_1 layer_input_0.vout_4 0.33979f
C478 a_58428_44960# vpost2 0.20198f
C479 a_37586_52169# vpost1 0.04851f
C480 layer_input_0.nvout_4 a_36944_31541# 0.45169f
C481 stdp_4x2_0.Current_limit_1.i_SUM a_35586_55752# 0.06673f
C482 a_55466_53749# a_57586_52169# 0.00332f
C483 a_55586_55752# avdd 6.7673f
C484 current_mirror_0.B a_41930_63369# 0.00473f
C485 a_58428_55960# a_55466_52169# 0
C486 a_37586_52169# a_35466_52169# 1.12049f
C487 layer_input_0.nvout_1 stdp_4x2_0.Current_limit_0.i_SUM 0.04864f
C488 current_mirror_0.B a_61930_52169# 0.00839f
C489 a_55712_33960# a_56944_31541# 0
C490 layer_output_0.nvout_2 a_57586_52169# 0.05655f
C491 a_38302_31541# a_35466_30169# 0
C492 layer_input_0.nvout_3 stdp_4x2_0.stdp_3.vw 0.0731f
C493 a_58302_42541# avdd 2.97831f
C494 a_38428_33960# a_38698_30169# 0
C495 stdp_4x2_0.Current_limit_1.i_SUM layer_input_0.nvout_3 0.05988f
C496 stdp_4x2_0.Current_limit_0.i_SUM a_58698_41169# 0.00404f
C497 stdp_4x2_0.stdp_3.vw a_55466_42749# 0.36212f
C498 current_mirror_0.A a_35466_30169# 0.66687f
C499 stdp_4x2_0.Current_limit_0.i_SUM a_58302_33752# 0.01081f
C500 layer_output_0.Iext1 avdd 7.25739f
C501 stdp_4x2_0.Current_limit_1.i_SUM a_35586_33752# 0.07756f
C502 a_58302_44752# vpost2 0.01579f
C503 layer_input_0.nvout_4 a_35466_31749# 0.00245f
C504 a_36944_53541# vpost1 0.25943f
C505 a_55466_53749# a_56944_53541# 0.13503f
C506 a_36944_53541# a_35466_52169# 0
C507 a_45786_9329# avdd 1.36398f
C508 current_mirror_0.B a_38698_63369# 0.05536f
C509 stdp_4x2_0.Current_limit_1.i_SUM stdp_4x2_0.stdp_2.vw 0.36474f
C510 stdp_4x2_0.stdp_4.vw avdd 11.7756f
C511 layer_input_0.nvout_1 stdp_4x2_0.stdp_5.vw 0
C512 layer_output_0.nvout_2 a_56944_53541# 0.04453f
C513 a_38428_33960# a_35466_30169# 0
C514 a_55586_33752# a_56944_31541# 0.00193f
C515 a_55712_33960# a_55466_31749# 0.014f
C516 current_mirror_0.B a_58698_52169# 0.05786f
C517 layer_input_0.nvout_3 a_38302_42541# 0.18623f
C518 a_58428_44960# avdd 1.61891f
C519 stdp_4x2_0.Current_limit_1.i_SUM a_38428_44960# 0.03886f
C520 stdp_4x2_0.Current_limit_0.i_SUM a_55466_41169# 0.04348f
C521 layer_output_0.nvout_1 layer_input_0.vout_3 0.0498f
C522 stdp_4x2_0.Current_limit_1.i_SUM a_37586_41169# 0.04949f
C523 Vin vpre2 0.25548f
C524 current_mirror_0.A a_57586_30169# 0.76293f
C525 layer_input_0.Iext3 vpre1 0.03898f
C526 layer_input_0.Iext1 vpre1 1.44313f
C527 stdp_4x2_0.Current_limit_0.i_SUM a_55712_33960# 0
C528 a_55466_63369# vpre1 0
C529 a_69620_23589# avdd 4.29706f
C530 stdp_4x2_0.Current_limit_1.i_SUM stdp_4x2_0.stdp_0.vw 0.33672f
C531 layer_input_0.nvout_4 a_58302_31541# 0.01441f
C532 avdd vpre1 9.84779f
C533 stdp_4x2_0.stdp_4.vw a_61930_52169# 0.00597f
C534 current_mirror_0.B a_35466_63369# 0.01567f
C535 a_35466_53749# a_35466_52169# 0
C536 a_33386_9329# avdd 1.25354f
C537 a_38302_53541# avdd 2.97966f
C538 layer_input_0.nvout_1 a_38302_64741# 0.21935f
C539 a_38428_44960# a_38302_42541# 0.72039f
C540 layer_output_0.nvout_2 a_55466_53749# 0.00823f
C541 current_mirror_0.B a_55466_52169# 0
C542 stdp_4x2_0.Current_limit_1.i_SUM a_38302_44752# 0.00397f
C543 a_58302_44752# avdd 1.8388f
C544 stdp_4x2_0.Current_limit_0.i_SUM vpre2 0.0034f
C545 a_38302_42541# a_37586_41169# 0.01443f
C546 layer_output_0.nvout_1 current_mirror_0.B 0.04688f
C547 stdp_4x2_0.Current_limit_1.i_SUM a_36944_42541# 0.03419f
C548 current_mirror_0.A a_56944_31541# 0.30533f
C549 stdp_4x2_0.Current_limit_0.i_SUM a_55586_33752# 0.0709f
C550 a_41930_63369# vpre1 0.09376f
C551 a_49420_23589# avdd 4.29706f
C552 a_55586_44752# vpost2 0.21987f
C553 stdp_4x2_0.Current_limit_0.i_SUM layer_input_0.nvout_2 0.05604f
C554 layer_input_0.nvout_4 a_58428_33960# 0.08349f
C555 current_mirror_0.B a_57586_63369# 0.03349f
C556 a_38428_67160# a_38302_64741# 0.72125f
C557 a_58428_33960# a_58302_31541# 0.72049f
C558 a_38302_44752# a_38302_42541# 0.0012f
C559 a_55712_44960# avdd 2.01807f
C560 current_mirror_0.B a_41930_52169# 0.00473f
C561 stdp_4x2_0.stdp_0.vw a_41930_30169# 0.00597f
C562 stdp_4x2_0.Current_limit_1.i_SUM a_35712_44960# 0.01432f
C563 a_58698_30169# vpost2 0.03711f
C564 a_55712_67160# layer_output_0.nvout_2 0.14003f
C565 layer_input_0.vout_4 vpost1 0.11137f
C566 a_38302_42541# a_36944_42541# 1.39663f
C567 stdp_4x2_0.Current_limit_1.i_SUM a_35466_42749# 0.00869f
C568 current_mirror_0.A a_55466_31749# 0
C569 a_38698_63369# vpre1 0.14678f
C570 stdp_4x2_0.stdp_3.vw vpost2 0.03788f
C571 layer_input_0.nvout_4 a_58302_33752# 0.18283f
C572 layer_input_0.Iext4 layer_input_0.Iext3 10.8518f
C573 layer_input_0.Iext1 layer_input_0.Iext4 0.31505f
C574 layer_output_0.nvout_1 layer_output_0.Iext1 5.23586f
C575 layer_input_0.Iext2 layer_input_0.Iext3 2.84268f
C576 layer_input_0.Iext2 layer_input_0.Iext1 0.34626f
C577 a_58302_53541# a_57586_52169# 0.01547f
C578 current_mirror_0.B a_56944_64741# 0.15089f
C579 stdp_4x2_0.Current_limit_0.i_SUM current_mirror_0.A 0.20824f
C580 a_38302_66952# a_38302_64741# 0.00102f
C581 a_38302_64741# vw11 0
C582 a_58302_33752# a_58302_31541# 0.0012f
C583 current_mirror_0.B a_38698_52169# 0.05543f
C584 a_38302_31541# a_37586_30169# 0.01455f
C585 a_55586_44752# avdd 6.77629f
C586 layer_input_0.Iext4 avdd 12.4632f
C587 a_55466_30169# vpost2 0.03611f
C588 layer_output_0.nvout_1 a_45786_9329# 0
C589 stdp_4x2_0.Current_limit_1.i_SUM a_35586_44752# 0.06966f
C590 layer_input_0.Iext2 avdd 5.36646f
C591 a_55586_66952# layer_output_0.nvout_2 0.00639f
C592 a_38302_42541# a_35466_42749# 0.0096f
C593 a_35586_66952# current_mirror_0.B 0.10086f
C594 current_mirror_0.A a_37586_30169# 1.02887f
C595 a_58698_41169# a_61930_41169# 1.05124f
C596 a_35466_63369# vpre1 0.0471f
C597 layer_input_0.nvout_4 a_55712_33960# 0.09236f
C598 a_10290_71650# layer_input_0.Iext3 0.16709f
C599 a_4794_71649# layer_input_0.Iext3 0.20346f
C600 a_58428_55960# a_57586_52169# 0.02754f
C601 a_4794_71649# layer_input_0.Iext1 0.12554f
C602 a_58302_53541# a_56944_53541# 1.39736f
C603 a_36944_53541# a_37586_52169# 1.09086f
C604 stdp_4x2_0.stdp_5.vw current_mirror_0.A 0.03463f
C605 vpost2 vw42 0.03788f
C606 layer_input_0.vout_3 vpost1 0.22731f
C607 a_38302_31541# a_36944_31541# 1.39771f
C608 a_38428_33960# a_37586_30169# 0.02739f
C609 a_58302_33752# a_58428_33960# 0.16397f
C610 layer_output_0.nvout_1 vpre1 0.04074f
C611 stdp_4x2_0.stdp_3.vw avdd 11.7751f
C612 a_35586_44752# a_38302_42541# 0.07669f
C613 stdp_4x2_0.Current_limit_1.i_SUM stdp_4x2_0.stdp_6.vw 0.46121f
C614 a_10290_71650# avdd 5.90654f
C615 layer_output_0.nvout_1 a_33386_9329# 1.48556f
C616 stdp_4x2_0.Current_limit_1.i_SUM avdd 16.8473f
C617 a_4794_71649# avdd 5.68562f
C618 layer_output_0.nvout_1 a_38302_53541# 0.09745f
C619 a_55586_66952# a_55712_67160# 0.30951f
C620 stdp_4x2_0.Current_limit_0.i_SUM a_57586_41169# 0.04664f
C621 Vin_neg vpre2 1.51658f
C622 current_mirror_0.A a_36944_31541# 0.38455f
C623 a_57586_63369# vpre1 0
C624 a_55466_41169# a_61930_41169# 0.0045f
C625 layer_input_0.nvout_4 a_55586_33752# 0.14262f
C626 a_7926_70021# layer_input_0.Iext3 0.02495f
C627 layer_input_0.Iext3 a_4666_70229# 0.00884f
C628 layer_input_0.Iext1 a_4666_70229# 0.00177f
C629 layer_input_0.Iext1 a_7926_70021# 0.02805f
C630 layer_output_0.nvout_1 a_49420_23589# 0
C631 a_38302_64741# current_mirror_0.A 0
C632 a_35466_53749# a_37586_52169# 0.00332f
C633 current_mirror_0.B a_37586_63369# 0.03997f
C634 a_58302_53541# a_55466_53749# 0.0096f
C635 a_58428_55960# a_56944_53541# 0.17308f
C636 a_38428_67160# layer_input_0.nvout_1 0.08498f
C637 current_mirror_0.B vpost1 0.13801f
C638 a_38428_33960# a_36944_31541# 0.17308f
C639 current_mirror_0.B a_35466_52169# 0.01567f
C640 layer_output_0.nvout_2 a_58302_53541# 0.07453f
C641 a_55586_33752# a_58302_31541# 0.07652f
C642 a_38302_31541# a_35466_31749# 0.0096f
C643 a_55712_33960# a_58428_33960# 0.03272f
C644 stdp_4x2_0.stdp_6.vw a_38302_42541# 0
C645 a_35712_67160# vpre1 0.01513f
C646 a_4666_70229# avdd 0.64941f
C647 a_38302_42541# avdd 2.98316f
C648 a_7926_70021# avdd 2.20477f
C649 stdp_4x2_0.Current_limit_0.i_SUM a_56944_42541# 0.02327f
C650 avdd vw42 13.3826f
C651 current_mirror_0.A a_35466_31749# 0.01644f
C652 a_55466_41169# a_58698_41169# 1.05124f
C653 a_56944_64741# vpre1 0.02582f
C654 layer_input_0.nvout_4 a_38302_31541# 0.19561f
C655 a_58302_55752# a_56944_53541# 0
C656 stdp_4x2_0.Current_limit_0.i_SUM a_58302_64741# 0.00271f
C657 a_35466_53749# a_36944_53541# 0.13503f
C658 a_38302_64741# a_36944_64741# 1.39736f
C659 stdp_4x2_0.Current_limit_0.i_SUM layer_input_0.nvout_3 0.06392f
C660 layer_input_0.nvout_1 vw11 0.43891f
C661 a_35586_66952# vpre1 0.00769f
C662 a_38302_66952# layer_input_0.nvout_1 0.10695f
C663 layer_output_0.nvout_2 a_58428_55960# 0.13477f
C664 a_55586_33752# a_58428_33960# 0.00852f
C665 current_mirror_0.B a_57586_52169# 0.032f
C666 a_38302_33752# a_36944_31541# 0
C667 current_mirror_0.A layer_input_0.nvout_4 0.14522f
C668 stdp_4x2_0.Current_limit_0.i_SUM a_55466_42749# 0
C669 layer_input_0.nvout_1 vpre2 0.23592f
C670 current_mirror_0.A a_58302_31541# 0.03728f
C671 layer_output_0.Iext1 vpost1 3.62221f
C672 a_55466_64949# vpre1 0.09414f
C673 stdp_4x2_0.Current_limit_0.i_SUM layer_output_0.Iext2 0.00961f
C674 layer_input_0.nvout_4 a_38428_33960# 0.10554f
C675 a_55712_55960# a_56944_53541# 0
C676 a_38302_64741# a_35466_64949# 0.0096f
C677 stdp_4x2_0.stdp_5.vw a_58302_64741# 0
C678 stdp_4x2_0.Current_limit_1.i_SUM a_35466_63369# 0.03171f
C679 stdp_4x2_0.Current_limit_0.i_SUM a_58428_67160# 0.00814f
C680 a_55586_33752# a_58302_33752# 0.37123f
C681 layer_output_0.nvout_2 a_58302_55752# 0.012f
C682 a_38302_66952# a_38428_67160# 0.16397f
C683 a_38428_67160# vw11 0.022f
C684 a_35712_33960# a_36944_31541# 0
C685 current_mirror_0.B a_56944_53541# 0.13905f
C686 a_57586_30169# vpost2 0.04345f
C687 current_mirror_0.A a_61930_41169# 0.72542f
C688 layer_output_0.nvout_2 layer_input_0.vout_3 0.00209f
C689 current_mirror_0.A a_58428_33960# 0.11136f
C690 stdp_4x2_0.Current_limit_1.i_SUM layer_output_0.nvout_1 6.76339f
C691 a_37586_63369# vpre1 0.89979f
C692 vpre1 vpost1 0.35547f
C693 a_33386_9329# vpost1 0.28905f
C694 a_38302_53541# vpost1 0.17182f
C695 layer_input_0.nvout_4 a_38302_33752# 0.1597f
C696 stdp_4x2_0.Current_limit_0.i_SUM a_58302_66952# 0.00169f
C697 a_55712_55960# a_55466_53749# 0.014f
C698 stdp_4x2_0.stdp_5.vw a_58428_67160# 0.022f
C699 a_55586_55752# a_56944_53541# 0.00193f
C700 a_38302_53541# a_35466_52169# 0.00311f
C701 layer_input_0.nvout_1 current_mirror_0.A 0.4462f
C702 a_38302_66952# vw11 0
C703 a_35712_33960# a_35466_31749# 0.014f
C704 layer_output_0.nvout_2 a_55712_55960# 0.14569f
C705 a_55586_33752# a_55712_33960# 0.30951f
C706 a_35586_33752# a_36944_31541# 0.00193f
C707 current_mirror_0.A a_58698_41169# 0.72859f
C708 a_56944_31541# vpost2 0.13989f
C709 current_mirror_0.B layer_output_0.nvout_2 0.06482f
C710 layer_output_0.nvout_1 a_38302_42541# 0.00313f
C711 stdp_4x2_0.Current_limit_1.i_SUM a_35712_67160# 0.03355f
C712 a_57586_41169# a_61930_41169# 0.07064f
C713 layer_input_0.nvout_4 a_35712_33960# 0.09184f
C714 stdp_4x2_0.stdp_4.vw a_56944_53541# 0.92323f
C715 stdp_4x2_0.stdp_5.vw a_58302_66952# 0
C716 a_38428_67160# current_mirror_0.A 0.067f
C717 layer_input_0.nvout_1 a_36944_64741# 0.29238f
C718 stdp_4x2_0.stdp_0.vw a_36944_31541# 0.92323f
C719 layer_output_0.nvout_2 a_55586_55752# 0.03916f
C720 current_mirror_0.B a_37586_52169# 0.04053f
C721 layer_input_0.nvout_2 vpre2 1.4224f
C722 current_mirror_0.A a_55466_41169# 0.6433f
C723 layer_input_0.Iext2 a_8786_49529# 1.52732f
C724 layer_output_0.nvout_2 a_58302_42541# 0.00544f
C725 stdp_4x2_0.Current_limit_1.i_SUM a_35586_66952# 0.04042f
C726 a_56944_31541# avdd 0.4642f
C727 a_38698_41169# a_41930_41169# 1.05124f
C728 a_57586_41169# a_58698_41169# 0.07349f
C729 a_56944_42541# a_61930_41169# 0
C730 stdp_4x2_0.Current_limit_0.i_SUM vpost2 0.08309f
C731 layer_input_0.Iext3 Vin 0.13023f
C732 layer_input_0.Iext1 Vin 0.05036f
C733 stdp_4x2_0.stdp_5.vw a_61930_63369# 0.00597f
C734 layer_input_0.nvout_4 a_35586_33752# 0.23404f
C735 layer_output_0.nvout_1 a_38698_30169# 0.0028f
C736 a_58428_55960# a_58302_53541# 0.72049f
C737 current_mirror_0.A vw11 0.03518f
C738 layer_input_0.nvout_1 a_35466_64949# 0.00103f
C739 a_38428_67160# a_36944_64741# 0.17302f
C740 stdp_4x2_0.stdp_4.vw a_55466_53749# 0.36212f
C741 layer_output_0.nvout_2 a_45786_9329# 1.59931f
C742 current_mirror_0.B a_36944_53541# 0.1547f
C743 stdp_4x2_0.stdp_0.vw a_35466_31749# 0.36212f
C744 layer_output_0.nvout_2 stdp_4x2_0.stdp_4.vw 0.17985f
C745 avdd Vin 20.8436f
C746 a_38428_55960# vpre2 0.04621f
C747 current_mirror_0.A a_41930_41169# 0.76756f
C748 current_mirror_0.A vpre2 0.62238f
C749 layer_output_0.nvout_2 a_58428_44960# 0.09134f
C750 current_mirror_0.B a_55586_66952# 0.10054f
C751 current_mirror_0.A a_55586_33752# 0.14113f
C752 a_55466_31749# avdd 0.00114f
C753 a_57586_41169# a_55466_41169# 1.12049f
C754 a_56944_42541# a_58698_41169# 0
C755 a_35466_41169# a_41930_41169# 0.0045f
C756 a_38428_55960# layer_input_0.nvout_2 0.10982f
C757 current_mirror_0.A layer_input_0.nvout_2 0.04811f
C758 layer_input_0.nvout_4 stdp_4x2_0.stdp_0.vw 0.457f
C759 stdp_4x2_0.Current_limit_0.i_SUM a_55466_63369# 0.03043f
C760 a_8786_33529# layer_input_0.vout_4 0.23229f
C761 layer_output_0.nvout_1 a_35466_30169# 0.03193f
C762 a_58302_55752# a_58302_53541# 0.00104f
C763 layer_input_0.nvout_1 a_58302_64741# 0.14879f
C764 a_38302_66952# a_36944_64741# 0
C765 a_36944_64741# vw11 0.92323f
C766 stdp_4x2_0.Current_limit_1.i_SUM a_37586_63369# 0.06354f
C767 stdp_4x2_0.Current_limit_0.i_SUM avdd 16.9022f
C768 stdp_4x2_0.Current_limit_1.i_SUM vpost1 0.0888f
C769 stdp_4x2_0.Current_limit_1.i_SUM a_35466_52169# 0.03055f
C770 current_mirror_0.A a_38698_41169# 0.66433f
C771 layer_output_0.nvout_2 a_58302_44752# 0.0066f
C772 current_mirror_0.A a_38302_31541# 0.05315f
C773 a_56944_42541# a_55466_41169# 0
C774 a_35466_41169# a_38698_41169# 1.05124f
C775 a_38302_55752# layer_input_0.nvout_2 0.15019f
C776 current_mirror_0.A a_38428_55960# 0.067f
C777 a_58302_55752# a_58428_55960# 0.16397f
C778 a_38302_53541# a_37586_52169# 0.01547f
C779 layer_input_0.nvout_1 a_58428_67160# 0.08058f
C780 a_35466_64949# vw11 0.36212f
C781 a_55712_67160# vpre1 0
C782 a_38302_42541# vpost1 0.17478f
C783 stdp_4x2_0.stdp_5.vw avdd 11.7055f
C784 a_38428_33960# a_38302_31541# 0.72125f
C785 a_35712_55960# vpre2 0.08295f
C786 current_mirror_0.B a_58302_53541# 0.97456f
C787 current_mirror_0.A a_35466_41169# 0.62773f
C788 layer_output_0.nvout_2 a_55712_44960# 0.15444f
C789 current_mirror_0.A a_38428_33960# 0.08698f
C790 a_55466_42749# a_55466_41169# 0
C791 current_mirror_0.B layer_input_0.vout_4 0.53518f
C792 a_36944_31541# avdd 0.46316f
C793 a_38302_55752# a_38428_55960# 0.16397f
C794 a_35712_55960# layer_input_0.nvout_2 0.07443f
C795 a_36944_64741# current_mirror_0.A 0.25485f
C796 layer_input_0.nvout_1 a_8786_57529# 1.49114f
C797 a_38302_53541# a_36944_53541# 1.39658f
C798 layer_input_0.nvout_4 vpost2 0.06625f
C799 a_55586_55752# a_58302_53541# 0.07645f
C800 a_55712_55960# a_58428_55960# 0.03179f
C801 layer_input_0.nvout_1 a_58302_66952# 0.16487f
C802 a_38302_64741# avdd 2.97911f
C803 current_mirror_0.B a_58428_55960# 0.06874f
C804 a_38302_33752# a_38302_31541# 0.0012f
C805 a_35586_55752# vpre2 0.13549f
C806 current_mirror_0.A a_57586_41169# 0.85432f
C807 a_58302_31541# vpost2 0.11954f
C808 layer_output_0.nvout_2 a_55586_44752# 0.03935f
C809 a_38698_30169# vpost1 0.03437f
C810 a_35466_31749# avdd 0.00114f
C811 a_35586_55752# layer_input_0.nvout_2 0.19043f
C812 a_35712_55960# a_38428_55960# 0.03272f
C813 layer_input_0.Iext3 Vin_neg 0.04345f
C814 layer_input_0.Iext1 Vin_neg 0.33204f
C815 a_35466_64949# current_mirror_0.A 0
C816 a_38302_53541# a_35466_53749# 0.0096f
C817 stdp_4x2_0.stdp_4.vw a_58302_53541# 0
C818 a_55586_55752# a_58428_55960# 0.00852f
C819 stdp_4x2_0.Current_limit_0.i_SUM a_55466_52169# 0.03043f
C820 avdd Vin_neg 0.68138f
C821 a_38302_33752# a_38428_33960# 0.16397f
C822 current_mirror_0.B a_58302_55752# 0
C823 a_58428_33960# vpost2 0.20136f
C824 stdp_4x2_0.stdp_2.vw vpre2 1.15746f
C825 current_mirror_0.A a_56944_42541# 0.28427f
C826 layer_output_0.nvout_2 stdp_4x2_0.stdp_3.vw 0.17792f
C827 a_8786_41529# layer_input_0.vout_3 0.23229f
C828 current_mirror_0.B layer_input_0.vout_3 0.04489f
C829 layer_input_0.nvout_4 avdd 9.54509f
C830 a_35466_30169# vpost1 0.0342f
C831 a_58302_31541# avdd 2.98358f
C832 a_37586_41169# a_41930_41169# 0.0705f
C833 a_35586_55752# a_38428_55960# 0.00852f
C834 stdp_4x2_0.stdp_2.vw layer_input_0.nvout_2 0.59031f
C835 layer_input_0.nvout_1 vpost2 0.06468f
C836 current_mirror_0.A a_35586_55752# 0.49749f
C837 layer_output_0.nvout_2 a_55466_30169# 0.02736f
C838 layer_output_0.nvout_1 a_37586_30169# 0.05763f
C839 stdp_4x2_0.Current_limit_0.i_SUM a_57586_63369# 0.06282f
C840 a_35466_64949# a_36944_64741# 0.13503f
C841 a_58302_64741# current_mirror_0.A 0.00122f
C842 layer_input_0.nvout_1 a_58698_63369# 0.00258f
C843 a_55586_55752# a_58302_55752# 0.37123f
C844 stdp_4x2_0.stdp_4.vw a_58428_55960# 0.02183f
C845 a_58698_41169# vpost2 0.04205f
C846 current_mirror_0.A layer_input_0.nvout_3 0.04811f
C847 a_35712_33960# a_38428_33960# 0.01041f
C848 a_35586_33752# a_38302_31541# 0.07669f
C849 stdp_4x2_0.Current_limit_1.i_SUM a_37586_52169# 0.06079f
C850 a_58302_33752# vpost2 0.01579f
C851 current_mirror_0.A a_55466_42749# 0
C852 a_38428_44960# a_38698_41169# 0
C853 current_mirror_0.A a_35586_33752# 0.49749f
C854 layer_output_0.nvout_2 vw42 0.20847f
C855 a_58428_33960# avdd 1.61923f
C856 a_56944_42541# a_57586_41169# 1.09114f
C857 a_37586_41169# a_38698_41169# 0.07349f
C858 a_36944_42541# a_41930_41169# 0
C859 a_35586_55752# a_38302_55752# 0.37123f
C860 stdp_4x2_0.stdp_2.vw a_38428_55960# 0.022f
C861 layer_input_0.Iext1 layer_input_0.nvout_1 0.97976f
C862 current_mirror_0.A stdp_4x2_0.stdp_2.vw 0.07817f
C863 a_58428_67160# current_mirror_0.A 0.06227f
C864 a_38302_64741# a_35466_63369# 0
C865 stdp_4x2_0.Current_limit_0.i_SUM a_56944_64741# 0.13498f
C866 layer_input_0.nvout_1 a_55466_63369# 0.02902f
C867 layer_output_0.nvout_1 a_36944_31541# 0.03768f
C868 stdp_4x2_0.stdp_4.vw a_58302_55752# 0
C869 a_55466_41169# vpost2 0.04472f
C870 a_55586_55752# a_55712_55960# 0.30951f
C871 current_mirror_0.A a_38428_44960# 0.06806f
C872 layer_input_0.nvout_1 avdd 10.6018f
C873 a_35586_33752# a_38428_33960# 0.00852f
C874 stdp_4x2_0.stdp_0.vw a_38302_31541# 0
C875 stdp_4x2_0.Current_limit_1.i_SUM a_36944_53541# 0.10977f
C876 current_mirror_0.B a_55586_55752# 0.28398f
C877 current_mirror_0.A a_37586_41169# 0.73528f
C878 layer_output_0.nvout_1 a_38302_64741# 0.17905f
C879 current_mirror_0.B a_58302_42541# 0.9809f
C880 a_38428_44960# a_35466_41169# 0
C881 current_mirror_0.A stdp_4x2_0.stdp_0.vw 0.48512f
C882 a_55466_42749# a_57586_41169# 0.00332f
C883 a_37586_41169# a_35466_41169# 1.12049f
C884 a_58302_33752# avdd 1.83974f
C885 a_35586_55752# a_35712_55960# 0.30951f
C886 stdp_4x2_0.stdp_2.vw a_38302_55752# 0
C887 stdp_4x2_0.Current_limit_0.i_SUM a_55466_64949# 0.02686f
C888 layer_input_0.nvout_1 a_41930_63369# 0.04221f
C889 stdp_4x2_0.stdp_5.vw a_56944_64741# 0.92323f
C890 layer_output_0.nvout_1 a_35466_31749# 0.00196f
C891 stdp_4x2_0.stdp_4.vw a_55712_55960# 0.82225f
C892 a_38428_67160# avdd 1.61868f
C893 a_35586_33752# a_38302_33752# 0.37123f
C894 stdp_4x2_0.stdp_0.vw a_38428_33960# 0.01489f
C895 current_mirror_0.B stdp_4x2_0.stdp_4.vw 0.0297f
C896 stdp_4x2_0.Current_limit_1.i_SUM a_35466_53749# 0.02521f
C897 a_55586_33752# vpost2 0.21987f
C898 current_mirror_0.A a_36944_42541# 0.34725f
C899 current_mirror_0.B a_58428_44960# 0.06552f
C900 layer_input_0.nvout_3 a_56944_42541# 0.017f
C901 layer_input_0.nvout_2 vpost2 0.0893f
C902 a_36944_42541# a_35466_41169# 0
C903 a_55712_33960# avdd 2.01807f
C904 a_55466_42749# a_56944_42541# 0.13503f
C905 layer_input_0.Iext4 layer_input_0.vout_4 0.15296f
C906 layer_output_0.nvout_1 layer_input_0.nvout_4 0.07868f
C907 stdp_4x2_0.stdp_2.vw a_35712_55960# 0.82227f
C908 current_mirror_0.A a_61930_63369# 0.73938f
C909 layer_input_0.nvout_1 a_38698_63369# 0.04204f
C910 stdp_4x2_0.stdp_5.vw a_55466_64949# 0.36212f
C911 stdp_4x2_0.stdp_4.vw a_55586_55752# 1.34914f
C912 current_mirror_0.B vpre1 0.04941f
C913 layer_input_0.Iext3 vpre2 0.04447f
C914 layer_input_0.Iext1 vpre2 0.04605f
C915 a_38302_66952# avdd 1.83974f
C916 avdd vw11 12.3758f
C917 a_35586_33752# a_35712_33960# 0.30951f
C918 stdp_4x2_0.stdp_0.vw a_38302_33752# 0
C919 current_mirror_0.B a_38302_53541# 0.89852f
C920 current_mirror_0.A a_35466_42749# 0
C921 a_58428_44960# a_58302_42541# 0.72049f
C922 current_mirror_0.B a_58302_44752# 0
C923 layer_input_0.nvout_3 a_55466_42749# 0.00299f
C924 a_55712_44960# layer_input_0.vout_3 0
C925 a_35586_66952# a_38302_64741# 0.07669f
C926 stdp_4x2_0.stdp_6.vw a_41930_41169# 0.00597f
C927 avdd vpre2 6.93774f
C928 a_37586_30169# vpost1 0.03751f
C929 current_mirror_0.A vpost2 1.97837f
C930 a_55586_33752# avdd 6.78389f
C931 a_35466_42749# a_35466_41169# 0
C932 stdp_4x2_0.Current_limit_1.i_SUM layer_input_0.vout_4 0.07397f
C933 stdp_4x2_0.stdp_2.vw a_35586_55752# 1.34914f
C934 layer_input_0.Iext4 a_8786_33529# 1.53083f
C935 current_mirror_0.A a_58698_63369# 0.71031f
C936 layer_output_0.nvout_2 a_57586_30169# 0.05715f
C937 a_58428_67160# a_58302_64741# 0.72049f
C938 layer_input_0.nvout_1 a_35466_63369# 0.04762f
C939 a_38428_67160# a_38698_63369# 0
C940 a_41930_63369# vw11 0.00597f
C941 layer_input_0.nvout_2 avdd 10.1285f
C942 current_mirror_0.A a_35586_44752# 0.49749f
C943 stdp_4x2_0.Current_limit_0.i_SUM a_57586_52169# 0.06324f
C944 a_38428_44960# layer_input_0.nvout_3 0.10678f
C945 layer_input_0.vout_4 a_55466_30169# 0.00193f
C946 stdp_4x2_0.stdp_0.vw a_35712_33960# 0.82141f
C947 a_58302_44752# a_58302_42541# 0.00104f
C948 layer_output_0.nvout_1 layer_input_0.nvout_1 0.04074f
C949 a_36944_31541# vpost1 0.24435f
C950 layer_output_0.Iext1 a_33386_9329# 1.52732f
C951 a_38302_31541# avdd 2.97746f
C952 current_mirror_0.A a_55466_63369# 0.62794f
C953 layer_output_0.nvout_2 a_56944_31541# 0.04726f
C954 a_38302_64741# a_37586_63369# 0.01443f
C955 layer_input_0.vout_4 vw42 0.1189f
C956 a_58302_66952# a_58302_64741# 0
C957 a_38428_55960# avdd 1.61889f
C958 layer_input_0.nvout_1 a_57586_63369# 0.20537f
C959 a_38428_67160# a_35466_63369# 0
C960 a_57586_41169# vpost2 0.06826f
C961 current_mirror_0.A stdp_4x2_0.stdp_6.vw 0.07921f
C962 current_mirror_0.A avdd 8.47356f
C963 a_38302_64741# vpost1 0.07653f
C964 stdp_4x2_0.Current_limit_0.i_SUM a_56944_53541# 0.13501f
C965 layer_input_0.vout_4 a_41930_30169# 0.01957f
C966 a_38302_44752# layer_input_0.nvout_3 0.15252f
C967 stdp_4x2_0.stdp_0.vw a_35586_33752# 1.34913f
C968 a_49420_23589# layer_output_0.Iext1 0.89639f
C969 a_58302_44752# a_58428_44960# 0.16397f
C970 stdp_4x2_0.stdp_3.vw layer_input_0.vout_3 0.08154f
C971 a_38428_44960# a_37586_41169# 0.02739f
C972 layer_input_0.nvout_3 a_36944_42541# 0.51189f
C973 stdp_4x2_0.Current_limit_1.i_SUM layer_input_0.vout_3 0.05083f
C974 current_mirror_0.B a_55586_44752# 0.2601f
C975 layer_output_0.nvout_1 a_38428_67160# 0.08213f
C976 a_38428_33960# avdd 1.61243f
C977 current_mirror_0.A a_41930_63369# 0.79735f
C978 layer_output_0.nvout_2 a_55466_31749# 0.01305f
C979 layer_input_0.nvout_1 a_56944_64741# 0.10563f
C980 a_58302_66952# a_58428_67160# 0.16237f
C981 a_38302_55752# avdd 1.83863f
C982 current_mirror_0.A a_61930_52169# 0.7238f
C983 a_56944_42541# vpost2 0.15249f
C984 a_36944_64741# avdd 0.4642f
C985 a_35712_44960# layer_input_0.nvout_3 0.09564f
C986 stdp_4x2_0.Current_limit_0.i_SUM a_55466_53749# 0.02686f
C987 a_38302_44752# a_38428_44960# 0.16397f
C988 layer_input_0.vout_4 a_38698_30169# 0.02601f
C989 layer_input_0.nvout_4 vpost1 0.07694f
C990 stdp_4x2_0.Current_limit_0.i_SUM layer_output_0.nvout_2 5.81062f
C991 a_38302_42541# layer_input_0.vout_3 0.04244f
C992 a_55586_44752# a_58302_42541# 0.07645f
C993 current_mirror_0.B stdp_4x2_0.stdp_3.vw 0.0297f
C994 a_55712_44960# a_58428_44960# 0.03272f
C995 a_38428_44960# a_36944_42541# 0.17308f
C996 layer_output_0.nvout_1 a_38302_66952# 0.00639f
C997 layer_output_0.nvout_1 vw11 0.06199f
C998 a_55466_52169# vpre2 0.00193f
C999 a_35712_67160# a_38428_67160# 0.02014f
C1000 stdp_4x2_0.Current_limit_1.i_SUM current_mirror_0.B 0.04963f
C1001 a_35586_66952# layer_input_0.nvout_1 0.09565f
C1002 a_58302_64741# vpost2 0.07653f
C1003 a_38302_33752# avdd 1.83974f
C1004 a_36944_42541# a_37586_41169# 1.08964f
C1005 layer_output_0.nvout_1 vpre2 0.05695f
C1006 layer_input_0.nvout_3 vpost2 0.06918f
C1007 current_mirror_0.A a_38698_63369# 0.66433f
C1008 a_36944_64741# a_41930_63369# 0
C1009 a_35712_55960# avdd 2.01807f
C1010 layer_input_0.nvout_1 a_55466_64949# 0.01508f
C1011 current_mirror_0.A a_58698_52169# 0.719f
C1012 a_35466_64949# avdd 0.00114f
C1013 a_35586_44752# layer_input_0.nvout_3 0.22857f
C1014 a_35712_44960# a_38428_44960# 0.0166f
C1015 layer_input_0.vout_4 a_35466_30169# 0.02602f
C1016 layer_output_0.nvout_1 layer_input_0.nvout_2 0.1268f
C1017 stdp_4x2_0.Current_limit_0.i_SUM a_55712_67160# 0.03726f
C1018 stdp_4x2_0.stdp_5.vw layer_output_0.nvout_2 0.06186f
C1019 a_55586_44752# a_58428_44960# 0.00852f
C1020 stdp_4x2_0.stdp_3.vw a_58302_42541# 0
C1021 current_mirror_0.B a_38302_42541# 0.9966f
C1022 a_38302_44752# a_36944_42541# 0
C1023 a_56944_42541# avdd 0.4642f
C1024 a_35712_67160# vw11 0.82227f
C1025 a_35586_66952# a_38428_67160# 0.00852f
C1026 a_41930_52169# vpre2 0.02137f
C1027 layer_output_0.Iext2 vpost2 1.13734f
C1028 a_58428_67160# vpost2 0
C1029 a_35712_33960# avdd 2.01325f
C1030 current_mirror_0.B vw42 0.09655f
C1031 a_35466_42749# a_37586_41169# 0.00297f
C1032 layer_input_0.Iext3 layer_input_0.nvout_3 0.96486f
C1033 current_mirror_0.A a_35466_63369# 0.62773f
C1034 a_58302_64741# a_55466_63369# 0
C1035 a_58428_67160# a_58698_63369# 0
C1036 current_mirror_0.B a_41930_30169# 0.00473f
C1037 stdp_4x2_0.Current_limit_1.i_SUM layer_output_0.Iext1 0.00963f
C1038 layer_input_0.nvout_1 a_37586_63369# 0.37854f
C1039 a_35586_55752# avdd 6.78369f
C1040 layer_output_0.nvout_1 a_38302_31541# 0.09745f
C1041 current_mirror_0.A a_55466_52169# 0.6433f
C1042 layer_input_0.nvout_1 vpost1 0.21928f
C1043 a_58302_64741# avdd 2.97858f
C1044 layer_input_0.Iext4 vpre1 0.03428f
C1045 layer_input_0.nvout_3 avdd 9.63973f
C1046 layer_input_0.vout_4 a_57586_30169# 0.00161f
C1047 layer_input_0.Iext2 vpre1 0.11474f
C1048 stdp_4x2_0.stdp_6.vw layer_input_0.nvout_3 0.54309f
C1049 a_35586_44752# a_38428_44960# 0.00852f
C1050 layer_output_0.nvout_1 a_38428_55960# 0.16413f
C1051 layer_output_0.nvout_1 current_mirror_0.A 0.22806f
C1052 stdp_4x2_0.stdp_5.vw a_55712_67160# 0.82227f
C1053 stdp_4x2_0.Current_limit_0.i_SUM a_55586_66952# 0.04074f
C1054 a_55466_42749# avdd 0.00114f
C1055 a_35712_44960# a_36944_42541# 0
C1056 a_55586_44752# a_58302_44752# 0.37123f
C1057 a_38698_52169# vpre2 0.02713f
C1058 stdp_4x2_0.stdp_3.vw a_58428_44960# 0.022f
C1059 a_35586_66952# a_38302_66952# 0.37123f
C1060 a_35586_66952# vw11 1.34914f
C1061 a_35466_42749# a_36944_42541# 0.13501f
C1062 layer_output_0.nvout_1 a_35466_41169# 0.0273f
C1063 a_35586_33752# avdd 6.78417f
C1064 current_mirror_0.A a_57586_63369# 0.78433f
C1065 a_58428_67160# a_55466_63369# 0
C1066 a_36944_64741# a_35466_63369# 0
C1067 layer_output_0.Iext2 avdd 6.88199f
C1068 current_mirror_0.B a_38698_30169# 0.15634f
C1069 layer_output_0.nvout_1 a_38428_33960# 0.14158f
C1070 a_38428_67160# a_37586_63369# 0.02759f
C1071 stdp_4x2_0.stdp_2.vw avdd 11.7887f
C1072 current_mirror_0.A a_41930_52169# 0.81283f
C1073 a_38428_67160# vpost1 0
C1074 a_58428_67160# avdd 1.61851f
C1075 layer_input_0.vout_4 a_56944_31541# 0.0337f
C1076 stdp_4x2_0.Current_limit_1.i_SUM vpre1 0.04519f
C1077 a_38428_44960# avdd 1.6138f
C1078 a_35586_44752# a_38302_44752# 0.37123f
C1079 stdp_4x2_0.stdp_6.vw a_38428_44960# 0.01267f
C1080 stdp_4x2_0.Current_limit_1.i_SUM a_38302_53541# 0.00313f
C1081 layer_output_0.nvout_1 a_38302_55752# 0.01208f
C1082 stdp_4x2_0.stdp_5.vw a_55586_66952# 1.34914f
C1083 layer_output_0.nvout_1 a_36944_64741# 0.05461f
C1084 a_35712_44960# a_35466_42749# 0.014f
C1085 a_35586_44752# a_36944_42541# 0.00193f
C1086 stdp_4x2_0.stdp_3.vw a_58302_44752# 0
C1087 a_55586_44752# a_55712_44960# 0.30951f
C1088 a_8786_49529# vpre2 0.23235f
C1089 layer_output_0.nvout_2 layer_input_0.nvout_4 0.11414f
C1090 layer_input_0.Iext1 a_8786_57529# 1.52732f
C1091 stdp_4x2_0.stdp_0.vw avdd 11.7893f
C1092 a_58698_63369# a_61930_63369# 1.05124f
C1093 current_mirror_0.A a_56944_64741# 0.25828f
C1094 a_35466_64949# a_35466_63369# 0
C1095 layer_output_0.nvout_2 a_58302_31541# 0.01839f
C1096 stdp_4x2_0.Current_limit_1.i_SUM a_49420_23589# 1.26805f
C1097 current_mirror_0.B a_35466_30169# 0.19438f
C1098 layer_input_0.nvout_2 a_8786_49529# 1.49604f
C1099 a_8786_57529# avdd 1.33172f
C1100 a_38428_55960# a_38698_52169# 0
C1101 layer_output_0.nvout_1 a_38302_33752# 0.00639f
C1102 current_mirror_0.A a_38698_52169# 0.67907f
C1103 a_58302_66952# avdd 1.83917f
C1104 layer_input_0.vout_4 a_55466_31749# 0.10774f
C1105 a_35586_44752# a_35712_44960# 0.30951f
C1106 stdp_4x2_0.Current_limit_0.i_SUM a_58302_53541# 0.00271f
C1107 stdp_4x2_0.stdp_6.vw a_38302_44752# 0
C1108 a_38302_44752# avdd 1.83974f
C1109 layer_output_0.nvout_1 a_35712_55960# 0.14268f
C1110 a_58698_30169# a_61930_30169# 1.05124f
C1111 layer_output_0.nvout_1 a_35466_64949# 0.0069f
C1112 a_35712_67160# a_36944_64741# 0
C1113 vpost1 vpre2 0.12464f
C1114 stdp_4x2_0.stdp_6.vw a_36944_42541# 0.92323f
C1115 a_36944_42541# avdd 0.46404f
C1116 stdp_4x2_0.stdp_3.vw a_55712_44960# 0.82227f
C1117 a_35466_52169# vpre2 0.02737f
C1118 a_58698_63369# vpost2 0.03404f
C1119 layer_input_0.Iext2 layer_input_0.Iext4 0.1423f
C1120 a_55466_63369# a_61930_63369# 0.0045f
C1121 vw42 avss 33.19121f
C1122 vpre2 avss 35.2361f
C1123 vpost2 avss 47.59291f
C1124 vpost1 avss 45.03709f
C1125 vpre1 avss 43.7623f
C1126 vw11 avss 33.4391f
C1127 Vin_neg avss 22.58203f
C1128 Vin avss 36.40325f
C1129 avdd avss 1.88488p
C1130 a_45786_9329# avss 26.3057f
C1131 a_33386_9329# avss 25.5252f
C1132 layer_output_0.Iext2 avss 31.7076f
C1133 layer_output_0.Iext1 avss 28.0826f
C1134 a_69620_23589# avss 0.89901f
C1135 a_49420_23589# avss 0.89862f
C1136 a_61930_30169# avss 3.31934f
C1137 a_58698_30169# avss 2.26037f
C1138 a_55466_30169# avss 2.28289f
C1139 a_41930_30169# avss 3.31934f
C1140 a_38698_30169# avss 2.26011f
C1141 a_35466_30169# avss 2.26762f
C1142 a_57586_30169# avss 6.47157f
C1143 a_56944_31541# avss 11.2109f
C1144 a_55466_31749# avss 1.86179f
C1145 a_37586_30169# avss 6.41379f
C1146 a_36944_31541# avss 11.0492f
C1147 a_35466_31749# avss 1.85343f
C1148 a_58302_31541# avss 4.80127f
C1149 a_58428_33960# avss 2.3953f
C1150 a_58302_33752# avss 0.15072f
C1151 a_55712_33960# avss 0.513f
C1152 a_55586_33752# avss 4.54453f
C1153 a_38302_31541# avss 4.80595f
C1154 a_38428_33960# avss 2.41949f
C1155 a_38302_33752# avss 0.15072f
C1156 a_35712_33960# avss 0.51397f
C1157 a_35586_33752# avss 4.21158f
C1158 stdp_4x2_0.stdp_0.vw avss 23.767f
C1159 layer_input_0.vout_4 avss 20.9431f
C1160 a_8786_33529# avss 25.5789f
C1161 layer_input_0.nvout_4 avss 25.608f
C1162 a_61930_41169# avss 3.31934f
C1163 a_58698_41169# avss 2.2584f
C1164 a_55466_41169# avss 2.2862f
C1165 a_41930_41169# avss 3.31132f
C1166 a_38698_41169# avss 2.25859f
C1167 a_35466_41169# avss 2.27991f
C1168 a_57586_41169# avss 6.47157f
C1169 a_56944_42541# avss 11.2242f
C1170 a_55466_42749# avss 1.86179f
C1171 a_37586_41169# avss 6.40305f
C1172 a_36944_42541# avss 11.0728f
C1173 a_35466_42749# avss 1.85358f
C1174 layer_input_0.vout_3 avss 20.9555f
C1175 a_8786_41529# avss 25.5789f
C1176 a_58302_42541# avss 4.76196f
C1177 a_58428_44960# avss 2.38956f
C1178 a_58302_44752# avss 0.15072f
C1179 a_55712_44960# avss 0.51891f
C1180 a_55586_44752# avss 4.53561f
C1181 stdp_4x2_0.stdp_3.vw avss 23.8743f
C1182 a_38302_42541# avss 4.76846f
C1183 layer_input_0.nvout_3 avss 26.0122f
C1184 a_38428_44960# avss 2.3873f
C1185 a_38302_44752# avss 0.15072f
C1186 a_35712_44960# avss 0.51114f
C1187 a_35586_44752# avss 4.21517f
C1188 stdp_4x2_0.stdp_6.vw avss 23.7626f
C1189 a_61930_52169# avss 3.31934f
C1190 a_58698_52169# avss 2.25965f
C1191 a_55466_52169# avss 2.2862f
C1192 a_41930_52169# avss 3.31862f
C1193 a_38698_52169# avss 2.26005f
C1194 a_8786_49529# avss 25.5798f
C1195 a_35466_52169# avss 2.2862f
C1196 a_57586_52169# avss 6.47136f
C1197 a_56944_53541# avss 11.2228f
C1198 a_55466_53749# avss 1.86179f
C1199 a_37586_52169# avss 6.46366f
C1200 a_36944_53541# avss 11.0915f
C1201 a_35466_53749# avss 1.86179f
C1202 a_58302_53541# avss 4.74448f
C1203 a_58428_55960# avss 2.39362f
C1204 a_58302_55752# avss 0.15072f
C1205 a_55712_55960# avss 0.51333f
C1206 a_55586_55752# avss 4.52198f
C1207 stdp_4x2_0.stdp_4.vw avss 23.8921f
C1208 a_38302_53541# avss 4.81027f
C1209 layer_input_0.nvout_2 avss 25.9454f
C1210 a_38428_55960# avss 2.43053f
C1211 a_38302_55752# avss 0.15072f
C1212 a_35712_55960# avss 0.51891f
C1213 a_35586_55752# avss 4.2117f
C1214 stdp_4x2_0.stdp_2.vw avss 23.7826f
C1215 a_8786_57529# avss 25.5798f
C1216 a_61930_63369# avss 3.31931f
C1217 a_58698_63369# avss 2.25965f
C1218 a_55466_63369# avss 2.2797f
C1219 a_41930_63369# avss 3.3091f
C1220 a_38698_63369# avss 2.25638f
C1221 a_35466_63369# avss 2.2797f
C1222 a_57586_63369# avss 6.4566f
C1223 a_56944_64741# avss 11.1992f
C1224 a_55466_64949# avss 1.85373f
C1225 a_37586_63369# avss 6.33451f
C1226 current_mirror_0.A avss 0.26675p
C1227 a_36944_64741# avss 11.0321f
C1228 a_35466_64949# avss 1.853f
C1229 a_58302_64741# avss 4.77308f
C1230 a_58428_67160# avss 2.39302f
C1231 a_58302_66952# avss 0.13862f
C1232 layer_output_0.nvout_2 avss 39.187f
C1233 a_55712_67160# avss 0.51891f
C1234 a_55586_66952# avss 4.55267f
C1235 stdp_4x2_0.Current_limit_0.i_SUM avss 13.2583f
C1236 stdp_4x2_0.stdp_5.vw avss 23.8945f
C1237 a_38302_64741# avss 4.78204f
C1238 current_mirror_0.B avss 37.8924f
C1239 layer_input_0.nvout_1 avss 24.9895f
C1240 a_38428_67160# avss 2.412f
C1241 a_38302_66952# avss 0.15072f
C1242 layer_output_0.nvout_1 avss 31.2103f
C1243 a_35712_67160# avss 0.50759f
C1244 a_35586_66952# avss 4.55267f
C1245 stdp_4x2_0.Current_limit_1.i_SUM avss 12.727f
C1246 a_4666_70229# avss 4.59268f
C1247 layer_input_0.Iext3 avss 26.3276f
C1248 layer_input_0.Iext4 avss 28.4348f
C1249 a_10290_71650# avss 2.98181f
C1250 a_7926_70021# avss 3.61871f
C1251 layer_input_0.Iext1 avss 25.3456f
C1252 layer_input_0.Iext2 avss 25.3781f
C1253 a_4794_71649# avss 2.92339f
C1254 avdd.n0 avss 0.3462f
C1255 avdd.n1 avss 1.52441f
C1256 avdd.n2 avss 1.18206f
C1257 avdd.n3 avss 1.18537f
C1258 avdd.n4 avss 1.56408f
C1259 avdd.n5 avss 3.12059f
C1260 avdd.n6 avss 0.98566f
C1261 avdd.n7 avss 1.38352f
C1262 avdd.t77 avss 0.01745f
C1263 avdd.n8 avss 0.05187f
C1264 avdd.n9 avss 0.04806f
C1265 avdd.n10 avss 0.01697f
C1266 avdd.n11 avss 0.15874f
C1267 avdd.n12 avss 0.0169f
C1268 avdd.n13 avss 0.15874f
C1269 avdd.n14 avss 0.00672f
C1270 avdd.n15 avss 0.02135f
C1271 avdd.n16 avss 0.02731f
C1272 avdd.n17 avss 0.02135f
C1273 avdd.n18 avss 0.00672f
C1274 avdd.n19 avss 0.0169f
C1275 avdd.n21 avss 0.10238f
C1276 avdd.t76 avss 0.04631f
C1277 avdd.n22 avss 0.10238f
C1278 avdd.n23 avss 0.01236f
C1279 avdd.n24 avss 0.0125f
C1280 avdd.n25 avss 0.29217f
C1281 avdd.t85 avss 0.01745f
C1282 avdd.n26 avss 0.05187f
C1283 avdd.n27 avss 0.04806f
C1284 avdd.n28 avss 0.01697f
C1285 avdd.n29 avss 0.15874f
C1286 avdd.n30 avss 0.0169f
C1287 avdd.n31 avss 0.15874f
C1288 avdd.n32 avss 0.00672f
C1289 avdd.n33 avss 0.02135f
C1290 avdd.n34 avss 0.02731f
C1291 avdd.n35 avss 0.02135f
C1292 avdd.n36 avss 0.00672f
C1293 avdd.n37 avss 0.0169f
C1294 avdd.n39 avss 0.10238f
C1295 avdd.t84 avss 0.04631f
C1296 avdd.n40 avss 0.10238f
C1297 avdd.n41 avss 0.01236f
C1298 avdd.n42 avss 0.0125f
C1299 avdd.n43 avss 0.16154f
C1300 avdd.n44 avss 0.20388f
C1301 avdd.t83 avss 0.01745f
C1302 avdd.n45 avss 0.05187f
C1303 avdd.n46 avss 0.04806f
C1304 avdd.n47 avss 0.01697f
C1305 avdd.n48 avss 0.15874f
C1306 avdd.n49 avss 0.0169f
C1307 avdd.n50 avss 0.15874f
C1308 avdd.n51 avss 0.00672f
C1309 avdd.n52 avss 0.02135f
C1310 avdd.n53 avss 0.02731f
C1311 avdd.n54 avss 0.02135f
C1312 avdd.n55 avss 0.00672f
C1313 avdd.n56 avss 0.0169f
C1314 avdd.n58 avss 0.10238f
C1315 avdd.t82 avss 0.04631f
C1316 avdd.n59 avss 0.10238f
C1317 avdd.n60 avss 0.01236f
C1318 avdd.n61 avss 0.0125f
C1319 avdd.n62 avss 0.16154f
C1320 avdd.n63 avss 0.27553f
C1321 avdd.n64 avss 0.84995f
C1322 avdd.t137 avss 0.01745f
C1323 avdd.n65 avss 0.05187f
C1324 avdd.n66 avss 0.04806f
C1325 avdd.n67 avss 0.01697f
C1326 avdd.n68 avss 0.15874f
C1327 avdd.n69 avss 0.0169f
C1328 avdd.n70 avss 0.15874f
C1329 avdd.n71 avss 0.00672f
C1330 avdd.n72 avss 0.02135f
C1331 avdd.n73 avss 0.02731f
C1332 avdd.n74 avss 0.02135f
C1333 avdd.n75 avss 0.00672f
C1334 avdd.n76 avss 0.0169f
C1335 avdd.n78 avss 0.10238f
C1336 avdd.t136 avss 0.04631f
C1337 avdd.n79 avss 0.10238f
C1338 avdd.n80 avss 0.01236f
C1339 avdd.n81 avss 0.0125f
C1340 avdd.n82 avss 0.29217f
C1341 avdd.t16 avss 0.01745f
C1342 avdd.n83 avss 0.05187f
C1343 avdd.n84 avss 0.04806f
C1344 avdd.n85 avss 0.01697f
C1345 avdd.n86 avss 0.15874f
C1346 avdd.n87 avss 0.0169f
C1347 avdd.n88 avss 0.15874f
C1348 avdd.n89 avss 0.00672f
C1349 avdd.n90 avss 0.02135f
C1350 avdd.n91 avss 0.02731f
C1351 avdd.n92 avss 0.02135f
C1352 avdd.n93 avss 0.00672f
C1353 avdd.n94 avss 0.0169f
C1354 avdd.n96 avss 0.10238f
C1355 avdd.t15 avss 0.04631f
C1356 avdd.n97 avss 0.10238f
C1357 avdd.n98 avss 0.01236f
C1358 avdd.n99 avss 0.0125f
C1359 avdd.n100 avss 0.16154f
C1360 avdd.n101 avss 0.20388f
C1361 avdd.t18 avss 0.01745f
C1362 avdd.n102 avss 0.05187f
C1363 avdd.n103 avss 0.04806f
C1364 avdd.n104 avss 0.01697f
C1365 avdd.n105 avss 0.15874f
C1366 avdd.n106 avss 0.0169f
C1367 avdd.n107 avss 0.15874f
C1368 avdd.n108 avss 0.00672f
C1369 avdd.n109 avss 0.02135f
C1370 avdd.n110 avss 0.02731f
C1371 avdd.n111 avss 0.02135f
C1372 avdd.n112 avss 0.00672f
C1373 avdd.n113 avss 0.0169f
C1374 avdd.n115 avss 0.10238f
C1375 avdd.t17 avss 0.04631f
C1376 avdd.n116 avss 0.10238f
C1377 avdd.n117 avss 0.01236f
C1378 avdd.n118 avss 0.0125f
C1379 avdd.n119 avss 0.16154f
C1380 avdd.n120 avss 0.27553f
C1381 avdd.n121 avss 0.65884f
C1382 avdd.n122 avss 1.38352f
C1383 avdd.n123 avss 0.85105f
C1384 avdd.n124 avss 1.44871f
C1385 avdd.n125 avss 1.67703f
C1386 avdd.n126 avss 0.88898f
C1387 avdd.n127 avss 0.28335f
C1388 avdd.n128 avss 0.73513f
C1389 avdd.n129 avss 0.58466f
C1390 avdd.n130 avss 0.33702f
C1391 avdd.n131 avss 0.82703f
C1392 avdd.n132 avss 0.04253f
C1393 avdd.n133 avss 0.02042f
C1394 avdd.n134 avss 0.00672f
C1395 avdd.n135 avss 0.01886f
C1396 avdd.n136 avss 0.18521f
C1397 avdd.t90 avss 0.05533f
C1398 avdd.n137 avss 0.01886f
C1399 avdd.n138 avss 0.00672f
C1400 avdd.t91 avss 0.02734f
C1401 avdd.n139 avss 0.04451f
C1402 avdd.n140 avss 0.1195f
C1403 avdd.n142 avss 0.18521f
C1404 avdd.n143 avss 0.03451f
C1405 avdd.n144 avss 0.0215f
C1406 avdd.n145 avss 0.0215f
C1407 avdd.n146 avss 0.00672f
C1408 avdd.n147 avss 0.01886f
C1409 avdd.n148 avss 0.1195f
C1410 avdd.n150 avss 0.01886f
C1411 avdd.n151 avss 0.00672f
C1412 avdd.n152 avss 0.0197f
C1413 avdd.n153 avss 0.07684f
C1414 avdd.n154 avss 0.08351f
C1415 avdd.n155 avss 0.02042f
C1416 avdd.n156 avss 0.00672f
C1417 avdd.n157 avss 0.03096f
C1418 avdd.n158 avss 0.35657f
C1419 avdd.t118 avss 0.10826f
C1420 avdd.n159 avss 0.03096f
C1421 avdd.n160 avss 0.00672f
C1422 avdd.t119 avss 0.26206f
C1423 avdd.n161 avss 0.06985f
C1424 avdd.n162 avss 0.23358f
C1425 avdd.n164 avss 0.35657f
C1426 avdd.n165 avss 0.07547f
C1427 avdd.n166 avss 0.02617f
C1428 avdd.n167 avss 0.02617f
C1429 avdd.n168 avss 0.00672f
C1430 avdd.n169 avss 0.03096f
C1431 avdd.n170 avss 0.23358f
C1432 avdd.n172 avss 0.03096f
C1433 avdd.n173 avss 0.00672f
C1434 avdd.n174 avss 0.0197f
C1435 avdd.n175 avss 0.05894f
C1436 avdd.n176 avss 0.08152f
C1437 avdd.n177 avss 0.67553f
C1438 avdd.n178 avss 0.4815f
C1439 avdd.n179 avss 0.40397f
C1440 avdd.n180 avss 0.12135f
C1441 avdd.n181 avss 0.16767f
C1442 avdd.n182 avss 0.37751f
C1443 avdd.n183 avss 0.08105f
C1444 avdd.n184 avss 0.11308f
C1445 avdd.n185 avss 0.98197f
C1446 avdd.n186 avss 0.69661f
C1447 avdd.n187 avss 0.72043f
C1448 avdd.n188 avss 0.91098f
C1449 avdd.n189 avss 0.90205f
C1450 avdd.n190 avss 0.90779f
C1451 avdd.n191 avss 0.88397f
C1452 avdd.n192 avss 0.69661f
C1453 avdd.n193 avss 0.69661f
C1454 avdd.n194 avss 0.72043f
C1455 avdd.n195 avss 0.72043f
C1456 avdd.n196 avss 0.08105f
C1457 avdd.n197 avss 0.68569f
C1458 avdd.n198 avss 0.66187f
C1459 avdd.n199 avss 0.76799f
C1460 avdd.n200 avss 0.35766f
C1461 avdd.n201 avss 0.08105f
C1462 avdd.n202 avss 0.83597f
C1463 avdd.n203 avss 1.44871f
C1464 avdd.n204 avss 1.39832f
C1465 avdd.n205 avss 0.40397f
C1466 avdd.n206 avss 0.4815f
C1467 avdd.n207 avss 0.27929f
C1468 avdd.n208 avss 0.58151f
C1469 avdd.n209 avss 0.42644f
C1470 avdd.n210 avss 1.14055f
C1471 avdd.n211 avss 1.34602f
C1472 avdd.n212 avss 0.32551f
C1473 avdd.n213 avss 0.49505f
C1474 avdd.n214 avss 0.16767f
C1475 avdd.n215 avss 0.32884f
C1476 avdd.n216 avss 0.48652f
C1477 avdd.n217 avss 0.1412f
C1478 avdd.n218 avss 1.7914f
C1479 avdd.n219 avss 1.63713f
C1480 avdd.n220 avss 0.38342f
C1481 avdd.n221 avss 0.32551f
C1482 avdd.n222 avss 0.16767f
C1483 avdd.n223 avss 0.33711f
C1484 avdd.n224 avss 0.08105f
C1485 avdd.n225 avss 0.24523f
C1486 avdd.n226 avss 1.49475f
C1487 avdd.n227 avss 0.26176f
C1488 avdd.n229 avss 0.02564f
C1489 avdd.n230 avss 0.47472f
C1490 avdd.n231 avss 0.17216f
C1491 avdd.n233 avss 0.02564f
C1492 avdd.n234 avss 0.47472f
C1493 avdd.n235 avss 0.17216f
C1494 avdd.n237 avss 0.02564f
C1495 avdd.n238 avss 0.55577f
C1496 avdd.n239 avss 0.17216f
C1497 avdd.n242 avss 0.02564f
C1498 avdd.n243 avss 0.17275f
C1499 avdd.n244 avss 0.33867f
C1500 avdd.n245 avss 0
C1501 avdd.n247 avss 0.17326f
C1502 avdd.n248 avss 0.33867f
C1503 avdd.n249 avss 0.02564f
C1504 avdd.n250 avss 0.02564f
C1505 avdd.n252 avss 0.17326f
C1506 avdd.n253 avss 0.02564f
C1507 avdd.n255 avss 0.33867f
C1508 avdd.n257 avss 0.17326f
C1509 avdd.n258 avss 0.02564f
C1510 avdd.n260 avss 0.33867f
C1511 avdd.n262 avss 0.02853f
C1512 avdd.n263 avss 0.02564f
C1513 avdd.n265 avss 0.02564f
C1514 avdd.n268 avss 2.07544f
C1515 avdd.n269 avss 0.02564f
C1516 avdd.n271 avss 2.07544f
C1517 avdd.n272 avss 0.02564f
C1518 avdd.n274 avss 0.02564f
C1519 avdd.n276 avss 2.07544f
C1520 avdd.n278 avss 0.02564f
C1521 avdd.n280 avss 0.09273f
C1522 avdd.n281 avss 0.02564f
C1523 avdd.n284 avss 0.0827f
C1524 avdd.n286 avss 0.11579f
C1525 avdd.n287 avss 0.11579f
C1526 avdd.n288 avss 0.0827f
C1527 avdd.n290 avss 0.11579f
C1528 avdd.n293 avss 0.0827f
C1529 avdd.n295 avss 0.11579f
C1530 avdd.n296 avss 0.11579f
C1531 avdd.n297 avss 0.0827f
C1532 avdd.n299 avss 0.11579f
C1533 avdd.n302 avss 0.13439f
C1534 avdd.t156 avss 0.0827f
C1535 avdd.n305 avss 0.33288f
C1536 avdd.n306 avss 0.13439f
C1537 avdd.n307 avss 0.36183f
C1538 avdd.n309 avss 0.13439f
C1539 avdd.t157 avss 0.0827f
C1540 avdd.n312 avss 0.36183f
C1541 avdd.n313 avss 0.13439f
C1542 avdd.n314 avss 0.2497f
C1543 avdd.n315 avss 0.0221f
C1544 avdd.n316 avss 0.00827f
C1545 avdd.n317 avss 0.00827f
C1546 avdd.n318 avss 0.00595f
C1547 avdd.n319 avss 0.1594f
C1548 avdd.n320 avss 0.09263f
C1549 avdd.n321 avss 0.00595f
C1550 avdd.n322 avss 0.00827f
C1551 avdd.n323 avss 0.00827f
C1552 avdd.n324 avss 0.00827f
C1553 avdd.n325 avss 0.00595f
C1554 avdd.n326 avss 0.09263f
C1555 avdd.n327 avss 0.00595f
C1556 avdd.n328 avss 0.00827f
C1557 avdd.n329 avss 0.00827f
C1558 avdd.n330 avss 0.00827f
C1559 avdd.n331 avss 0.00595f
C1560 avdd.n332 avss 0.09263f
C1561 avdd.n333 avss 0.00595f
C1562 avdd.n334 avss 0.00827f
C1563 avdd.n335 avss 0.00827f
C1564 avdd.n336 avss 0.00827f
C1565 avdd.n337 avss 0.00595f
C1566 avdd.n338 avss 0.09263f
C1567 avdd.n339 avss 0.00595f
C1568 avdd.n340 avss 0.00827f
C1569 avdd.n341 avss 0.00827f
C1570 avdd.n342 avss 0.00827f
C1571 avdd.n343 avss 0.00595f
C1572 avdd.n344 avss 0.06947f
C1573 avdd.n345 avss 0.00595f
C1574 avdd.n346 avss 0.00827f
C1575 avdd.n347 avss 0.00827f
C1576 avdd.n348 avss 0.00827f
C1577 avdd.n349 avss 0.00595f
C1578 avdd.n350 avss 0.09263f
C1579 avdd.t39 avss 0.04631f
C1580 avdd.n351 avss 0.00595f
C1581 avdd.n352 avss 0.00827f
C1582 avdd.n353 avss 0.00827f
C1583 avdd.n354 avss 0.00827f
C1584 avdd.n355 avss 0.00595f
C1585 avdd.n356 avss 0.09263f
C1586 avdd.n357 avss 0.00595f
C1587 avdd.n358 avss 0.00827f
C1588 avdd.n359 avss 0.00827f
C1589 avdd.n360 avss 0.00827f
C1590 avdd.n361 avss 0.00595f
C1591 avdd.n362 avss 0.09263f
C1592 avdd.n363 avss 0.00595f
C1593 avdd.n364 avss 0.00827f
C1594 avdd.n365 avss 0.00827f
C1595 avdd.n366 avss 0.00827f
C1596 avdd.n367 avss 0.00595f
C1597 avdd.n368 avss 0.09263f
C1598 avdd.n369 avss 0.00595f
C1599 avdd.n370 avss 0.00827f
C1600 avdd.n371 avss 0.02145f
C1601 avdd.n372 avss 0.00672f
C1602 avdd.n373 avss 0.01693f
C1603 avdd.n374 avss 0.12611f
C1604 avdd.n375 avss 0.01693f
C1605 avdd.n376 avss 0.00672f
C1606 avdd.n378 avss 0.1594f
C1607 avdd.n379 avss 0.02732f
C1608 avdd.t40 avss 0.06136f
C1609 avdd.n380 avss 0.15554f
C1610 avdd.n381 avss 0.02091f
C1611 avdd.n382 avss 0.00827f
C1612 avdd.n383 avss 0.00827f
C1613 avdd.n384 avss 0.00595f
C1614 avdd.n385 avss 0.09263f
C1615 avdd.n386 avss 0.00595f
C1616 avdd.n387 avss 0.00827f
C1617 avdd.n388 avss 0.00827f
C1618 avdd.n389 avss 0.00827f
C1619 avdd.n390 avss 0.00827f
C1620 avdd.n391 avss 0.00827f
C1621 avdd.n392 avss 0.00595f
C1622 avdd.n393 avss 0.09263f
C1623 avdd.n394 avss 0.00595f
C1624 avdd.n395 avss 0.00827f
C1625 avdd.n396 avss 0.00827f
C1626 avdd.n397 avss 0.00827f
C1627 avdd.n398 avss 0.00827f
C1628 avdd.n399 avss 0.00827f
C1629 avdd.n400 avss 0.00595f
C1630 avdd.n401 avss 0.09263f
C1631 avdd.n402 avss 0.00595f
C1632 avdd.n403 avss 0.00827f
C1633 avdd.n404 avss 0.00827f
C1634 avdd.n405 avss 0.00827f
C1635 avdd.n406 avss 0.00827f
C1636 avdd.n407 avss 0.00827f
C1637 avdd.n408 avss 0.00595f
C1638 avdd.n409 avss 0.09263f
C1639 avdd.n410 avss 0.00595f
C1640 avdd.n411 avss 0.00827f
C1641 avdd.n412 avss 0.00827f
C1642 avdd.n413 avss 0.00827f
C1643 avdd.n414 avss 0.00827f
C1644 avdd.n415 avss 0.00827f
C1645 avdd.n416 avss 0.00595f
C1646 avdd.n417 avss 0.06947f
C1647 avdd.n418 avss 0.00595f
C1648 avdd.n419 avss 0.00827f
C1649 avdd.n420 avss 0.00827f
C1650 avdd.n421 avss 0.00827f
C1651 avdd.n422 avss 0.00827f
C1652 avdd.n423 avss 0.00827f
C1653 avdd.n424 avss 0.00595f
C1654 avdd.n425 avss 0.09263f
C1655 avdd.n426 avss 0.00595f
C1656 avdd.n427 avss 0.00827f
C1657 avdd.n428 avss 0.00827f
C1658 avdd.n429 avss 0.00827f
C1659 avdd.n430 avss 0.00827f
C1660 avdd.n431 avss 0.00827f
C1661 avdd.n432 avss 0.00595f
C1662 avdd.n433 avss 0.09263f
C1663 avdd.n434 avss 0.00595f
C1664 avdd.n435 avss 0.00827f
C1665 avdd.n436 avss 0.00827f
C1666 avdd.n437 avss 0.00827f
C1667 avdd.n438 avss 0.00827f
C1668 avdd.n439 avss 0.00827f
C1669 avdd.n440 avss 0.00595f
C1670 avdd.n441 avss 0.09263f
C1671 avdd.n442 avss 0.00595f
C1672 avdd.n443 avss 0.00827f
C1673 avdd.n444 avss 0.00827f
C1674 avdd.n445 avss 0.00827f
C1675 avdd.n446 avss 0.00827f
C1676 avdd.n447 avss 0.00827f
C1677 avdd.n448 avss 0.00595f
C1678 avdd.n449 avss 0.09263f
C1679 avdd.n450 avss 0.00595f
C1680 avdd.n451 avss 0.00827f
C1681 avdd.n452 avss 0.00827f
C1682 avdd.n453 avss 0.00827f
C1683 avdd.n454 avss 0.03533f
C1684 avdd.n455 avss 0.02034f
C1685 avdd.n456 avss 0.00672f
C1686 avdd.n457 avss 0.01699f
C1687 avdd.n458 avss 0.16039f
C1688 avdd.t41 avss 0.04631f
C1689 avdd.n459 avss 0.01699f
C1690 avdd.n460 avss 0.00672f
C1691 avdd.n461 avss 0.02034f
C1692 avdd.t42 avss 0.0179f
C1693 avdd.n462 avss 0.1115f
C1694 avdd.n463 avss 0.01699f
C1695 avdd.n464 avss 0.01699f
C1696 avdd.n466 avss 0.16039f
C1697 avdd.n467 avss 0.00672f
C1698 avdd.n468 avss 0.01699f
C1699 avdd.n469 avss 0.00672f
C1700 avdd.n470 avss 0.00672f
C1701 avdd.n471 avss 0.0216f
C1702 avdd.n472 avss 0.04856f
C1703 avdd.n473 avss 0.06616f
C1704 avdd.n474 avss 0.02034f
C1705 avdd.n475 avss 0.0216f
C1706 avdd.n476 avss 0.00672f
C1707 avdd.n477 avss 0.01699f
C1708 avdd.n478 avss 0.10382f
C1709 avdd.t142 avss 0.04631f
C1710 avdd.n479 avss 0.10382f
C1711 avdd.n481 avss 0.16039f
C1712 avdd.n482 avss 0.10382f
C1713 avdd.n484 avss 0.16039f
C1714 avdd.n485 avss 0.1082f
C1715 avdd.n486 avss 0.09068f
C1716 avdd.n487 avss 0.02034f
C1717 avdd.n488 avss 0.0216f
C1718 avdd.n489 avss 0.00672f
C1719 avdd.n490 avss 0.01699f
C1720 avdd.n491 avss 0.10382f
C1721 avdd.n493 avss 0.01699f
C1722 avdd.n494 avss 0.00672f
C1723 avdd.n495 avss 0.02033f
C1724 avdd.n496 avss 0.02743f
C1725 avdd.n497 avss 0.02742f
C1726 avdd.n498 avss 0.02019f
C1727 avdd.n499 avss 0.00672f
C1728 avdd.n500 avss 0.01693f
C1729 avdd.n501 avss 0.12611f
C1730 avdd.n503 avss 0.01693f
C1731 avdd.n504 avss 0.00672f
C1732 avdd.n505 avss 0.02019f
C1733 avdd.n506 avss 0.13851f
C1734 avdd.n507 avss 0.03533f
C1735 avdd.n508 avss 0.02034f
C1736 avdd.n509 avss 0.01699f
C1737 avdd.n510 avss 0.16039f
C1738 avdd.t14 avss 0.04631f
C1739 avdd.n511 avss 0.16039f
C1740 avdd.n512 avss 0.10382f
C1741 avdd.n514 avss 0.01699f
C1742 avdd.n515 avss 0.00672f
C1743 avdd.n516 avss 0.0216f
C1744 avdd.n517 avss 0.02034f
C1745 avdd.t139 avss 0.0179f
C1746 avdd.n518 avss 0.1115f
C1747 avdd.n519 avss 0.01699f
C1748 avdd.n520 avss 0.01699f
C1749 avdd.n522 avss 0.16039f
C1750 avdd.n523 avss 0.00672f
C1751 avdd.n524 avss 0.06616f
C1752 avdd.n525 avss 0.02034f
C1753 avdd.n526 avss 0.00672f
C1754 avdd.n527 avss 0.01699f
C1755 avdd.n528 avss 0.00672f
C1756 avdd.n529 avss 0.0216f
C1757 avdd.n530 avss 0.04856f
C1758 avdd.n531 avss 0.0216f
C1759 avdd.n532 avss 0.00672f
C1760 avdd.n533 avss 0.01699f
C1761 avdd.n534 avss 0.10382f
C1762 avdd.t138 avss 0.04631f
C1763 avdd.n535 avss 0.10382f
C1764 avdd.n537 avss 0.16039f
C1765 avdd.n538 avss 0.1082f
C1766 avdd.n539 avss 0.09068f
C1767 avdd.n540 avss 0.02034f
C1768 avdd.n541 avss 0.00672f
C1769 avdd.n542 avss 0.01699f
C1770 avdd.n543 avss 0.10382f
C1771 avdd.n545 avss 0.01699f
C1772 avdd.n546 avss 0.00672f
C1773 avdd.n547 avss 0.00672f
C1774 avdd.n548 avss 0.02033f
C1775 avdd.n549 avss 0.13515f
C1776 avdd.n550 avss 0.25322f
C1777 avdd.n551 avss 0.03532f
C1778 avdd.n552 avss 0.00827f
C1779 avdd.n553 avss 0.00827f
C1780 avdd.n554 avss 0.00595f
C1781 avdd.n555 avss 0.1594f
C1782 avdd.n556 avss 0.09263f
C1783 avdd.n557 avss 0.00595f
C1784 avdd.n558 avss 0.00827f
C1785 avdd.n559 avss 0.00827f
C1786 avdd.n560 avss 0.00827f
C1787 avdd.n561 avss 0.00595f
C1788 avdd.t112 avss 0.09263f
C1789 avdd.n562 avss 0.00595f
C1790 avdd.n563 avss 0.00827f
C1791 avdd.n564 avss 0.00827f
C1792 avdd.n565 avss 0.00827f
C1793 avdd.n566 avss 0.00595f
C1794 avdd.n567 avss 0.09263f
C1795 avdd.n568 avss 0.00595f
C1796 avdd.n569 avss 0.00827f
C1797 avdd.n570 avss 0.02732f
C1798 avdd.n571 avss 0.1594f
C1799 avdd.t113 avss 0.02909f
C1800 avdd.n572 avss 0.0803f
C1801 avdd.n573 avss 0.02091f
C1802 avdd.n574 avss 0.00672f
C1803 avdd.n575 avss 0.01693f
C1804 avdd.n576 avss 0.12611f
C1805 avdd.n578 avss 0.01693f
C1806 avdd.n579 avss 0.00672f
C1807 avdd.n580 avss 0.02145f
C1808 avdd.n581 avss 0.00827f
C1809 avdd.n582 avss 0.00827f
C1810 avdd.n583 avss 0.00827f
C1811 avdd.n584 avss 0.00595f
C1812 avdd.n585 avss 0.09263f
C1813 avdd.n586 avss 0.00595f
C1814 avdd.n587 avss 0.00827f
C1815 avdd.n588 avss 0.00827f
C1816 avdd.n589 avss 0.00827f
C1817 avdd.n590 avss 0.00827f
C1818 avdd.n591 avss 0.00827f
C1819 avdd.n592 avss 0.00595f
C1820 avdd.n593 avss 0.09263f
C1821 avdd.n594 avss 0.00595f
C1822 avdd.n595 avss 0.00827f
C1823 avdd.n596 avss 0.00827f
C1824 avdd.n597 avss 0.00827f
C1825 avdd.n598 avss 0.02145f
C1826 avdd.n599 avss 0.00672f
C1827 avdd.n600 avss 0.01693f
C1828 avdd.n601 avss 0.12611f
C1829 avdd.n603 avss 0.01693f
C1830 avdd.n604 avss 0.00672f
C1831 avdd.n605 avss 0.02019f
C1832 avdd.n606 avss 0.13514f
C1833 avdd.n607 avss 0.10476f
C1834 avdd.n608 avss 0.09706f
C1835 avdd.n609 avss 0.00827f
C1836 avdd.n610 avss 0.00827f
C1837 avdd.n611 avss 0.00595f
C1838 avdd.n612 avss 0.40723f
C1839 avdd.n613 avss 0.25291f
C1840 avdd.n614 avss 0.00595f
C1841 avdd.n615 avss 0.00827f
C1842 avdd.n616 avss 0.00827f
C1843 avdd.n617 avss 0.00827f
C1844 avdd.n618 avss 0.00595f
C1845 avdd.n619 avss 0.25291f
C1846 avdd.n620 avss 0.00595f
C1847 avdd.n621 avss 0.00827f
C1848 avdd.t121 avss 0.34639f
C1849 avdd.n622 avss 0.08935f
C1850 avdd.n623 avss 0.40723f
C1851 avdd.n624 avss 0.08903f
C1852 avdd.n625 avss 0.02779f
C1853 avdd.n626 avss 0.00672f
C1854 avdd.n627 avss 0.03491f
C1855 avdd.n629 avss 0.32813f
C1856 avdd.n630 avss 0.03491f
C1857 avdd.n631 avss 0.00672f
C1858 avdd.n632 avss 0.01993f
C1859 avdd.n633 avss 0.00827f
C1860 avdd.n634 avss 0.00827f
C1861 avdd.n635 avss 0.00827f
C1862 avdd.n636 avss 0.00595f
C1863 avdd.t120 avss 0.25291f
C1864 avdd.n637 avss 0.00595f
C1865 avdd.n638 avss 0.00827f
C1866 avdd.n639 avss 0.00827f
C1867 avdd.n640 avss 0.00827f
C1868 avdd.n641 avss 0.02779f
C1869 avdd.n642 avss 0.00672f
C1870 avdd.n643 avss 0.03491f
C1871 avdd.n644 avss 0.32813f
C1872 avdd.n646 avss 0.03491f
C1873 avdd.n647 avss 0.00672f
C1874 avdd.n648 avss 0.01921f
C1875 avdd.n649 avss 0.11366f
C1876 avdd.n650 avss 0.18885f
C1877 avdd.n651 avss 0.0391f
C1878 avdd.n652 avss 1.58791f
C1879 avdd.n654 avss 2.07544f
C1880 avdd.n655 avss 0.02564f
C1881 avdd.n657 avss 0.02564f
C1882 avdd.n659 avss 0.0827f
C1883 avdd.n661 avss 0.11579f
C1884 avdd.n662 avss 0.11579f
C1885 avdd.n663 avss 0.0827f
C1886 avdd.n665 avss 0.11579f
C1887 avdd.n668 avss 0.0827f
C1888 avdd.n670 avss 0.11579f
C1889 avdd.n671 avss 0.11579f
C1890 avdd.n672 avss 0.0827f
C1891 avdd.n674 avss 0.11579f
C1892 avdd.n677 avss 0.13439f
C1893 avdd.t162 avss 0.0827f
C1894 avdd.n680 avss 0.33288f
C1895 avdd.n681 avss 0.13439f
C1896 avdd.n682 avss 0.36183f
C1897 avdd.n684 avss 0.13439f
C1898 avdd.t163 avss 0.0827f
C1899 avdd.n687 avss 0.36183f
C1900 avdd.n688 avss 0.13439f
C1901 avdd.n689 avss 0.2497f
C1902 avdd.n690 avss 0.0221f
C1903 avdd.n691 avss 0.00827f
C1904 avdd.n692 avss 0.00827f
C1905 avdd.n693 avss 0.00595f
C1906 avdd.n694 avss 0.1594f
C1907 avdd.n695 avss 0.09263f
C1908 avdd.n696 avss 0.00595f
C1909 avdd.n697 avss 0.00827f
C1910 avdd.n698 avss 0.00827f
C1911 avdd.n699 avss 0.00827f
C1912 avdd.n700 avss 0.00595f
C1913 avdd.n701 avss 0.09263f
C1914 avdd.n702 avss 0.00595f
C1915 avdd.n703 avss 0.00827f
C1916 avdd.n704 avss 0.00827f
C1917 avdd.n705 avss 0.00827f
C1918 avdd.n706 avss 0.00595f
C1919 avdd.n707 avss 0.09263f
C1920 avdd.n708 avss 0.00595f
C1921 avdd.n709 avss 0.00827f
C1922 avdd.n710 avss 0.00827f
C1923 avdd.n711 avss 0.00827f
C1924 avdd.n712 avss 0.00595f
C1925 avdd.n713 avss 0.09263f
C1926 avdd.n714 avss 0.00595f
C1927 avdd.n715 avss 0.00827f
C1928 avdd.n716 avss 0.00827f
C1929 avdd.n717 avss 0.00827f
C1930 avdd.n718 avss 0.00595f
C1931 avdd.n719 avss 0.06947f
C1932 avdd.n720 avss 0.00595f
C1933 avdd.n721 avss 0.00827f
C1934 avdd.n722 avss 0.00827f
C1935 avdd.n723 avss 0.00827f
C1936 avdd.n724 avss 0.00595f
C1937 avdd.n725 avss 0.09263f
C1938 avdd.t54 avss 0.04631f
C1939 avdd.n726 avss 0.00595f
C1940 avdd.n727 avss 0.00827f
C1941 avdd.n728 avss 0.00827f
C1942 avdd.n729 avss 0.00827f
C1943 avdd.n730 avss 0.00595f
C1944 avdd.n731 avss 0.09263f
C1945 avdd.n732 avss 0.00595f
C1946 avdd.n733 avss 0.00827f
C1947 avdd.n734 avss 0.00827f
C1948 avdd.n735 avss 0.00827f
C1949 avdd.n736 avss 0.00595f
C1950 avdd.n737 avss 0.09263f
C1951 avdd.n738 avss 0.00595f
C1952 avdd.n739 avss 0.00827f
C1953 avdd.n740 avss 0.00827f
C1954 avdd.n741 avss 0.00827f
C1955 avdd.n742 avss 0.00595f
C1956 avdd.n743 avss 0.09263f
C1957 avdd.n744 avss 0.00595f
C1958 avdd.n745 avss 0.00827f
C1959 avdd.n746 avss 0.02145f
C1960 avdd.n747 avss 0.00672f
C1961 avdd.n748 avss 0.01693f
C1962 avdd.n749 avss 0.12611f
C1963 avdd.n750 avss 0.01693f
C1964 avdd.n751 avss 0.00672f
C1965 avdd.n753 avss 0.1594f
C1966 avdd.n754 avss 0.02732f
C1967 avdd.t55 avss 0.06136f
C1968 avdd.n755 avss 0.15554f
C1969 avdd.n756 avss 0.02091f
C1970 avdd.n757 avss 0.00827f
C1971 avdd.n758 avss 0.00827f
C1972 avdd.n759 avss 0.00595f
C1973 avdd.n760 avss 0.09263f
C1974 avdd.n761 avss 0.00595f
C1975 avdd.n762 avss 0.00827f
C1976 avdd.n763 avss 0.00827f
C1977 avdd.n764 avss 0.00827f
C1978 avdd.n765 avss 0.00827f
C1979 avdd.n766 avss 0.00827f
C1980 avdd.n767 avss 0.00595f
C1981 avdd.n768 avss 0.09263f
C1982 avdd.n769 avss 0.00595f
C1983 avdd.n770 avss 0.00827f
C1984 avdd.n771 avss 0.00827f
C1985 avdd.n772 avss 0.00827f
C1986 avdd.n773 avss 0.00827f
C1987 avdd.n774 avss 0.00827f
C1988 avdd.n775 avss 0.00595f
C1989 avdd.n776 avss 0.09263f
C1990 avdd.n777 avss 0.00595f
C1991 avdd.n778 avss 0.00827f
C1992 avdd.n779 avss 0.00827f
C1993 avdd.n780 avss 0.00827f
C1994 avdd.n781 avss 0.00827f
C1995 avdd.n782 avss 0.00827f
C1996 avdd.n783 avss 0.00595f
C1997 avdd.n784 avss 0.09263f
C1998 avdd.n785 avss 0.00595f
C1999 avdd.n786 avss 0.00827f
C2000 avdd.n787 avss 0.00827f
C2001 avdd.n788 avss 0.00827f
C2002 avdd.n789 avss 0.00827f
C2003 avdd.n790 avss 0.00827f
C2004 avdd.n791 avss 0.00595f
C2005 avdd.n792 avss 0.06947f
C2006 avdd.n793 avss 0.00595f
C2007 avdd.n794 avss 0.00827f
C2008 avdd.n795 avss 0.00827f
C2009 avdd.n796 avss 0.00827f
C2010 avdd.n797 avss 0.00827f
C2011 avdd.n798 avss 0.00827f
C2012 avdd.n799 avss 0.00595f
C2013 avdd.n800 avss 0.09263f
C2014 avdd.n801 avss 0.00595f
C2015 avdd.n802 avss 0.00827f
C2016 avdd.n803 avss 0.00827f
C2017 avdd.n804 avss 0.00827f
C2018 avdd.n805 avss 0.00827f
C2019 avdd.n806 avss 0.00827f
C2020 avdd.n807 avss 0.00595f
C2021 avdd.n808 avss 0.09263f
C2022 avdd.n809 avss 0.00595f
C2023 avdd.n810 avss 0.00827f
C2024 avdd.n811 avss 0.00827f
C2025 avdd.n812 avss 0.00827f
C2026 avdd.n813 avss 0.00827f
C2027 avdd.n814 avss 0.00827f
C2028 avdd.n815 avss 0.00595f
C2029 avdd.n816 avss 0.09263f
C2030 avdd.n817 avss 0.00595f
C2031 avdd.n818 avss 0.00827f
C2032 avdd.n819 avss 0.00827f
C2033 avdd.n820 avss 0.00827f
C2034 avdd.n821 avss 0.00827f
C2035 avdd.n822 avss 0.00827f
C2036 avdd.n823 avss 0.00595f
C2037 avdd.n824 avss 0.09263f
C2038 avdd.n825 avss 0.00595f
C2039 avdd.n826 avss 0.00827f
C2040 avdd.n827 avss 0.00827f
C2041 avdd.n828 avss 0.00827f
C2042 avdd.n829 avss 0.03533f
C2043 avdd.n830 avss 0.02034f
C2044 avdd.n831 avss 0.00672f
C2045 avdd.n832 avss 0.01699f
C2046 avdd.n833 avss 0.16039f
C2047 avdd.t52 avss 0.04631f
C2048 avdd.n834 avss 0.01699f
C2049 avdd.n835 avss 0.00672f
C2050 avdd.n836 avss 0.02034f
C2051 avdd.t53 avss 0.0179f
C2052 avdd.n837 avss 0.1115f
C2053 avdd.n838 avss 0.01699f
C2054 avdd.n839 avss 0.01699f
C2055 avdd.n841 avss 0.16039f
C2056 avdd.n842 avss 0.00672f
C2057 avdd.n843 avss 0.01699f
C2058 avdd.n844 avss 0.00672f
C2059 avdd.n845 avss 0.00672f
C2060 avdd.n846 avss 0.0216f
C2061 avdd.n847 avss 0.04856f
C2062 avdd.n848 avss 0.06616f
C2063 avdd.n849 avss 0.02034f
C2064 avdd.n850 avss 0.0216f
C2065 avdd.n851 avss 0.00672f
C2066 avdd.n852 avss 0.01699f
C2067 avdd.n853 avss 0.10382f
C2068 avdd.t61 avss 0.04631f
C2069 avdd.n854 avss 0.10382f
C2070 avdd.n856 avss 0.16039f
C2071 avdd.n857 avss 0.10382f
C2072 avdd.n859 avss 0.16039f
C2073 avdd.n860 avss 0.1082f
C2074 avdd.n861 avss 0.09068f
C2075 avdd.n862 avss 0.02034f
C2076 avdd.n863 avss 0.0216f
C2077 avdd.n864 avss 0.00672f
C2078 avdd.n865 avss 0.01699f
C2079 avdd.n866 avss 0.10382f
C2080 avdd.n868 avss 0.01699f
C2081 avdd.n869 avss 0.00672f
C2082 avdd.n870 avss 0.02033f
C2083 avdd.n871 avss 0.02743f
C2084 avdd.n872 avss 0.02742f
C2085 avdd.n873 avss 0.02019f
C2086 avdd.n874 avss 0.00672f
C2087 avdd.n875 avss 0.01693f
C2088 avdd.n876 avss 0.12611f
C2089 avdd.n878 avss 0.01693f
C2090 avdd.n879 avss 0.00672f
C2091 avdd.n880 avss 0.02019f
C2092 avdd.n881 avss 0.13851f
C2093 avdd.n882 avss 0.03533f
C2094 avdd.n883 avss 0.02034f
C2095 avdd.n884 avss 0.01699f
C2096 avdd.n885 avss 0.16039f
C2097 avdd.t33 avss 0.04631f
C2098 avdd.n886 avss 0.16039f
C2099 avdd.n887 avss 0.10382f
C2100 avdd.n889 avss 0.01699f
C2101 avdd.n890 avss 0.00672f
C2102 avdd.n891 avss 0.0216f
C2103 avdd.n892 avss 0.02034f
C2104 avdd.t149 avss 0.0179f
C2105 avdd.n893 avss 0.1115f
C2106 avdd.n894 avss 0.01699f
C2107 avdd.n895 avss 0.01699f
C2108 avdd.n897 avss 0.16039f
C2109 avdd.n898 avss 0.00672f
C2110 avdd.n899 avss 0.06616f
C2111 avdd.n900 avss 0.02034f
C2112 avdd.n901 avss 0.00672f
C2113 avdd.n902 avss 0.01699f
C2114 avdd.n903 avss 0.00672f
C2115 avdd.n904 avss 0.0216f
C2116 avdd.n905 avss 0.04856f
C2117 avdd.n906 avss 0.0216f
C2118 avdd.n907 avss 0.00672f
C2119 avdd.n908 avss 0.01699f
C2120 avdd.n909 avss 0.10382f
C2121 avdd.t148 avss 0.04631f
C2122 avdd.n910 avss 0.10382f
C2123 avdd.n912 avss 0.16039f
C2124 avdd.n913 avss 0.1082f
C2125 avdd.n914 avss 0.09068f
C2126 avdd.n915 avss 0.02034f
C2127 avdd.n916 avss 0.00672f
C2128 avdd.n917 avss 0.01699f
C2129 avdd.n918 avss 0.10382f
C2130 avdd.n920 avss 0.01699f
C2131 avdd.n921 avss 0.00672f
C2132 avdd.n922 avss 0.00672f
C2133 avdd.n923 avss 0.02033f
C2134 avdd.n924 avss 0.13515f
C2135 avdd.n925 avss 0.25322f
C2136 avdd.n926 avss 0.03532f
C2137 avdd.n927 avss 0.00827f
C2138 avdd.n928 avss 0.00827f
C2139 avdd.n929 avss 0.00595f
C2140 avdd.n930 avss 0.1594f
C2141 avdd.n931 avss 0.09263f
C2142 avdd.n932 avss 0.00595f
C2143 avdd.n933 avss 0.00827f
C2144 avdd.n934 avss 0.00827f
C2145 avdd.n935 avss 0.00827f
C2146 avdd.n936 avss 0.00595f
C2147 avdd.t114 avss 0.09263f
C2148 avdd.n937 avss 0.00595f
C2149 avdd.n938 avss 0.00827f
C2150 avdd.n939 avss 0.00827f
C2151 avdd.n940 avss 0.00827f
C2152 avdd.n941 avss 0.00595f
C2153 avdd.n942 avss 0.09263f
C2154 avdd.n943 avss 0.00595f
C2155 avdd.n944 avss 0.00827f
C2156 avdd.n945 avss 0.02732f
C2157 avdd.n946 avss 0.1594f
C2158 avdd.t115 avss 0.02909f
C2159 avdd.n947 avss 0.0803f
C2160 avdd.n948 avss 0.02091f
C2161 avdd.n949 avss 0.00672f
C2162 avdd.n950 avss 0.01693f
C2163 avdd.n951 avss 0.12611f
C2164 avdd.n953 avss 0.01693f
C2165 avdd.n954 avss 0.00672f
C2166 avdd.n955 avss 0.02145f
C2167 avdd.n956 avss 0.00827f
C2168 avdd.n957 avss 0.00827f
C2169 avdd.n958 avss 0.00827f
C2170 avdd.n959 avss 0.00595f
C2171 avdd.n960 avss 0.09263f
C2172 avdd.n961 avss 0.00595f
C2173 avdd.n962 avss 0.00827f
C2174 avdd.n963 avss 0.00827f
C2175 avdd.n964 avss 0.00827f
C2176 avdd.n965 avss 0.00827f
C2177 avdd.n966 avss 0.00827f
C2178 avdd.n967 avss 0.00595f
C2179 avdd.n968 avss 0.09263f
C2180 avdd.n969 avss 0.00595f
C2181 avdd.n970 avss 0.00827f
C2182 avdd.n971 avss 0.00827f
C2183 avdd.n972 avss 0.00827f
C2184 avdd.n973 avss 0.02145f
C2185 avdd.n974 avss 0.00672f
C2186 avdd.n975 avss 0.01693f
C2187 avdd.n976 avss 0.12611f
C2188 avdd.n978 avss 0.01693f
C2189 avdd.n979 avss 0.00672f
C2190 avdd.n980 avss 0.02019f
C2191 avdd.n981 avss 0.13514f
C2192 avdd.n982 avss 0.10476f
C2193 avdd.n983 avss 0.09706f
C2194 avdd.n984 avss 0.00827f
C2195 avdd.n985 avss 0.00827f
C2196 avdd.n986 avss 0.00595f
C2197 avdd.n987 avss 0.40723f
C2198 avdd.n988 avss 0.25291f
C2199 avdd.n989 avss 0.00595f
C2200 avdd.n990 avss 0.00827f
C2201 avdd.n991 avss 0.00827f
C2202 avdd.n992 avss 0.00827f
C2203 avdd.n993 avss 0.00595f
C2204 avdd.n994 avss 0.25291f
C2205 avdd.n995 avss 0.00595f
C2206 avdd.n996 avss 0.00827f
C2207 avdd.t123 avss 0.34639f
C2208 avdd.n997 avss 0.08935f
C2209 avdd.n998 avss 0.40723f
C2210 avdd.n999 avss 0.08903f
C2211 avdd.n1000 avss 0.02779f
C2212 avdd.n1001 avss 0.00672f
C2213 avdd.n1002 avss 0.03491f
C2214 avdd.n1004 avss 0.32813f
C2215 avdd.n1005 avss 0.03491f
C2216 avdd.n1006 avss 0.00672f
C2217 avdd.n1007 avss 0.01993f
C2218 avdd.n1008 avss 0.00827f
C2219 avdd.n1009 avss 0.00827f
C2220 avdd.n1010 avss 0.00827f
C2221 avdd.n1011 avss 0.00595f
C2222 avdd.t122 avss 0.25291f
C2223 avdd.n1012 avss 0.00595f
C2224 avdd.n1013 avss 0.00827f
C2225 avdd.n1014 avss 0.00827f
C2226 avdd.n1015 avss 0.00827f
C2227 avdd.n1016 avss 0.02779f
C2228 avdd.n1017 avss 0.00672f
C2229 avdd.n1018 avss 0.03491f
C2230 avdd.n1019 avss 0.32813f
C2231 avdd.n1021 avss 0.03491f
C2232 avdd.n1022 avss 0.00672f
C2233 avdd.n1023 avss 0.01921f
C2234 avdd.n1024 avss 0.11366f
C2235 avdd.n1025 avss 0.18885f
C2236 avdd.n1026 avss 0.0391f
C2237 avdd.n1027 avss 1.58149f
C2238 avdd.n1028 avss 1.04444f
C2239 avdd.n1029 avss 0.55577f
C2240 avdd.n1032 avss 0.33867f
C2241 avdd.n1033 avss 0.02564f
C2242 avdd.n1035 avss 2.07544f
C2243 avdd.n1036 avss 2.07544f
C2244 avdd.n1037 avss 0.02564f
C2245 avdd.n1039 avss 1.12435f
C2246 avdd.n1041 avss 0.02564f
C2247 avdd.n1044 avss 0.76211f
C2248 avdd.n1045 avss 0.02564f
C2249 avdd.n1047 avss 1.26134f
C2250 avdd.n1048 avss 1.35358f
C2251 avdd.n1049 avss 1.1532f
C2252 avdd.n1050 avss 0.78115f
C2253 avdd.n1051 avss 0.62943f
C2254 avdd.n1052 avss 0.88898f
C2255 avdd.n1053 avss 0.88898f
C2256 avdd.n1054 avss 0.54291f
C2257 avdd.n1055 avss 1.17313f
C2258 avdd.n1056 avss 0.80099f
C2259 avdd.n1057 avss -0.88083f
C2260 avdd.n1058 avss 0.15699f
C2261 avdd.n1059 avss 1.69474f
C2262 avdd.n1060 avss 0.62943f
C2263 avdd.n1061 avss 0.2825f
C2264 avdd.n1062 avss 0.62487f
C2265 avdd.n1063 avss 0.54592f
C2266 avdd.n1064 avss 1.11322f
C2267 avdd.n1065 avss 5.70256f
C2268 avdd.n1066 avss 4.31517f
C2269 avdd.n1067 avss 0.36514f
C2270 avdd.n1069 avss 0.02564f
C2271 avdd.n1070 avss 1.12435f
C2272 avdd.n1073 avss 0.02564f
C2273 avdd.n1074 avss 0.02564f
C2274 avdd.n1076 avss 0.76211f
C2275 avdd.n1077 avss 1.12435f
C2276 avdd.n1078 avss 1.12435f
C2277 avdd.n1082 avss 0.09273f
C2278 avdd.n1084 avss 0.02564f
C2279 avdd.n1086 avss 2.07544f
C2280 avdd.n1087 avss 0.02564f
C2281 avdd.n1088 avss 0.02564f
C2282 avdd.n1090 avss 0.02564f
C2283 avdd.n1092 avss 0.02564f
C2284 avdd.n1093 avss 0.17216f
C2285 avdd.n1095 avss 1.24055f
C2286 avdd.n1097 avss 0.02564f
C2287 avdd.n1098 avss 0.02564f
C2288 avdd.n1102 avss 0.02564f
C2289 avdd.n1103 avss 1.12435f
C2290 avdd.n1105 avss 0.02564f
C2291 avdd.n1107 avss 0.76211f
C2292 avdd.n1108 avss 0.76211f
C2293 avdd.n1110 avss 0.02564f
C2294 avdd.n1111 avss 0.02564f
C2295 avdd.n1113 avss 0.17326f
C2296 avdd.n1114 avss 0.4619f
C2297 avdd.n1115 avss 1.61986f
C2298 avdd.n1116 avss 0.79147f
C2299 avdd.n1117 avss 0
C2300 avdd.n1118 avss 0.02863f
C2301 avdd.n1119 avss 0.02835f
C2302 avdd.n1120 avss 0.76211f
C2303 avdd.n1121 avss 0.02564f
C2304 avdd.n1122 avss 0.0011f
C2305 avdd.n1123 avss 0.76211f
C2306 avdd.n1124 avss 1.24055f
C2307 avdd.n1125 avss 2.07544f
C2308 avdd.n1126 avss 0.17326f
C2309 avdd.n1127 avss 2.07544f
C2310 avdd.n1128 avss 0.02564f
C2311 avdd.n1130 avss 0.18825f
C2312 avdd.n1132 avss 0.0827f
C2313 avdd.n1134 avss 0.11579f
C2314 avdd.n1135 avss 0.11579f
C2315 avdd.n1136 avss 0.0827f
C2316 avdd.n1138 avss 0.11579f
C2317 avdd.n1141 avss 0.0827f
C2318 avdd.n1143 avss 0.11579f
C2319 avdd.n1144 avss 0.11579f
C2320 avdd.n1145 avss 0.0827f
C2321 avdd.n1147 avss 0.11579f
C2322 avdd.n1150 avss 0.13439f
C2323 avdd.t160 avss 0.0827f
C2324 avdd.n1153 avss 0.33288f
C2325 avdd.n1154 avss 0.13439f
C2326 avdd.n1155 avss 0.36183f
C2327 avdd.n1157 avss 0.13439f
C2328 avdd.t161 avss 0.0827f
C2329 avdd.n1160 avss 0.36183f
C2330 avdd.n1161 avss 0.13439f
C2331 avdd.n1162 avss 0.2497f
C2332 avdd.n1163 avss 0.0221f
C2333 avdd.n1164 avss 0.00827f
C2334 avdd.n1165 avss 0.00827f
C2335 avdd.n1166 avss 0.00595f
C2336 avdd.n1167 avss 0.1594f
C2337 avdd.n1168 avss 0.09263f
C2338 avdd.n1169 avss 0.00595f
C2339 avdd.n1170 avss 0.00827f
C2340 avdd.n1171 avss 0.00827f
C2341 avdd.n1172 avss 0.00827f
C2342 avdd.n1173 avss 0.00595f
C2343 avdd.n1174 avss 0.09263f
C2344 avdd.n1175 avss 0.00595f
C2345 avdd.n1176 avss 0.00827f
C2346 avdd.n1177 avss 0.00827f
C2347 avdd.n1178 avss 0.00827f
C2348 avdd.n1179 avss 0.00595f
C2349 avdd.n1180 avss 0.09263f
C2350 avdd.n1181 avss 0.00595f
C2351 avdd.n1182 avss 0.00827f
C2352 avdd.n1183 avss 0.00827f
C2353 avdd.n1184 avss 0.00827f
C2354 avdd.n1185 avss 0.00595f
C2355 avdd.n1186 avss 0.09263f
C2356 avdd.n1187 avss 0.00595f
C2357 avdd.n1188 avss 0.00827f
C2358 avdd.n1189 avss 0.00827f
C2359 avdd.n1190 avss 0.00827f
C2360 avdd.n1191 avss 0.00595f
C2361 avdd.n1192 avss 0.06947f
C2362 avdd.n1193 avss 0.00595f
C2363 avdd.n1194 avss 0.00827f
C2364 avdd.n1195 avss 0.00827f
C2365 avdd.n1196 avss 0.00827f
C2366 avdd.n1197 avss 0.00595f
C2367 avdd.n1198 avss 0.09263f
C2368 avdd.t66 avss 0.04631f
C2369 avdd.n1199 avss 0.00595f
C2370 avdd.n1200 avss 0.00827f
C2371 avdd.n1201 avss 0.00827f
C2372 avdd.n1202 avss 0.00827f
C2373 avdd.n1203 avss 0.00595f
C2374 avdd.n1204 avss 0.09263f
C2375 avdd.n1205 avss 0.00595f
C2376 avdd.n1206 avss 0.00827f
C2377 avdd.n1207 avss 0.00827f
C2378 avdd.n1208 avss 0.00827f
C2379 avdd.n1209 avss 0.00595f
C2380 avdd.n1210 avss 0.09263f
C2381 avdd.n1211 avss 0.00595f
C2382 avdd.n1212 avss 0.00827f
C2383 avdd.n1213 avss 0.00827f
C2384 avdd.n1214 avss 0.00827f
C2385 avdd.n1215 avss 0.00595f
C2386 avdd.n1216 avss 0.09263f
C2387 avdd.n1217 avss 0.00595f
C2388 avdd.n1218 avss 0.00827f
C2389 avdd.n1219 avss 0.02145f
C2390 avdd.n1220 avss 0.00672f
C2391 avdd.n1221 avss 0.01693f
C2392 avdd.n1222 avss 0.12611f
C2393 avdd.n1223 avss 0.01693f
C2394 avdd.n1224 avss 0.00672f
C2395 avdd.n1226 avss 0.1594f
C2396 avdd.n1227 avss 0.02732f
C2397 avdd.t67 avss 0.06136f
C2398 avdd.n1228 avss 0.15554f
C2399 avdd.n1229 avss 0.02091f
C2400 avdd.n1230 avss 0.00827f
C2401 avdd.n1231 avss 0.00827f
C2402 avdd.n1232 avss 0.00595f
C2403 avdd.n1233 avss 0.09263f
C2404 avdd.n1234 avss 0.00595f
C2405 avdd.n1235 avss 0.00827f
C2406 avdd.n1236 avss 0.00827f
C2407 avdd.n1237 avss 0.00827f
C2408 avdd.n1238 avss 0.00827f
C2409 avdd.n1239 avss 0.00827f
C2410 avdd.n1240 avss 0.00595f
C2411 avdd.n1241 avss 0.09263f
C2412 avdd.n1242 avss 0.00595f
C2413 avdd.n1243 avss 0.00827f
C2414 avdd.n1244 avss 0.00827f
C2415 avdd.n1245 avss 0.00827f
C2416 avdd.n1246 avss 0.00827f
C2417 avdd.n1247 avss 0.00827f
C2418 avdd.n1248 avss 0.00595f
C2419 avdd.n1249 avss 0.09263f
C2420 avdd.n1250 avss 0.00595f
C2421 avdd.n1251 avss 0.00827f
C2422 avdd.n1252 avss 0.00827f
C2423 avdd.n1253 avss 0.00827f
C2424 avdd.n1254 avss 0.00827f
C2425 avdd.n1255 avss 0.00827f
C2426 avdd.n1256 avss 0.00595f
C2427 avdd.n1257 avss 0.09263f
C2428 avdd.n1258 avss 0.00595f
C2429 avdd.n1259 avss 0.00827f
C2430 avdd.n1260 avss 0.00827f
C2431 avdd.n1261 avss 0.00827f
C2432 avdd.n1262 avss 0.00827f
C2433 avdd.n1263 avss 0.00827f
C2434 avdd.n1264 avss 0.00595f
C2435 avdd.n1265 avss 0.06947f
C2436 avdd.n1266 avss 0.00595f
C2437 avdd.n1267 avss 0.00827f
C2438 avdd.n1268 avss 0.00827f
C2439 avdd.n1269 avss 0.00827f
C2440 avdd.n1270 avss 0.00827f
C2441 avdd.n1271 avss 0.00827f
C2442 avdd.n1272 avss 0.00595f
C2443 avdd.n1273 avss 0.09263f
C2444 avdd.n1274 avss 0.00595f
C2445 avdd.n1275 avss 0.00827f
C2446 avdd.n1276 avss 0.00827f
C2447 avdd.n1277 avss 0.00827f
C2448 avdd.n1278 avss 0.00827f
C2449 avdd.n1279 avss 0.00827f
C2450 avdd.n1280 avss 0.00595f
C2451 avdd.n1281 avss 0.09263f
C2452 avdd.n1282 avss 0.00595f
C2453 avdd.n1283 avss 0.00827f
C2454 avdd.n1284 avss 0.00827f
C2455 avdd.n1285 avss 0.00827f
C2456 avdd.n1286 avss 0.00827f
C2457 avdd.n1287 avss 0.00827f
C2458 avdd.n1288 avss 0.00595f
C2459 avdd.n1289 avss 0.09263f
C2460 avdd.n1290 avss 0.00595f
C2461 avdd.n1291 avss 0.00827f
C2462 avdd.n1292 avss 0.00827f
C2463 avdd.n1293 avss 0.00827f
C2464 avdd.n1294 avss 0.00827f
C2465 avdd.n1295 avss 0.00827f
C2466 avdd.n1296 avss 0.00595f
C2467 avdd.n1297 avss 0.09263f
C2468 avdd.n1298 avss 0.00595f
C2469 avdd.n1299 avss 0.00827f
C2470 avdd.n1300 avss 0.00827f
C2471 avdd.n1301 avss 0.00827f
C2472 avdd.n1302 avss 0.03533f
C2473 avdd.n1303 avss 0.02034f
C2474 avdd.n1304 avss 0.00672f
C2475 avdd.n1305 avss 0.01699f
C2476 avdd.n1306 avss 0.16039f
C2477 avdd.t72 avss 0.04631f
C2478 avdd.n1307 avss 0.01699f
C2479 avdd.n1308 avss 0.00672f
C2480 avdd.n1309 avss 0.02034f
C2481 avdd.t73 avss 0.0179f
C2482 avdd.n1310 avss 0.1115f
C2483 avdd.n1311 avss 0.01699f
C2484 avdd.n1312 avss 0.01699f
C2485 avdd.n1314 avss 0.16039f
C2486 avdd.n1315 avss 0.00672f
C2487 avdd.n1316 avss 0.01699f
C2488 avdd.n1317 avss 0.00672f
C2489 avdd.n1318 avss 0.00672f
C2490 avdd.n1319 avss 0.0216f
C2491 avdd.n1320 avss 0.04856f
C2492 avdd.n1321 avss 0.06616f
C2493 avdd.n1322 avss 0.02034f
C2494 avdd.n1323 avss 0.0216f
C2495 avdd.n1324 avss 0.00672f
C2496 avdd.n1325 avss 0.01699f
C2497 avdd.n1326 avss 0.10382f
C2498 avdd.t140 avss 0.04631f
C2499 avdd.n1327 avss 0.10382f
C2500 avdd.n1329 avss 0.16039f
C2501 avdd.n1330 avss 0.10382f
C2502 avdd.n1332 avss 0.16039f
C2503 avdd.n1333 avss 0.1082f
C2504 avdd.n1334 avss 0.09068f
C2505 avdd.n1335 avss 0.02034f
C2506 avdd.n1336 avss 0.0216f
C2507 avdd.n1337 avss 0.00672f
C2508 avdd.n1338 avss 0.01699f
C2509 avdd.n1339 avss 0.10382f
C2510 avdd.n1341 avss 0.01699f
C2511 avdd.n1342 avss 0.00672f
C2512 avdd.n1343 avss 0.02033f
C2513 avdd.n1344 avss 0.02743f
C2514 avdd.n1345 avss 0.02742f
C2515 avdd.n1346 avss 0.02019f
C2516 avdd.n1347 avss 0.00672f
C2517 avdd.n1348 avss 0.01693f
C2518 avdd.n1349 avss 0.12611f
C2519 avdd.n1351 avss 0.01693f
C2520 avdd.n1352 avss 0.00672f
C2521 avdd.n1353 avss 0.02019f
C2522 avdd.n1354 avss 0.13851f
C2523 avdd.n1355 avss 0.03533f
C2524 avdd.n1356 avss 0.02034f
C2525 avdd.n1357 avss 0.01699f
C2526 avdd.n1358 avss 0.16039f
C2527 avdd.t81 avss 0.04631f
C2528 avdd.n1359 avss 0.16039f
C2529 avdd.n1360 avss 0.10382f
C2530 avdd.n1362 avss 0.01699f
C2531 avdd.n1363 avss 0.00672f
C2532 avdd.n1364 avss 0.0216f
C2533 avdd.n1365 avss 0.02034f
C2534 avdd.t38 avss 0.0179f
C2535 avdd.n1366 avss 0.1115f
C2536 avdd.n1367 avss 0.01699f
C2537 avdd.n1368 avss 0.01699f
C2538 avdd.n1370 avss 0.16039f
C2539 avdd.n1371 avss 0.00672f
C2540 avdd.n1372 avss 0.06616f
C2541 avdd.n1373 avss 0.02034f
C2542 avdd.n1374 avss 0.00672f
C2543 avdd.n1375 avss 0.01699f
C2544 avdd.n1376 avss 0.00672f
C2545 avdd.n1377 avss 0.0216f
C2546 avdd.n1378 avss 0.04856f
C2547 avdd.n1379 avss 0.0216f
C2548 avdd.n1380 avss 0.00672f
C2549 avdd.n1381 avss 0.01699f
C2550 avdd.n1382 avss 0.10382f
C2551 avdd.t37 avss 0.04631f
C2552 avdd.n1383 avss 0.10382f
C2553 avdd.n1385 avss 0.16039f
C2554 avdd.n1386 avss 0.1082f
C2555 avdd.n1387 avss 0.09068f
C2556 avdd.n1388 avss 0.02034f
C2557 avdd.n1389 avss 0.00672f
C2558 avdd.n1390 avss 0.01699f
C2559 avdd.n1391 avss 0.10382f
C2560 avdd.n1393 avss 0.01699f
C2561 avdd.n1394 avss 0.00672f
C2562 avdd.n1395 avss 0.00672f
C2563 avdd.n1396 avss 0.02033f
C2564 avdd.n1397 avss 0.13515f
C2565 avdd.n1398 avss 0.25322f
C2566 avdd.n1399 avss 0.03532f
C2567 avdd.n1400 avss 0.00827f
C2568 avdd.n1401 avss 0.00827f
C2569 avdd.n1402 avss 0.00595f
C2570 avdd.n1403 avss 0.1594f
C2571 avdd.n1404 avss 0.09263f
C2572 avdd.n1405 avss 0.00595f
C2573 avdd.n1406 avss 0.00827f
C2574 avdd.n1407 avss 0.00827f
C2575 avdd.n1408 avss 0.00827f
C2576 avdd.n1409 avss 0.00595f
C2577 avdd.t94 avss 0.09263f
C2578 avdd.n1410 avss 0.00595f
C2579 avdd.n1411 avss 0.00827f
C2580 avdd.n1412 avss 0.00827f
C2581 avdd.n1413 avss 0.00827f
C2582 avdd.n1414 avss 0.00595f
C2583 avdd.n1415 avss 0.09263f
C2584 avdd.n1416 avss 0.00595f
C2585 avdd.n1417 avss 0.00827f
C2586 avdd.n1418 avss 0.02732f
C2587 avdd.n1419 avss 0.1594f
C2588 avdd.t95 avss 0.02909f
C2589 avdd.n1420 avss 0.0803f
C2590 avdd.n1421 avss 0.02091f
C2591 avdd.n1422 avss 0.00672f
C2592 avdd.n1423 avss 0.01693f
C2593 avdd.n1424 avss 0.12611f
C2594 avdd.n1426 avss 0.01693f
C2595 avdd.n1427 avss 0.00672f
C2596 avdd.n1428 avss 0.02145f
C2597 avdd.n1429 avss 0.00827f
C2598 avdd.n1430 avss 0.00827f
C2599 avdd.n1431 avss 0.00827f
C2600 avdd.n1432 avss 0.00595f
C2601 avdd.n1433 avss 0.09263f
C2602 avdd.n1434 avss 0.00595f
C2603 avdd.n1435 avss 0.00827f
C2604 avdd.n1436 avss 0.00827f
C2605 avdd.n1437 avss 0.00827f
C2606 avdd.n1438 avss 0.00827f
C2607 avdd.n1439 avss 0.00827f
C2608 avdd.n1440 avss 0.00595f
C2609 avdd.n1441 avss 0.09263f
C2610 avdd.n1442 avss 0.00595f
C2611 avdd.n1443 avss 0.00827f
C2612 avdd.n1444 avss 0.00827f
C2613 avdd.n1445 avss 0.00827f
C2614 avdd.n1446 avss 0.02145f
C2615 avdd.n1447 avss 0.00672f
C2616 avdd.n1448 avss 0.01693f
C2617 avdd.n1449 avss 0.12611f
C2618 avdd.n1451 avss 0.01693f
C2619 avdd.n1452 avss 0.00672f
C2620 avdd.n1453 avss 0.02019f
C2621 avdd.n1454 avss 0.13514f
C2622 avdd.n1455 avss 0.10476f
C2623 avdd.n1456 avss 0.09706f
C2624 avdd.n1457 avss 0.00827f
C2625 avdd.n1458 avss 0.00827f
C2626 avdd.n1459 avss 0.00595f
C2627 avdd.n1460 avss 0.40723f
C2628 avdd.n1461 avss 0.25291f
C2629 avdd.n1462 avss 0.00595f
C2630 avdd.n1463 avss 0.00827f
C2631 avdd.n1464 avss 0.00827f
C2632 avdd.n1465 avss 0.00827f
C2633 avdd.n1466 avss 0.00595f
C2634 avdd.n1467 avss 0.25291f
C2635 avdd.n1468 avss 0.00595f
C2636 avdd.n1469 avss 0.00827f
C2637 avdd.t101 avss 0.34639f
C2638 avdd.n1470 avss 0.08935f
C2639 avdd.n1471 avss 0.40723f
C2640 avdd.n1472 avss 0.08903f
C2641 avdd.n1473 avss 0.02779f
C2642 avdd.n1474 avss 0.00672f
C2643 avdd.n1475 avss 0.03491f
C2644 avdd.n1477 avss 0.32813f
C2645 avdd.n1478 avss 0.03491f
C2646 avdd.n1479 avss 0.00672f
C2647 avdd.n1480 avss 0.01993f
C2648 avdd.n1481 avss 0.00827f
C2649 avdd.n1482 avss 0.00827f
C2650 avdd.n1483 avss 0.00827f
C2651 avdd.n1484 avss 0.00595f
C2652 avdd.t100 avss 0.25291f
C2653 avdd.n1485 avss 0.00595f
C2654 avdd.n1486 avss 0.00827f
C2655 avdd.n1487 avss 0.00827f
C2656 avdd.n1488 avss 0.00827f
C2657 avdd.n1489 avss 0.02779f
C2658 avdd.n1490 avss 0.00672f
C2659 avdd.n1491 avss 0.03491f
C2660 avdd.n1492 avss 0.32813f
C2661 avdd.n1494 avss 0.03491f
C2662 avdd.n1495 avss 0.00672f
C2663 avdd.n1496 avss 0.01921f
C2664 avdd.n1497 avss 0.11366f
C2665 avdd.n1498 avss 0.18885f
C2666 avdd.n1499 avss 0.0391f
C2667 avdd.n1500 avss 1.70411f
C2668 avdd.n1502 avss 1.06512f
C2669 avdd.n1504 avss 2.07544f
C2670 avdd.n1505 avss 0.09273f
C2671 avdd.n1507 avss 0.0827f
C2672 avdd.n1509 avss 0.11579f
C2673 avdd.n1510 avss 0.11579f
C2674 avdd.n1511 avss 0.0827f
C2675 avdd.n1513 avss 0.11579f
C2676 avdd.n1516 avss 0.0827f
C2677 avdd.n1518 avss 0.11579f
C2678 avdd.n1519 avss 0.11579f
C2679 avdd.n1520 avss 0.0827f
C2680 avdd.n1522 avss 0.11579f
C2681 avdd.n1525 avss 0.13439f
C2682 avdd.t158 avss 0.0827f
C2683 avdd.n1528 avss 0.33288f
C2684 avdd.n1529 avss 0.13439f
C2685 avdd.n1530 avss 0.36183f
C2686 avdd.n1532 avss 0.13439f
C2687 avdd.t159 avss 0.0827f
C2688 avdd.n1535 avss 0.36183f
C2689 avdd.n1536 avss 0.13439f
C2690 avdd.n1537 avss 0.2497f
C2691 avdd.n1538 avss 0.0221f
C2692 avdd.n1539 avss 0.00827f
C2693 avdd.n1540 avss 0.00827f
C2694 avdd.n1541 avss 0.00595f
C2695 avdd.n1542 avss 0.1594f
C2696 avdd.n1543 avss 0.09263f
C2697 avdd.n1544 avss 0.00595f
C2698 avdd.n1545 avss 0.00827f
C2699 avdd.n1546 avss 0.00827f
C2700 avdd.n1547 avss 0.00827f
C2701 avdd.n1548 avss 0.00595f
C2702 avdd.n1549 avss 0.09263f
C2703 avdd.n1550 avss 0.00595f
C2704 avdd.n1551 avss 0.00827f
C2705 avdd.n1552 avss 0.00827f
C2706 avdd.n1553 avss 0.00827f
C2707 avdd.n1554 avss 0.00595f
C2708 avdd.n1555 avss 0.09263f
C2709 avdd.n1556 avss 0.00595f
C2710 avdd.n1557 avss 0.00827f
C2711 avdd.n1558 avss 0.00827f
C2712 avdd.n1559 avss 0.00827f
C2713 avdd.n1560 avss 0.00595f
C2714 avdd.n1561 avss 0.09263f
C2715 avdd.n1562 avss 0.00595f
C2716 avdd.n1563 avss 0.00827f
C2717 avdd.n1564 avss 0.00827f
C2718 avdd.n1565 avss 0.00827f
C2719 avdd.n1566 avss 0.00595f
C2720 avdd.n1567 avss 0.06947f
C2721 avdd.n1568 avss 0.00595f
C2722 avdd.n1569 avss 0.00827f
C2723 avdd.n1570 avss 0.00827f
C2724 avdd.n1571 avss 0.00827f
C2725 avdd.n1572 avss 0.00595f
C2726 avdd.n1573 avss 0.09263f
C2727 avdd.t150 avss 0.04631f
C2728 avdd.n1574 avss 0.00595f
C2729 avdd.n1575 avss 0.00827f
C2730 avdd.n1576 avss 0.00827f
C2731 avdd.n1577 avss 0.00827f
C2732 avdd.n1578 avss 0.00595f
C2733 avdd.n1579 avss 0.09263f
C2734 avdd.n1580 avss 0.00595f
C2735 avdd.n1581 avss 0.00827f
C2736 avdd.n1582 avss 0.00827f
C2737 avdd.n1583 avss 0.00827f
C2738 avdd.n1584 avss 0.00595f
C2739 avdd.n1585 avss 0.09263f
C2740 avdd.n1586 avss 0.00595f
C2741 avdd.n1587 avss 0.00827f
C2742 avdd.n1588 avss 0.00827f
C2743 avdd.n1589 avss 0.00827f
C2744 avdd.n1590 avss 0.00595f
C2745 avdd.n1591 avss 0.09263f
C2746 avdd.n1592 avss 0.00595f
C2747 avdd.n1593 avss 0.00827f
C2748 avdd.n1594 avss 0.02145f
C2749 avdd.n1595 avss 0.00672f
C2750 avdd.n1596 avss 0.01693f
C2751 avdd.n1597 avss 0.12611f
C2752 avdd.n1598 avss 0.01693f
C2753 avdd.n1599 avss 0.00672f
C2754 avdd.n1601 avss 0.1594f
C2755 avdd.n1602 avss 0.02732f
C2756 avdd.t151 avss 0.06136f
C2757 avdd.n1603 avss 0.15554f
C2758 avdd.n1604 avss 0.02091f
C2759 avdd.n1605 avss 0.00827f
C2760 avdd.n1606 avss 0.00827f
C2761 avdd.n1607 avss 0.00595f
C2762 avdd.n1608 avss 0.09263f
C2763 avdd.n1609 avss 0.00595f
C2764 avdd.n1610 avss 0.00827f
C2765 avdd.n1611 avss 0.00827f
C2766 avdd.n1612 avss 0.00827f
C2767 avdd.n1613 avss 0.00827f
C2768 avdd.n1614 avss 0.00827f
C2769 avdd.n1615 avss 0.00595f
C2770 avdd.n1616 avss 0.09263f
C2771 avdd.n1617 avss 0.00595f
C2772 avdd.n1618 avss 0.00827f
C2773 avdd.n1619 avss 0.00827f
C2774 avdd.n1620 avss 0.00827f
C2775 avdd.n1621 avss 0.00827f
C2776 avdd.n1622 avss 0.00827f
C2777 avdd.n1623 avss 0.00595f
C2778 avdd.n1624 avss 0.09263f
C2779 avdd.n1625 avss 0.00595f
C2780 avdd.n1626 avss 0.00827f
C2781 avdd.n1627 avss 0.00827f
C2782 avdd.n1628 avss 0.00827f
C2783 avdd.n1629 avss 0.00827f
C2784 avdd.n1630 avss 0.00827f
C2785 avdd.n1631 avss 0.00595f
C2786 avdd.n1632 avss 0.09263f
C2787 avdd.n1633 avss 0.00595f
C2788 avdd.n1634 avss 0.00827f
C2789 avdd.n1635 avss 0.00827f
C2790 avdd.n1636 avss 0.00827f
C2791 avdd.n1637 avss 0.00827f
C2792 avdd.n1638 avss 0.00827f
C2793 avdd.n1639 avss 0.00595f
C2794 avdd.n1640 avss 0.06947f
C2795 avdd.n1641 avss 0.00595f
C2796 avdd.n1642 avss 0.00827f
C2797 avdd.n1643 avss 0.00827f
C2798 avdd.n1644 avss 0.00827f
C2799 avdd.n1645 avss 0.00827f
C2800 avdd.n1646 avss 0.00827f
C2801 avdd.n1647 avss 0.00595f
C2802 avdd.n1648 avss 0.09263f
C2803 avdd.n1649 avss 0.00595f
C2804 avdd.n1650 avss 0.00827f
C2805 avdd.n1651 avss 0.00827f
C2806 avdd.n1652 avss 0.00827f
C2807 avdd.n1653 avss 0.00827f
C2808 avdd.n1654 avss 0.00827f
C2809 avdd.n1655 avss 0.00595f
C2810 avdd.n1656 avss 0.09263f
C2811 avdd.n1657 avss 0.00595f
C2812 avdd.n1658 avss 0.00827f
C2813 avdd.n1659 avss 0.00827f
C2814 avdd.n1660 avss 0.00827f
C2815 avdd.n1661 avss 0.00827f
C2816 avdd.n1662 avss 0.00827f
C2817 avdd.n1663 avss 0.00595f
C2818 avdd.n1664 avss 0.09263f
C2819 avdd.n1665 avss 0.00595f
C2820 avdd.n1666 avss 0.00827f
C2821 avdd.n1667 avss 0.00827f
C2822 avdd.n1668 avss 0.00827f
C2823 avdd.n1669 avss 0.00827f
C2824 avdd.n1670 avss 0.00827f
C2825 avdd.n1671 avss 0.00595f
C2826 avdd.n1672 avss 0.09263f
C2827 avdd.n1673 avss 0.00595f
C2828 avdd.n1674 avss 0.00827f
C2829 avdd.n1675 avss 0.00827f
C2830 avdd.n1676 avss 0.00827f
C2831 avdd.n1677 avss 0.03533f
C2832 avdd.n1678 avss 0.02034f
C2833 avdd.n1679 avss 0.00672f
C2834 avdd.n1680 avss 0.01699f
C2835 avdd.n1681 avss 0.16039f
C2836 avdd.t133 avss 0.04631f
C2837 avdd.n1682 avss 0.01699f
C2838 avdd.n1683 avss 0.00672f
C2839 avdd.n1684 avss 0.02034f
C2840 avdd.t134 avss 0.0179f
C2841 avdd.n1685 avss 0.1115f
C2842 avdd.n1686 avss 0.01699f
C2843 avdd.n1687 avss 0.01699f
C2844 avdd.n1689 avss 0.16039f
C2845 avdd.n1690 avss 0.00672f
C2846 avdd.n1691 avss 0.01699f
C2847 avdd.n1692 avss 0.00672f
C2848 avdd.n1693 avss 0.00672f
C2849 avdd.n1694 avss 0.0216f
C2850 avdd.n1695 avss 0.04856f
C2851 avdd.n1696 avss 0.06616f
C2852 avdd.n1697 avss 0.02034f
C2853 avdd.n1698 avss 0.0216f
C2854 avdd.n1699 avss 0.00672f
C2855 avdd.n1700 avss 0.01699f
C2856 avdd.n1701 avss 0.10382f
C2857 avdd.t141 avss 0.04631f
C2858 avdd.n1702 avss 0.10382f
C2859 avdd.n1704 avss 0.16039f
C2860 avdd.n1705 avss 0.10382f
C2861 avdd.n1707 avss 0.16039f
C2862 avdd.n1708 avss 0.1082f
C2863 avdd.n1709 avss 0.09068f
C2864 avdd.n1710 avss 0.02034f
C2865 avdd.n1711 avss 0.0216f
C2866 avdd.n1712 avss 0.00672f
C2867 avdd.n1713 avss 0.01699f
C2868 avdd.n1714 avss 0.10382f
C2869 avdd.n1716 avss 0.01699f
C2870 avdd.n1717 avss 0.00672f
C2871 avdd.n1718 avss 0.02033f
C2872 avdd.n1719 avss 0.02743f
C2873 avdd.n1720 avss 0.02742f
C2874 avdd.n1721 avss 0.02019f
C2875 avdd.n1722 avss 0.00672f
C2876 avdd.n1723 avss 0.01693f
C2877 avdd.n1724 avss 0.12611f
C2878 avdd.n1726 avss 0.01693f
C2879 avdd.n1727 avss 0.00672f
C2880 avdd.n1728 avss 0.02019f
C2881 avdd.n1729 avss 0.13851f
C2882 avdd.n1730 avss 0.03533f
C2883 avdd.n1731 avss 0.02034f
C2884 avdd.n1732 avss 0.01699f
C2885 avdd.n1733 avss 0.16039f
C2886 avdd.t22 avss 0.04631f
C2887 avdd.n1734 avss 0.16039f
C2888 avdd.n1735 avss 0.10382f
C2889 avdd.n1737 avss 0.01699f
C2890 avdd.n1738 avss 0.00672f
C2891 avdd.n1739 avss 0.0216f
C2892 avdd.n1740 avss 0.02034f
C2893 avdd.t71 avss 0.0179f
C2894 avdd.n1741 avss 0.1115f
C2895 avdd.n1742 avss 0.01699f
C2896 avdd.n1743 avss 0.01699f
C2897 avdd.n1745 avss 0.16039f
C2898 avdd.n1746 avss 0.00672f
C2899 avdd.n1747 avss 0.06616f
C2900 avdd.n1748 avss 0.02034f
C2901 avdd.n1749 avss 0.00672f
C2902 avdd.n1750 avss 0.01699f
C2903 avdd.n1751 avss 0.00672f
C2904 avdd.n1752 avss 0.0216f
C2905 avdd.n1753 avss 0.04856f
C2906 avdd.n1754 avss 0.0216f
C2907 avdd.n1755 avss 0.00672f
C2908 avdd.n1756 avss 0.01699f
C2909 avdd.n1757 avss 0.10382f
C2910 avdd.t70 avss 0.04631f
C2911 avdd.n1758 avss 0.10382f
C2912 avdd.n1760 avss 0.16039f
C2913 avdd.n1761 avss 0.1082f
C2914 avdd.n1762 avss 0.09068f
C2915 avdd.n1763 avss 0.02034f
C2916 avdd.n1764 avss 0.00672f
C2917 avdd.n1765 avss 0.01699f
C2918 avdd.n1766 avss 0.10382f
C2919 avdd.n1768 avss 0.01699f
C2920 avdd.n1769 avss 0.00672f
C2921 avdd.n1770 avss 0.00672f
C2922 avdd.n1771 avss 0.02033f
C2923 avdd.n1772 avss 0.13515f
C2924 avdd.n1773 avss 0.25322f
C2925 avdd.n1774 avss 0.03532f
C2926 avdd.n1775 avss 0.00827f
C2927 avdd.n1776 avss 0.00827f
C2928 avdd.n1777 avss 0.00595f
C2929 avdd.n1778 avss 0.1594f
C2930 avdd.n1779 avss 0.09263f
C2931 avdd.n1780 avss 0.00595f
C2932 avdd.n1781 avss 0.00827f
C2933 avdd.n1782 avss 0.00827f
C2934 avdd.n1783 avss 0.00827f
C2935 avdd.n1784 avss 0.00595f
C2936 avdd.t106 avss 0.09263f
C2937 avdd.n1785 avss 0.00595f
C2938 avdd.n1786 avss 0.00827f
C2939 avdd.n1787 avss 0.00827f
C2940 avdd.n1788 avss 0.00827f
C2941 avdd.n1789 avss 0.00595f
C2942 avdd.n1790 avss 0.09263f
C2943 avdd.n1791 avss 0.00595f
C2944 avdd.n1792 avss 0.00827f
C2945 avdd.n1793 avss 0.02732f
C2946 avdd.n1794 avss 0.1594f
C2947 avdd.t107 avss 0.02909f
C2948 avdd.n1795 avss 0.0803f
C2949 avdd.n1796 avss 0.02091f
C2950 avdd.n1797 avss 0.00672f
C2951 avdd.n1798 avss 0.01693f
C2952 avdd.n1799 avss 0.12611f
C2953 avdd.n1801 avss 0.01693f
C2954 avdd.n1802 avss 0.00672f
C2955 avdd.n1803 avss 0.02145f
C2956 avdd.n1804 avss 0.00827f
C2957 avdd.n1805 avss 0.00827f
C2958 avdd.n1806 avss 0.00827f
C2959 avdd.n1807 avss 0.00595f
C2960 avdd.n1808 avss 0.09263f
C2961 avdd.n1809 avss 0.00595f
C2962 avdd.n1810 avss 0.00827f
C2963 avdd.n1811 avss 0.00827f
C2964 avdd.n1812 avss 0.00827f
C2965 avdd.n1813 avss 0.00827f
C2966 avdd.n1814 avss 0.00827f
C2967 avdd.n1815 avss 0.00595f
C2968 avdd.n1816 avss 0.09263f
C2969 avdd.n1817 avss 0.00595f
C2970 avdd.n1818 avss 0.00827f
C2971 avdd.n1819 avss 0.00827f
C2972 avdd.n1820 avss 0.00827f
C2973 avdd.n1821 avss 0.02145f
C2974 avdd.n1822 avss 0.00672f
C2975 avdd.n1823 avss 0.01693f
C2976 avdd.n1824 avss 0.12611f
C2977 avdd.n1826 avss 0.01693f
C2978 avdd.n1827 avss 0.00672f
C2979 avdd.n1828 avss 0.02019f
C2980 avdd.n1829 avss 0.13514f
C2981 avdd.n1830 avss 0.10476f
C2982 avdd.n1831 avss 0.09706f
C2983 avdd.n1832 avss 0.00827f
C2984 avdd.n1833 avss 0.00827f
C2985 avdd.n1834 avss 0.00595f
C2986 avdd.n1835 avss 0.40723f
C2987 avdd.n1836 avss 0.25291f
C2988 avdd.n1837 avss 0.00595f
C2989 avdd.n1838 avss 0.00827f
C2990 avdd.n1839 avss 0.00827f
C2991 avdd.n1840 avss 0.00827f
C2992 avdd.n1841 avss 0.00595f
C2993 avdd.n1842 avss 0.25291f
C2994 avdd.n1843 avss 0.00595f
C2995 avdd.n1844 avss 0.00827f
C2996 avdd.t109 avss 0.34639f
C2997 avdd.n1845 avss 0.08935f
C2998 avdd.n1846 avss 0.40723f
C2999 avdd.n1847 avss 0.08903f
C3000 avdd.n1848 avss 0.02779f
C3001 avdd.n1849 avss 0.00672f
C3002 avdd.n1850 avss 0.03491f
C3003 avdd.n1852 avss 0.32813f
C3004 avdd.n1853 avss 0.03491f
C3005 avdd.n1854 avss 0.00672f
C3006 avdd.n1855 avss 0.01993f
C3007 avdd.n1856 avss 0.00827f
C3008 avdd.n1857 avss 0.00827f
C3009 avdd.n1858 avss 0.00827f
C3010 avdd.n1859 avss 0.00595f
C3011 avdd.t108 avss 0.25291f
C3012 avdd.n1860 avss 0.00595f
C3013 avdd.n1861 avss 0.00827f
C3014 avdd.n1862 avss 0.00827f
C3015 avdd.n1863 avss 0.00827f
C3016 avdd.n1864 avss 0.02779f
C3017 avdd.n1865 avss 0.00672f
C3018 avdd.n1866 avss 0.03491f
C3019 avdd.n1867 avss 0.32813f
C3020 avdd.n1869 avss 0.03491f
C3021 avdd.n1870 avss 0.00672f
C3022 avdd.n1871 avss 0.01921f
C3023 avdd.n1872 avss 0.11366f
C3024 avdd.n1873 avss 0.18885f
C3025 avdd.n1874 avss 0.0391f
C3026 avdd.n1875 avss 1.58791f
C3027 avdd.n1876 avss 0.02564f
C3028 avdd.n1878 avss 1.04444f
C3029 avdd.n1880 avss 2.07544f
C3030 avdd.n1881 avss 2.07544f
C3031 avdd.n1882 avss 0.02564f
C3032 avdd.n1884 avss 0.76211f
C3033 avdd.n1885 avss 0.76211f
C3034 avdd.n1886 avss 0.02564f
C3035 avdd.n1888 avss 0.055f
C3036 avdd.n1889 avss 0.02564f
C3037 avdd.n1891 avss 0.17326f
C3038 avdd.n1892 avss 0.77203f
C3039 avdd.n1893 avss 1.50366f
C3040 avdd.n1894 avss 1.49475f
C3041 avdd.n1895 avss 1.49475f
C3042 avdd.n1896 avss 1.49475f
C3043 avdd.n1897 avss 1.46148f
C3044 avdd.n1898 avss 0.25514f
C3045 avdd.n1899 avss 0.17326f
C3046 avdd.n1900 avss 0.02564f
C3047 avdd.n1902 avss 0.57189f
C3048 avdd.n1903 avss 1.50366f
C3049 avdd.n1905 avss 0.02564f
C3050 avdd.n1907 avss 0.17326f
C3051 avdd.n1908 avss 0.56528f
C3052 avdd.n1909 avss 0.76211f
C3053 avdd.n1910 avss 0.02564f
C3054 avdd.n1911 avss 0.0221f
C3055 avdd.n1912 avss 0.00827f
C3056 avdd.n1913 avss 0.00827f
C3057 avdd.n1914 avss 0.00595f
C3058 avdd.n1915 avss 0.1462f
C3059 avdd.n1916 avss 0.09263f
C3060 avdd.n1917 avss 0.00595f
C3061 avdd.n1918 avss 0.00827f
C3062 avdd.n1919 avss 0.00827f
C3063 avdd.n1920 avss 0.00827f
C3064 avdd.n1921 avss 0.00595f
C3065 avdd.n1922 avss 0.06947f
C3066 avdd.n1923 avss 0.00595f
C3067 avdd.n1924 avss 0.00827f
C3068 avdd.n1925 avss 0.00827f
C3069 avdd.n1926 avss 0.00827f
C3070 avdd.n1927 avss 0.00595f
C3071 avdd.n1928 avss 0.09263f
C3072 avdd.n1929 avss 0.00595f
C3073 avdd.n1930 avss 0.00827f
C3074 avdd.n1931 avss 0.0195f
C3075 avdd.n1932 avss 0.00672f
C3076 avdd.n1933 avss 0.01624f
C3077 avdd.n1934 avss 0.11457f
C3078 avdd.n1935 avss 0.01624f
C3079 avdd.n1936 avss 0.00672f
C3080 avdd.n1938 avss 0.1462f
C3081 avdd.n1939 avss 0.04832f
C3082 avdd.n1940 avss 0.0195f
C3083 avdd.n1941 avss 0.00827f
C3084 avdd.n1942 avss 0.00827f
C3085 avdd.n1943 avss 0.00595f
C3086 avdd.n1944 avss 0.09263f
C3087 avdd.n1945 avss 0.00595f
C3088 avdd.n1946 avss 0.00827f
C3089 avdd.n1947 avss 0.00827f
C3090 avdd.n1948 avss 0.00827f
C3091 avdd.n1949 avss 0.00827f
C3092 avdd.n1950 avss 0.00827f
C3093 avdd.n1951 avss 0.00595f
C3094 avdd.t132 avss 0.04631f
C3095 avdd.n1952 avss 0.06947f
C3096 avdd.n1953 avss 0.00595f
C3097 avdd.n1954 avss 0.00827f
C3098 avdd.n1955 avss 0.00827f
C3099 avdd.n1956 avss 0.00827f
C3100 avdd.n1957 avss 0.00827f
C3101 avdd.n1958 avss 0.00827f
C3102 avdd.n1959 avss 0.00595f
C3103 avdd.n1960 avss 0.09263f
C3104 avdd.n1961 avss 0.00595f
C3105 avdd.n1962 avss 0.00827f
C3106 avdd.n1963 avss 0.00827f
C3107 avdd.n1964 avss 0.00827f
C3108 avdd.n1965 avss 0.03521f
C3109 avdd.n1966 avss 0.00827f
C3110 avdd.n1967 avss 0.00827f
C3111 avdd.n1968 avss 0.00595f
C3112 avdd.n1969 avss 0.1462f
C3113 avdd.n1970 avss 0.09263f
C3114 avdd.n1971 avss 0.00595f
C3115 avdd.n1972 avss 0.00827f
C3116 avdd.n1973 avss 0.00827f
C3117 avdd.n1974 avss 0.00827f
C3118 avdd.n1975 avss 0.00595f
C3119 avdd.n1976 avss 0.06947f
C3120 avdd.n1977 avss 0.00595f
C3121 avdd.n1978 avss 0.00827f
C3122 avdd.n1979 avss 0.00827f
C3123 avdd.n1980 avss 0.00827f
C3124 avdd.n1981 avss 0.00595f
C3125 avdd.n1982 avss 0.09263f
C3126 avdd.n1983 avss 0.00595f
C3127 avdd.n1984 avss 0.00827f
C3128 avdd.n1985 avss 0.0195f
C3129 avdd.n1986 avss 0.00672f
C3130 avdd.n1987 avss 0.01624f
C3131 avdd.n1988 avss 0.11457f
C3132 avdd.n1989 avss 0.01624f
C3133 avdd.n1990 avss 0.00672f
C3134 avdd.n1992 avss 0.1462f
C3135 avdd.n1993 avss 0.04832f
C3136 avdd.n1994 avss 0.0195f
C3137 avdd.n1995 avss 0.00827f
C3138 avdd.n1996 avss 0.00827f
C3139 avdd.n1997 avss 0.00595f
C3140 avdd.n1998 avss 0.09263f
C3141 avdd.n1999 avss 0.00595f
C3142 avdd.n2000 avss 0.00827f
C3143 avdd.n2001 avss 0.00827f
C3144 avdd.n2002 avss 0.00827f
C3145 avdd.n2003 avss 0.00827f
C3146 avdd.n2004 avss 0.00827f
C3147 avdd.n2005 avss 0.00595f
C3148 avdd.t10 avss 0.04631f
C3149 avdd.n2006 avss 0.06947f
C3150 avdd.n2007 avss 0.00595f
C3151 avdd.n2008 avss 0.00827f
C3152 avdd.n2009 avss 0.00827f
C3153 avdd.n2010 avss 0.00827f
C3154 avdd.n2011 avss 0.00827f
C3155 avdd.n2012 avss 0.00827f
C3156 avdd.n2013 avss 0.00595f
C3157 avdd.n2014 avss 0.09263f
C3158 avdd.n2015 avss 0.00595f
C3159 avdd.n2016 avss 0.00827f
C3160 avdd.n2017 avss 0.00827f
C3161 avdd.n2018 avss 0.00827f
C3162 avdd.n2019 avss 0.0195f
C3163 avdd.n2020 avss 0.00672f
C3164 avdd.n2021 avss 0.01624f
C3165 avdd.n2022 avss 0.11457f
C3166 avdd.n2024 avss 0.01624f
C3167 avdd.n2025 avss 0.00672f
C3168 avdd.n2026 avss 0.01823f
C3169 avdd.n2027 avss 0.03206f
C3170 avdd.n2028 avss 0.03206f
C3171 avdd.n2029 avss 0.01823f
C3172 avdd.n2030 avss 0.00672f
C3173 avdd.n2031 avss 0.01624f
C3174 avdd.n2032 avss 0.11457f
C3175 avdd.n2034 avss 0.01624f
C3176 avdd.n2035 avss 0.00672f
C3177 avdd.n2036 avss 0.01823f
C3178 avdd.n2037 avss 0.10924f
C3179 avdd.n2038 avss 0.62573f
C3180 avdd.n2039 avss 0.09387f
C3181 avdd.n2041 avss 0.76211f
C3182 avdd.n2042 avss 1.12435f
C3183 avdd.n2043 avss 2.07544f
C3184 avdd.n2044 avss 0.02564f
C3185 avdd.n2045 avss 0.0221f
C3186 avdd.n2046 avss 0.00827f
C3187 avdd.n2047 avss 0.00827f
C3188 avdd.n2048 avss 0.00595f
C3189 avdd.n2049 avss 0.1462f
C3190 avdd.n2050 avss 0.09263f
C3191 avdd.n2051 avss 0.00595f
C3192 avdd.n2052 avss 0.00827f
C3193 avdd.n2053 avss 0.00827f
C3194 avdd.n2054 avss 0.00827f
C3195 avdd.n2055 avss 0.00595f
C3196 avdd.n2056 avss 0.06947f
C3197 avdd.n2057 avss 0.00595f
C3198 avdd.n2058 avss 0.00827f
C3199 avdd.n2059 avss 0.00827f
C3200 avdd.n2060 avss 0.00827f
C3201 avdd.n2061 avss 0.00595f
C3202 avdd.n2062 avss 0.09263f
C3203 avdd.n2063 avss 0.00595f
C3204 avdd.n2064 avss 0.00827f
C3205 avdd.n2065 avss 0.0195f
C3206 avdd.n2066 avss 0.00672f
C3207 avdd.n2067 avss 0.01624f
C3208 avdd.n2068 avss 0.11457f
C3209 avdd.n2069 avss 0.01624f
C3210 avdd.n2070 avss 0.00672f
C3211 avdd.n2072 avss 0.1462f
C3212 avdd.n2073 avss 0.04832f
C3213 avdd.n2074 avss 0.0195f
C3214 avdd.n2075 avss 0.00827f
C3215 avdd.n2076 avss 0.00827f
C3216 avdd.n2077 avss 0.00595f
C3217 avdd.n2078 avss 0.09263f
C3218 avdd.n2079 avss 0.00595f
C3219 avdd.n2080 avss 0.00827f
C3220 avdd.n2081 avss 0.00827f
C3221 avdd.n2082 avss 0.00827f
C3222 avdd.n2083 avss 0.00827f
C3223 avdd.n2084 avss 0.00827f
C3224 avdd.n2085 avss 0.00595f
C3225 avdd.t135 avss 0.04631f
C3226 avdd.n2086 avss 0.06947f
C3227 avdd.n2087 avss 0.00595f
C3228 avdd.n2088 avss 0.00827f
C3229 avdd.n2089 avss 0.00827f
C3230 avdd.n2090 avss 0.00827f
C3231 avdd.n2091 avss 0.00827f
C3232 avdd.n2092 avss 0.00827f
C3233 avdd.n2093 avss 0.00595f
C3234 avdd.n2094 avss 0.09263f
C3235 avdd.n2095 avss 0.00595f
C3236 avdd.n2096 avss 0.00827f
C3237 avdd.n2097 avss 0.00827f
C3238 avdd.n2098 avss 0.00827f
C3239 avdd.n2099 avss 0.03521f
C3240 avdd.n2100 avss 0.00827f
C3241 avdd.n2101 avss 0.00827f
C3242 avdd.n2102 avss 0.00595f
C3243 avdd.n2103 avss 0.1462f
C3244 avdd.n2104 avss 0.09263f
C3245 avdd.n2105 avss 0.00595f
C3246 avdd.n2106 avss 0.00827f
C3247 avdd.n2107 avss 0.00827f
C3248 avdd.n2108 avss 0.00827f
C3249 avdd.n2109 avss 0.00595f
C3250 avdd.n2110 avss 0.06947f
C3251 avdd.n2111 avss 0.00595f
C3252 avdd.n2112 avss 0.00827f
C3253 avdd.n2113 avss 0.00827f
C3254 avdd.n2114 avss 0.00827f
C3255 avdd.n2115 avss 0.00595f
C3256 avdd.n2116 avss 0.09263f
C3257 avdd.n2117 avss 0.00595f
C3258 avdd.n2118 avss 0.00827f
C3259 avdd.n2119 avss 0.0195f
C3260 avdd.n2120 avss 0.00672f
C3261 avdd.n2121 avss 0.01624f
C3262 avdd.n2122 avss 0.11457f
C3263 avdd.n2123 avss 0.01624f
C3264 avdd.n2124 avss 0.00672f
C3265 avdd.n2126 avss 0.1462f
C3266 avdd.n2127 avss 0.04832f
C3267 avdd.n2128 avss 0.0195f
C3268 avdd.n2129 avss 0.00827f
C3269 avdd.n2130 avss 0.00827f
C3270 avdd.n2131 avss 0.00595f
C3271 avdd.n2132 avss 0.09263f
C3272 avdd.n2133 avss 0.00595f
C3273 avdd.n2134 avss 0.00827f
C3274 avdd.n2135 avss 0.00827f
C3275 avdd.n2136 avss 0.00827f
C3276 avdd.n2137 avss 0.00827f
C3277 avdd.n2138 avss 0.00827f
C3278 avdd.n2139 avss 0.00595f
C3279 avdd.t43 avss 0.04631f
C3280 avdd.n2140 avss 0.06947f
C3281 avdd.n2141 avss 0.00595f
C3282 avdd.n2142 avss 0.00827f
C3283 avdd.n2143 avss 0.00827f
C3284 avdd.n2144 avss 0.00827f
C3285 avdd.n2145 avss 0.00827f
C3286 avdd.n2146 avss 0.00827f
C3287 avdd.n2147 avss 0.00595f
C3288 avdd.n2148 avss 0.09263f
C3289 avdd.n2149 avss 0.00595f
C3290 avdd.n2150 avss 0.00827f
C3291 avdd.n2151 avss 0.00827f
C3292 avdd.n2152 avss 0.00827f
C3293 avdd.n2153 avss 0.0195f
C3294 avdd.n2154 avss 0.00672f
C3295 avdd.n2155 avss 0.01624f
C3296 avdd.n2156 avss 0.11457f
C3297 avdd.n2158 avss 0.01624f
C3298 avdd.n2159 avss 0.00672f
C3299 avdd.n2160 avss 0.01823f
C3300 avdd.n2161 avss 0.03206f
C3301 avdd.n2162 avss 0.03206f
C3302 avdd.n2163 avss 0.01823f
C3303 avdd.n2164 avss 0.00672f
C3304 avdd.n2165 avss 0.01624f
C3305 avdd.n2166 avss 0.11457f
C3306 avdd.n2168 avss 0.01624f
C3307 avdd.n2169 avss 0.00672f
C3308 avdd.n2170 avss 0.01823f
C3309 avdd.n2171 avss 0.10924f
C3310 avdd.n2172 avss 0.62573f
C3311 avdd.n2174 avss 0.09387f
C3312 avdd.n2175 avss 0.02564f
C3313 avdd.n2177 avss 2.07544f
C3314 avdd.n2178 avss 1.04444f
C3315 avdd.n2180 avss 0.0827f
C3316 avdd.n2182 avss 0.11579f
C3317 avdd.n2183 avss 0.11579f
C3318 avdd.n2184 avss 0.0827f
C3319 avdd.n2186 avss 0.11579f
C3320 avdd.n2189 avss 0.0827f
C3321 avdd.n2191 avss 0.11579f
C3322 avdd.n2192 avss 0.11579f
C3323 avdd.n2193 avss 0.0827f
C3324 avdd.n2195 avss 0.11579f
C3325 avdd.n2198 avss 0.13439f
C3326 avdd.t154 avss 0.0827f
C3327 avdd.n2201 avss 0.33288f
C3328 avdd.n2202 avss 0.13439f
C3329 avdd.n2203 avss 0.36183f
C3330 avdd.n2205 avss 0.13439f
C3331 avdd.t155 avss 0.0827f
C3332 avdd.n2208 avss 0.36183f
C3333 avdd.n2209 avss 0.13439f
C3334 avdd.n2210 avss 0.2497f
C3335 avdd.n2211 avss 0.0221f
C3336 avdd.n2212 avss 0.00827f
C3337 avdd.n2213 avss 0.00827f
C3338 avdd.n2214 avss 0.00595f
C3339 avdd.n2215 avss 0.1594f
C3340 avdd.n2216 avss 0.09263f
C3341 avdd.n2217 avss 0.00595f
C3342 avdd.n2218 avss 0.00827f
C3343 avdd.n2219 avss 0.00827f
C3344 avdd.n2220 avss 0.00827f
C3345 avdd.n2221 avss 0.00595f
C3346 avdd.n2222 avss 0.09263f
C3347 avdd.n2223 avss 0.00595f
C3348 avdd.n2224 avss 0.00827f
C3349 avdd.n2225 avss 0.00827f
C3350 avdd.n2226 avss 0.00827f
C3351 avdd.n2227 avss 0.00595f
C3352 avdd.n2228 avss 0.09263f
C3353 avdd.n2229 avss 0.00595f
C3354 avdd.n2230 avss 0.00827f
C3355 avdd.n2231 avss 0.00827f
C3356 avdd.n2232 avss 0.00827f
C3357 avdd.n2233 avss 0.00595f
C3358 avdd.n2234 avss 0.09263f
C3359 avdd.n2235 avss 0.00595f
C3360 avdd.n2236 avss 0.00827f
C3361 avdd.n2237 avss 0.00827f
C3362 avdd.n2238 avss 0.00827f
C3363 avdd.n2239 avss 0.00595f
C3364 avdd.n2240 avss 0.06947f
C3365 avdd.n2241 avss 0.00595f
C3366 avdd.n2242 avss 0.00827f
C3367 avdd.n2243 avss 0.00827f
C3368 avdd.n2244 avss 0.00827f
C3369 avdd.n2245 avss 0.00595f
C3370 avdd.n2246 avss 0.09263f
C3371 avdd.t50 avss 0.04631f
C3372 avdd.n2247 avss 0.00595f
C3373 avdd.n2248 avss 0.00827f
C3374 avdd.n2249 avss 0.00827f
C3375 avdd.n2250 avss 0.00827f
C3376 avdd.n2251 avss 0.00595f
C3377 avdd.n2252 avss 0.09263f
C3378 avdd.n2253 avss 0.00595f
C3379 avdd.n2254 avss 0.00827f
C3380 avdd.n2255 avss 0.00827f
C3381 avdd.n2256 avss 0.00827f
C3382 avdd.n2257 avss 0.00595f
C3383 avdd.n2258 avss 0.09263f
C3384 avdd.n2259 avss 0.00595f
C3385 avdd.n2260 avss 0.00827f
C3386 avdd.n2261 avss 0.00827f
C3387 avdd.n2262 avss 0.00827f
C3388 avdd.n2263 avss 0.00595f
C3389 avdd.n2264 avss 0.09263f
C3390 avdd.n2265 avss 0.00595f
C3391 avdd.n2266 avss 0.00827f
C3392 avdd.n2267 avss 0.02145f
C3393 avdd.n2268 avss 0.00672f
C3394 avdd.n2269 avss 0.01693f
C3395 avdd.n2270 avss 0.12611f
C3396 avdd.n2271 avss 0.01693f
C3397 avdd.n2272 avss 0.00672f
C3398 avdd.n2274 avss 0.1594f
C3399 avdd.n2275 avss 0.02732f
C3400 avdd.t51 avss 0.06136f
C3401 avdd.n2276 avss 0.15554f
C3402 avdd.n2277 avss 0.02091f
C3403 avdd.n2278 avss 0.00827f
C3404 avdd.n2279 avss 0.00827f
C3405 avdd.n2280 avss 0.00595f
C3406 avdd.n2281 avss 0.09263f
C3407 avdd.n2282 avss 0.00595f
C3408 avdd.n2283 avss 0.00827f
C3409 avdd.n2284 avss 0.00827f
C3410 avdd.n2285 avss 0.00827f
C3411 avdd.n2286 avss 0.00827f
C3412 avdd.n2287 avss 0.00827f
C3413 avdd.n2288 avss 0.00595f
C3414 avdd.n2289 avss 0.09263f
C3415 avdd.n2290 avss 0.00595f
C3416 avdd.n2291 avss 0.00827f
C3417 avdd.n2292 avss 0.00827f
C3418 avdd.n2293 avss 0.00827f
C3419 avdd.n2294 avss 0.00827f
C3420 avdd.n2295 avss 0.00827f
C3421 avdd.n2296 avss 0.00595f
C3422 avdd.n2297 avss 0.09263f
C3423 avdd.n2298 avss 0.00595f
C3424 avdd.n2299 avss 0.00827f
C3425 avdd.n2300 avss 0.00827f
C3426 avdd.n2301 avss 0.00827f
C3427 avdd.n2302 avss 0.00827f
C3428 avdd.n2303 avss 0.00827f
C3429 avdd.n2304 avss 0.00595f
C3430 avdd.n2305 avss 0.09263f
C3431 avdd.n2306 avss 0.00595f
C3432 avdd.n2307 avss 0.00827f
C3433 avdd.n2308 avss 0.00827f
C3434 avdd.n2309 avss 0.00827f
C3435 avdd.n2310 avss 0.00827f
C3436 avdd.n2311 avss 0.00827f
C3437 avdd.n2312 avss 0.00595f
C3438 avdd.n2313 avss 0.06947f
C3439 avdd.n2314 avss 0.00595f
C3440 avdd.n2315 avss 0.00827f
C3441 avdd.n2316 avss 0.00827f
C3442 avdd.n2317 avss 0.00827f
C3443 avdd.n2318 avss 0.00827f
C3444 avdd.n2319 avss 0.00827f
C3445 avdd.n2320 avss 0.00595f
C3446 avdd.n2321 avss 0.09263f
C3447 avdd.n2322 avss 0.00595f
C3448 avdd.n2323 avss 0.00827f
C3449 avdd.n2324 avss 0.00827f
C3450 avdd.n2325 avss 0.00827f
C3451 avdd.n2326 avss 0.00827f
C3452 avdd.n2327 avss 0.00827f
C3453 avdd.n2328 avss 0.00595f
C3454 avdd.n2329 avss 0.09263f
C3455 avdd.n2330 avss 0.00595f
C3456 avdd.n2331 avss 0.00827f
C3457 avdd.n2332 avss 0.00827f
C3458 avdd.n2333 avss 0.00827f
C3459 avdd.n2334 avss 0.00827f
C3460 avdd.n2335 avss 0.00827f
C3461 avdd.n2336 avss 0.00595f
C3462 avdd.n2337 avss 0.09263f
C3463 avdd.n2338 avss 0.00595f
C3464 avdd.n2339 avss 0.00827f
C3465 avdd.n2340 avss 0.00827f
C3466 avdd.n2341 avss 0.00827f
C3467 avdd.n2342 avss 0.00827f
C3468 avdd.n2343 avss 0.00827f
C3469 avdd.n2344 avss 0.00595f
C3470 avdd.n2345 avss 0.09263f
C3471 avdd.n2346 avss 0.00595f
C3472 avdd.n2347 avss 0.00827f
C3473 avdd.n2348 avss 0.00827f
C3474 avdd.n2349 avss 0.00827f
C3475 avdd.n2350 avss 0.03533f
C3476 avdd.n2351 avss 0.02034f
C3477 avdd.n2352 avss 0.00672f
C3478 avdd.n2353 avss 0.01699f
C3479 avdd.n2354 avss 0.16039f
C3480 avdd.t152 avss 0.04631f
C3481 avdd.n2355 avss 0.01699f
C3482 avdd.n2356 avss 0.00672f
C3483 avdd.n2357 avss 0.02034f
C3484 avdd.t153 avss 0.0179f
C3485 avdd.n2358 avss 0.1115f
C3486 avdd.n2359 avss 0.01699f
C3487 avdd.n2360 avss 0.01699f
C3488 avdd.n2362 avss 0.16039f
C3489 avdd.n2363 avss 0.00672f
C3490 avdd.n2364 avss 0.01699f
C3491 avdd.n2365 avss 0.00672f
C3492 avdd.n2366 avss 0.00672f
C3493 avdd.n2367 avss 0.0216f
C3494 avdd.n2368 avss 0.04856f
C3495 avdd.n2369 avss 0.06616f
C3496 avdd.n2370 avss 0.02034f
C3497 avdd.n2371 avss 0.0216f
C3498 avdd.n2372 avss 0.00672f
C3499 avdd.n2373 avss 0.01699f
C3500 avdd.n2374 avss 0.10382f
C3501 avdd.t143 avss 0.04631f
C3502 avdd.n2375 avss 0.10382f
C3503 avdd.n2377 avss 0.16039f
C3504 avdd.n2378 avss 0.10382f
C3505 avdd.n2380 avss 0.16039f
C3506 avdd.n2381 avss 0.1082f
C3507 avdd.n2382 avss 0.09068f
C3508 avdd.n2383 avss 0.02034f
C3509 avdd.n2384 avss 0.0216f
C3510 avdd.n2385 avss 0.00672f
C3511 avdd.n2386 avss 0.01699f
C3512 avdd.n2387 avss 0.10382f
C3513 avdd.n2389 avss 0.01699f
C3514 avdd.n2390 avss 0.00672f
C3515 avdd.n2391 avss 0.02033f
C3516 avdd.n2392 avss 0.02743f
C3517 avdd.n2393 avss 0.02742f
C3518 avdd.n2394 avss 0.02019f
C3519 avdd.n2395 avss 0.00672f
C3520 avdd.n2396 avss 0.01693f
C3521 avdd.n2397 avss 0.12611f
C3522 avdd.n2399 avss 0.01693f
C3523 avdd.n2400 avss 0.00672f
C3524 avdd.n2401 avss 0.02019f
C3525 avdd.n2402 avss 0.13851f
C3526 avdd.n2403 avss 0.03533f
C3527 avdd.n2404 avss 0.02034f
C3528 avdd.n2405 avss 0.01699f
C3529 avdd.n2406 avss 0.16039f
C3530 avdd.t34 avss 0.04631f
C3531 avdd.n2407 avss 0.16039f
C3532 avdd.n2408 avss 0.10382f
C3533 avdd.n2410 avss 0.01699f
C3534 avdd.n2411 avss 0.00672f
C3535 avdd.n2412 avss 0.0216f
C3536 avdd.n2413 avss 0.02034f
C3537 avdd.t9 avss 0.0179f
C3538 avdd.n2414 avss 0.1115f
C3539 avdd.n2415 avss 0.01699f
C3540 avdd.n2416 avss 0.01699f
C3541 avdd.n2418 avss 0.16039f
C3542 avdd.n2419 avss 0.00672f
C3543 avdd.n2420 avss 0.06616f
C3544 avdd.n2421 avss 0.02034f
C3545 avdd.n2422 avss 0.00672f
C3546 avdd.n2423 avss 0.01699f
C3547 avdd.n2424 avss 0.00672f
C3548 avdd.n2425 avss 0.0216f
C3549 avdd.n2426 avss 0.04856f
C3550 avdd.n2427 avss 0.0216f
C3551 avdd.n2428 avss 0.00672f
C3552 avdd.n2429 avss 0.01699f
C3553 avdd.n2430 avss 0.10382f
C3554 avdd.t8 avss 0.04631f
C3555 avdd.n2431 avss 0.10382f
C3556 avdd.n2433 avss 0.16039f
C3557 avdd.n2434 avss 0.1082f
C3558 avdd.n2435 avss 0.09068f
C3559 avdd.n2436 avss 0.02034f
C3560 avdd.n2437 avss 0.00672f
C3561 avdd.n2438 avss 0.01699f
C3562 avdd.n2439 avss 0.10382f
C3563 avdd.n2441 avss 0.01699f
C3564 avdd.n2442 avss 0.00672f
C3565 avdd.n2443 avss 0.00672f
C3566 avdd.n2444 avss 0.02033f
C3567 avdd.n2445 avss 0.13515f
C3568 avdd.n2446 avss 0.25322f
C3569 avdd.n2447 avss 0.03532f
C3570 avdd.n2448 avss 0.00827f
C3571 avdd.n2449 avss 0.00827f
C3572 avdd.n2450 avss 0.00595f
C3573 avdd.n2451 avss 0.1594f
C3574 avdd.n2452 avss 0.09263f
C3575 avdd.n2453 avss 0.00595f
C3576 avdd.n2454 avss 0.00827f
C3577 avdd.n2455 avss 0.00827f
C3578 avdd.n2456 avss 0.00827f
C3579 avdd.n2457 avss 0.00595f
C3580 avdd.t124 avss 0.09263f
C3581 avdd.n2458 avss 0.00595f
C3582 avdd.n2459 avss 0.00827f
C3583 avdd.n2460 avss 0.00827f
C3584 avdd.n2461 avss 0.00827f
C3585 avdd.n2462 avss 0.00595f
C3586 avdd.n2463 avss 0.09263f
C3587 avdd.n2464 avss 0.00595f
C3588 avdd.n2465 avss 0.00827f
C3589 avdd.n2466 avss 0.02732f
C3590 avdd.n2467 avss 0.1594f
C3591 avdd.t125 avss 0.02909f
C3592 avdd.n2468 avss 0.0803f
C3593 avdd.n2469 avss 0.02091f
C3594 avdd.n2470 avss 0.00672f
C3595 avdd.n2471 avss 0.01693f
C3596 avdd.n2472 avss 0.12611f
C3597 avdd.n2474 avss 0.01693f
C3598 avdd.n2475 avss 0.00672f
C3599 avdd.n2476 avss 0.02145f
C3600 avdd.n2477 avss 0.00827f
C3601 avdd.n2478 avss 0.00827f
C3602 avdd.n2479 avss 0.00827f
C3603 avdd.n2480 avss 0.00595f
C3604 avdd.n2481 avss 0.09263f
C3605 avdd.n2482 avss 0.00595f
C3606 avdd.n2483 avss 0.00827f
C3607 avdd.n2484 avss 0.00827f
C3608 avdd.n2485 avss 0.00827f
C3609 avdd.n2486 avss 0.00827f
C3610 avdd.n2487 avss 0.00827f
C3611 avdd.n2488 avss 0.00595f
C3612 avdd.n2489 avss 0.09263f
C3613 avdd.n2490 avss 0.00595f
C3614 avdd.n2491 avss 0.00827f
C3615 avdd.n2492 avss 0.00827f
C3616 avdd.n2493 avss 0.00827f
C3617 avdd.n2494 avss 0.02145f
C3618 avdd.n2495 avss 0.00672f
C3619 avdd.n2496 avss 0.01693f
C3620 avdd.n2497 avss 0.12611f
C3621 avdd.n2499 avss 0.01693f
C3622 avdd.n2500 avss 0.00672f
C3623 avdd.n2501 avss 0.02019f
C3624 avdd.n2502 avss 0.13514f
C3625 avdd.n2503 avss 0.10476f
C3626 avdd.n2504 avss 0.09706f
C3627 avdd.n2505 avss 0.00827f
C3628 avdd.n2506 avss 0.00827f
C3629 avdd.n2507 avss 0.00595f
C3630 avdd.n2508 avss 0.40723f
C3631 avdd.n2509 avss 0.25291f
C3632 avdd.n2510 avss 0.00595f
C3633 avdd.n2511 avss 0.00827f
C3634 avdd.n2512 avss 0.00827f
C3635 avdd.n2513 avss 0.00827f
C3636 avdd.n2514 avss 0.00595f
C3637 avdd.n2515 avss 0.25291f
C3638 avdd.n2516 avss 0.00595f
C3639 avdd.n2517 avss 0.00827f
C3640 avdd.t117 avss 0.34639f
C3641 avdd.n2518 avss 0.08935f
C3642 avdd.n2519 avss 0.40723f
C3643 avdd.n2520 avss 0.08903f
C3644 avdd.n2521 avss 0.02779f
C3645 avdd.n2522 avss 0.00672f
C3646 avdd.n2523 avss 0.03491f
C3647 avdd.n2525 avss 0.32813f
C3648 avdd.n2526 avss 0.03491f
C3649 avdd.n2527 avss 0.00672f
C3650 avdd.n2528 avss 0.01993f
C3651 avdd.n2529 avss 0.00827f
C3652 avdd.n2530 avss 0.00827f
C3653 avdd.n2531 avss 0.00827f
C3654 avdd.n2532 avss 0.00595f
C3655 avdd.t116 avss 0.25291f
C3656 avdd.n2533 avss 0.00595f
C3657 avdd.n2534 avss 0.00827f
C3658 avdd.n2535 avss 0.00827f
C3659 avdd.n2536 avss 0.00827f
C3660 avdd.n2537 avss 0.02779f
C3661 avdd.n2538 avss 0.00672f
C3662 avdd.n2539 avss 0.03491f
C3663 avdd.n2540 avss 0.32813f
C3664 avdd.n2542 avss 0.03491f
C3665 avdd.n2543 avss 0.00672f
C3666 avdd.n2544 avss 0.01921f
C3667 avdd.n2545 avss 0.11366f
C3668 avdd.n2546 avss 0.18885f
C3669 avdd.n2547 avss 0.0391f
C3670 avdd.n2548 avss 1.58791f
C3671 avdd.n2549 avss 0.09273f
C3672 avdd.n2551 avss 2.07544f
C3673 avdd.n2552 avss 1.04444f
C3674 avdd.n2553 avss 2.07544f
C3675 avdd.n2554 avss 2.07544f
C3676 avdd.n2556 avss 0.02564f
C3677 avdd.n2558 avss 1.04444f
C3678 avdd.n2560 avss 0.0827f
C3679 avdd.n2562 avss 0.11579f
C3680 avdd.n2563 avss 0.11579f
C3681 avdd.n2564 avss 0.0827f
C3682 avdd.n2566 avss 0.11579f
C3683 avdd.n2569 avss 0.0827f
C3684 avdd.n2571 avss 0.11579f
C3685 avdd.n2572 avss 0.11579f
C3686 avdd.n2573 avss 0.0827f
C3687 avdd.n2575 avss 0.11579f
C3688 avdd.n2578 avss 0.13439f
C3689 avdd.t164 avss 0.0827f
C3690 avdd.n2581 avss 0.33288f
C3691 avdd.n2582 avss 0.13439f
C3692 avdd.n2583 avss 0.36183f
C3693 avdd.n2585 avss 0.13439f
C3694 avdd.t165 avss 0.0827f
C3695 avdd.n2588 avss 0.36183f
C3696 avdd.n2589 avss 0.13439f
C3697 avdd.n2590 avss 0.2497f
C3698 avdd.n2591 avss 0.0221f
C3699 avdd.n2592 avss 0.00827f
C3700 avdd.n2593 avss 0.00827f
C3701 avdd.n2594 avss 0.00595f
C3702 avdd.n2595 avss 0.1594f
C3703 avdd.n2596 avss 0.09263f
C3704 avdd.n2597 avss 0.00595f
C3705 avdd.n2598 avss 0.00827f
C3706 avdd.n2599 avss 0.00827f
C3707 avdd.n2600 avss 0.00827f
C3708 avdd.n2601 avss 0.00595f
C3709 avdd.n2602 avss 0.09263f
C3710 avdd.n2603 avss 0.00595f
C3711 avdd.n2604 avss 0.00827f
C3712 avdd.n2605 avss 0.00827f
C3713 avdd.n2606 avss 0.00827f
C3714 avdd.n2607 avss 0.00595f
C3715 avdd.n2608 avss 0.09263f
C3716 avdd.n2609 avss 0.00595f
C3717 avdd.n2610 avss 0.00827f
C3718 avdd.n2611 avss 0.00827f
C3719 avdd.n2612 avss 0.00827f
C3720 avdd.n2613 avss 0.00595f
C3721 avdd.n2614 avss 0.09263f
C3722 avdd.n2615 avss 0.00595f
C3723 avdd.n2616 avss 0.00827f
C3724 avdd.n2617 avss 0.00827f
C3725 avdd.n2618 avss 0.00827f
C3726 avdd.n2619 avss 0.00595f
C3727 avdd.n2620 avss 0.06947f
C3728 avdd.n2621 avss 0.00595f
C3729 avdd.n2622 avss 0.00827f
C3730 avdd.n2623 avss 0.00827f
C3731 avdd.n2624 avss 0.00827f
C3732 avdd.n2625 avss 0.00595f
C3733 avdd.n2626 avss 0.09263f
C3734 avdd.t56 avss 0.04631f
C3735 avdd.n2627 avss 0.00595f
C3736 avdd.n2628 avss 0.00827f
C3737 avdd.n2629 avss 0.00827f
C3738 avdd.n2630 avss 0.00827f
C3739 avdd.n2631 avss 0.00595f
C3740 avdd.n2632 avss 0.09263f
C3741 avdd.n2633 avss 0.00595f
C3742 avdd.n2634 avss 0.00827f
C3743 avdd.n2635 avss 0.00827f
C3744 avdd.n2636 avss 0.00827f
C3745 avdd.n2637 avss 0.00595f
C3746 avdd.n2638 avss 0.09263f
C3747 avdd.n2639 avss 0.00595f
C3748 avdd.n2640 avss 0.00827f
C3749 avdd.n2641 avss 0.00827f
C3750 avdd.n2642 avss 0.00827f
C3751 avdd.n2643 avss 0.00595f
C3752 avdd.n2644 avss 0.09263f
C3753 avdd.n2645 avss 0.00595f
C3754 avdd.n2646 avss 0.00827f
C3755 avdd.n2647 avss 0.02145f
C3756 avdd.n2648 avss 0.00672f
C3757 avdd.n2649 avss 0.01693f
C3758 avdd.n2650 avss 0.12611f
C3759 avdd.n2651 avss 0.01693f
C3760 avdd.n2652 avss 0.00672f
C3761 avdd.n2654 avss 0.1594f
C3762 avdd.n2655 avss 0.02732f
C3763 avdd.t57 avss 0.06136f
C3764 avdd.n2656 avss 0.15554f
C3765 avdd.n2657 avss 0.02091f
C3766 avdd.n2658 avss 0.00827f
C3767 avdd.n2659 avss 0.00827f
C3768 avdd.n2660 avss 0.00595f
C3769 avdd.n2661 avss 0.09263f
C3770 avdd.n2662 avss 0.00595f
C3771 avdd.n2663 avss 0.00827f
C3772 avdd.n2664 avss 0.00827f
C3773 avdd.n2665 avss 0.00827f
C3774 avdd.n2666 avss 0.00827f
C3775 avdd.n2667 avss 0.00827f
C3776 avdd.n2668 avss 0.00595f
C3777 avdd.n2669 avss 0.09263f
C3778 avdd.n2670 avss 0.00595f
C3779 avdd.n2671 avss 0.00827f
C3780 avdd.n2672 avss 0.00827f
C3781 avdd.n2673 avss 0.00827f
C3782 avdd.n2674 avss 0.00827f
C3783 avdd.n2675 avss 0.00827f
C3784 avdd.n2676 avss 0.00595f
C3785 avdd.n2677 avss 0.09263f
C3786 avdd.n2678 avss 0.00595f
C3787 avdd.n2679 avss 0.00827f
C3788 avdd.n2680 avss 0.00827f
C3789 avdd.n2681 avss 0.00827f
C3790 avdd.n2682 avss 0.00827f
C3791 avdd.n2683 avss 0.00827f
C3792 avdd.n2684 avss 0.00595f
C3793 avdd.n2685 avss 0.09263f
C3794 avdd.n2686 avss 0.00595f
C3795 avdd.n2687 avss 0.00827f
C3796 avdd.n2688 avss 0.00827f
C3797 avdd.n2689 avss 0.00827f
C3798 avdd.n2690 avss 0.00827f
C3799 avdd.n2691 avss 0.00827f
C3800 avdd.n2692 avss 0.00595f
C3801 avdd.n2693 avss 0.06947f
C3802 avdd.n2694 avss 0.00595f
C3803 avdd.n2695 avss 0.00827f
C3804 avdd.n2696 avss 0.00827f
C3805 avdd.n2697 avss 0.00827f
C3806 avdd.n2698 avss 0.00827f
C3807 avdd.n2699 avss 0.00827f
C3808 avdd.n2700 avss 0.00595f
C3809 avdd.n2701 avss 0.09263f
C3810 avdd.n2702 avss 0.00595f
C3811 avdd.n2703 avss 0.00827f
C3812 avdd.n2704 avss 0.00827f
C3813 avdd.n2705 avss 0.00827f
C3814 avdd.n2706 avss 0.00827f
C3815 avdd.n2707 avss 0.00827f
C3816 avdd.n2708 avss 0.00595f
C3817 avdd.n2709 avss 0.09263f
C3818 avdd.n2710 avss 0.00595f
C3819 avdd.n2711 avss 0.00827f
C3820 avdd.n2712 avss 0.00827f
C3821 avdd.n2713 avss 0.00827f
C3822 avdd.n2714 avss 0.00827f
C3823 avdd.n2715 avss 0.00827f
C3824 avdd.n2716 avss 0.00595f
C3825 avdd.n2717 avss 0.09263f
C3826 avdd.n2718 avss 0.00595f
C3827 avdd.n2719 avss 0.00827f
C3828 avdd.n2720 avss 0.00827f
C3829 avdd.n2721 avss 0.00827f
C3830 avdd.n2722 avss 0.00827f
C3831 avdd.n2723 avss 0.00827f
C3832 avdd.n2724 avss 0.00595f
C3833 avdd.n2725 avss 0.09263f
C3834 avdd.n2726 avss 0.00595f
C3835 avdd.n2727 avss 0.00827f
C3836 avdd.n2728 avss 0.00827f
C3837 avdd.n2729 avss 0.00827f
C3838 avdd.n2730 avss 0.03533f
C3839 avdd.n2731 avss 0.02034f
C3840 avdd.n2732 avss 0.00672f
C3841 avdd.n2733 avss 0.01699f
C3842 avdd.n2734 avss 0.16039f
C3843 avdd.t74 avss 0.04631f
C3844 avdd.n2735 avss 0.01699f
C3845 avdd.n2736 avss 0.00672f
C3846 avdd.n2737 avss 0.02034f
C3847 avdd.t75 avss 0.0179f
C3848 avdd.n2738 avss 0.1115f
C3849 avdd.n2739 avss 0.01699f
C3850 avdd.n2740 avss 0.01699f
C3851 avdd.n2742 avss 0.16039f
C3852 avdd.n2743 avss 0.00672f
C3853 avdd.n2744 avss 0.01699f
C3854 avdd.n2745 avss 0.00672f
C3855 avdd.n2746 avss 0.00672f
C3856 avdd.n2747 avss 0.0216f
C3857 avdd.n2748 avss 0.04856f
C3858 avdd.n2749 avss 0.06616f
C3859 avdd.n2750 avss 0.02034f
C3860 avdd.n2751 avss 0.0216f
C3861 avdd.n2752 avss 0.00672f
C3862 avdd.n2753 avss 0.01699f
C3863 avdd.n2754 avss 0.10382f
C3864 avdd.t60 avss 0.04631f
C3865 avdd.n2755 avss 0.10382f
C3866 avdd.n2757 avss 0.16039f
C3867 avdd.n2758 avss 0.10382f
C3868 avdd.n2760 avss 0.16039f
C3869 avdd.n2761 avss 0.1082f
C3870 avdd.n2762 avss 0.09068f
C3871 avdd.n2763 avss 0.02034f
C3872 avdd.n2764 avss 0.0216f
C3873 avdd.n2765 avss 0.00672f
C3874 avdd.n2766 avss 0.01699f
C3875 avdd.n2767 avss 0.10382f
C3876 avdd.n2769 avss 0.01699f
C3877 avdd.n2770 avss 0.00672f
C3878 avdd.n2771 avss 0.02033f
C3879 avdd.n2772 avss 0.02743f
C3880 avdd.n2773 avss 0.02742f
C3881 avdd.n2774 avss 0.02019f
C3882 avdd.n2775 avss 0.00672f
C3883 avdd.n2776 avss 0.01693f
C3884 avdd.n2777 avss 0.12611f
C3885 avdd.n2779 avss 0.01693f
C3886 avdd.n2780 avss 0.00672f
C3887 avdd.n2781 avss 0.02019f
C3888 avdd.n2782 avss 0.13851f
C3889 avdd.n2783 avss 0.03533f
C3890 avdd.n2784 avss 0.02034f
C3891 avdd.n2785 avss 0.01699f
C3892 avdd.n2786 avss 0.16039f
C3893 avdd.t13 avss 0.04631f
C3894 avdd.n2787 avss 0.16039f
C3895 avdd.n2788 avss 0.10382f
C3896 avdd.n2790 avss 0.01699f
C3897 avdd.n2791 avss 0.00672f
C3898 avdd.n2792 avss 0.0216f
C3899 avdd.n2793 avss 0.02034f
C3900 avdd.t87 avss 0.0179f
C3901 avdd.n2794 avss 0.1115f
C3902 avdd.n2795 avss 0.01699f
C3903 avdd.n2796 avss 0.01699f
C3904 avdd.n2798 avss 0.16039f
C3905 avdd.n2799 avss 0.00672f
C3906 avdd.n2800 avss 0.06616f
C3907 avdd.n2801 avss 0.02034f
C3908 avdd.n2802 avss 0.00672f
C3909 avdd.n2803 avss 0.01699f
C3910 avdd.n2804 avss 0.00672f
C3911 avdd.n2805 avss 0.0216f
C3912 avdd.n2806 avss 0.04856f
C3913 avdd.n2807 avss 0.0216f
C3914 avdd.n2808 avss 0.00672f
C3915 avdd.n2809 avss 0.01699f
C3916 avdd.n2810 avss 0.10382f
C3917 avdd.t86 avss 0.04631f
C3918 avdd.n2811 avss 0.10382f
C3919 avdd.n2813 avss 0.16039f
C3920 avdd.n2814 avss 0.1082f
C3921 avdd.n2815 avss 0.09068f
C3922 avdd.n2816 avss 0.02034f
C3923 avdd.n2817 avss 0.00672f
C3924 avdd.n2818 avss 0.01699f
C3925 avdd.n2819 avss 0.10382f
C3926 avdd.n2821 avss 0.01699f
C3927 avdd.n2822 avss 0.00672f
C3928 avdd.n2823 avss 0.00672f
C3929 avdd.n2824 avss 0.02033f
C3930 avdd.n2825 avss 0.13515f
C3931 avdd.n2826 avss 0.25322f
C3932 avdd.n2827 avss 0.03532f
C3933 avdd.n2828 avss 0.00827f
C3934 avdd.n2829 avss 0.00827f
C3935 avdd.n2830 avss 0.00595f
C3936 avdd.n2831 avss 0.1594f
C3937 avdd.n2832 avss 0.09263f
C3938 avdd.n2833 avss 0.00595f
C3939 avdd.n2834 avss 0.00827f
C3940 avdd.n2835 avss 0.00827f
C3941 avdd.n2836 avss 0.00827f
C3942 avdd.n2837 avss 0.00595f
C3943 avdd.t104 avss 0.09263f
C3944 avdd.n2838 avss 0.00595f
C3945 avdd.n2839 avss 0.00827f
C3946 avdd.n2840 avss 0.00827f
C3947 avdd.n2841 avss 0.00827f
C3948 avdd.n2842 avss 0.00595f
C3949 avdd.n2843 avss 0.09263f
C3950 avdd.n2844 avss 0.00595f
C3951 avdd.n2845 avss 0.00827f
C3952 avdd.n2846 avss 0.02732f
C3953 avdd.n2847 avss 0.1594f
C3954 avdd.t105 avss 0.02909f
C3955 avdd.n2848 avss 0.0803f
C3956 avdd.n2849 avss 0.02091f
C3957 avdd.n2850 avss 0.00672f
C3958 avdd.n2851 avss 0.01693f
C3959 avdd.n2852 avss 0.12611f
C3960 avdd.n2854 avss 0.01693f
C3961 avdd.n2855 avss 0.00672f
C3962 avdd.n2856 avss 0.02145f
C3963 avdd.n2857 avss 0.00827f
C3964 avdd.n2858 avss 0.00827f
C3965 avdd.n2859 avss 0.00827f
C3966 avdd.n2860 avss 0.00595f
C3967 avdd.n2861 avss 0.09263f
C3968 avdd.n2862 avss 0.00595f
C3969 avdd.n2863 avss 0.00827f
C3970 avdd.n2864 avss 0.00827f
C3971 avdd.n2865 avss 0.00827f
C3972 avdd.n2866 avss 0.00827f
C3973 avdd.n2867 avss 0.00827f
C3974 avdd.n2868 avss 0.00595f
C3975 avdd.n2869 avss 0.09263f
C3976 avdd.n2870 avss 0.00595f
C3977 avdd.n2871 avss 0.00827f
C3978 avdd.n2872 avss 0.00827f
C3979 avdd.n2873 avss 0.00827f
C3980 avdd.n2874 avss 0.02145f
C3981 avdd.n2875 avss 0.00672f
C3982 avdd.n2876 avss 0.01693f
C3983 avdd.n2877 avss 0.12611f
C3984 avdd.n2879 avss 0.01693f
C3985 avdd.n2880 avss 0.00672f
C3986 avdd.n2881 avss 0.02019f
C3987 avdd.n2882 avss 0.13514f
C3988 avdd.n2883 avss 0.10476f
C3989 avdd.n2884 avss 0.09706f
C3990 avdd.n2885 avss 0.00827f
C3991 avdd.n2886 avss 0.00827f
C3992 avdd.n2887 avss 0.00595f
C3993 avdd.n2888 avss 0.40723f
C3994 avdd.n2889 avss 0.25291f
C3995 avdd.n2890 avss 0.00595f
C3996 avdd.n2891 avss 0.00827f
C3997 avdd.n2892 avss 0.00827f
C3998 avdd.n2893 avss 0.00827f
C3999 avdd.n2894 avss 0.00595f
C4000 avdd.n2895 avss 0.25291f
C4001 avdd.n2896 avss 0.00595f
C4002 avdd.n2897 avss 0.00827f
C4003 avdd.t111 avss 0.34639f
C4004 avdd.n2898 avss 0.08935f
C4005 avdd.n2899 avss 0.40723f
C4006 avdd.n2900 avss 0.08903f
C4007 avdd.n2901 avss 0.02779f
C4008 avdd.n2902 avss 0.00672f
C4009 avdd.n2903 avss 0.03491f
C4010 avdd.n2905 avss 0.32813f
C4011 avdd.n2906 avss 0.03491f
C4012 avdd.n2907 avss 0.00672f
C4013 avdd.n2908 avss 0.01993f
C4014 avdd.n2909 avss 0.00827f
C4015 avdd.n2910 avss 0.00827f
C4016 avdd.n2911 avss 0.00827f
C4017 avdd.n2912 avss 0.00595f
C4018 avdd.t110 avss 0.25291f
C4019 avdd.n2913 avss 0.00595f
C4020 avdd.n2914 avss 0.00827f
C4021 avdd.n2915 avss 0.00827f
C4022 avdd.n2916 avss 0.00827f
C4023 avdd.n2917 avss 0.02779f
C4024 avdd.n2918 avss 0.00672f
C4025 avdd.n2919 avss 0.03491f
C4026 avdd.n2920 avss 0.32813f
C4027 avdd.n2922 avss 0.03491f
C4028 avdd.n2923 avss 0.00672f
C4029 avdd.n2924 avss 0.01921f
C4030 avdd.n2925 avss 0.11366f
C4031 avdd.n2926 avss 0.18885f
C4032 avdd.n2927 avss 0.0391f
C4033 avdd.n2928 avss 1.58149f
C4034 avdd.n2929 avss 0.09273f
C4035 avdd.n2930 avss 2.07544f
C4036 avdd.n2931 avss 0.02564f
C4037 avdd.n2933 avss 1.04444f
C4038 avdd.n2935 avss 0.0827f
C4039 avdd.n2937 avss 0.11579f
C4040 avdd.n2938 avss 0.11579f
C4041 avdd.n2939 avss 0.0827f
C4042 avdd.n2941 avss 0.11579f
C4043 avdd.n2944 avss 0.0827f
C4044 avdd.n2946 avss 0.11579f
C4045 avdd.n2947 avss 0.11579f
C4046 avdd.n2948 avss 0.0827f
C4047 avdd.n2950 avss 0.11579f
C4048 avdd.n2953 avss 0.13439f
C4049 avdd.t166 avss 0.0827f
C4050 avdd.n2956 avss 0.33288f
C4051 avdd.n2957 avss 0.13439f
C4052 avdd.n2958 avss 0.36183f
C4053 avdd.n2960 avss 0.13439f
C4054 avdd.t167 avss 0.0827f
C4055 avdd.n2963 avss 0.36183f
C4056 avdd.n2964 avss 0.13439f
C4057 avdd.n2965 avss 0.2497f
C4058 avdd.n2966 avss 0.0221f
C4059 avdd.n2967 avss 0.00827f
C4060 avdd.n2968 avss 0.00827f
C4061 avdd.n2969 avss 0.00595f
C4062 avdd.n2970 avss 0.1594f
C4063 avdd.n2971 avss 0.09263f
C4064 avdd.n2972 avss 0.00595f
C4065 avdd.n2973 avss 0.00827f
C4066 avdd.n2974 avss 0.00827f
C4067 avdd.n2975 avss 0.00827f
C4068 avdd.n2976 avss 0.00595f
C4069 avdd.n2977 avss 0.09263f
C4070 avdd.n2978 avss 0.00595f
C4071 avdd.n2979 avss 0.00827f
C4072 avdd.n2980 avss 0.00827f
C4073 avdd.n2981 avss 0.00827f
C4074 avdd.n2982 avss 0.00595f
C4075 avdd.n2983 avss 0.09263f
C4076 avdd.n2984 avss 0.00595f
C4077 avdd.n2985 avss 0.00827f
C4078 avdd.n2986 avss 0.00827f
C4079 avdd.n2987 avss 0.00827f
C4080 avdd.n2988 avss 0.00595f
C4081 avdd.n2989 avss 0.09263f
C4082 avdd.n2990 avss 0.00595f
C4083 avdd.n2991 avss 0.00827f
C4084 avdd.n2992 avss 0.00827f
C4085 avdd.n2993 avss 0.00827f
C4086 avdd.n2994 avss 0.00595f
C4087 avdd.n2995 avss 0.06947f
C4088 avdd.n2996 avss 0.00595f
C4089 avdd.n2997 avss 0.00827f
C4090 avdd.n2998 avss 0.00827f
C4091 avdd.n2999 avss 0.00827f
C4092 avdd.n3000 avss 0.00595f
C4093 avdd.n3001 avss 0.09263f
C4094 avdd.t27 avss 0.04631f
C4095 avdd.n3002 avss 0.00595f
C4096 avdd.n3003 avss 0.00827f
C4097 avdd.n3004 avss 0.00827f
C4098 avdd.n3005 avss 0.00827f
C4099 avdd.n3006 avss 0.00595f
C4100 avdd.n3007 avss 0.09263f
C4101 avdd.n3008 avss 0.00595f
C4102 avdd.n3009 avss 0.00827f
C4103 avdd.n3010 avss 0.00827f
C4104 avdd.n3011 avss 0.00827f
C4105 avdd.n3012 avss 0.00595f
C4106 avdd.n3013 avss 0.09263f
C4107 avdd.n3014 avss 0.00595f
C4108 avdd.n3015 avss 0.00827f
C4109 avdd.n3016 avss 0.00827f
C4110 avdd.n3017 avss 0.00827f
C4111 avdd.n3018 avss 0.00595f
C4112 avdd.n3019 avss 0.09263f
C4113 avdd.n3020 avss 0.00595f
C4114 avdd.n3021 avss 0.00827f
C4115 avdd.n3022 avss 0.02145f
C4116 avdd.n3023 avss 0.00672f
C4117 avdd.n3024 avss 0.01693f
C4118 avdd.n3025 avss 0.12611f
C4119 avdd.n3026 avss 0.01693f
C4120 avdd.n3027 avss 0.00672f
C4121 avdd.n3029 avss 0.1594f
C4122 avdd.n3030 avss 0.02732f
C4123 avdd.t28 avss 0.06136f
C4124 avdd.n3031 avss 0.15554f
C4125 avdd.n3032 avss 0.02091f
C4126 avdd.n3033 avss 0.00827f
C4127 avdd.n3034 avss 0.00827f
C4128 avdd.n3035 avss 0.00595f
C4129 avdd.n3036 avss 0.09263f
C4130 avdd.n3037 avss 0.00595f
C4131 avdd.n3038 avss 0.00827f
C4132 avdd.n3039 avss 0.00827f
C4133 avdd.n3040 avss 0.00827f
C4134 avdd.n3041 avss 0.00827f
C4135 avdd.n3042 avss 0.00827f
C4136 avdd.n3043 avss 0.00595f
C4137 avdd.n3044 avss 0.09263f
C4138 avdd.n3045 avss 0.00595f
C4139 avdd.n3046 avss 0.00827f
C4140 avdd.n3047 avss 0.00827f
C4141 avdd.n3048 avss 0.00827f
C4142 avdd.n3049 avss 0.00827f
C4143 avdd.n3050 avss 0.00827f
C4144 avdd.n3051 avss 0.00595f
C4145 avdd.n3052 avss 0.09263f
C4146 avdd.n3053 avss 0.00595f
C4147 avdd.n3054 avss 0.00827f
C4148 avdd.n3055 avss 0.00827f
C4149 avdd.n3056 avss 0.00827f
C4150 avdd.n3057 avss 0.00827f
C4151 avdd.n3058 avss 0.00827f
C4152 avdd.n3059 avss 0.00595f
C4153 avdd.n3060 avss 0.09263f
C4154 avdd.n3061 avss 0.00595f
C4155 avdd.n3062 avss 0.00827f
C4156 avdd.n3063 avss 0.00827f
C4157 avdd.n3064 avss 0.00827f
C4158 avdd.n3065 avss 0.00827f
C4159 avdd.n3066 avss 0.00827f
C4160 avdd.n3067 avss 0.00595f
C4161 avdd.n3068 avss 0.06947f
C4162 avdd.n3069 avss 0.00595f
C4163 avdd.n3070 avss 0.00827f
C4164 avdd.n3071 avss 0.00827f
C4165 avdd.n3072 avss 0.00827f
C4166 avdd.n3073 avss 0.00827f
C4167 avdd.n3074 avss 0.00827f
C4168 avdd.n3075 avss 0.00595f
C4169 avdd.n3076 avss 0.09263f
C4170 avdd.n3077 avss 0.00595f
C4171 avdd.n3078 avss 0.00827f
C4172 avdd.n3079 avss 0.00827f
C4173 avdd.n3080 avss 0.00827f
C4174 avdd.n3081 avss 0.00827f
C4175 avdd.n3082 avss 0.00827f
C4176 avdd.n3083 avss 0.00595f
C4177 avdd.n3084 avss 0.09263f
C4178 avdd.n3085 avss 0.00595f
C4179 avdd.n3086 avss 0.00827f
C4180 avdd.n3087 avss 0.00827f
C4181 avdd.n3088 avss 0.00827f
C4182 avdd.n3089 avss 0.00827f
C4183 avdd.n3090 avss 0.00827f
C4184 avdd.n3091 avss 0.00595f
C4185 avdd.n3092 avss 0.09263f
C4186 avdd.n3093 avss 0.00595f
C4187 avdd.n3094 avss 0.00827f
C4188 avdd.n3095 avss 0.00827f
C4189 avdd.n3096 avss 0.00827f
C4190 avdd.n3097 avss 0.00827f
C4191 avdd.n3098 avss 0.00827f
C4192 avdd.n3099 avss 0.00595f
C4193 avdd.n3100 avss 0.09263f
C4194 avdd.n3101 avss 0.00595f
C4195 avdd.n3102 avss 0.00827f
C4196 avdd.n3103 avss 0.00827f
C4197 avdd.n3104 avss 0.00827f
C4198 avdd.n3105 avss 0.03533f
C4199 avdd.n3106 avss 0.02034f
C4200 avdd.n3107 avss 0.00672f
C4201 avdd.n3108 avss 0.01699f
C4202 avdd.n3109 avss 0.16039f
C4203 avdd.t48 avss 0.04631f
C4204 avdd.n3110 avss 0.01699f
C4205 avdd.n3111 avss 0.00672f
C4206 avdd.n3112 avss 0.02034f
C4207 avdd.t49 avss 0.0179f
C4208 avdd.n3113 avss 0.1115f
C4209 avdd.n3114 avss 0.01699f
C4210 avdd.n3115 avss 0.01699f
C4211 avdd.n3117 avss 0.16039f
C4212 avdd.n3118 avss 0.00672f
C4213 avdd.n3119 avss 0.01699f
C4214 avdd.n3120 avss 0.00672f
C4215 avdd.n3121 avss 0.00672f
C4216 avdd.n3122 avss 0.0216f
C4217 avdd.n3123 avss 0.04856f
C4218 avdd.n3124 avss 0.06616f
C4219 avdd.n3125 avss 0.02034f
C4220 avdd.n3126 avss 0.0216f
C4221 avdd.n3127 avss 0.00672f
C4222 avdd.n3128 avss 0.01699f
C4223 avdd.n3129 avss 0.10382f
C4224 avdd.t59 avss 0.04631f
C4225 avdd.n3130 avss 0.10382f
C4226 avdd.n3132 avss 0.16039f
C4227 avdd.n3133 avss 0.10382f
C4228 avdd.n3135 avss 0.16039f
C4229 avdd.n3136 avss 0.1082f
C4230 avdd.n3137 avss 0.09068f
C4231 avdd.n3138 avss 0.02034f
C4232 avdd.n3139 avss 0.0216f
C4233 avdd.n3140 avss 0.00672f
C4234 avdd.n3141 avss 0.01699f
C4235 avdd.n3142 avss 0.10382f
C4236 avdd.n3144 avss 0.01699f
C4237 avdd.n3145 avss 0.00672f
C4238 avdd.n3146 avss 0.02033f
C4239 avdd.n3147 avss 0.02743f
C4240 avdd.n3148 avss 0.02742f
C4241 avdd.n3149 avss 0.02019f
C4242 avdd.n3150 avss 0.00672f
C4243 avdd.n3151 avss 0.01693f
C4244 avdd.n3152 avss 0.12611f
C4245 avdd.n3154 avss 0.01693f
C4246 avdd.n3155 avss 0.00672f
C4247 avdd.n3156 avss 0.02019f
C4248 avdd.n3157 avss 0.13851f
C4249 avdd.n3158 avss 0.03533f
C4250 avdd.n3159 avss 0.02034f
C4251 avdd.n3160 avss 0.01699f
C4252 avdd.n3161 avss 0.16039f
C4253 avdd.t21 avss 0.04631f
C4254 avdd.n3162 avss 0.16039f
C4255 avdd.n3163 avss 0.10382f
C4256 avdd.n3165 avss 0.01699f
C4257 avdd.n3166 avss 0.00672f
C4258 avdd.n3167 avss 0.0216f
C4259 avdd.n3168 avss 0.02034f
C4260 avdd.t47 avss 0.0179f
C4261 avdd.n3169 avss 0.1115f
C4262 avdd.n3170 avss 0.01699f
C4263 avdd.n3171 avss 0.01699f
C4264 avdd.n3173 avss 0.16039f
C4265 avdd.n3174 avss 0.00672f
C4266 avdd.n3175 avss 0.06616f
C4267 avdd.n3176 avss 0.02034f
C4268 avdd.n3177 avss 0.00672f
C4269 avdd.n3178 avss 0.01699f
C4270 avdd.n3179 avss 0.00672f
C4271 avdd.n3180 avss 0.0216f
C4272 avdd.n3181 avss 0.04856f
C4273 avdd.n3182 avss 0.0216f
C4274 avdd.n3183 avss 0.00672f
C4275 avdd.n3184 avss 0.01699f
C4276 avdd.n3185 avss 0.10382f
C4277 avdd.t46 avss 0.04631f
C4278 avdd.n3186 avss 0.10382f
C4279 avdd.n3188 avss 0.16039f
C4280 avdd.n3189 avss 0.1082f
C4281 avdd.n3190 avss 0.09068f
C4282 avdd.n3191 avss 0.02034f
C4283 avdd.n3192 avss 0.00672f
C4284 avdd.n3193 avss 0.01699f
C4285 avdd.n3194 avss 0.10382f
C4286 avdd.n3196 avss 0.01699f
C4287 avdd.n3197 avss 0.00672f
C4288 avdd.n3198 avss 0.00672f
C4289 avdd.n3199 avss 0.02033f
C4290 avdd.n3200 avss 0.13515f
C4291 avdd.n3201 avss 0.25322f
C4292 avdd.n3202 avss 0.03532f
C4293 avdd.n3203 avss 0.00827f
C4294 avdd.n3204 avss 0.00827f
C4295 avdd.n3205 avss 0.00595f
C4296 avdd.n3206 avss 0.1594f
C4297 avdd.n3207 avss 0.09263f
C4298 avdd.n3208 avss 0.00595f
C4299 avdd.n3209 avss 0.00827f
C4300 avdd.n3210 avss 0.00827f
C4301 avdd.n3211 avss 0.00827f
C4302 avdd.n3212 avss 0.00595f
C4303 avdd.t92 avss 0.09263f
C4304 avdd.n3213 avss 0.00595f
C4305 avdd.n3214 avss 0.00827f
C4306 avdd.n3215 avss 0.00827f
C4307 avdd.n3216 avss 0.00827f
C4308 avdd.n3217 avss 0.00595f
C4309 avdd.n3218 avss 0.09263f
C4310 avdd.n3219 avss 0.00595f
C4311 avdd.n3220 avss 0.00827f
C4312 avdd.n3221 avss 0.02732f
C4313 avdd.n3222 avss 0.1594f
C4314 avdd.t93 avss 0.02909f
C4315 avdd.n3223 avss 0.0803f
C4316 avdd.n3224 avss 0.02091f
C4317 avdd.n3225 avss 0.00672f
C4318 avdd.n3226 avss 0.01693f
C4319 avdd.n3227 avss 0.12611f
C4320 avdd.n3229 avss 0.01693f
C4321 avdd.n3230 avss 0.00672f
C4322 avdd.n3231 avss 0.02145f
C4323 avdd.n3232 avss 0.00827f
C4324 avdd.n3233 avss 0.00827f
C4325 avdd.n3234 avss 0.00827f
C4326 avdd.n3235 avss 0.00595f
C4327 avdd.n3236 avss 0.09263f
C4328 avdd.n3237 avss 0.00595f
C4329 avdd.n3238 avss 0.00827f
C4330 avdd.n3239 avss 0.00827f
C4331 avdd.n3240 avss 0.00827f
C4332 avdd.n3241 avss 0.00827f
C4333 avdd.n3242 avss 0.00827f
C4334 avdd.n3243 avss 0.00595f
C4335 avdd.n3244 avss 0.09263f
C4336 avdd.n3245 avss 0.00595f
C4337 avdd.n3246 avss 0.00827f
C4338 avdd.n3247 avss 0.00827f
C4339 avdd.n3248 avss 0.00827f
C4340 avdd.n3249 avss 0.02145f
C4341 avdd.n3250 avss 0.00672f
C4342 avdd.n3251 avss 0.01693f
C4343 avdd.n3252 avss 0.12611f
C4344 avdd.n3254 avss 0.01693f
C4345 avdd.n3255 avss 0.00672f
C4346 avdd.n3256 avss 0.02019f
C4347 avdd.n3257 avss 0.13514f
C4348 avdd.n3258 avss 0.10476f
C4349 avdd.n3259 avss 0.09706f
C4350 avdd.n3260 avss 0.00827f
C4351 avdd.n3261 avss 0.00827f
C4352 avdd.n3262 avss 0.00595f
C4353 avdd.n3263 avss 0.40723f
C4354 avdd.n3264 avss 0.25291f
C4355 avdd.n3265 avss 0.00595f
C4356 avdd.n3266 avss 0.00827f
C4357 avdd.n3267 avss 0.00827f
C4358 avdd.n3268 avss 0.00827f
C4359 avdd.n3269 avss 0.00595f
C4360 avdd.n3270 avss 0.25291f
C4361 avdd.n3271 avss 0.00595f
C4362 avdd.n3272 avss 0.00827f
C4363 avdd.t103 avss 0.34639f
C4364 avdd.n3273 avss 0.08935f
C4365 avdd.n3274 avss 0.40723f
C4366 avdd.n3275 avss 0.08903f
C4367 avdd.n3276 avss 0.02779f
C4368 avdd.n3277 avss 0.00672f
C4369 avdd.n3278 avss 0.03491f
C4370 avdd.n3280 avss 0.32813f
C4371 avdd.n3281 avss 0.03491f
C4372 avdd.n3282 avss 0.00672f
C4373 avdd.n3283 avss 0.01993f
C4374 avdd.n3284 avss 0.00827f
C4375 avdd.n3285 avss 0.00827f
C4376 avdd.n3286 avss 0.00827f
C4377 avdd.n3287 avss 0.00595f
C4378 avdd.t102 avss 0.25291f
C4379 avdd.n3288 avss 0.00595f
C4380 avdd.n3289 avss 0.00827f
C4381 avdd.n3290 avss 0.00827f
C4382 avdd.n3291 avss 0.00827f
C4383 avdd.n3292 avss 0.02779f
C4384 avdd.n3293 avss 0.00672f
C4385 avdd.n3294 avss 0.03491f
C4386 avdd.n3295 avss 0.32813f
C4387 avdd.n3297 avss 0.03491f
C4388 avdd.n3298 avss 0.00672f
C4389 avdd.n3299 avss 0.01921f
C4390 avdd.n3300 avss 0.11366f
C4391 avdd.n3301 avss 0.18885f
C4392 avdd.n3302 avss 0.0391f
C4393 avdd.n3303 avss 1.58149f
C4394 avdd.n3305 avss 0.09273f
C4395 avdd.n3306 avss 0.02564f
C4396 avdd.n3308 avss 2.07544f
C4397 avdd.n3309 avss 1.06512f
C4398 avdd.n3311 avss 0.0827f
C4399 avdd.n3313 avss 0.11579f
C4400 avdd.n3314 avss 0.11579f
C4401 avdd.n3315 avss 0.0827f
C4402 avdd.n3317 avss 0.11579f
C4403 avdd.n3320 avss 0.0827f
C4404 avdd.n3322 avss 0.11579f
C4405 avdd.n3323 avss 0.11579f
C4406 avdd.n3324 avss 0.0827f
C4407 avdd.n3326 avss 0.11579f
C4408 avdd.n3329 avss 0.13439f
C4409 avdd.t168 avss 0.0827f
C4410 avdd.n3332 avss 0.33288f
C4411 avdd.n3333 avss 0.13439f
C4412 avdd.n3334 avss 0.36183f
C4413 avdd.n3336 avss 0.13439f
C4414 avdd.t169 avss 0.0827f
C4415 avdd.n3339 avss 0.36183f
C4416 avdd.n3340 avss 0.13439f
C4417 avdd.n3341 avss 0.2497f
C4418 avdd.n3342 avss 0.0221f
C4419 avdd.n3343 avss 0.00827f
C4420 avdd.n3344 avss 0.00827f
C4421 avdd.n3345 avss 0.00595f
C4422 avdd.n3346 avss 0.1594f
C4423 avdd.n3347 avss 0.09263f
C4424 avdd.n3348 avss 0.00595f
C4425 avdd.n3349 avss 0.00827f
C4426 avdd.n3350 avss 0.00827f
C4427 avdd.n3351 avss 0.00827f
C4428 avdd.n3352 avss 0.00595f
C4429 avdd.n3353 avss 0.09263f
C4430 avdd.n3354 avss 0.00595f
C4431 avdd.n3355 avss 0.00827f
C4432 avdd.n3356 avss 0.00827f
C4433 avdd.n3357 avss 0.00827f
C4434 avdd.n3358 avss 0.00595f
C4435 avdd.n3359 avss 0.09263f
C4436 avdd.n3360 avss 0.00595f
C4437 avdd.n3361 avss 0.00827f
C4438 avdd.n3362 avss 0.00827f
C4439 avdd.n3363 avss 0.00827f
C4440 avdd.n3364 avss 0.00595f
C4441 avdd.n3365 avss 0.09263f
C4442 avdd.n3366 avss 0.00595f
C4443 avdd.n3367 avss 0.00827f
C4444 avdd.n3368 avss 0.00827f
C4445 avdd.n3369 avss 0.00827f
C4446 avdd.n3370 avss 0.00595f
C4447 avdd.n3371 avss 0.06947f
C4448 avdd.n3372 avss 0.00595f
C4449 avdd.n3373 avss 0.00827f
C4450 avdd.n3374 avss 0.00827f
C4451 avdd.n3375 avss 0.00827f
C4452 avdd.n3376 avss 0.00595f
C4453 avdd.n3377 avss 0.09263f
C4454 avdd.t35 avss 0.04631f
C4455 avdd.n3378 avss 0.00595f
C4456 avdd.n3379 avss 0.00827f
C4457 avdd.n3380 avss 0.00827f
C4458 avdd.n3381 avss 0.00827f
C4459 avdd.n3382 avss 0.00595f
C4460 avdd.n3383 avss 0.09263f
C4461 avdd.n3384 avss 0.00595f
C4462 avdd.n3385 avss 0.00827f
C4463 avdd.n3386 avss 0.00827f
C4464 avdd.n3387 avss 0.00827f
C4465 avdd.n3388 avss 0.00595f
C4466 avdd.n3389 avss 0.09263f
C4467 avdd.n3390 avss 0.00595f
C4468 avdd.n3391 avss 0.00827f
C4469 avdd.n3392 avss 0.00827f
C4470 avdd.n3393 avss 0.00827f
C4471 avdd.n3394 avss 0.00595f
C4472 avdd.n3395 avss 0.09263f
C4473 avdd.n3396 avss 0.00595f
C4474 avdd.n3397 avss 0.00827f
C4475 avdd.n3398 avss 0.02145f
C4476 avdd.n3399 avss 0.00672f
C4477 avdd.n3400 avss 0.01693f
C4478 avdd.n3401 avss 0.12611f
C4479 avdd.n3402 avss 0.01693f
C4480 avdd.n3403 avss 0.00672f
C4481 avdd.n3405 avss 0.1594f
C4482 avdd.n3406 avss 0.02732f
C4483 avdd.t36 avss 0.06136f
C4484 avdd.n3407 avss 0.15554f
C4485 avdd.n3408 avss 0.02091f
C4486 avdd.n3409 avss 0.00827f
C4487 avdd.n3410 avss 0.00827f
C4488 avdd.n3411 avss 0.00595f
C4489 avdd.n3412 avss 0.09263f
C4490 avdd.n3413 avss 0.00595f
C4491 avdd.n3414 avss 0.00827f
C4492 avdd.n3415 avss 0.00827f
C4493 avdd.n3416 avss 0.00827f
C4494 avdd.n3417 avss 0.00827f
C4495 avdd.n3418 avss 0.00827f
C4496 avdd.n3419 avss 0.00595f
C4497 avdd.n3420 avss 0.09263f
C4498 avdd.n3421 avss 0.00595f
C4499 avdd.n3422 avss 0.00827f
C4500 avdd.n3423 avss 0.00827f
C4501 avdd.n3424 avss 0.00827f
C4502 avdd.n3425 avss 0.00827f
C4503 avdd.n3426 avss 0.00827f
C4504 avdd.n3427 avss 0.00595f
C4505 avdd.n3428 avss 0.09263f
C4506 avdd.n3429 avss 0.00595f
C4507 avdd.n3430 avss 0.00827f
C4508 avdd.n3431 avss 0.00827f
C4509 avdd.n3432 avss 0.00827f
C4510 avdd.n3433 avss 0.00827f
C4511 avdd.n3434 avss 0.00827f
C4512 avdd.n3435 avss 0.00595f
C4513 avdd.n3436 avss 0.09263f
C4514 avdd.n3437 avss 0.00595f
C4515 avdd.n3438 avss 0.00827f
C4516 avdd.n3439 avss 0.00827f
C4517 avdd.n3440 avss 0.00827f
C4518 avdd.n3441 avss 0.00827f
C4519 avdd.n3442 avss 0.00827f
C4520 avdd.n3443 avss 0.00595f
C4521 avdd.n3444 avss 0.06947f
C4522 avdd.n3445 avss 0.00595f
C4523 avdd.n3446 avss 0.00827f
C4524 avdd.n3447 avss 0.00827f
C4525 avdd.n3448 avss 0.00827f
C4526 avdd.n3449 avss 0.00827f
C4527 avdd.n3450 avss 0.00827f
C4528 avdd.n3451 avss 0.00595f
C4529 avdd.n3452 avss 0.09263f
C4530 avdd.n3453 avss 0.00595f
C4531 avdd.n3454 avss 0.00827f
C4532 avdd.n3455 avss 0.00827f
C4533 avdd.n3456 avss 0.00827f
C4534 avdd.n3457 avss 0.00827f
C4535 avdd.n3458 avss 0.00827f
C4536 avdd.n3459 avss 0.00595f
C4537 avdd.n3460 avss 0.09263f
C4538 avdd.n3461 avss 0.00595f
C4539 avdd.n3462 avss 0.00827f
C4540 avdd.n3463 avss 0.00827f
C4541 avdd.n3464 avss 0.00827f
C4542 avdd.n3465 avss 0.00827f
C4543 avdd.n3466 avss 0.00827f
C4544 avdd.n3467 avss 0.00595f
C4545 avdd.n3468 avss 0.09263f
C4546 avdd.n3469 avss 0.00595f
C4547 avdd.n3470 avss 0.00827f
C4548 avdd.n3471 avss 0.00827f
C4549 avdd.n3472 avss 0.00827f
C4550 avdd.n3473 avss 0.00827f
C4551 avdd.n3474 avss 0.00827f
C4552 avdd.n3475 avss 0.00595f
C4553 avdd.n3476 avss 0.09263f
C4554 avdd.n3477 avss 0.00595f
C4555 avdd.n3478 avss 0.00827f
C4556 avdd.n3479 avss 0.00827f
C4557 avdd.n3480 avss 0.00827f
C4558 avdd.n3481 avss 0.03533f
C4559 avdd.n3482 avss 0.02034f
C4560 avdd.n3483 avss 0.00672f
C4561 avdd.n3484 avss 0.01699f
C4562 avdd.n3485 avss 0.16039f
C4563 avdd.t78 avss 0.04631f
C4564 avdd.n3486 avss 0.01699f
C4565 avdd.n3487 avss 0.00672f
C4566 avdd.n3488 avss 0.02034f
C4567 avdd.t79 avss 0.0179f
C4568 avdd.n3489 avss 0.1115f
C4569 avdd.n3490 avss 0.01699f
C4570 avdd.n3491 avss 0.01699f
C4571 avdd.n3493 avss 0.16039f
C4572 avdd.n3494 avss 0.00672f
C4573 avdd.n3495 avss 0.01699f
C4574 avdd.n3496 avss 0.00672f
C4575 avdd.n3497 avss 0.00672f
C4576 avdd.n3498 avss 0.0216f
C4577 avdd.n3499 avss 0.04856f
C4578 avdd.n3500 avss 0.06616f
C4579 avdd.n3501 avss 0.02034f
C4580 avdd.n3502 avss 0.0216f
C4581 avdd.n3503 avss 0.00672f
C4582 avdd.n3504 avss 0.01699f
C4583 avdd.n3505 avss 0.10382f
C4584 avdd.t58 avss 0.04631f
C4585 avdd.n3506 avss 0.10382f
C4586 avdd.n3508 avss 0.16039f
C4587 avdd.n3509 avss 0.10382f
C4588 avdd.n3511 avss 0.16039f
C4589 avdd.n3512 avss 0.1082f
C4590 avdd.n3513 avss 0.09068f
C4591 avdd.n3514 avss 0.02034f
C4592 avdd.n3515 avss 0.0216f
C4593 avdd.n3516 avss 0.00672f
C4594 avdd.n3517 avss 0.01699f
C4595 avdd.n3518 avss 0.10382f
C4596 avdd.n3520 avss 0.01699f
C4597 avdd.n3521 avss 0.00672f
C4598 avdd.n3522 avss 0.02033f
C4599 avdd.n3523 avss 0.02743f
C4600 avdd.n3524 avss 0.02742f
C4601 avdd.n3525 avss 0.02019f
C4602 avdd.n3526 avss 0.00672f
C4603 avdd.n3527 avss 0.01693f
C4604 avdd.n3528 avss 0.12611f
C4605 avdd.n3530 avss 0.01693f
C4606 avdd.n3531 avss 0.00672f
C4607 avdd.n3532 avss 0.02019f
C4608 avdd.n3533 avss 0.13851f
C4609 avdd.n3534 avss 0.03533f
C4610 avdd.n3535 avss 0.02034f
C4611 avdd.n3536 avss 0.01699f
C4612 avdd.n3537 avss 0.16039f
C4613 avdd.t80 avss 0.04631f
C4614 avdd.n3538 avss 0.16039f
C4615 avdd.n3539 avss 0.10382f
C4616 avdd.n3541 avss 0.01699f
C4617 avdd.n3542 avss 0.00672f
C4618 avdd.n3543 avss 0.0216f
C4619 avdd.n3544 avss 0.02034f
C4620 avdd.t69 avss 0.0179f
C4621 avdd.n3545 avss 0.1115f
C4622 avdd.n3546 avss 0.01699f
C4623 avdd.n3547 avss 0.01699f
C4624 avdd.n3549 avss 0.16039f
C4625 avdd.n3550 avss 0.00672f
C4626 avdd.n3551 avss 0.06616f
C4627 avdd.n3552 avss 0.02034f
C4628 avdd.n3553 avss 0.00672f
C4629 avdd.n3554 avss 0.01699f
C4630 avdd.n3555 avss 0.00672f
C4631 avdd.n3556 avss 0.0216f
C4632 avdd.n3557 avss 0.04856f
C4633 avdd.n3558 avss 0.0216f
C4634 avdd.n3559 avss 0.00672f
C4635 avdd.n3560 avss 0.01699f
C4636 avdd.n3561 avss 0.10382f
C4637 avdd.t68 avss 0.04631f
C4638 avdd.n3562 avss 0.10382f
C4639 avdd.n3564 avss 0.16039f
C4640 avdd.n3565 avss 0.1082f
C4641 avdd.n3566 avss 0.09068f
C4642 avdd.n3567 avss 0.02034f
C4643 avdd.n3568 avss 0.00672f
C4644 avdd.n3569 avss 0.01699f
C4645 avdd.n3570 avss 0.10382f
C4646 avdd.n3572 avss 0.01699f
C4647 avdd.n3573 avss 0.00672f
C4648 avdd.n3574 avss 0.00672f
C4649 avdd.n3575 avss 0.02033f
C4650 avdd.n3576 avss 0.13515f
C4651 avdd.n3577 avss 0.25322f
C4652 avdd.n3578 avss 0.03532f
C4653 avdd.n3579 avss 0.00827f
C4654 avdd.n3580 avss 0.00827f
C4655 avdd.n3581 avss 0.00595f
C4656 avdd.n3582 avss 0.1594f
C4657 avdd.n3583 avss 0.09263f
C4658 avdd.n3584 avss 0.00595f
C4659 avdd.n3585 avss 0.00827f
C4660 avdd.n3586 avss 0.00827f
C4661 avdd.n3587 avss 0.00827f
C4662 avdd.n3588 avss 0.00595f
C4663 avdd.t96 avss 0.09263f
C4664 avdd.n3589 avss 0.00595f
C4665 avdd.n3590 avss 0.00827f
C4666 avdd.n3591 avss 0.00827f
C4667 avdd.n3592 avss 0.00827f
C4668 avdd.n3593 avss 0.00595f
C4669 avdd.n3594 avss 0.09263f
C4670 avdd.n3595 avss 0.00595f
C4671 avdd.n3596 avss 0.00827f
C4672 avdd.n3597 avss 0.02732f
C4673 avdd.n3598 avss 0.1594f
C4674 avdd.t97 avss 0.02909f
C4675 avdd.n3599 avss 0.0803f
C4676 avdd.n3600 avss 0.02091f
C4677 avdd.n3601 avss 0.00672f
C4678 avdd.n3602 avss 0.01693f
C4679 avdd.n3603 avss 0.12611f
C4680 avdd.n3605 avss 0.01693f
C4681 avdd.n3606 avss 0.00672f
C4682 avdd.n3607 avss 0.02145f
C4683 avdd.n3608 avss 0.00827f
C4684 avdd.n3609 avss 0.00827f
C4685 avdd.n3610 avss 0.00827f
C4686 avdd.n3611 avss 0.00595f
C4687 avdd.n3612 avss 0.09263f
C4688 avdd.n3613 avss 0.00595f
C4689 avdd.n3614 avss 0.00827f
C4690 avdd.n3615 avss 0.00827f
C4691 avdd.n3616 avss 0.00827f
C4692 avdd.n3617 avss 0.00827f
C4693 avdd.n3618 avss 0.00827f
C4694 avdd.n3619 avss 0.00595f
C4695 avdd.n3620 avss 0.09263f
C4696 avdd.n3621 avss 0.00595f
C4697 avdd.n3622 avss 0.00827f
C4698 avdd.n3623 avss 0.00827f
C4699 avdd.n3624 avss 0.00827f
C4700 avdd.n3625 avss 0.02145f
C4701 avdd.n3626 avss 0.00672f
C4702 avdd.n3627 avss 0.01693f
C4703 avdd.n3628 avss 0.12611f
C4704 avdd.n3630 avss 0.01693f
C4705 avdd.n3631 avss 0.00672f
C4706 avdd.n3632 avss 0.02019f
C4707 avdd.n3633 avss 0.13514f
C4708 avdd.n3634 avss 0.10476f
C4709 avdd.n3635 avss 0.09706f
C4710 avdd.n3636 avss 0.00827f
C4711 avdd.n3637 avss 0.00827f
C4712 avdd.n3638 avss 0.00595f
C4713 avdd.n3639 avss 0.40723f
C4714 avdd.n3640 avss 0.25291f
C4715 avdd.n3641 avss 0.00595f
C4716 avdd.n3642 avss 0.00827f
C4717 avdd.n3643 avss 0.00827f
C4718 avdd.n3644 avss 0.00827f
C4719 avdd.n3645 avss 0.00595f
C4720 avdd.n3646 avss 0.25291f
C4721 avdd.n3647 avss 0.00595f
C4722 avdd.n3648 avss 0.00827f
C4723 avdd.t99 avss 0.34639f
C4724 avdd.n3649 avss 0.08935f
C4725 avdd.n3650 avss 0.40723f
C4726 avdd.n3651 avss 0.08903f
C4727 avdd.n3652 avss 0.02779f
C4728 avdd.n3653 avss 0.00672f
C4729 avdd.n3654 avss 0.03491f
C4730 avdd.n3656 avss 0.32813f
C4731 avdd.n3657 avss 0.03491f
C4732 avdd.n3658 avss 0.00672f
C4733 avdd.n3659 avss 0.01993f
C4734 avdd.n3660 avss 0.00827f
C4735 avdd.n3661 avss 0.00827f
C4736 avdd.n3662 avss 0.00827f
C4737 avdd.n3663 avss 0.00595f
C4738 avdd.t98 avss 0.25291f
C4739 avdd.n3664 avss 0.00595f
C4740 avdd.n3665 avss 0.00827f
C4741 avdd.n3666 avss 0.00827f
C4742 avdd.n3667 avss 0.00827f
C4743 avdd.n3668 avss 0.02779f
C4744 avdd.n3669 avss 0.00672f
C4745 avdd.n3670 avss 0.03491f
C4746 avdd.n3671 avss 0.32813f
C4747 avdd.n3673 avss 0.03491f
C4748 avdd.n3674 avss 0.00672f
C4749 avdd.n3675 avss 0.01921f
C4750 avdd.n3676 avss 0.11366f
C4751 avdd.n3677 avss 0.18885f
C4752 avdd.n3678 avss 0.0391f
C4753 avdd.n3679 avss 1.69769f
C4754 avdd.n3680 avss 0.18825f
C4755 avdd.n3682 avss 2.07544f
C4756 avdd.n3683 avss 0.17326f
C4757 avdd.n3684 avss 0.33867f
C4758 avdd.n3685 avss 0.02853f
C4759 avdd.n3686 avss 0.33867f
C4760 avdd.n3687 avss 0.02564f
C4761 avdd.n3689 avss 1.24055f
C4762 avdd.n3690 avss 1.24055f
C4763 avdd.n3691 avss 0.33867f
C4764 avdd.n3692 avss 0.02564f
C4765 avdd.n3694 avss 1.12435f
C4766 avdd.n3695 avss 1.12435f
C4767 avdd.n3696 avss 0.33867f
C4768 avdd.n3697 avss 0.02564f
C4769 avdd.n3699 avss 1.12435f
C4770 avdd.n3701 avss 1.12435f
C4771 avdd.n3703 avss 0.33867f
C4772 avdd.n3704 avss 1.12435f
C4773 avdd.n3705 avss 1.12435f
C4774 avdd.n3707 avss 0.02564f
C4775 avdd.n3708 avss 0.02564f
C4776 avdd.n3710 avss 0.55577f
C4777 avdd.n3711 avss 0.02564f
C4778 avdd.n3712 avss 0.02068f
C4779 avdd.n3714 avss 0.02068f
C4780 avdd.n3716 avss 0.55577f
C4781 avdd.n3718 avss 0.33867f
C4782 avdd.n3719 avss 0.33867f
C4783 avdd.n3720 avss 0.02564f
C4784 avdd.n3721 avss 0.0011f
C4785 avdd.n3722 avss 2.07544f
C4786 avdd.n3723 avss 2.07544f
C4787 avdd.n3724 avss 0.02564f
C4788 avdd.n3725 avss 0.0011f
C4789 avdd.n3726 avss 2.07544f
C4790 avdd.n3727 avss 2.07544f
C4791 avdd.n3728 avss 0.02564f
C4792 avdd.n3729 avss 0.0011f
C4793 avdd.n3730 avss 0.76211f
C4794 avdd.n3731 avss 0.76211f
C4795 avdd.n3732 avss 0.02564f
C4796 avdd.n3733 avss 0.02835f
C4797 avdd.n3734 avss 0.02564f
C4798 avdd.n3735 avss 0
C4799 avdd.n3736 avss 0.02853f
C4800 avdd.n3737 avss 0.30683f
C4801 avdd.n3738 avss 0.93507f
C4802 avdd.n3739 avss 1.49475f
C4803 avdd.n3740 avss 1.41634f
C4804 avdd.n3741 avss 0.96678f
C4805 avdd.n3742 avss 0.55788f
C4806 avdd.n3743 avss 0.92245f
C4807 avdd.n3744 avss 0.67066f
C4808 avdd.n3745 avss 0.08105f
C4809 avdd.n3746 avss 0.79556f
C4810 avdd.n3747 avss 1.27735f
C4811 avdd.n3748 avss 0.08353f
C4812 avdd.n3749 avss 0.17275f
C4813 avdd.n3750 avss 0.02564f
C4814 avdd.n3751 avss 0.02564f
C4815 avdd.n3753 avss 0.02564f
C4816 avdd.t12 avss 0.01745f
C4817 avdd.n3756 avss 0.05187f
C4818 avdd.n3757 avss 0.04806f
C4819 avdd.n3758 avss 0.01697f
C4820 avdd.n3759 avss 0.15874f
C4821 avdd.n3760 avss 0.0169f
C4822 avdd.n3761 avss 0.15874f
C4823 avdd.n3762 avss 0.00672f
C4824 avdd.n3763 avss 0.02135f
C4825 avdd.n3764 avss 0.02731f
C4826 avdd.n3765 avss 0.02135f
C4827 avdd.n3766 avss 0.00672f
C4828 avdd.n3767 avss 0.0169f
C4829 avdd.n3769 avss 0.10238f
C4830 avdd.t11 avss 0.04631f
C4831 avdd.n3770 avss 0.10238f
C4832 avdd.n3771 avss 0.01236f
C4833 avdd.n3772 avss 0.0125f
C4834 avdd.n3773 avss 0.29217f
C4835 avdd.t145 avss 0.01745f
C4836 avdd.n3774 avss 0.05187f
C4837 avdd.n3775 avss 0.04806f
C4838 avdd.n3776 avss 0.01697f
C4839 avdd.n3777 avss 0.15874f
C4840 avdd.n3778 avss 0.0169f
C4841 avdd.n3779 avss 0.15874f
C4842 avdd.n3780 avss 0.00672f
C4843 avdd.n3781 avss 0.02135f
C4844 avdd.n3782 avss 0.02731f
C4845 avdd.n3783 avss 0.02135f
C4846 avdd.n3784 avss 0.00672f
C4847 avdd.n3785 avss 0.0169f
C4848 avdd.n3787 avss 0.10238f
C4849 avdd.t144 avss 0.04631f
C4850 avdd.n3788 avss 0.10238f
C4851 avdd.n3789 avss 0.01236f
C4852 avdd.n3790 avss 0.0125f
C4853 avdd.n3791 avss 0.16154f
C4854 avdd.n3792 avss 0.20388f
C4855 avdd.t147 avss 0.01745f
C4856 avdd.n3793 avss 0.05187f
C4857 avdd.n3794 avss 0.04806f
C4858 avdd.n3795 avss 0.01697f
C4859 avdd.n3796 avss 0.15874f
C4860 avdd.n3797 avss 0.0169f
C4861 avdd.n3798 avss 0.15874f
C4862 avdd.n3799 avss 0.00672f
C4863 avdd.n3800 avss 0.02135f
C4864 avdd.n3801 avss 0.02731f
C4865 avdd.n3802 avss 0.02135f
C4866 avdd.n3803 avss 0.00672f
C4867 avdd.n3804 avss 0.0169f
C4868 avdd.n3806 avss 0.10238f
C4869 avdd.t146 avss 0.04631f
C4870 avdd.n3807 avss 0.10238f
C4871 avdd.n3808 avss 0.01236f
C4872 avdd.n3809 avss 0.0125f
C4873 avdd.n3810 avss 0.16154f
C4874 avdd.n3811 avss 0.27553f
C4875 avdd.n3812 avss 1.17179f
C4876 avdd.n3813 avss 0.02564f
C4877 avdd.n3814 avss 1.33111f
C4878 avdd.n3816 avss 0.02564f
C4879 avdd.n3817 avss 0.17326f
C4880 avdd.n3818 avss 0.08353f
C4881 avdd.n3822 avss 0.02564f
C4882 avdd.n3823 avss 0.02564f
C4883 avdd.n3825 avss 0.17326f
C4884 avdd.n3826 avss 0.33867f
C4885 avdd.n3827 avss 0.02564f
C4886 avdd.n3829 avss 0.02068f
C4887 avdd.n3830 avss 0.02564f
C4888 avdd.n3833 avss 0.0011f
C4889 avdd.n3834 avss 0.02564f
C4890 avdd.n3835 avss 0.02564f
C4891 avdd.n3836 avss 0.02564f
C4892 avdd.n3837 avss 0.02835f
C4893 avdd.n3838 avss 0
C4894 avdd.n3839 avss 0.95895f
C4895 avdd.n3841 avss 0.02564f
C4896 avdd.n3842 avss 0
C4897 avdd.n3843 avss 0.02853f
C4898 avdd.n3844 avss 0.95895f
C4899 avdd.n3845 avss 1.19796f
C4900 avdd.n3846 avss 0.17216f
C4901 avdd.n3847 avss 1.19796f
C4902 avdd.n3849 avss 0.69698f
C4903 avdd.n3851 avss 1.33111f
C4904 avdd.n3852 avss 0.02564f
C4905 avdd.n3854 avss 0.02564f
C4906 avdd.n3855 avss 0.84771f
C4907 avdd.n3856 avss 0.26465f
C4908 avdd.n3857 avss 0.20676f
C4909 avdd.n3859 avss 0.02564f
C4910 avdd.n3861 avss 0.27478f
C4911 avdd.t45 avss 0.01745f
C4912 avdd.n3862 avss 0.05187f
C4913 avdd.n3863 avss 0.04806f
C4914 avdd.n3864 avss 0.01697f
C4915 avdd.n3865 avss 0.15874f
C4916 avdd.n3866 avss 0.0169f
C4917 avdd.n3867 avss 0.15874f
C4918 avdd.n3868 avss 0.00672f
C4919 avdd.n3869 avss 0.02135f
C4920 avdd.n3870 avss 0.02731f
C4921 avdd.n3871 avss 0.02135f
C4922 avdd.n3872 avss 0.00672f
C4923 avdd.n3873 avss 0.0169f
C4924 avdd.n3875 avss 0.10238f
C4925 avdd.t44 avss 0.04631f
C4926 avdd.n3876 avss 0.10238f
C4927 avdd.n3877 avss 0.01236f
C4928 avdd.n3878 avss 0.0125f
C4929 avdd.n3879 avss 0.29217f
C4930 avdd.t63 avss 0.01745f
C4931 avdd.n3880 avss 0.05187f
C4932 avdd.n3881 avss 0.04806f
C4933 avdd.n3882 avss 0.01697f
C4934 avdd.n3883 avss 0.15874f
C4935 avdd.n3884 avss 0.0169f
C4936 avdd.n3885 avss 0.15874f
C4937 avdd.n3886 avss 0.00672f
C4938 avdd.n3887 avss 0.02135f
C4939 avdd.n3888 avss 0.02731f
C4940 avdd.n3889 avss 0.02135f
C4941 avdd.n3890 avss 0.00672f
C4942 avdd.n3891 avss 0.0169f
C4943 avdd.n3893 avss 0.10238f
C4944 avdd.t62 avss 0.04631f
C4945 avdd.n3894 avss 0.10238f
C4946 avdd.n3895 avss 0.01236f
C4947 avdd.n3896 avss 0.0125f
C4948 avdd.n3897 avss 0.16154f
C4949 avdd.n3898 avss 0.20388f
C4950 avdd.t65 avss 0.01745f
C4951 avdd.n3899 avss 0.05187f
C4952 avdd.n3900 avss 0.04806f
C4953 avdd.n3901 avss 0.01697f
C4954 avdd.n3902 avss 0.15874f
C4955 avdd.n3903 avss 0.0169f
C4956 avdd.n3904 avss 0.15874f
C4957 avdd.n3905 avss 0.00672f
C4958 avdd.n3906 avss 0.02135f
C4959 avdd.n3907 avss 0.02731f
C4960 avdd.n3908 avss 0.02135f
C4961 avdd.n3909 avss 0.00672f
C4962 avdd.n3910 avss 0.0169f
C4963 avdd.n3912 avss 0.10238f
C4964 avdd.t64 avss 0.04631f
C4965 avdd.n3913 avss 0.10238f
C4966 avdd.n3914 avss 0.01236f
C4967 avdd.n3915 avss 0.0125f
C4968 avdd.n3916 avss 0.16154f
C4969 avdd.n3917 avss 0.27553f
C4970 avdd.n3918 avss 1.1628f
C4971 avdd.n3919 avss 0.69698f
C4972 avdd.n3921 avss 1.33111f
C4973 avdd.n3922 avss 0.17326f
C4974 avdd.n3923 avss 0.33867f
C4975 avdd.n3924 avss 0.02564f
C4976 avdd.n3926 avss 0.02068f
C4977 avdd.n3927 avss 0.02564f
C4978 avdd.n3929 avss 0.33867f
C4979 avdd.n3930 avss 0.35149f
C4980 avdd.n3931 avss 1.32504f
C4981 avdd.n3933 avss 0.62028f
C4982 avdd.n3934 avss 0.02564f
C4983 avdd.n3936 avss 0.33867f
C4984 avdd.n3937 avss 0.20676f
C4985 avdd.n3938 avss 0.26465f
C4986 avdd.n3939 avss 0.08353f
C4987 avdd.n3940 avss 0.02845f
C4988 avdd.n3941 avss 0.02844f
C4989 avdd.n3942 avss 0
C4990 avdd.n3943 avss 0.33867f
C4991 avdd.n3944 avss 0.33867f
C4992 avdd.n3945 avss 0.02564f
C4993 avdd.n3947 avss 1.33111f
C4994 avdd.n3948 avss 1.33111f
C4995 avdd.n3949 avss 0.02564f
C4996 avdd.n3951 avss 0.02564f
C4997 avdd.n3953 avss 0.02564f
C4998 avdd.n3954 avss 0.02853f
C4999 avdd.n3955 avss 0
C5000 avdd.n3956 avss 0.02835f
C5001 avdd.n3957 avss 1.19796f
C5002 avdd.n3958 avss 0.17326f
C5003 avdd.n3959 avss 1.19796f
C5004 avdd.n3960 avss 0.02564f
C5005 avdd.n3962 avss 0.08353f
C5006 avdd.n3963 avss 0.26465f
C5007 avdd.n3964 avss 0.20676f
C5008 avdd.n3966 avss 1.33111f
C5009 avdd.n3967 avss 0.27478f
C5010 avdd.n3968 avss 1.19796f
C5011 avdd.n3969 avss 1.19796f
C5012 avdd.n3971 avss 0.20676f
C5013 avdd.n3972 avss 0.26465f
C5014 avdd.n3973 avss 0.77534f
C5015 avdd.n3974 avss 0.58347f
C5016 avdd.n3975 avss 0.82703f
C5017 avdd.n3976 avss 0.08105f
C5018 avdd.n3977 avss 0.12135f
C5019 avdd.n3978 avss 0.92245f
C5020 avdd.n3979 avss 0.2792f
C5021 avdd.n3980 avss 0.32551f
C5022 avdd.n3981 avss 0.92245f
C5023 avdd.n3982 avss 0.38342f
C5024 avdd.n3983 avss 0.38342f
C5025 avdd.n3984 avss 0.92245f
C5026 avdd.n3985 avss 0.16767f
C5027 avdd.n3986 avss 0.16767f
C5028 avdd.n3987 avss 0.92245f
C5029 avdd.n3988 avss 0.32551f
C5030 avdd.n3989 avss 0.29904f
C5031 avdd.n3990 avss 0.92245f
C5032 avdd.n3991 avss 0.35696f
C5033 avdd.n3992 avss 0.08105f
C5034 avdd.n3993 avss 0.79556f
C5035 avdd.n3994 avss 1.11213f
C5036 avdd.n3995 avss 0.08105f
C5037 avdd.n3996 avss 0.11308f
C5038 avdd.n3997 avss 0.92245f
C5039 avdd.n3998 avss 0.27093f
C5040 avdd.n3999 avss 0.32551f
C5041 avdd.n4000 avss 0.92245f
C5042 avdd.n4001 avss 0.38342f
C5043 avdd.n4002 avss 0.38342f
C5044 avdd.n4003 avss 0.92245f
C5045 avdd.n4004 avss 0.16767f
C5046 avdd.n4005 avss 0.27929f
C5047 avdd.n4006 avss 0.92245f
C5048 avdd.n4007 avss 0.43714f
C5049 avdd.n4008 avss 3.57822f
C5050 avdd.n4009 avss 1.34602f
C5051 avdd.n4010 avss 3.54485f
C5052 avdd.n4011 avss 0.59313f
C5053 avdd.n4012 avss 1.12105f
C5054 avdd.n4013 avss 0.5156f
C5055 avdd.n4014 avss 0.40397f
C5056 avdd.n4015 avss 1.12105f
C5057 avdd.n4016 avss 0.16767f
C5058 avdd.n4017 avss 0.16767f
C5059 avdd.n4018 avss 1.12105f
C5060 avdd.n4019 avss 0.4815f
C5061 avdd.n4020 avss 0.42691f
C5062 avdd.n4021 avss 1.12105f
C5063 avdd.n4022 avss 0.34939f
C5064 avdd.n4023 avss 0.08105f
C5065 avdd.n4024 avss 0.83597f
C5066 avdd.n4025 avss 0.82703f
C5067 avdd.n4026 avss 0.08105f
C5068 avdd.n4027 avss 0.1412f
C5069 avdd.n4028 avss 1.12105f
C5070 avdd.n4029 avss 0.45503f
C5071 avdd.n4030 avss 0.4815f
C5072 avdd.n4031 avss 1.12105f
C5073 avdd.n4032 avss 0.40397f
C5074 avdd.n4033 avss 0.40397f
C5075 avdd.n4034 avss 1.12105f
C5076 avdd.n4035 avss 0.16767f
C5077 avdd.n4036 avss 0.16767f
C5078 avdd.n4037 avss 1.12105f
C5079 avdd.n4038 avss 0.4815f
C5080 avdd.n4039 avss 0.12135f
C5081 avdd.n4040 avss 0.42758f
C5082 avdd.n4041 avss 0.69678f
C5083 avdd.n4042 avss 0.44453f
C5084 avdd.n4043 avss 0.49214f
C5085 avdd.n4044 avss 1.35199f
C5086 avdd.n4045 avss 1.1706f
C5087 avdd.n4046 avss 0.90816f
C5088 avdd.n4047 avss 0.37045f
C5089 avdd.n4048 avss 0.62943f
C5090 avdd.n4049 avss 0.78115f
C5091 avdd.n4050 avss 1.38352f
C5092 avdd.n4051 avss 1.66671f
C5093 avdd.n4052 avss 0.49622f
C5094 avdd.t20 avss 0.01745f
C5095 avdd.n4053 avss 0.05187f
C5096 avdd.n4054 avss 0.04806f
C5097 avdd.n4055 avss 0.01697f
C5098 avdd.n4056 avss 0.15874f
C5099 avdd.n4057 avss 0.0169f
C5100 avdd.n4058 avss 0.15874f
C5101 avdd.n4059 avss 0.00672f
C5102 avdd.n4060 avss 0.02135f
C5103 avdd.n4061 avss 0.02731f
C5104 avdd.n4062 avss 0.02135f
C5105 avdd.n4063 avss 0.00672f
C5106 avdd.n4064 avss 0.0169f
C5107 avdd.n4066 avss 0.10238f
C5108 avdd.t19 avss 0.04631f
C5109 avdd.n4067 avss 0.10238f
C5110 avdd.n4068 avss 0.01236f
C5111 avdd.n4069 avss 0.0125f
C5112 avdd.n4070 avss 0.29217f
C5113 avdd.t32 avss 0.01745f
C5114 avdd.n4071 avss 0.05187f
C5115 avdd.n4072 avss 0.04806f
C5116 avdd.n4073 avss 0.01697f
C5117 avdd.n4074 avss 0.15874f
C5118 avdd.n4075 avss 0.0169f
C5119 avdd.n4076 avss 0.15874f
C5120 avdd.n4077 avss 0.00672f
C5121 avdd.n4078 avss 0.02135f
C5122 avdd.n4079 avss 0.02731f
C5123 avdd.n4080 avss 0.02135f
C5124 avdd.n4081 avss 0.00672f
C5125 avdd.n4082 avss 0.0169f
C5126 avdd.n4084 avss 0.10238f
C5127 avdd.t31 avss 0.04631f
C5128 avdd.n4085 avss 0.10238f
C5129 avdd.n4086 avss 0.01236f
C5130 avdd.n4087 avss 0.0125f
C5131 avdd.n4088 avss 0.16154f
C5132 avdd.n4089 avss 0.20388f
C5133 avdd.t30 avss 0.01745f
C5134 avdd.n4090 avss 0.05187f
C5135 avdd.n4091 avss 0.04806f
C5136 avdd.n4092 avss 0.01697f
C5137 avdd.n4093 avss 0.15874f
C5138 avdd.n4094 avss 0.0169f
C5139 avdd.n4095 avss 0.15874f
C5140 avdd.n4096 avss 0.00672f
C5141 avdd.n4097 avss 0.02135f
C5142 avdd.n4098 avss 0.02731f
C5143 avdd.n4099 avss 0.02135f
C5144 avdd.n4100 avss 0.00672f
C5145 avdd.n4101 avss 0.0169f
C5146 avdd.n4103 avss 0.10238f
C5147 avdd.t29 avss 0.04631f
C5148 avdd.n4104 avss 0.10238f
C5149 avdd.n4105 avss 0.01236f
C5150 avdd.n4106 avss 0.0125f
C5151 avdd.n4107 avss 0.16154f
C5152 avdd.n4108 avss 0.27553f
C5153 avdd.n4109 avss 0.82301f
C5154 avdd.n4110 avss 2.66157f
C5155 avdd.n4111 avss 0.42644f
C5156 avdd.n4112 avss 0.3334f
C5157 avdd.n4113 avss 1.04381f
C5158 avdd.n4114 avss 1.56408f
C5159 avdd.n4115 avss 1.56408f
C5160 avdd.n4116 avss 0.98566f
C5161 avdd.n4117 avss 0.85105f
C5162 avdd.n4118 avss 1.66671f
C5163 avdd.n4119 avss 0.49622f
C5164 avdd.t7 avss 0.01745f
C5165 avdd.n4120 avss 0.05187f
C5166 avdd.n4121 avss 0.04806f
C5167 avdd.n4122 avss 0.01697f
C5168 avdd.n4123 avss 0.15874f
C5169 avdd.n4124 avss 0.0169f
C5170 avdd.n4125 avss 0.15874f
C5171 avdd.n4126 avss 0.00672f
C5172 avdd.n4127 avss 0.02135f
C5173 avdd.n4128 avss 0.02731f
C5174 avdd.n4129 avss 0.02135f
C5175 avdd.n4130 avss 0.00672f
C5176 avdd.n4131 avss 0.0169f
C5177 avdd.n4133 avss 0.10238f
C5178 avdd.t6 avss 0.04631f
C5179 avdd.n4134 avss 0.10238f
C5180 avdd.n4135 avss 0.01236f
C5181 avdd.n4136 avss 0.0125f
C5182 avdd.n4137 avss 0.29217f
C5183 avdd.t24 avss 0.01745f
C5184 avdd.n4138 avss 0.05187f
C5185 avdd.n4139 avss 0.04806f
C5186 avdd.n4140 avss 0.01697f
C5187 avdd.n4141 avss 0.15874f
C5188 avdd.n4142 avss 0.0169f
C5189 avdd.n4143 avss 0.15874f
C5190 avdd.n4144 avss 0.00672f
C5191 avdd.n4145 avss 0.02135f
C5192 avdd.n4146 avss 0.02731f
C5193 avdd.n4147 avss 0.02135f
C5194 avdd.n4148 avss 0.00672f
C5195 avdd.n4149 avss 0.0169f
C5196 avdd.n4151 avss 0.10238f
C5197 avdd.t23 avss 0.04631f
C5198 avdd.n4152 avss 0.10238f
C5199 avdd.n4153 avss 0.01236f
C5200 avdd.n4154 avss 0.0125f
C5201 avdd.n4155 avss 0.16154f
C5202 avdd.n4156 avss 0.20388f
C5203 avdd.t26 avss 0.01745f
C5204 avdd.n4157 avss 0.05187f
C5205 avdd.n4158 avss 0.04806f
C5206 avdd.n4159 avss 0.01697f
C5207 avdd.n4160 avss 0.15874f
C5208 avdd.n4161 avss 0.0169f
C5209 avdd.n4162 avss 0.15874f
C5210 avdd.n4163 avss 0.00672f
C5211 avdd.n4164 avss 0.02135f
C5212 avdd.n4165 avss 0.02731f
C5213 avdd.n4166 avss 0.02135f
C5214 avdd.n4167 avss 0.00672f
C5215 avdd.n4168 avss 0.0169f
C5216 avdd.n4170 avss 0.10238f
C5217 avdd.t25 avss 0.04631f
C5218 avdd.n4171 avss 0.10238f
C5219 avdd.n4172 avss 0.01236f
C5220 avdd.n4173 avss 0.0125f
C5221 avdd.n4174 avss 0.16154f
C5222 avdd.n4175 avss 0.27553f
C5223 avdd.n4176 avss 0.65884f
C5224 avdd.n4177 avss 0.49622f
C5225 avdd.n4178 avss 1.66671f
C5226 avdd.n4179 avss 0.85105f
C5227 avdd.n4180 avss 1.3875f
C5228 avdd.n4181 avss 1.56408f
C5229 avdd.n4182 avss 1.44871f
C5230 avdd.n4183 avss 1.33123f
C5231 avdd.n4184 avss 0.83597f
C5232 avdd.n4185 avss 0.54291f
C5233 avdd.n4186 avss 0.36357f
C5234 avdd.n4187 avss 0.06069f
C5235 avdd.t1 avss 0.07204f
C5236 avdd.n4188 avss 0.05781f
C5237 avdd.n4189 avss 0.01984f
C5238 avdd.n4190 avss 0.19917f
C5239 avdd.n4191 avss 0.01976f
C5240 avdd.n4192 avss 0.19917f
C5241 avdd.n4193 avss 0.00672f
C5242 avdd.n4194 avss 0.03716f
C5243 avdd.n4195 avss 0.02211f
C5244 avdd.n4196 avss 0.02211f
C5245 avdd.n4197 avss 0.00672f
C5246 avdd.n4198 avss 0.01976f
C5247 avdd.n4200 avss 0.12955f
C5248 avdd.t0 avss 0.05864f
C5249 avdd.n4201 avss 0.12955f
C5250 avdd.n4202 avss 0.01309f
C5251 avdd.n4203 avss 0.01463f
C5252 avdd.n4204 avss 0.29661f
C5253 avdd.n4205 avss 0.05164f
C5254 avdd.t5 avss 0.02561f
C5255 avdd.n4206 avss 0.05689f
C5256 avdd.n4207 avss 0.00664f
C5257 avdd.n4208 avss 0.01725f
C5258 avdd.n4209 avss 0.00827f
C5259 avdd.n4210 avss 0.00595f
C5260 avdd.t4 avss 0.04987f
C5261 avdd.n4211 avss 0.00595f
C5262 avdd.n4212 avss 0.15914f
C5263 avdd.n4213 avss 0.00827f
C5264 avdd.n4214 avss 0.01999f
C5265 avdd.n4215 avss 0.00672f
C5266 avdd.n4216 avss 0.01717f
C5267 avdd.n4217 avss 0.03009f
C5268 avdd.n4218 avss 0.15914f
C5269 avdd.n4219 avss 0.01725f
C5270 avdd.n4221 avss 0.1252f
C5271 avdd.n4222 avss 0.07481f
C5272 avdd.n4223 avss 0.00595f
C5273 avdd.n4224 avss 0.00827f
C5274 avdd.n4225 avss 0.00827f
C5275 avdd.n4226 avss 0.00827f
C5276 avdd.n4227 avss 0.01999f
C5277 avdd.n4228 avss 0.00672f
C5278 avdd.n4229 avss 0.01717f
C5279 avdd.n4231 avss 0.1252f
C5280 avdd.n4232 avss 0.07481f
C5281 avdd.n4233 avss 0.00595f
C5282 avdd.n4234 avss 0.00827f
C5283 avdd.n4235 avss 0.00664f
C5284 avdd.n4236 avss 0.26401f
C5285 avdd.n4237 avss 0.31253f
C5286 avdd.n4238 avss 0.05164f
C5287 avdd.t3 avss 0.02561f
C5288 avdd.n4239 avss 0.05689f
C5289 avdd.n4240 avss 0.00664f
C5290 avdd.n4241 avss 0.01725f
C5291 avdd.n4242 avss 0.00827f
C5292 avdd.n4243 avss 0.00595f
C5293 avdd.t2 avss 0.04987f
C5294 avdd.n4244 avss 0.00595f
C5295 avdd.n4245 avss 0.15914f
C5296 avdd.n4246 avss 0.00827f
C5297 avdd.n4247 avss 0.01999f
C5298 avdd.n4248 avss 0.00672f
C5299 avdd.n4249 avss 0.01717f
C5300 avdd.n4250 avss 0.03009f
C5301 avdd.n4251 avss 0.15914f
C5302 avdd.n4252 avss 0.01725f
C5303 avdd.n4254 avss 0.1252f
C5304 avdd.n4255 avss 0.07481f
C5305 avdd.n4256 avss 0.00595f
C5306 avdd.n4257 avss 0.00827f
C5307 avdd.n4258 avss 0.00827f
C5308 avdd.n4259 avss 0.00827f
C5309 avdd.n4260 avss 0.01999f
C5310 avdd.n4261 avss 0.00672f
C5311 avdd.n4262 avss 0.01717f
C5312 avdd.n4264 avss 0.1252f
C5313 avdd.n4265 avss 0.07481f
C5314 avdd.n4266 avss 0.00595f
C5315 avdd.n4267 avss 0.00827f
C5316 avdd.n4268 avss 0.00664f
C5317 avdd.n4269 avss 0.26401f
C5318 avdd.n4270 avss 0.28521f
C5319 avdd.n4271 avss 0.06069f
C5320 avdd.t129 avss 0.07204f
C5321 avdd.n4272 avss 0.05781f
C5322 avdd.n4273 avss 0.01984f
C5323 avdd.n4274 avss 0.19917f
C5324 avdd.t128 avss 0.05864f
C5325 avdd.n4275 avss 0.01976f
C5326 avdd.n4276 avss 0.00672f
C5327 avdd.n4277 avss 0.12955f
C5328 avdd.n4279 avss 0.19917f
C5329 avdd.n4280 avss 0.03716f
C5330 avdd.n4281 avss 0.02211f
C5331 avdd.n4282 avss 0.02211f
C5332 avdd.n4283 avss 0.00672f
C5333 avdd.n4284 avss 0.01976f
C5334 avdd.n4286 avss 0.12955f
C5335 avdd.n4287 avss 0.01984f
C5336 avdd.n4288 avss 0.00788f
C5337 avdd.n4289 avss 0.29661f
C5338 avdd.n4290 avss 0.05164f
C5339 avdd.t127 avss 0.02561f
C5340 avdd.n4291 avss 0.05689f
C5341 avdd.n4292 avss 0.00664f
C5342 avdd.n4293 avss 0.01725f
C5343 avdd.n4294 avss 0.00827f
C5344 avdd.n4295 avss 0.00595f
C5345 avdd.t126 avss 0.04987f
C5346 avdd.n4296 avss 0.00595f
C5347 avdd.n4297 avss 0.15914f
C5348 avdd.n4298 avss 0.00827f
C5349 avdd.n4299 avss 0.01999f
C5350 avdd.n4300 avss 0.00672f
C5351 avdd.n4301 avss 0.01717f
C5352 avdd.n4302 avss 0.03009f
C5353 avdd.n4303 avss 0.15914f
C5354 avdd.n4304 avss 0.01725f
C5355 avdd.n4306 avss 0.1252f
C5356 avdd.n4307 avss 0.07481f
C5357 avdd.n4308 avss 0.00595f
C5358 avdd.n4309 avss 0.00827f
C5359 avdd.n4310 avss 0.00827f
C5360 avdd.n4311 avss 0.00827f
C5361 avdd.n4312 avss 0.01999f
C5362 avdd.n4313 avss 0.00672f
C5363 avdd.n4314 avss 0.01717f
C5364 avdd.n4316 avss 0.1252f
C5365 avdd.n4317 avss 0.07481f
C5366 avdd.n4318 avss 0.00595f
C5367 avdd.n4319 avss 0.00827f
C5368 avdd.n4320 avss 0.00664f
C5369 avdd.n4321 avss 0.26401f
C5370 avdd.n4322 avss 0.31253f
C5371 avdd.n4323 avss 0.05164f
C5372 avdd.t131 avss 0.02561f
C5373 avdd.n4324 avss 0.05689f
C5374 avdd.n4325 avss 0.00664f
C5375 avdd.n4326 avss 0.01725f
C5376 avdd.n4327 avss 0.00827f
C5377 avdd.n4328 avss 0.00595f
C5378 avdd.t130 avss 0.04987f
C5379 avdd.n4329 avss 0.00595f
C5380 avdd.n4330 avss 0.15914f
C5381 avdd.n4331 avss 0.00827f
C5382 avdd.n4332 avss 0.01999f
C5383 avdd.n4333 avss 0.00672f
C5384 avdd.n4334 avss 0.01717f
C5385 avdd.n4335 avss 0.03009f
C5386 avdd.n4336 avss 0.15914f
C5387 avdd.n4337 avss 0.01725f
C5388 avdd.n4339 avss 0.1252f
C5389 avdd.n4340 avss 0.07481f
C5390 avdd.n4341 avss 0.00595f
C5391 avdd.n4342 avss 0.00827f
C5392 avdd.n4343 avss 0.00827f
C5393 avdd.n4344 avss 0.00827f
C5394 avdd.n4345 avss 0.01999f
C5395 avdd.n4346 avss 0.00672f
C5396 avdd.n4347 avss 0.01717f
C5397 avdd.n4349 avss 0.1252f
C5398 avdd.n4350 avss 0.07481f
C5399 avdd.n4351 avss 0.00595f
C5400 avdd.n4352 avss 0.00827f
C5401 avdd.n4353 avss 0.00664f
C5402 avdd.n4354 avss 0.26401f
C5403 avdd.n4355 avss 0.28521f
C5404 avdd.n4356 avss 0.04806f
C5405 avdd.t89 avss 0.01744f
C5406 avdd.n4357 avss 0.05147f
C5407 avdd.n4358 avss 0.01697f
C5408 avdd.n4359 avss 0.15874f
C5409 avdd.n4360 avss 0.0169f
C5410 avdd.n4361 avss 0.15874f
C5411 avdd.n4362 avss 0.00672f
C5412 avdd.n4363 avss 0.02731f
C5413 avdd.n4364 avss 0.02135f
C5414 avdd.n4365 avss 0.02135f
C5415 avdd.n4366 avss 0.00672f
C5416 avdd.n4367 avss 0.0169f
C5417 avdd.n4369 avss 0.10238f
C5418 avdd.t88 avss 0.04631f
C5419 avdd.n4370 avss 0.10238f
C5420 avdd.n4371 avss 0.01236f
C5421 avdd.n4372 avss 0.0125f
C5422 avdd.n4373 avss 0.21021f
C5423 avdd.n4374 avss 0.23138f
C5424 Vin.t0 avss 2.57356f
C5425 Vin_neg.t0 avss 0.55747f
C5426 vw11.n0 avss 0
C5427 vw11.n1 avss 0.00736f
C5428 vw11.n2 avss 0.03176f
C5429 vw11.n4 avss 0.07365f
C5430 vw11.n5 avss 0.11968f
C5431 vw11.t10 avss 0.07365f
C5432 vw11.n7 avss 0.07365f
C5433 vw11.n8 avss 0.07365f
C5434 vw11.n9 avss 0.11968f
C5435 vw11.n12 avss 0.21211f
C5436 vw11.n14 avss 0.21211f
C5437 vw11.n15 avss 0.07365f
C5438 vw11.n18 avss 0.11968f
C5439 vw11.n21 avss 0.07365f
C5440 vw11.n22 avss 0.11968f
C5441 vw11.t8 avss 0.07365f
C5442 vw11.n24 avss 0.07365f
C5443 vw11.n25 avss 0.07365f
C5444 vw11.n26 avss 0.11968f
C5445 vw11.n29 avss 0.21211f
C5446 vw11.n31 avss 0.21211f
C5447 vw11.n32 avss 0.07365f
C5448 vw11.n35 avss 0.11968f
C5449 vw11.n38 avss 0.07365f
C5450 vw11.n39 avss 0.11968f
C5451 vw11.t6 avss 0.07365f
C5452 vw11.n41 avss 0.07365f
C5453 vw11.n42 avss 0.07365f
C5454 vw11.n43 avss 0.11968f
C5455 vw11.n46 avss 0.21211f
C5456 vw11.n48 avss 0.21211f
C5457 vw11.n49 avss 0.07365f
C5458 vw11.n52 avss 0.11968f
C5459 vw11.n55 avss 0.07365f
C5460 vw11.n56 avss 0.11968f
C5461 vw11.t4 avss 0.07365f
C5462 vw11.n58 avss 0.07365f
C5463 vw11.n59 avss 0.07365f
C5464 vw11.n60 avss 0.11968f
C5465 vw11.n63 avss 0.21211f
C5466 vw11.n65 avss 0.21211f
C5467 vw11.n66 avss 0.07365f
C5468 vw11.n69 avss 0.11968f
C5469 vw11.n72 avss 0.07365f
C5470 vw11.n73 avss 0.11968f
C5471 vw11.t2 avss 0.07365f
C5472 vw11.n75 avss 0.07365f
C5473 vw11.n76 avss 0.07365f
C5474 vw11.n77 avss 0.11968f
C5475 vw11.n80 avss 0.21211f
C5476 vw11.n82 avss 0.21211f
C5477 vw11.n83 avss 0.07365f
C5478 vw11.n86 avss 0.11968f
C5479 vw11.n91 avss 0.21211f
C5480 vw11.t3 avss 0.07365f
C5481 vw11.n93 avss 0.60981f
C5482 vw11.n94 avss 0.11968f
C5483 vw11.n95 avss 0.66284f
C5484 vw11.n99 avss 0.21211f
C5485 vw11.t5 avss 0.07365f
C5486 vw11.n101 avss 0.66284f
C5487 vw11.n102 avss 0.11968f
C5488 vw11.n103 avss 0.66284f
C5489 vw11.n107 avss 0.21211f
C5490 vw11.t7 avss 0.07365f
C5491 vw11.n109 avss 0.66284f
C5492 vw11.n110 avss 0.11968f
C5493 vw11.n111 avss 0.66284f
C5494 vw11.n115 avss 0.21211f
C5495 vw11.t9 avss 0.07365f
C5496 vw11.n117 avss 0.66284f
C5497 vw11.n118 avss 0.11968f
C5498 vw11.n119 avss 0.66284f
C5499 vw11.n123 avss 0.21211f
C5500 vw11.t11 avss 0.07365f
C5501 vw11.n125 avss 0.66284f
C5502 vw11.n126 avss 0.11968f
C5503 vw11.n127 avss 0.35794f
C5504 vw11.n128 avss 0.00736f
C5505 vw11.t0 avss 0.09829f
C5506 vw11.t12 avss 0.49529f
C5507 vw11.n129 avss 0.46523f
C5508 vw11.t1 avss 0.06354f
C5509 vw11.n130 avss 0.44815f
C5510 vw11.n131 avss 0.28672f
C5511 vw11.n132 avss 0.22271f
C5512 vw11.n133 avss 0.49739f
C5513 vw11.n134 avss 0.03176f
C5514 vw11.n135 avss 0.01896f
C5515 vw11.n136 avss 0.29668f
C5516 vw11.n137 avss 0.44365f
C5517 vpre1.t2 avss 0.09048f
C5518 vpre1.t3 avss 0.09048f
C5519 vpre1.t1 avss 0.06615f
C5520 vpre1.t0 avss 0.36124f
C5521 vpre1.n0 avss 2.96247f
C5522 vpre1.n1 avss 4.7997f
C5523 vpre1.n2 avss 1.97046f
C5524 vpost1.t5 avss 0.0615f
C5525 vpost1.t4 avss 0.0615f
C5526 vpost1.n0 avss 1.427f
C5527 vpost1.t3 avss 0.0615f
C5528 vpost1.n1 avss 1.43746f
C5529 vpost1.t2 avss 0.0615f
C5530 vpost1.t1 avss 0.04496f
C5531 vpost1.t0 avss 0.24551f
C5532 vpost1.n2 avss 2.01341f
C5533 vpost1.n3 avss 1.55193f
C5534 vpost1.n4 avss 3.88382f
C5535 vpost2.t5 avss 0.06789f
C5536 vpost2.t4 avss 0.06789f
C5537 vpost2.t3 avss 0.06789f
C5538 vpost2.t2 avss 0.06789f
C5539 vpost2.t0 avss 0.04963f
C5540 vpost2.t1 avss 0.27104f
C5541 vpost2.n0 avss 2.22276f
C5542 vpost2.n1 avss 2.17954f
C5543 vpost2.n2 avss 2.97922f
C5544 vpre2.t3 avss 0.06288f
C5545 vpre2.t2 avss 0.06288f
C5546 vpre2.n0 avss 2.42761f
C5547 vpre2.t1 avss 0.04597f
C5548 vpre2.t0 avss 0.25103f
C5549 vpre2.n1 avss 2.05864f
C5550 vpre2.n2 avss 0.84363f
C5551 vpre2.n3 avss 2.59238f
C5552 vpre2.n4 avss 1.38408f
C5553 vw42.n0 avss 0
C5554 vw42.n1 avss 0.00757f
C5555 vw42.n2 avss 0.03263f
C5556 vw42.n4 avss 0.07567f
C5557 vw42.n5 avss 0.12296f
C5558 vw42.t10 avss 0.07567f
C5559 vw42.n7 avss 0.07567f
C5560 vw42.n8 avss 0.07567f
C5561 vw42.n9 avss 0.12296f
C5562 vw42.n12 avss 0.21793f
C5563 vw42.n14 avss 0.21793f
C5564 vw42.n15 avss 0.07567f
C5565 vw42.n18 avss 0.12296f
C5566 vw42.n21 avss 0.07567f
C5567 vw42.n22 avss 0.12296f
C5568 vw42.t8 avss 0.07567f
C5569 vw42.n24 avss 0.07567f
C5570 vw42.n25 avss 0.07567f
C5571 vw42.n26 avss 0.12296f
C5572 vw42.n29 avss 0.21793f
C5573 vw42.n31 avss 0.21793f
C5574 vw42.n32 avss 0.07567f
C5575 vw42.n35 avss 0.12296f
C5576 vw42.n38 avss 0.07567f
C5577 vw42.n39 avss 0.12296f
C5578 vw42.t6 avss 0.07567f
C5579 vw42.n41 avss 0.07567f
C5580 vw42.n42 avss 0.07567f
C5581 vw42.n43 avss 0.12296f
C5582 vw42.n46 avss 0.21793f
C5583 vw42.n48 avss 0.21793f
C5584 vw42.n49 avss 0.07567f
C5585 vw42.n52 avss 0.12296f
C5586 vw42.n55 avss 0.07567f
C5587 vw42.n56 avss 0.12296f
C5588 vw42.t4 avss 0.07567f
C5589 vw42.n58 avss 0.07567f
C5590 vw42.n59 avss 0.07567f
C5591 vw42.n60 avss 0.12296f
C5592 vw42.n63 avss 0.21793f
C5593 vw42.n65 avss 0.21793f
C5594 vw42.n66 avss 0.07567f
C5595 vw42.n69 avss 0.12296f
C5596 vw42.n72 avss 0.07567f
C5597 vw42.n73 avss 0.12296f
C5598 vw42.t2 avss 0.07567f
C5599 vw42.n75 avss 0.07567f
C5600 vw42.n76 avss 0.07567f
C5601 vw42.n77 avss 0.12296f
C5602 vw42.n80 avss 0.21793f
C5603 vw42.n82 avss 0.21793f
C5604 vw42.n83 avss 0.07567f
C5605 vw42.n86 avss 0.12296f
C5606 vw42.n91 avss 0.21793f
C5607 vw42.t3 avss 0.07567f
C5608 vw42.n93 avss 0.62655f
C5609 vw42.n94 avss 0.12296f
C5610 vw42.n95 avss 0.68104f
C5611 vw42.n99 avss 0.21793f
C5612 vw42.t5 avss 0.07567f
C5613 vw42.n101 avss 0.68104f
C5614 vw42.n102 avss 0.12296f
C5615 vw42.n103 avss 0.68104f
C5616 vw42.n107 avss 0.21793f
C5617 vw42.t7 avss 0.07567f
C5618 vw42.n109 avss 0.68104f
C5619 vw42.n110 avss 0.12296f
C5620 vw42.n111 avss 0.68104f
C5621 vw42.n115 avss 0.21793f
C5622 vw42.t9 avss 0.07567f
C5623 vw42.n117 avss 0.68104f
C5624 vw42.n118 avss 0.12296f
C5625 vw42.n119 avss 0.68104f
C5626 vw42.n123 avss 0.21793f
C5627 vw42.t11 avss 0.07567f
C5628 vw42.n125 avss 0.68104f
C5629 vw42.n126 avss 0.12296f
C5630 vw42.n127 avss 0.36776f
C5631 vw42.n128 avss 0.00757f
C5632 vw42.t0 avss 0.10099f
C5633 vw42.t12 avss 0.50889f
C5634 vw42.n129 avss 0.478f
C5635 vw42.t1 avss 0.06529f
C5636 vw42.n130 avss 0.46045f
C5637 vw42.n131 avss 0.29459f
C5638 vw42.n132 avss 0.22882f
C5639 vw42.n133 avss 0.51105f
C5640 vw42.n134 avss 0.03263f
C5641 vw42.n135 avss 0.01948f
C5642 vw42.n136 avss 0.46151f
.ends
