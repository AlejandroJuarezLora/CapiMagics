* NGSPICE file created from current_mirror.ext - technology: gf180mcuD

.subckt M3 a_n170_n881# a_50_n881# w_n436_n1309# a_n50_n1089# VSUBS
X0 a_50_n881# a_n50_n1089# a_n170_n881# w_n436_n1309# pfet_03v3 ad=4.8p pd=17.2u as=4.8p ps=17.2u w=8u l=0.5u
C0 a_50_n881# a_n170_n881# 1.38159f
C1 a_n50_n1089# a_n170_n881# 0.1643f
C2 w_n436_n1309# a_50_n881# 1.11309f
C3 a_n50_n1089# w_n436_n1309# 0.40291f
C4 a_n50_n1089# a_50_n881# 0.1511f
C5 w_n436_n1309# a_n170_n881# 0.85443f
C6 a_50_n881# VSUBS 0.22915f
C7 a_n170_n881# VSUBS 0.23296f
C8 a_n50_n1089# VSUBS 0.05695f
C9 w_n436_n1309# VSUBS 8.14076f
.ends

.subckt M1 a_n50_n689# a_n388_n853# a_28_n481# a_n178_n481#
X0 a_28_n481# a_n50_n689# a_n178_n481# a_n388_n853# nfet_03v3 ad=3p pd=9.5u as=3p ps=9.5u w=4u l=0.28u
C0 a_n178_n481# a_28_n481# 0.79223f
C1 a_n178_n481# a_n50_n689# 0.05931f
C2 a_n50_n689# a_28_n481# 0.04852f
C3 a_28_n481# a_n388_n853# 0.91438f
C4 a_n178_n481# a_n388_n853# 0.65403f
C5 a_n50_n689# a_n388_n853# 0.43511f
.ends

.subckt M4 a_n170_n241# a_50_n241# w_n436_n669# a_n50_n449# VSUBS
X0 a_50_n241# a_n50_n449# a_n170_n241# w_n436_n669# pfet_03v3 ad=0.96p pd=4.4u as=0.96p ps=4.4u w=1.6u l=0.5u
C0 a_50_n241# a_n170_n241# 0.49483f
C1 a_n50_n449# a_n170_n241# 0.0504f
C2 w_n436_n669# a_50_n241# 0.57366f
C3 a_n50_n449# w_n436_n669# 0.40991f
C4 a_n50_n449# a_50_n241# 0.03432f
C5 w_n436_n669# a_n170_n241# 0.31605f
C6 a_50_n241# VSUBS 0.07004f
C7 a_n170_n241# VSUBS 0.06917f
C8 a_n50_n449# VSUBS 0.05013f
C9 w_n436_n669# VSUBS 4.31562f
.ends

.subckt M2 a_n400_n689# a_n520_n481# a_400_n481# a_n730_n853#
X0 a_400_n481# a_n400_n689# a_n520_n481# a_n730_n853# nfet_03v3 ad=2.4p pd=9.2u as=2.4p ps=9.2u w=4u l=4u
C0 a_n520_n481# a_400_n481# 0.60052f
C1 a_n520_n481# a_n400_n689# 0.38556f
C2 a_n400_n689# a_400_n481# 0.25939f
C3 a_400_n481# a_n730_n853# 1.23378f
C4 a_n520_n481# a_n730_n853# 0.71367f
C5 a_n400_n689# a_n730_n853# 1.90584f
.ends

.subckt current_mirror avdd avss A B
XM3_0 avdd B avdd B avss M3
XM1_0 A avss A avss M1
XM4_0 avdd A avdd A avss M4
XM2_0 A avss B avss M2
R0 B.n2 B.n1 87.6185
R1 B.n2 B.n0 13.0311
R2 B B.n2 5.0855
R3 A.n6 A.n4 88.4721
R4 A.n3 A.n2 40.6645
R5 A A.n0 20.1346
R6 A.n3 A.n1 14.5508
R7 A.n6 A.n5 11.8027
R8 A A.n7 5.4545
R9 A.n7 A.n3 0.9455
R10 A.n7 A.n6 0.4775
R11 avss.n43 avss.n42 22716.8
R12 avss.n33 avss.n7 551.184
R13 avss.n66 avss.n7 364.974
R14 avss.n33 avss.n22 337.663
R15 avss.n43 avss.n19 288.007
R16 avss.n50 avss.n19 198.625
R17 avss.n50 avss.n13 198.625
R18 avss.n58 avss.n13 198.625
R19 avss.n58 avss.n6 198.625
R20 avss.n66 avss.n6 198.625
R21 avss.n42 avss.n22 191.177
R22 avss.n44 avss.n20 104.514
R23 avss.n44 avss.n18 104.514
R24 avss.n65 avss.n5 104.514
R25 avss.n67 avss.n5 104.514
R26 avss.n34 avss.n24 102.376
R27 avss.n40 avss.n25 102.376
R28 avss.n34 avss.n32 102.376
R29 avss.n25 avss.n23 77.6615
R30 avss.n44 avss.n43 77.3391
R31 avss.n40 avss.n24 15.5561
R32 avss.n32 avss.n28 15.5561
R33 avss.n49 avss.n20 15.5561
R34 avss.n49 avss.n12 15.5561
R35 avss.n59 avss.n12 15.5561
R36 avss.n59 avss.n8 15.5561
R37 avss.n65 avss.n8 15.5561
R38 avss.n51 avss.n18 15.5561
R39 avss.n51 avss.n14 15.5561
R40 avss.n57 avss.n14 15.5561
R41 avss.n57 avss.n4 15.5561
R42 avss.n67 avss.n4 15.5561
R43 avss.n42 avss.n41 7.44893
R44 avss.n45 avss.n16 5.55683
R45 avss.n63 avss.n1 5.55683
R46 avss.n46 avss.n45 5.549
R47 avss.n38 avss.n37 5.53703
R48 avss.n35 avss.n27 5.53703
R49 avss.n36 avss.n35 5.5292
R50 avss.n71 avss.n0 5.34384
R51 avss.n30 avss.n28 5.2005
R52 avss.n32 avss.n31 5.2005
R53 avss.n32 avss.n22 5.2005
R54 avss.n26 avss.n24 5.2005
R55 avss.n24 avss.n22 5.2005
R56 avss.n40 avss.n39 5.2005
R57 avss.n41 avss.n40 5.2005
R58 avss.n65 avss.n64 5.2005
R59 avss.n66 avss.n65 5.2005
R60 avss.n9 avss.n8 5.2005
R61 avss.n8 avss.n6 5.2005
R62 avss.n60 avss.n59 5.2005
R63 avss.n59 avss.n58 5.2005
R64 avss.n12 avss.n11 5.2005
R65 avss.n13 avss.n12 5.2005
R66 avss.n49 avss.n48 5.2005
R67 avss.n50 avss.n49 5.2005
R68 avss.n21 avss.n20 5.2005
R69 avss.n20 avss.n19 5.2005
R70 avss.n68 avss.n67 5.2005
R71 avss.n67 avss.n66 5.2005
R72 avss.n4 avss.n3 5.2005
R73 avss.n6 avss.n4 5.2005
R74 avss.n57 avss.n56 5.2005
R75 avss.n58 avss.n57 5.2005
R76 avss.n15 avss.n14 5.2005
R77 avss.n14 avss.n13 5.2005
R78 avss.n52 avss.n51 5.2005
R79 avss.n51 avss.n50 5.2005
R80 avss.n18 avss.n17 5.2005
R81 avss.n19 avss.n18 5.2005
R82 avss.n71 avss.n70 4.82724
R83 avss.n70 avss.n69 4.7615
R84 avss.n29 avss.n0 4.7417
R85 avss.n36 avss.n26 4.5005
R86 avss.n39 avss.n38 4.5005
R87 avss.n30 avss.n29 4.5005
R88 avss.n31 avss.n27 4.5005
R89 avss.n53 avss.n52 4.5005
R90 avss.n54 avss.n15 4.5005
R91 avss.n56 avss.n55 4.5005
R92 avss.n3 avss.n2 4.5005
R93 avss.n69 avss.n68 4.5005
R94 avss.n17 avss.n16 4.5005
R95 avss.n48 avss.n47 4.5005
R96 avss.n11 avss.n10 4.5005
R97 avss.n61 avss.n60 4.5005
R98 avss.n62 avss.n9 4.5005
R99 avss.n64 avss.n63 4.5005
R100 avss.n46 avss.n21 4.5005
R101 avss.n41 avss.n23 3.94566
R102 avss.n28 avss.n23 1.19566
R103 avss.n37 avss.n0 0.795826
R104 avss.n70 avss.n1 0.795826
R105 avss.n35 avss.n34 0.371929
R106 avss.n34 avss.n33 0.371929
R107 avss.n37 avss.n25 0.371929
R108 avss.n45 avss.n44 0.371929
R109 avss.n5 avss.n1 0.371929
R110 avss.n7 avss.n5 0.371929
R111 avss.n31 avss.n30 0.1445
R112 avss.n39 avss.n26 0.1445
R113 avss.n38 avss.n36 0.1445
R114 avss.n29 avss.n27 0.1445
R115 avss.n48 avss.n21 0.1445
R116 avss.n48 avss.n11 0.1445
R117 avss.n60 avss.n11 0.1445
R118 avss.n60 avss.n9 0.1445
R119 avss.n64 avss.n9 0.1445
R120 avss.n52 avss.n17 0.1445
R121 avss.n52 avss.n15 0.1445
R122 avss.n56 avss.n15 0.1445
R123 avss.n56 avss.n3 0.1445
R124 avss.n68 avss.n3 0.1445
R125 avss.n53 avss.n16 0.1445
R126 avss.n54 avss.n53 0.1445
R127 avss.n55 avss.n54 0.1445
R128 avss.n55 avss.n2 0.1445
R129 avss.n69 avss.n2 0.1445
R130 avss.n47 avss.n46 0.1445
R131 avss.n47 avss.n10 0.1445
R132 avss.n61 avss.n10 0.1445
R133 avss.n62 avss.n61 0.1445
R134 avss.n63 avss.n62 0.1445
R135 avss avss.n71 0.0527
R136 avdd.n34 avdd.n23 1397.13
R137 avdd.n34 avdd.n33 1397.13
R138 avdd.n15 avdd.n4 663.191
R139 avdd.n7 avdd.n4 663.191
R140 avdd.n36 avdd.n35 126.439
R141 avdd.n35 avdd.n24 126.439
R142 avdd.n32 avdd.n26 126.439
R143 avdd.n26 avdd.n25 126.439
R144 avdd.n16 avdd.n3 70.438
R145 avdd.n8 avdd.n3 70.438
R146 avdd.n13 avdd.n5 70.438
R147 avdd.n14 avdd.n13 70.438
R148 avdd.n9 avdd.n8 6.3005
R149 avdd.n10 avdd.n5 6.3005
R150 avdd.n17 avdd.n16 6.3005
R151 avdd.n14 avdd.n2 6.3005
R152 avdd.n27 avdd.n24 6.3005
R153 avdd.n32 avdd.n31 6.3005
R154 avdd.n25 avdd.n22 6.3005
R155 avdd.n37 avdd.n36 6.3005
R156 avdd.n40 avdd.n19 6.15838
R157 avdd.n30 avdd.n28 5.92113
R158 avdd.n29 avdd.n20 5.92113
R159 avdd.n28 avdd.n21 5.9133
R160 avdd.n12 avdd.n11 5.29504
R161 avdd.n6 avdd.n0 5.29504
R162 avdd.n12 avdd.n1 5.28722
R163 avdd.n40 avdd.n39 5.02289
R164 avdd.n19 avdd.n18 4.7345
R165 avdd.n39 avdd.n38 4.7345
R166 avdd.n18 avdd.n17 4.5005
R167 avdd.n2 avdd.n1 4.5005
R168 avdd.n9 avdd.n6 4.5005
R169 avdd.n11 avdd.n10 4.5005
R170 avdd.n22 avdd.n21 4.5005
R171 avdd.n38 avdd.n37 4.5005
R172 avdd.n29 avdd.n27 4.5005
R173 avdd.n31 avdd.n30 4.5005
R174 avdd.n7 avdd.n5 3.31679
R175 avdd.n8 avdd.n7 3.31679
R176 avdd.n15 avdd.n14 3.31679
R177 avdd.n16 avdd.n15 3.31679
R178 avdd.n33 avdd.n32 3.31679
R179 avdd.n33 avdd.n24 3.31679
R180 avdd.n36 avdd.n23 3.31679
R181 avdd.n25 avdd.n23 3.31679
R182 avdd.n39 avdd.n20 1.18713
R183 avdd.n13 avdd.n12 0.7005
R184 avdd.n13 avdd.n4 0.7005
R185 avdd.n3 avdd.n0 0.7005
R186 avdd.n4 avdd.n3 0.7005
R187 avdd.n19 avdd.n0 0.561043
R188 avdd.n28 avdd.n26 0.274413
R189 avdd.n34 avdd.n26 0.274413
R190 avdd.n35 avdd.n20 0.274413
R191 avdd.n35 avdd.n34 0.274413
R192 avdd.n10 avdd.n9 0.1445
R193 avdd.n17 avdd.n2 0.1445
R194 avdd.n18 avdd.n1 0.1445
R195 avdd.n11 avdd.n6 0.1445
R196 avdd.n31 avdd.n27 0.1445
R197 avdd.n37 avdd.n22 0.1445
R198 avdd.n38 avdd.n21 0.1445
R199 avdd.n30 avdd.n29 0.1445
R200 avdd avdd.n40 0.0563
C0 A avdd 0.64053f
C1 A B 0.19897f
C2 B avdd 0.80348f
C3 avdd.n0 avss 0.01516f
C4 avdd.n1 avss 0.00778f
C5 avdd.n2 avss 0.0024f
C6 avdd.n3 avss 0.011f
C7 avdd.n4 avss 0.09301f
C8 avdd.n5 avss 0.00672f
C9 avdd.n6 avss 0.00767f
C10 avdd.n7 avss 0.06101f
C11 avdd.n8 avss 0.00672f
C12 avdd.n9 avss 0.0024f
C13 avdd.n10 avss 0.0024f
C14 avdd.n11 avss 0.00767f
C15 avdd.n12 avss 0.02327f
C16 avdd.n13 avss 0.011f
C17 avdd.n14 avss 0.00672f
C18 avdd.n15 avss 0.06101f
C19 avdd.n16 avss 0.00672f
C20 avdd.n17 avss 0.0024f
C21 avdd.n18 avss 0.00702f
C22 avdd.n19 avss 0.0261f
C23 avdd.n20 avss 0.02978f
C24 avdd.n21 avss 0.01417f
C25 avdd.n22 avss 0.0024f
C26 avdd.n23 avss 0.11246f
C27 avdd.n24 avss 0.01104f
C28 avdd.n25 avss 0.01104f
C29 avdd.n26 avss 0.01935f
C30 avdd.n27 avss 0.0024f
C31 avdd.n28 avss 0.0676f
C32 avdd.n29 avss 0.00933f
C33 avdd.n30 avss 0.00933f
C34 avdd.n31 avss 0.0024f
C35 avdd.n32 avss 0.01104f
C36 avdd.n33 avss 0.11246f
C37 avdd.n34 avss 0.19583f
C38 avdd.n35 avss 0.01935f
C39 avdd.n36 avss 0.01104f
C40 avdd.n37 avss 0.0024f
C41 avdd.n38 avss 0.00702f
C42 avdd.n39 avss 0.01875f
C43 avdd.n40 avss 0.06147f
C44 avss.n0 avss 0.00682f
C45 avss.n1 avss 0.00883f
C46 avss.n2 avss 0.00125f
C47 avss.n3 avss 0.00125f
C48 avss.n4 avss 0
C49 avss.n5 avss 0.00618f
C50 avss.n6 avss 0.03282f
C51 avss.n7 avss 0.07569f
C52 avss.n8 avss 0
C53 avss.n9 avss 0.00125f
C54 avss.n10 avss 0.00125f
C55 avss.n11 avss 0.00125f
C56 avss.n12 avss 0
C57 avss.n13 avss 0.03282f
C58 avss.n14 avss 0
C59 avss.n15 avss 0.00125f
C60 avss.n16 avss 0.0037f
C61 avss.n17 avss 0.00102f
C62 avss.n18 avss 0.00363f
C63 avss.n19 avss 0.0402f
C64 avss.n20 avss 0.00363f
C65 avss.n21 avss 0.00102f
C66 avss.n22 avss 0.04369f
C67 avss.n24 avss 0.00357f
C68 avss.n25 avss 0.13471f
C69 avss.n26 avss 0.00102f
C70 avss.n27 avss 0.00354f
C71 avss.n28 avss 0.00357f
C72 avss.n29 avss 0.00304f
C73 avss.n30 avss 0.00102f
C74 avss.n31 avss 0.00102f
C75 avss.n32 avss 0.00357f
C76 avss.n33 avss 0.07343f
C77 avss.n34 avss 0.00604f
C78 avss.n35 avss 0.01861f
C79 avss.n36 avss 0.00416f
C80 avss.n37 avss 0.00882f
C81 avss.n38 avss 0.00354f
C82 avss.n39 avss 0.00102f
C83 avss.n40 avss 0.00357f
C84 avss.n41 avss 0.02865f
C85 avss.n42 avss 0.31855f
C86 avss.n43 avss 0.34572f
C87 avss.n44 avss 0.11293f
C88 avss.n45 avss 0.02526f
C89 avss.n46 avss 0.00493f
C90 avss.n47 avss 0.00125f
C91 avss.n48 avss 0.00125f
C92 avss.n49 avss 0
C93 avss.n50 avss 0.03282f
C94 avss.n51 avss 0
C95 avss.n52 avss 0.00125f
C96 avss.n53 avss 0.00125f
C97 avss.n54 avss 0.00125f
C98 avss.n55 avss 0.00125f
C99 avss.n56 avss 0.00125f
C100 avss.n57 avss 0
C101 avss.n58 avss 0.03282f
C102 avss.n59 avss 0
C103 avss.n60 avss 0.00125f
C104 avss.n61 avss 0.00125f
C105 avss.n62 avss 0.00125f
C106 avss.n63 avss 0.0037f
C107 avss.n64 avss 0.00102f
C108 avss.n65 avss 0.00363f
C109 avss.n66 avss 0.04656f
C110 avss.n67 avss 0.00363f
C111 avss.n68 avss 0.00102f
C112 avss.n69 avss 0.00321f
C113 avss.n70 avss 0.00521f
C114 avss.n71 avss 0.02517f
C115 A.n0 avss 0.62596f
C116 A.n1 avss 0.0544f
C117 A.n2 avss 0.03364f
C118 A.n3 avss 0.1916f
C119 A.n4 avss 0.03396f
C120 A.n5 avss 0.21581f
C121 A.n6 avss 0.23345f
C122 A.n7 avss 0.0661f
C123 B.n0 avss 0.41365f
C124 B.n1 avss 0.102f
C125 B.n2 avss 0.32772f
C126 B avss -0.79945f
C127 A avss -1.33256f
C128 avdd avss -2.51922f
.ends
