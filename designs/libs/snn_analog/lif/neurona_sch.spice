** sch_path: /foss/designs/libs/snn_analog/lif/sch/neurona_lvs.sch
.subckt neurona_lvs Iin Vdd Vss spike spike_neg
*.PININFO Vdd:B Vss:B Iin:I spike:O spike_neg:O
M1 spike_neg Iin Vdd Vdd pfet_03v3 L=0.28u W=0.5u nf=1
M2 spike_neg Iin Vss Vss nfet_03v3 L=0.28u W=0.5u nf=1
M3 spike_reset spike_neg Vdd Vdd pfet_03v3 L=0.28u W=0.5u nf=1
M4 spike_reset spike_neg Vss Vss nfet_03v3 L=0.28u W=0.5u nf=1
M7 spike spike_neg Vdd Vdd pfet_03v3 L=0.28u W=0.5u nf=1
M8 spike spike_neg Vss Vss nfet_03v3 L=0.28u W=0.5u nf=1
M5 Iin spike_reset Vss Vss nfet_03v3 L=50u W=2.3u nf=1
XC2 Iin Vss cap_mim_2f0fF c_width=15u c_length=5u m=1
.ends
