* NGSPICE file created from neurona_lvs.ext - technology: gf180mcuD

.subckt m1 a_n178_n131# a_n50_n339# w_n444_n560# a_28_n131# VSUBS
X0 a_28_n131# a_n50_n339# a_n178_n131# w_n444_n560# pfet_03v3 ad=0.375p pd=2.5u as=0.375p ps=2.5u w=0.5u l=0.28u
C0 w_n444_n560# a_28_n131# 0.48499f
C1 a_n50_n339# a_28_n131# 0.01004f
C2 w_n444_n560# a_n50_n339# 0.39308f
C3 a_n178_n131# a_28_n131# 0.34063f
C4 a_n178_n131# w_n444_n560# 0.22952f
C5 a_n178_n131# a_n50_n339# 0.02611f
C6 a_28_n131# VSUBS 0.04441f
C7 a_n178_n131# VSUBS 0.04328f
C8 a_n50_n339# VSUBS 0.04859f
C9 w_n444_n560# VSUBS 3.73985f
.ends

.subckt m8 a_n178_n131# a_n50_n339# a_n388_n504# a_28_n131#
X0 a_28_n131# a_n50_n339# a_n178_n131# a_n388_n504# nfet_03v3 ad=0.375p pd=2.5u as=0.375p ps=2.5u w=0.5u l=0.28u
C0 a_n50_n339# a_n178_n131# 0.02611f
C1 a_28_n131# a_n50_n339# 0.01004f
C2 a_28_n131# a_n178_n131# 0.34063f
C3 a_28_n131# a_n388_n504# 0.52938f
C4 a_n178_n131# a_n388_n504# 0.27279f
C5 a_n50_n339# a_n388_n504# 0.44167f
.ends

.subckt cap m4_n1620_n800# m4_n1500_n500# VSUBS
X0 m4_n1500_n500# m4_n1620_n800# cap_mim_2f0_m4m5_noshield c_width=15u c_length=5u
C0 m4_n1620_n800# m4_n1500_n500# 3.46344f
C1 m4_n1500_n500# VSUBS 1.29621f
C2 m4_n1620_n800# VSUBS 2.14627f
.ends

.subckt m4 a_n178_n131# a_n50_n339# a_n388_n504# a_28_n131#
X0 a_28_n131# a_n50_n339# a_n178_n131# a_n388_n504# nfet_03v3 ad=0.375p pd=2.5u as=0.375p ps=2.5u w=0.5u l=0.28u
C0 a_n50_n339# a_n178_n131# 0.02611f
C1 a_28_n131# a_n50_n339# 0.01004f
C2 a_28_n131# a_n178_n131# 0.34063f
C3 a_28_n131# a_n388_n504# 0.52938f
C4 a_n178_n131# a_n388_n504# 0.27279f
C5 a_n50_n339# a_n388_n504# 0.44167f
.ends

.subckt m2 a_n178_n131# a_n50_n339# a_n388_n504# a_28_n131#
X0 a_28_n131# a_n50_n339# a_n178_n131# a_n388_n504# nfet_03v3 ad=0.375p pd=2.5u as=0.375p ps=2.5u w=0.5u l=0.28u
C0 a_n50_n339# a_n178_n131# 0.02611f
C1 a_28_n131# a_n50_n339# 0.01004f
C2 a_28_n131# a_n178_n131# 0.34063f
C3 a_28_n131# a_n388_n504# 0.52938f
C4 a_n178_n131# a_n388_n504# 0.27279f
C5 a_n50_n339# a_n388_n504# 0.44167f
.ends

.subckt m7 a_n178_n131# a_n50_n339# w_n444_n560# a_28_n131# VSUBS
X0 a_28_n131# a_n50_n339# a_n178_n131# w_n444_n560# pfet_03v3 ad=0.375p pd=2.5u as=0.375p ps=2.5u w=0.5u l=0.28u
C0 w_n444_n560# a_28_n131# 0.48499f
C1 a_n50_n339# a_28_n131# 0.01004f
C2 w_n444_n560# a_n50_n339# 0.39308f
C3 a_n178_n131# a_28_n131# 0.34063f
C4 a_n178_n131# w_n444_n560# 0.22952f
C5 a_n178_n131# a_n50_n339# 0.02611f
C6 a_28_n131# VSUBS 0.04441f
C7 a_n178_n131# VSUBS 0.04328f
C8 a_n50_n339# VSUBS 0.04859f
C9 w_n444_n560# VSUBS 3.73985f
.ends

.subckt m5 a_n5000_n519# a_n5120_n311# a_n5330_n683# a_5000_n311#
X0 a_5000_n311# a_n5000_n519# a_n5120_n311# a_n5330_n683# nfet_03v3 ad=1.38p pd=5.8u as=1.38p ps=5.8u w=2.3u l=50u
C0 a_n5000_n519# a_n5120_n311# 1.8049f
C1 a_5000_n311# a_n5000_n519# 0.22856f
C2 a_5000_n311# a_n5120_n311# 4.41467f
C3 a_5000_n311# a_n5330_n683# 5.37377f
C4 a_n5120_n311# a_n5330_n683# 1.24677f
C5 a_n5000_n519# a_n5330_n683# 21.8141f
.ends

.subckt m3 a_n178_n131# a_n50_n339# w_n444_n560# a_28_n131# VSUBS
X0 a_28_n131# a_n50_n339# a_n178_n131# w_n444_n560# pfet_03v3 ad=0.375p pd=2.5u as=0.375p ps=2.5u w=0.5u l=0.28u
C0 w_n444_n560# a_28_n131# 0.48499f
C1 a_n50_n339# a_28_n131# 0.01004f
C2 w_n444_n560# a_n50_n339# 0.39308f
C3 a_n178_n131# a_28_n131# 0.34063f
C4 a_n178_n131# w_n444_n560# 0.22952f
C5 a_n178_n131# a_n50_n339# 0.02611f
C6 a_28_n131# VSUBS 0.04441f
C7 a_n178_n131# VSUBS 0.04328f
C8 a_n50_n339# VSUBS 0.04859f
C9 w_n444_n560# VSUBS 3.73985f
.ends

.subckt neurona_lvs vdd vss spike spike_neg Iin
Xm1_0 vdd Iin vdd spike_neg vss m1
Xm8_0 vss spike_neg vss spike m8
Xcap_0 vss Iin vss cap
Xm4_0 vss spike_neg vss m4_0/a_28_n131# m4
Xm2_0 vss Iin vss spike_neg m2
Xm7_0 vdd spike_neg vdd spike vss m7
Xm5_0 m4_0/a_28_n131# vss vss Iin m5
Xm3_0 vdd spike_neg vdd m4_0/a_28_n131# vss m3
R0 Iin.n2 Iin.n1 43.3961
R1 Iin.n2 Iin.n0 41.8859
R2 Iin.n4 Iin.n3 13.5956
R3 Iin Iin.n4 9.5027
R4 Iin.n4 Iin.n2 8.4965
R5 spike_neg.n5 spike_neg.n0 48.4901
R6 spike_neg.n3 spike_neg.n1 48.4901
R7 spike_neg.n5 spike_neg.n4 36.7469
R8 spike_neg.n3 spike_neg.n2 36.7469
R9 spike_neg spike_neg.n5 17.5055
R10 spike_neg.n5 spike_neg.n3 0.9797
R11 vss.n467 vss.n54 18200
R12 vss.n502 vss.n26 18200
R13 vss.n468 vss.n467 14173.5
R14 vss.n467 vss.n26 4420
R15 vss.n410 vss.n26 4013.75
R16 vss.n468 vss.n67 215.087
R17 vss.n421 vss.n5 135.488
R18 vss.n504 vss.n503 135.488
R19 vss.n495 vss.n36 135.488
R20 vss.n478 vss.n477 135.488
R21 vss.n428 vss.n23 133.794
R22 vss.n444 vss.n54 133.794
R23 vss.n494 vss.n39 123.632
R24 vss.n485 vss.n484 123.632
R25 vss.n72 vss.n57 120.246
R26 vss.n464 vss.n463 120.246
R27 vss.n502 vss.n501 110.084
R28 vss.n476 vss.n57 110.084
R29 vss.n484 vss.n46 106.697
R30 vss.n511 vss.n510 96.5352
R31 vss.n428 vss.n8 96.5352
R32 vss.n232 vss.n222 90.3096
R33 vss.n232 vss.n216 90.3096
R34 vss.n240 vss.n216 90.3096
R35 vss.n240 vss.n210 90.3096
R36 vss.n248 vss.n210 90.3096
R37 vss.n248 vss.n204 90.3096
R38 vss.n256 vss.n204 90.3096
R39 vss.n256 vss.n198 90.3096
R40 vss.n264 vss.n198 90.3096
R41 vss.n264 vss.n192 90.3096
R42 vss.n272 vss.n192 90.3096
R43 vss.n272 vss.n186 90.3096
R44 vss.n280 vss.n186 90.3096
R45 vss.n280 vss.n180 90.3096
R46 vss.n288 vss.n180 90.3096
R47 vss.n288 vss.n174 90.3096
R48 vss.n296 vss.n174 90.3096
R49 vss.n296 vss.n168 90.3096
R50 vss.n304 vss.n168 90.3096
R51 vss.n304 vss.n162 90.3096
R52 vss.n312 vss.n162 90.3096
R53 vss.n312 vss.n156 90.3096
R54 vss.n320 vss.n156 90.3096
R55 vss.n320 vss.n150 90.3096
R56 vss.n328 vss.n150 90.3096
R57 vss.n328 vss.n144 90.3096
R58 vss.n336 vss.n144 90.3096
R59 vss.n336 vss.n138 90.3096
R60 vss.n344 vss.n138 90.3096
R61 vss.n344 vss.n132 90.3096
R62 vss.n352 vss.n132 90.3096
R63 vss.n352 vss.n126 90.3096
R64 vss.n360 vss.n126 90.3096
R65 vss.n360 vss.n120 90.3096
R66 vss.n368 vss.n120 90.3096
R67 vss.n368 vss.n114 90.3096
R68 vss.n376 vss.n114 90.3096
R69 vss.n376 vss.n108 90.3096
R70 vss.n384 vss.n108 90.3096
R71 vss.n384 vss.n102 90.3096
R72 vss.n392 vss.n102 90.3096
R73 vss.n392 vss.n96 90.3096
R74 vss.n400 vss.n96 90.3096
R75 vss.n400 vss.n90 90.3096
R76 vss.n412 vss.n90 90.3096
R77 vss.n412 vss.n411 90.3096
R78 vss.n226 vss.n221 84.0977
R79 vss.n469 vss.n65 84.0977
R80 vss.n469 vss.n66 84.0977
R81 vss.n36 vss.n28 82.9864
R82 vss.n410 vss.n84 77.9057
R83 vss.n466 vss.n71 68.4449
R84 vss.n466 vss.n465 68.4449
R85 vss.n475 vss.n59 68.4449
R86 vss.n475 vss.n58 68.4449
R87 vss.n486 vss.n44 68.4449
R88 vss.n44 vss.n41 68.4449
R89 vss.n493 vss.n40 68.4449
R90 vss.n40 vss.n38 68.4449
R91 vss.n6 vss.n4 68.4449
R92 vss.n512 vss.n4 68.4449
R93 vss.n22 vss.n21 68.4449
R94 vss.n22 vss.n3 68.4449
R95 vss.n421 vss.n84 55.889
R96 vss.n501 vss.n28 52.5018
R97 vss.n226 vss.n225 51.8867
R98 vss.n511 vss.n5 38.9531
R99 vss.n510 vss.n8 38.9531
R100 vss.n444 vss.n46 28.7915
R101 vss.n503 vss.n502 25.4044
R102 vss.n477 vss.n476 25.4044
R103 vss.n71 vss.n58 15.5561
R104 vss.n486 vss.n38 15.5561
R105 vss.n233 vss.n221 15.5561
R106 vss.n233 vss.n217 15.5561
R107 vss.n239 vss.n217 15.5561
R108 vss.n239 vss.n209 15.5561
R109 vss.n249 vss.n209 15.5561
R110 vss.n249 vss.n205 15.5561
R111 vss.n255 vss.n205 15.5561
R112 vss.n255 vss.n197 15.5561
R113 vss.n265 vss.n197 15.5561
R114 vss.n265 vss.n193 15.5561
R115 vss.n271 vss.n193 15.5561
R116 vss.n271 vss.n185 15.5561
R117 vss.n281 vss.n185 15.5561
R118 vss.n281 vss.n181 15.5561
R119 vss.n287 vss.n181 15.5561
R120 vss.n287 vss.n173 15.5561
R121 vss.n297 vss.n173 15.5561
R122 vss.n297 vss.n169 15.5561
R123 vss.n303 vss.n169 15.5561
R124 vss.n303 vss.n161 15.5561
R125 vss.n313 vss.n161 15.5561
R126 vss.n313 vss.n157 15.5561
R127 vss.n319 vss.n157 15.5561
R128 vss.n319 vss.n149 15.5561
R129 vss.n329 vss.n149 15.5561
R130 vss.n329 vss.n145 15.5561
R131 vss.n335 vss.n145 15.5561
R132 vss.n335 vss.n137 15.5561
R133 vss.n345 vss.n137 15.5561
R134 vss.n345 vss.n133 15.5561
R135 vss.n351 vss.n133 15.5561
R136 vss.n351 vss.n125 15.5561
R137 vss.n361 vss.n125 15.5561
R138 vss.n361 vss.n121 15.5561
R139 vss.n367 vss.n121 15.5561
R140 vss.n367 vss.n113 15.5561
R141 vss.n377 vss.n113 15.5561
R142 vss.n377 vss.n109 15.5561
R143 vss.n383 vss.n109 15.5561
R144 vss.n383 vss.n101 15.5561
R145 vss.n393 vss.n101 15.5561
R146 vss.n393 vss.n97 15.5561
R147 vss.n399 vss.n97 15.5561
R148 vss.n399 vss.n89 15.5561
R149 vss.n413 vss.n89 15.5561
R150 vss.n413 vss.n85 15.5561
R151 vss.n420 vss.n85 15.5561
R152 vss.n420 vss.n9 15.5561
R153 vss.n509 vss.n9 15.5561
R154 vss.n509 vss.n10 15.5561
R155 vss.n505 vss.n10 15.5561
R156 vss.n505 vss.n16 15.5561
R157 vss.n500 vss.n16 15.5561
R158 vss.n500 vss.n29 15.5561
R159 vss.n496 vss.n29 15.5561
R160 vss.n496 vss.n35 15.5561
R161 vss.n483 vss.n35 15.5561
R162 vss.n483 vss.n47 15.5561
R163 vss.n479 vss.n47 15.5561
R164 vss.n479 vss.n53 15.5561
R165 vss.n455 vss.n53 15.5561
R166 vss.n462 vss.n455 15.5561
R167 vss.n462 vss.n65 15.5561
R168 vss.n231 vss.n223 15.5561
R169 vss.n231 vss.n215 15.5561
R170 vss.n241 vss.n215 15.5561
R171 vss.n241 vss.n211 15.5561
R172 vss.n247 vss.n211 15.5561
R173 vss.n247 vss.n203 15.5561
R174 vss.n257 vss.n203 15.5561
R175 vss.n257 vss.n199 15.5561
R176 vss.n263 vss.n199 15.5561
R177 vss.n263 vss.n191 15.5561
R178 vss.n273 vss.n191 15.5561
R179 vss.n273 vss.n187 15.5561
R180 vss.n279 vss.n187 15.5561
R181 vss.n279 vss.n179 15.5561
R182 vss.n289 vss.n179 15.5561
R183 vss.n289 vss.n175 15.5561
R184 vss.n295 vss.n175 15.5561
R185 vss.n295 vss.n167 15.5561
R186 vss.n305 vss.n167 15.5561
R187 vss.n305 vss.n163 15.5561
R188 vss.n311 vss.n163 15.5561
R189 vss.n311 vss.n155 15.5561
R190 vss.n321 vss.n155 15.5561
R191 vss.n321 vss.n151 15.5561
R192 vss.n327 vss.n151 15.5561
R193 vss.n327 vss.n143 15.5561
R194 vss.n337 vss.n143 15.5561
R195 vss.n337 vss.n139 15.5561
R196 vss.n343 vss.n139 15.5561
R197 vss.n343 vss.n131 15.5561
R198 vss.n353 vss.n131 15.5561
R199 vss.n353 vss.n127 15.5561
R200 vss.n359 vss.n127 15.5561
R201 vss.n359 vss.n119 15.5561
R202 vss.n369 vss.n119 15.5561
R203 vss.n369 vss.n115 15.5561
R204 vss.n375 vss.n115 15.5561
R205 vss.n375 vss.n107 15.5561
R206 vss.n385 vss.n107 15.5561
R207 vss.n385 vss.n103 15.5561
R208 vss.n391 vss.n103 15.5561
R209 vss.n391 vss.n95 15.5561
R210 vss.n401 vss.n95 15.5561
R211 vss.n401 vss.n91 15.5561
R212 vss.n409 vss.n91 15.5561
R213 vss.n409 vss.n83 15.5561
R214 vss.n422 vss.n83 15.5561
R215 vss.n423 vss.n422 15.5561
R216 vss.n423 vss.n7 15.5561
R217 vss.n429 vss.n7 15.5561
R218 vss.n429 vss.n24 15.5561
R219 vss.n25 vss.n24 15.5561
R220 vss.n27 vss.n25 15.5561
R221 vss.n436 vss.n27 15.5561
R222 vss.n436 vss.n37 15.5561
R223 vss.n439 vss.n37 15.5561
R224 vss.n439 vss.n45 15.5561
R225 vss.n445 vss.n45 15.5561
R226 vss.n445 vss.n55 15.5561
R227 vss.n56 vss.n55 15.5561
R228 vss.n73 vss.n56 15.5561
R229 vss.n454 vss.n73 15.5561
R230 vss.n454 vss.n66 15.5561
R231 vss.n21 vss.n6 15.5561
R232 vss.n463 vss.n72 15.2428
R233 vss.n464 vss.n67 15.2428
R234 vss.n495 vss.n494 11.8556
R235 vss.n485 vss.n39 11.8556
R236 vss.n472 vss.n471 11.2271
R237 vss vss.n515 5.603
R238 vss.n227 vss.n219 5.35452
R239 vss.n228 vss.n227 5.35452
R240 vss.n470 vss.n64 5.3467
R241 vss.n407 vss.n83 5.2005
R242 vss.n411 vss.n83 5.2005
R243 vss.n409 vss.n408 5.2005
R244 vss.n412 vss.n409 5.2005
R245 vss.n92 vss.n91 5.2005
R246 vss.n91 vss.n90 5.2005
R247 vss.n402 vss.n401 5.2005
R248 vss.n401 vss.n400 5.2005
R249 vss.n95 vss.n94 5.2005
R250 vss.n96 vss.n95 5.2005
R251 vss.n391 vss.n390 5.2005
R252 vss.n392 vss.n391 5.2005
R253 vss.n104 vss.n103 5.2005
R254 vss.n103 vss.n102 5.2005
R255 vss.n386 vss.n385 5.2005
R256 vss.n385 vss.n384 5.2005
R257 vss.n107 vss.n106 5.2005
R258 vss.n108 vss.n107 5.2005
R259 vss.n375 vss.n374 5.2005
R260 vss.n376 vss.n375 5.2005
R261 vss.n116 vss.n115 5.2005
R262 vss.n115 vss.n114 5.2005
R263 vss.n370 vss.n369 5.2005
R264 vss.n369 vss.n368 5.2005
R265 vss.n119 vss.n118 5.2005
R266 vss.n120 vss.n119 5.2005
R267 vss.n359 vss.n358 5.2005
R268 vss.n360 vss.n359 5.2005
R269 vss.n128 vss.n127 5.2005
R270 vss.n127 vss.n126 5.2005
R271 vss.n354 vss.n353 5.2005
R272 vss.n353 vss.n352 5.2005
R273 vss.n131 vss.n130 5.2005
R274 vss.n132 vss.n131 5.2005
R275 vss.n343 vss.n342 5.2005
R276 vss.n344 vss.n343 5.2005
R277 vss.n140 vss.n139 5.2005
R278 vss.n139 vss.n138 5.2005
R279 vss.n338 vss.n337 5.2005
R280 vss.n337 vss.n336 5.2005
R281 vss.n143 vss.n142 5.2005
R282 vss.n144 vss.n143 5.2005
R283 vss.n327 vss.n326 5.2005
R284 vss.n328 vss.n327 5.2005
R285 vss.n152 vss.n151 5.2005
R286 vss.n151 vss.n150 5.2005
R287 vss.n322 vss.n321 5.2005
R288 vss.n321 vss.n320 5.2005
R289 vss.n155 vss.n154 5.2005
R290 vss.n156 vss.n155 5.2005
R291 vss.n311 vss.n310 5.2005
R292 vss.n312 vss.n311 5.2005
R293 vss.n164 vss.n163 5.2005
R294 vss.n163 vss.n162 5.2005
R295 vss.n306 vss.n305 5.2005
R296 vss.n305 vss.n304 5.2005
R297 vss.n167 vss.n166 5.2005
R298 vss.n168 vss.n167 5.2005
R299 vss.n295 vss.n294 5.2005
R300 vss.n296 vss.n295 5.2005
R301 vss.n176 vss.n175 5.2005
R302 vss.n175 vss.n174 5.2005
R303 vss.n290 vss.n289 5.2005
R304 vss.n289 vss.n288 5.2005
R305 vss.n179 vss.n178 5.2005
R306 vss.n180 vss.n179 5.2005
R307 vss.n279 vss.n278 5.2005
R308 vss.n280 vss.n279 5.2005
R309 vss.n188 vss.n187 5.2005
R310 vss.n187 vss.n186 5.2005
R311 vss.n274 vss.n273 5.2005
R312 vss.n273 vss.n272 5.2005
R313 vss.n191 vss.n190 5.2005
R314 vss.n192 vss.n191 5.2005
R315 vss.n263 vss.n262 5.2005
R316 vss.n264 vss.n263 5.2005
R317 vss.n200 vss.n199 5.2005
R318 vss.n199 vss.n198 5.2005
R319 vss.n258 vss.n257 5.2005
R320 vss.n257 vss.n256 5.2005
R321 vss.n203 vss.n202 5.2005
R322 vss.n204 vss.n203 5.2005
R323 vss.n247 vss.n246 5.2005
R324 vss.n248 vss.n247 5.2005
R325 vss.n212 vss.n211 5.2005
R326 vss.n211 vss.n210 5.2005
R327 vss.n242 vss.n241 5.2005
R328 vss.n241 vss.n240 5.2005
R329 vss.n215 vss.n214 5.2005
R330 vss.n216 vss.n215 5.2005
R331 vss.n231 vss.n230 5.2005
R332 vss.n232 vss.n231 5.2005
R333 vss.n224 vss.n223 5.2005
R334 vss.n221 vss.n220 5.2005
R335 vss.n222 vss.n221 5.2005
R336 vss.n234 vss.n233 5.2005
R337 vss.n233 vss.n232 5.2005
R338 vss.n218 vss.n217 5.2005
R339 vss.n217 vss.n216 5.2005
R340 vss.n239 vss.n238 5.2005
R341 vss.n240 vss.n239 5.2005
R342 vss.n209 vss.n208 5.2005
R343 vss.n210 vss.n209 5.2005
R344 vss.n250 vss.n249 5.2005
R345 vss.n249 vss.n248 5.2005
R346 vss.n206 vss.n205 5.2005
R347 vss.n205 vss.n204 5.2005
R348 vss.n255 vss.n254 5.2005
R349 vss.n256 vss.n255 5.2005
R350 vss.n197 vss.n196 5.2005
R351 vss.n198 vss.n197 5.2005
R352 vss.n266 vss.n265 5.2005
R353 vss.n265 vss.n264 5.2005
R354 vss.n194 vss.n193 5.2005
R355 vss.n193 vss.n192 5.2005
R356 vss.n271 vss.n270 5.2005
R357 vss.n272 vss.n271 5.2005
R358 vss.n185 vss.n184 5.2005
R359 vss.n186 vss.n185 5.2005
R360 vss.n282 vss.n281 5.2005
R361 vss.n281 vss.n280 5.2005
R362 vss.n182 vss.n181 5.2005
R363 vss.n181 vss.n180 5.2005
R364 vss.n287 vss.n286 5.2005
R365 vss.n288 vss.n287 5.2005
R366 vss.n173 vss.n172 5.2005
R367 vss.n174 vss.n173 5.2005
R368 vss.n298 vss.n297 5.2005
R369 vss.n297 vss.n296 5.2005
R370 vss.n170 vss.n169 5.2005
R371 vss.n169 vss.n168 5.2005
R372 vss.n303 vss.n302 5.2005
R373 vss.n304 vss.n303 5.2005
R374 vss.n161 vss.n160 5.2005
R375 vss.n162 vss.n161 5.2005
R376 vss.n314 vss.n313 5.2005
R377 vss.n313 vss.n312 5.2005
R378 vss.n158 vss.n157 5.2005
R379 vss.n157 vss.n156 5.2005
R380 vss.n319 vss.n318 5.2005
R381 vss.n320 vss.n319 5.2005
R382 vss.n149 vss.n148 5.2005
R383 vss.n150 vss.n149 5.2005
R384 vss.n330 vss.n329 5.2005
R385 vss.n329 vss.n328 5.2005
R386 vss.n146 vss.n145 5.2005
R387 vss.n145 vss.n144 5.2005
R388 vss.n335 vss.n334 5.2005
R389 vss.n336 vss.n335 5.2005
R390 vss.n137 vss.n136 5.2005
R391 vss.n138 vss.n137 5.2005
R392 vss.n346 vss.n345 5.2005
R393 vss.n345 vss.n344 5.2005
R394 vss.n134 vss.n133 5.2005
R395 vss.n133 vss.n132 5.2005
R396 vss.n351 vss.n350 5.2005
R397 vss.n352 vss.n351 5.2005
R398 vss.n125 vss.n124 5.2005
R399 vss.n126 vss.n125 5.2005
R400 vss.n362 vss.n361 5.2005
R401 vss.n361 vss.n360 5.2005
R402 vss.n122 vss.n121 5.2005
R403 vss.n121 vss.n120 5.2005
R404 vss.n367 vss.n366 5.2005
R405 vss.n368 vss.n367 5.2005
R406 vss.n113 vss.n112 5.2005
R407 vss.n114 vss.n113 5.2005
R408 vss.n378 vss.n377 5.2005
R409 vss.n377 vss.n376 5.2005
R410 vss.n110 vss.n109 5.2005
R411 vss.n109 vss.n108 5.2005
R412 vss.n383 vss.n382 5.2005
R413 vss.n384 vss.n383 5.2005
R414 vss.n101 vss.n100 5.2005
R415 vss.n102 vss.n101 5.2005
R416 vss.n394 vss.n393 5.2005
R417 vss.n393 vss.n392 5.2005
R418 vss.n98 vss.n97 5.2005
R419 vss.n97 vss.n96 5.2005
R420 vss.n399 vss.n398 5.2005
R421 vss.n400 vss.n399 5.2005
R422 vss.n89 vss.n88 5.2005
R423 vss.n90 vss.n89 5.2005
R424 vss.n414 vss.n413 5.2005
R425 vss.n413 vss.n412 5.2005
R426 vss.n86 vss.n85 5.2005
R427 vss.n411 vss.n85 5.2005
R428 vss.n487 vss.n486 5.2005
R429 vss.n486 vss.n485 5.2005
R430 vss.n488 vss.n38 5.2005
R431 vss.n494 vss.n38 5.2005
R432 vss.n485 vss.n41 5.2005
R433 vss.n494 vss.n493 5.2005
R434 vss.n71 vss.n70 5.2005
R435 vss.n464 vss.n71 5.2005
R436 vss.n68 vss.n58 5.2005
R437 vss.n72 vss.n58 5.2005
R438 vss.n465 vss.n464 5.2005
R439 vss.n72 vss.n59 5.2005
R440 vss.n452 vss.n66 5.2005
R441 vss.n67 vss.n66 5.2005
R442 vss.n454 vss.n453 5.2005
R443 vss.n463 vss.n454 5.2005
R444 vss.n74 vss.n73 5.2005
R445 vss.n73 vss.n57 5.2005
R446 vss.n448 vss.n56 5.2005
R447 vss.n477 vss.n56 5.2005
R448 vss.n447 vss.n55 5.2005
R449 vss.n478 vss.n55 5.2005
R450 vss.n446 vss.n445 5.2005
R451 vss.n445 vss.n444 5.2005
R452 vss.n76 vss.n45 5.2005
R453 vss.n484 vss.n45 5.2005
R454 vss.n440 vss.n439 5.2005
R455 vss.n439 vss.n39 5.2005
R456 vss.n438 vss.n37 5.2005
R457 vss.n495 vss.n37 5.2005
R458 vss.n437 vss.n436 5.2005
R459 vss.n436 vss.n36 5.2005
R460 vss.n78 vss.n27 5.2005
R461 vss.n501 vss.n27 5.2005
R462 vss.n432 vss.n25 5.2005
R463 vss.n503 vss.n25 5.2005
R464 vss.n431 vss.n24 5.2005
R465 vss.n504 vss.n24 5.2005
R466 vss.n430 vss.n429 5.2005
R467 vss.n429 vss.n428 5.2005
R468 vss.n80 vss.n7 5.2005
R469 vss.n510 vss.n7 5.2005
R470 vss.n424 vss.n423 5.2005
R471 vss.n423 vss.n5 5.2005
R472 vss.n422 vss.n82 5.2005
R473 vss.n422 vss.n421 5.2005
R474 vss.n420 vss.n419 5.2005
R475 vss.n421 vss.n420 5.2005
R476 vss.n11 vss.n9 5.2005
R477 vss.n9 vss.n5 5.2005
R478 vss.n509 vss.n508 5.2005
R479 vss.n510 vss.n509 5.2005
R480 vss.n507 vss.n10 5.2005
R481 vss.n428 vss.n10 5.2005
R482 vss.n506 vss.n505 5.2005
R483 vss.n505 vss.n504 5.2005
R484 vss.n16 vss.n15 5.2005
R485 vss.n503 vss.n16 5.2005
R486 vss.n500 vss.n499 5.2005
R487 vss.n501 vss.n500 5.2005
R488 vss.n498 vss.n29 5.2005
R489 vss.n36 vss.n29 5.2005
R490 vss.n497 vss.n496 5.2005
R491 vss.n496 vss.n495 5.2005
R492 vss.n35 vss.n34 5.2005
R493 vss.n39 vss.n35 5.2005
R494 vss.n483 vss.n482 5.2005
R495 vss.n484 vss.n483 5.2005
R496 vss.n481 vss.n47 5.2005
R497 vss.n444 vss.n47 5.2005
R498 vss.n480 vss.n479 5.2005
R499 vss.n479 vss.n478 5.2005
R500 vss.n53 vss.n52 5.2005
R501 vss.n477 vss.n53 5.2005
R502 vss.n456 vss.n455 5.2005
R503 vss.n455 vss.n57 5.2005
R504 vss.n462 vss.n461 5.2005
R505 vss.n463 vss.n462 5.2005
R506 vss.n460 vss.n65 5.2005
R507 vss.n67 vss.n65 5.2005
R508 vss.n21 vss.n20 5.2005
R509 vss.n21 vss.n8 5.2005
R510 vss.n17 vss.n6 5.2005
R511 vss.n511 vss.n6 5.2005
R512 vss.n8 vss.n3 5.2005
R513 vss.n512 vss.n511 5.2005
R514 vss.n490 vss.n489 5.19561
R515 vss.n474 vss.n60 5.19561
R516 vss.n18 vss.n2 5.19561
R517 vss.n43 vss.n42 5.18779
R518 vss.n69 vss.n61 5.18779
R519 vss.n19 vss.n1 5.18779
R520 vss.n471 vss.n470 5.12952
R521 vss.n491 vss.n490 4.98321
R522 vss.n491 vss.n42 4.98321
R523 vss.n474 vss.n473 4.98321
R524 vss.n473 vss.n61 4.98321
R525 vss.n514 vss.n1 4.98321
R526 vss.n514 vss.n2 4.98321
R527 vss.n220 vss.n219 4.5005
R528 vss.n235 vss.n234 4.5005
R529 vss.n236 vss.n218 4.5005
R530 vss.n238 vss.n237 4.5005
R531 vss.n208 vss.n207 4.5005
R532 vss.n251 vss.n250 4.5005
R533 vss.n252 vss.n206 4.5005
R534 vss.n254 vss.n253 4.5005
R535 vss.n196 vss.n195 4.5005
R536 vss.n267 vss.n266 4.5005
R537 vss.n268 vss.n194 4.5005
R538 vss.n270 vss.n269 4.5005
R539 vss.n184 vss.n183 4.5005
R540 vss.n283 vss.n282 4.5005
R541 vss.n284 vss.n182 4.5005
R542 vss.n286 vss.n285 4.5005
R543 vss.n172 vss.n171 4.5005
R544 vss.n299 vss.n298 4.5005
R545 vss.n300 vss.n170 4.5005
R546 vss.n302 vss.n301 4.5005
R547 vss.n160 vss.n159 4.5005
R548 vss.n315 vss.n314 4.5005
R549 vss.n316 vss.n158 4.5005
R550 vss.n318 vss.n317 4.5005
R551 vss.n148 vss.n147 4.5005
R552 vss.n331 vss.n330 4.5005
R553 vss.n332 vss.n146 4.5005
R554 vss.n334 vss.n333 4.5005
R555 vss.n136 vss.n135 4.5005
R556 vss.n347 vss.n346 4.5005
R557 vss.n348 vss.n134 4.5005
R558 vss.n350 vss.n349 4.5005
R559 vss.n124 vss.n123 4.5005
R560 vss.n363 vss.n362 4.5005
R561 vss.n364 vss.n122 4.5005
R562 vss.n366 vss.n365 4.5005
R563 vss.n112 vss.n111 4.5005
R564 vss.n379 vss.n378 4.5005
R565 vss.n380 vss.n110 4.5005
R566 vss.n382 vss.n381 4.5005
R567 vss.n100 vss.n99 4.5005
R568 vss.n395 vss.n394 4.5005
R569 vss.n396 vss.n98 4.5005
R570 vss.n398 vss.n397 4.5005
R571 vss.n88 vss.n87 4.5005
R572 vss.n415 vss.n414 4.5005
R573 vss.n416 vss.n86 4.5005
R574 vss.n419 vss.n418 4.5005
R575 vss.n417 vss.n11 4.5005
R576 vss.n508 vss.n12 4.5005
R577 vss.n507 vss.n13 4.5005
R578 vss.n506 vss.n14 4.5005
R579 vss.n30 vss.n15 4.5005
R580 vss.n499 vss.n31 4.5005
R581 vss.n498 vss.n32 4.5005
R582 vss.n497 vss.n33 4.5005
R583 vss.n48 vss.n34 4.5005
R584 vss.n482 vss.n49 4.5005
R585 vss.n481 vss.n50 4.5005
R586 vss.n480 vss.n51 4.5005
R587 vss.n457 vss.n52 4.5005
R588 vss.n458 vss.n456 4.5005
R589 vss.n461 vss.n459 4.5005
R590 vss.n460 vss.n64 4.5005
R591 vss.n487 vss.n43 4.5005
R592 vss.n489 vss.n488 4.5005
R593 vss.n70 vss.n69 4.5005
R594 vss.n68 vss.n60 4.5005
R595 vss.n230 vss.n229 4.5005
R596 vss.n214 vss.n213 4.5005
R597 vss.n243 vss.n242 4.5005
R598 vss.n244 vss.n212 4.5005
R599 vss.n246 vss.n245 4.5005
R600 vss.n202 vss.n201 4.5005
R601 vss.n259 vss.n258 4.5005
R602 vss.n260 vss.n200 4.5005
R603 vss.n262 vss.n261 4.5005
R604 vss.n190 vss.n189 4.5005
R605 vss.n275 vss.n274 4.5005
R606 vss.n276 vss.n188 4.5005
R607 vss.n278 vss.n277 4.5005
R608 vss.n178 vss.n177 4.5005
R609 vss.n291 vss.n290 4.5005
R610 vss.n292 vss.n176 4.5005
R611 vss.n294 vss.n293 4.5005
R612 vss.n166 vss.n165 4.5005
R613 vss.n307 vss.n306 4.5005
R614 vss.n308 vss.n164 4.5005
R615 vss.n310 vss.n309 4.5005
R616 vss.n154 vss.n153 4.5005
R617 vss.n323 vss.n322 4.5005
R618 vss.n324 vss.n152 4.5005
R619 vss.n326 vss.n325 4.5005
R620 vss.n142 vss.n141 4.5005
R621 vss.n339 vss.n338 4.5005
R622 vss.n340 vss.n140 4.5005
R623 vss.n342 vss.n341 4.5005
R624 vss.n130 vss.n129 4.5005
R625 vss.n355 vss.n354 4.5005
R626 vss.n356 vss.n128 4.5005
R627 vss.n358 vss.n357 4.5005
R628 vss.n118 vss.n117 4.5005
R629 vss.n371 vss.n370 4.5005
R630 vss.n372 vss.n116 4.5005
R631 vss.n374 vss.n373 4.5005
R632 vss.n106 vss.n105 4.5005
R633 vss.n387 vss.n386 4.5005
R634 vss.n388 vss.n104 4.5005
R635 vss.n390 vss.n389 4.5005
R636 vss.n94 vss.n93 4.5005
R637 vss.n403 vss.n402 4.5005
R638 vss.n404 vss.n92 4.5005
R639 vss.n408 vss.n405 4.5005
R640 vss.n407 vss.n406 4.5005
R641 vss.n82 vss.n81 4.5005
R642 vss.n425 vss.n424 4.5005
R643 vss.n426 vss.n80 4.5005
R644 vss.n430 vss.n427 4.5005
R645 vss.n431 vss.n79 4.5005
R646 vss.n433 vss.n432 4.5005
R647 vss.n434 vss.n78 4.5005
R648 vss.n437 vss.n435 4.5005
R649 vss.n438 vss.n77 4.5005
R650 vss.n441 vss.n440 4.5005
R651 vss.n442 vss.n76 4.5005
R652 vss.n446 vss.n443 4.5005
R653 vss.n447 vss.n75 4.5005
R654 vss.n449 vss.n448 4.5005
R655 vss.n450 vss.n74 4.5005
R656 vss.n453 vss.n451 4.5005
R657 vss.n452 vss.n63 4.5005
R658 vss.n228 vss.n224 4.5005
R659 vss.n20 vss.n19 4.5005
R660 vss.n18 vss.n17 4.5005
R661 vss.n492 vss.n491 3.28078
R662 vss.n473 vss.n62 3.28078
R663 vss.n514 vss.n513 3.28078
R664 vss.n225 vss.n222 3.20926
R665 vss.n62 vss.n59 3.14293
R666 vss.n493 vss.n492 3.14293
R667 vss.n492 vss.n41 3.14293
R668 vss.n465 vss.n62 3.14293
R669 vss.n513 vss.n512 3.14293
R670 vss.n513 vss.n3 3.14293
R671 vss.n225 vss.n223 1.87676
R672 vss.n504 vss.n23 1.69409
R673 vss.n478 vss.n54 1.69409
R674 vss.n411 vss.n410 1.12936
R675 vss.n490 vss.n40 0.743357
R676 vss.n40 vss.n28 0.743357
R677 vss.n44 vss.n42 0.743357
R678 vss.n46 vss.n44 0.743357
R679 vss.n475 vss.n474 0.743357
R680 vss.n476 vss.n475 0.743357
R681 vss.n466 vss.n61 0.743357
R682 vss.n468 vss.n466 0.743357
R683 vss.n4 vss.n2 0.743357
R684 vss.n84 vss.n4 0.743357
R685 vss.n22 vss.n1 0.743357
R686 vss.n23 vss.n22 0.743357
R687 vss.n227 vss.n226 0.473227
R688 vss.n470 vss.n469 0.473227
R689 vss.n469 vss.n468 0.473227
R690 vss.n471 vss.n63 0.2255
R691 vss.n515 vss.n0 0.2057
R692 vss.n472 vss.n0 0.2057
R693 vss.n230 vss.n224 0.1445
R694 vss.n230 vss.n214 0.1445
R695 vss.n242 vss.n214 0.1445
R696 vss.n242 vss.n212 0.1445
R697 vss.n246 vss.n212 0.1445
R698 vss.n246 vss.n202 0.1445
R699 vss.n258 vss.n202 0.1445
R700 vss.n258 vss.n200 0.1445
R701 vss.n262 vss.n200 0.1445
R702 vss.n262 vss.n190 0.1445
R703 vss.n274 vss.n190 0.1445
R704 vss.n274 vss.n188 0.1445
R705 vss.n278 vss.n188 0.1445
R706 vss.n278 vss.n178 0.1445
R707 vss.n290 vss.n178 0.1445
R708 vss.n290 vss.n176 0.1445
R709 vss.n294 vss.n176 0.1445
R710 vss.n294 vss.n166 0.1445
R711 vss.n306 vss.n166 0.1445
R712 vss.n306 vss.n164 0.1445
R713 vss.n310 vss.n164 0.1445
R714 vss.n310 vss.n154 0.1445
R715 vss.n322 vss.n154 0.1445
R716 vss.n322 vss.n152 0.1445
R717 vss.n326 vss.n152 0.1445
R718 vss.n326 vss.n142 0.1445
R719 vss.n338 vss.n142 0.1445
R720 vss.n338 vss.n140 0.1445
R721 vss.n342 vss.n140 0.1445
R722 vss.n342 vss.n130 0.1445
R723 vss.n354 vss.n130 0.1445
R724 vss.n354 vss.n128 0.1445
R725 vss.n358 vss.n128 0.1445
R726 vss.n358 vss.n118 0.1445
R727 vss.n370 vss.n118 0.1445
R728 vss.n370 vss.n116 0.1445
R729 vss.n374 vss.n116 0.1445
R730 vss.n374 vss.n106 0.1445
R731 vss.n386 vss.n106 0.1445
R732 vss.n386 vss.n104 0.1445
R733 vss.n390 vss.n104 0.1445
R734 vss.n390 vss.n94 0.1445
R735 vss.n402 vss.n94 0.1445
R736 vss.n402 vss.n92 0.1445
R737 vss.n408 vss.n92 0.1445
R738 vss.n408 vss.n407 0.1445
R739 vss.n407 vss.n82 0.1445
R740 vss.n424 vss.n82 0.1445
R741 vss.n424 vss.n80 0.1445
R742 vss.n430 vss.n80 0.1445
R743 vss.n431 vss.n430 0.1445
R744 vss.n432 vss.n431 0.1445
R745 vss.n432 vss.n78 0.1445
R746 vss.n437 vss.n78 0.1445
R747 vss.n438 vss.n437 0.1445
R748 vss.n440 vss.n438 0.1445
R749 vss.n440 vss.n76 0.1445
R750 vss.n446 vss.n76 0.1445
R751 vss.n447 vss.n446 0.1445
R752 vss.n448 vss.n447 0.1445
R753 vss.n448 vss.n74 0.1445
R754 vss.n453 vss.n74 0.1445
R755 vss.n453 vss.n452 0.1445
R756 vss.n234 vss.n220 0.1445
R757 vss.n234 vss.n218 0.1445
R758 vss.n238 vss.n218 0.1445
R759 vss.n238 vss.n208 0.1445
R760 vss.n250 vss.n208 0.1445
R761 vss.n250 vss.n206 0.1445
R762 vss.n254 vss.n206 0.1445
R763 vss.n254 vss.n196 0.1445
R764 vss.n266 vss.n196 0.1445
R765 vss.n266 vss.n194 0.1445
R766 vss.n270 vss.n194 0.1445
R767 vss.n270 vss.n184 0.1445
R768 vss.n282 vss.n184 0.1445
R769 vss.n282 vss.n182 0.1445
R770 vss.n286 vss.n182 0.1445
R771 vss.n286 vss.n172 0.1445
R772 vss.n298 vss.n172 0.1445
R773 vss.n298 vss.n170 0.1445
R774 vss.n302 vss.n170 0.1445
R775 vss.n302 vss.n160 0.1445
R776 vss.n314 vss.n160 0.1445
R777 vss.n314 vss.n158 0.1445
R778 vss.n318 vss.n158 0.1445
R779 vss.n318 vss.n148 0.1445
R780 vss.n330 vss.n148 0.1445
R781 vss.n330 vss.n146 0.1445
R782 vss.n334 vss.n146 0.1445
R783 vss.n334 vss.n136 0.1445
R784 vss.n346 vss.n136 0.1445
R785 vss.n346 vss.n134 0.1445
R786 vss.n350 vss.n134 0.1445
R787 vss.n350 vss.n124 0.1445
R788 vss.n362 vss.n124 0.1445
R789 vss.n362 vss.n122 0.1445
R790 vss.n366 vss.n122 0.1445
R791 vss.n366 vss.n112 0.1445
R792 vss.n378 vss.n112 0.1445
R793 vss.n378 vss.n110 0.1445
R794 vss.n382 vss.n110 0.1445
R795 vss.n382 vss.n100 0.1445
R796 vss.n394 vss.n100 0.1445
R797 vss.n394 vss.n98 0.1445
R798 vss.n398 vss.n98 0.1445
R799 vss.n398 vss.n88 0.1445
R800 vss.n414 vss.n88 0.1445
R801 vss.n414 vss.n86 0.1445
R802 vss.n419 vss.n86 0.1445
R803 vss.n419 vss.n11 0.1445
R804 vss.n508 vss.n11 0.1445
R805 vss.n508 vss.n507 0.1445
R806 vss.n507 vss.n506 0.1445
R807 vss.n506 vss.n15 0.1445
R808 vss.n499 vss.n15 0.1445
R809 vss.n499 vss.n498 0.1445
R810 vss.n498 vss.n497 0.1445
R811 vss.n497 vss.n34 0.1445
R812 vss.n482 vss.n34 0.1445
R813 vss.n482 vss.n481 0.1445
R814 vss.n481 vss.n480 0.1445
R815 vss.n480 vss.n52 0.1445
R816 vss.n456 vss.n52 0.1445
R817 vss.n461 vss.n456 0.1445
R818 vss.n461 vss.n460 0.1445
R819 vss.n235 vss.n219 0.1445
R820 vss.n236 vss.n235 0.1445
R821 vss.n237 vss.n236 0.1445
R822 vss.n237 vss.n207 0.1445
R823 vss.n251 vss.n207 0.1445
R824 vss.n252 vss.n251 0.1445
R825 vss.n253 vss.n252 0.1445
R826 vss.n253 vss.n195 0.1445
R827 vss.n267 vss.n195 0.1445
R828 vss.n268 vss.n267 0.1445
R829 vss.n269 vss.n268 0.1445
R830 vss.n269 vss.n183 0.1445
R831 vss.n283 vss.n183 0.1445
R832 vss.n284 vss.n283 0.1445
R833 vss.n285 vss.n284 0.1445
R834 vss.n285 vss.n171 0.1445
R835 vss.n299 vss.n171 0.1445
R836 vss.n300 vss.n299 0.1445
R837 vss.n301 vss.n300 0.1445
R838 vss.n301 vss.n159 0.1445
R839 vss.n315 vss.n159 0.1445
R840 vss.n316 vss.n315 0.1445
R841 vss.n317 vss.n316 0.1445
R842 vss.n317 vss.n147 0.1445
R843 vss.n331 vss.n147 0.1445
R844 vss.n332 vss.n331 0.1445
R845 vss.n333 vss.n332 0.1445
R846 vss.n333 vss.n135 0.1445
R847 vss.n347 vss.n135 0.1445
R848 vss.n348 vss.n347 0.1445
R849 vss.n349 vss.n348 0.1445
R850 vss.n349 vss.n123 0.1445
R851 vss.n363 vss.n123 0.1445
R852 vss.n364 vss.n363 0.1445
R853 vss.n365 vss.n364 0.1445
R854 vss.n365 vss.n111 0.1445
R855 vss.n379 vss.n111 0.1445
R856 vss.n380 vss.n379 0.1445
R857 vss.n381 vss.n380 0.1445
R858 vss.n381 vss.n99 0.1445
R859 vss.n395 vss.n99 0.1445
R860 vss.n396 vss.n395 0.1445
R861 vss.n397 vss.n396 0.1445
R862 vss.n397 vss.n87 0.1445
R863 vss.n415 vss.n87 0.1445
R864 vss.n416 vss.n415 0.1445
R865 vss.n418 vss.n416 0.1445
R866 vss.n418 vss.n417 0.1445
R867 vss.n417 vss.n12 0.1445
R868 vss.n13 vss.n12 0.1445
R869 vss.n14 vss.n13 0.1445
R870 vss.n30 vss.n14 0.1445
R871 vss.n31 vss.n30 0.1445
R872 vss.n32 vss.n31 0.1445
R873 vss.n33 vss.n32 0.1445
R874 vss.n48 vss.n33 0.1445
R875 vss.n49 vss.n48 0.1445
R876 vss.n50 vss.n49 0.1445
R877 vss.n51 vss.n50 0.1445
R878 vss.n457 vss.n51 0.1445
R879 vss.n458 vss.n457 0.1445
R880 vss.n459 vss.n458 0.1445
R881 vss.n459 vss.n64 0.1445
R882 vss.n488 vss.n487 0.1445
R883 vss.n489 vss.n43 0.1445
R884 vss.n70 vss.n68 0.1445
R885 vss.n69 vss.n60 0.1445
R886 vss.n229 vss.n228 0.1445
R887 vss.n229 vss.n213 0.1445
R888 vss.n243 vss.n213 0.1445
R889 vss.n244 vss.n243 0.1445
R890 vss.n245 vss.n244 0.1445
R891 vss.n245 vss.n201 0.1445
R892 vss.n259 vss.n201 0.1445
R893 vss.n260 vss.n259 0.1445
R894 vss.n261 vss.n260 0.1445
R895 vss.n261 vss.n189 0.1445
R896 vss.n275 vss.n189 0.1445
R897 vss.n276 vss.n275 0.1445
R898 vss.n277 vss.n276 0.1445
R899 vss.n277 vss.n177 0.1445
R900 vss.n291 vss.n177 0.1445
R901 vss.n292 vss.n291 0.1445
R902 vss.n293 vss.n292 0.1445
R903 vss.n293 vss.n165 0.1445
R904 vss.n307 vss.n165 0.1445
R905 vss.n308 vss.n307 0.1445
R906 vss.n309 vss.n308 0.1445
R907 vss.n309 vss.n153 0.1445
R908 vss.n323 vss.n153 0.1445
R909 vss.n324 vss.n323 0.1445
R910 vss.n325 vss.n324 0.1445
R911 vss.n325 vss.n141 0.1445
R912 vss.n339 vss.n141 0.1445
R913 vss.n340 vss.n339 0.1445
R914 vss.n341 vss.n340 0.1445
R915 vss.n341 vss.n129 0.1445
R916 vss.n355 vss.n129 0.1445
R917 vss.n356 vss.n355 0.1445
R918 vss.n357 vss.n356 0.1445
R919 vss.n357 vss.n117 0.1445
R920 vss.n371 vss.n117 0.1445
R921 vss.n372 vss.n371 0.1445
R922 vss.n373 vss.n372 0.1445
R923 vss.n373 vss.n105 0.1445
R924 vss.n387 vss.n105 0.1445
R925 vss.n388 vss.n387 0.1445
R926 vss.n389 vss.n388 0.1445
R927 vss.n389 vss.n93 0.1445
R928 vss.n403 vss.n93 0.1445
R929 vss.n404 vss.n403 0.1445
R930 vss.n405 vss.n404 0.1445
R931 vss.n406 vss.n405 0.1445
R932 vss.n406 vss.n81 0.1445
R933 vss.n425 vss.n81 0.1445
R934 vss.n426 vss.n425 0.1445
R935 vss.n427 vss.n426 0.1445
R936 vss.n427 vss.n79 0.1445
R937 vss.n433 vss.n79 0.1445
R938 vss.n434 vss.n433 0.1445
R939 vss.n435 vss.n434 0.1445
R940 vss.n435 vss.n77 0.1445
R941 vss.n441 vss.n77 0.1445
R942 vss.n442 vss.n441 0.1445
R943 vss.n443 vss.n442 0.1445
R944 vss.n443 vss.n75 0.1445
R945 vss.n449 vss.n75 0.1445
R946 vss.n450 vss.n449 0.1445
R947 vss.n451 vss.n450 0.1445
R948 vss.n451 vss.n63 0.1445
R949 vss.n20 vss.n17 0.1445
R950 vss.n19 vss.n18 0.1445
R951 vss.n491 vss.n0 0.118981
R952 vss.n473 vss.n472 0.118981
R953 vss.n515 vss.n514 0.118981
R954 vdd.n13 vdd.n12 528.52
R955 vdd.n12 vdd.n4 528.52
R956 vdd.n30 vdd.n29 528.52
R957 vdd.n29 vdd.n28 528.52
R958 vdd.n48 vdd.n47 528.52
R959 vdd.n47 vdd.n46 528.52
R960 vdd.n11 vdd.n2 61.6005
R961 vdd.n11 vdd.n10 61.6005
R962 vdd.n5 vdd.n3 61.6005
R963 vdd.n14 vdd.n3 61.6005
R964 vdd.n31 vdd.n20 61.6005
R965 vdd.n27 vdd.n20 61.6005
R966 vdd.n22 vdd.n21 61.6005
R967 vdd.n21 vdd.n19 61.6005
R968 vdd.n49 vdd.n38 61.6005
R969 vdd.n45 vdd.n38 61.6005
R970 vdd.n40 vdd.n39 61.6005
R971 vdd.n39 vdd.n37 61.6005
R972 vdd.n15 vdd.n14 6.37187
R973 vdd.n15 vdd.n2 6.37187
R974 vdd.n32 vdd.n31 6.37187
R975 vdd.n32 vdd.n19 6.37187
R976 vdd.n50 vdd.n49 6.37187
R977 vdd.n50 vdd.n37 6.37187
R978 vdd.n10 vdd.n9 6.3005
R979 vdd.n6 vdd.n5 6.3005
R980 vdd.n27 vdd.n26 6.3005
R981 vdd.n23 vdd.n22 6.3005
R982 vdd.n45 vdd.n44 6.3005
R983 vdd.n41 vdd.n40 6.3005
R984 vdd vdd.n52 5.603
R985 vdd.n7 vdd.n1 5.19561
R986 vdd.n8 vdd.n0 5.19561
R987 vdd.n24 vdd.n18 5.19561
R988 vdd.n25 vdd.n17 5.19561
R989 vdd.n42 vdd.n36 5.19561
R990 vdd.n43 vdd.n35 5.19561
R991 vdd.n16 vdd.n1 4.98321
R992 vdd.n33 vdd.n18 4.98321
R993 vdd.n51 vdd.n36 4.98321
R994 vdd.n16 vdd.n0 4.97539
R995 vdd.n33 vdd.n17 4.97539
R996 vdd.n51 vdd.n35 4.97539
R997 vdd.n9 vdd.n8 4.5005
R998 vdd.n7 vdd.n6 4.5005
R999 vdd.n26 vdd.n25 4.5005
R1000 vdd.n24 vdd.n23 4.5005
R1001 vdd.n44 vdd.n43 4.5005
R1002 vdd.n42 vdd.n41 4.5005
R1003 vdd.n10 vdd.n4 3.31679
R1004 vdd.n5 vdd.n4 3.31679
R1005 vdd.n13 vdd.n2 3.31679
R1006 vdd.n14 vdd.n13 3.31679
R1007 vdd.n28 vdd.n27 3.31679
R1008 vdd.n28 vdd.n22 3.31679
R1009 vdd.n30 vdd.n19 3.31679
R1010 vdd.n31 vdd.n30 3.31679
R1011 vdd.n46 vdd.n45 3.31679
R1012 vdd.n46 vdd.n40 3.31679
R1013 vdd.n48 vdd.n37 3.31679
R1014 vdd.n49 vdd.n48 3.31679
R1015 vdd.n16 vdd.n15 2.21557
R1016 vdd.n33 vdd.n32 2.21557
R1017 vdd.n51 vdd.n50 2.21557
R1018 vdd.n11 vdd.n0 0.9005
R1019 vdd.n12 vdd.n11 0.9005
R1020 vdd.n3 vdd.n1 0.9005
R1021 vdd.n12 vdd.n3 0.9005
R1022 vdd.n20 vdd.n17 0.9005
R1023 vdd.n29 vdd.n20 0.9005
R1024 vdd.n21 vdd.n18 0.9005
R1025 vdd.n29 vdd.n21 0.9005
R1026 vdd.n38 vdd.n35 0.9005
R1027 vdd.n47 vdd.n38 0.9005
R1028 vdd.n39 vdd.n36 0.9005
R1029 vdd.n47 vdd.n39 0.9005
R1030 vdd.n34 vdd.n16 0.318485
R1031 vdd.n52 vdd.n34 0.2057
R1032 vdd.n9 vdd.n6 0.1445
R1033 vdd.n8 vdd.n7 0.1445
R1034 vdd.n26 vdd.n23 0.1445
R1035 vdd.n25 vdd.n24 0.1445
R1036 vdd.n44 vdd.n41 0.1445
R1037 vdd.n43 vdd.n42 0.1445
R1038 vdd.n34 vdd.n33 0.113285
R1039 vdd.n52 vdd.n51 0.113285
C0 Iin spike_neg 0.94275f
C1 m4_0/a_28_n131# spike 0.23746f
C2 Iin spike 0.17272f
C3 spike_neg spike 0.65333f
C4 m4_0/a_28_n131# vdd 0.38515f
C5 Iin vdd 0.10924f
C6 spike_neg vdd 0.59553f
C7 spike vdd 0.31811f
C8 Iin m4_0/a_28_n131# 0.84453f
C9 m4_0/a_28_n131# spike_neg 1.46457f
C10 spike vss 0.80662f
C11 vdd.n0 vss 0.01362f
C12 vdd.n1 vss 0.0082f
C13 vdd.n2 vss 0.0029f
C14 vdd.n3 vss 0.00465f
C15 vdd.n4 vss 0.02546f
C16 vdd.n5 vss 0.00288f
C17 vdd.n6 vss 0.00115f
C18 vdd.n7 vss 0.00364f
C19 vdd.n8 vss 0.00364f
C20 vdd.n9 vss 0.00115f
C21 vdd.n10 vss 0.00288f
C22 vdd.n11 vss 0.00465f
C23 vdd.n12 vss 0.0368f
C24 vdd.n13 vss 0.02546f
C25 vdd.n14 vss 0.0029f
C26 vdd.n15 vss 0.00227f
C27 vdd.n16 vss 0.0413f
C28 vdd.n17 vss 0.01362f
C29 vdd.n18 vss 0.0082f
C30 vdd.n19 vss 0.0029f
C31 vdd.n20 vss 0.00465f
C32 vdd.n21 vss 0.00465f
C33 vdd.n22 vss 0.00288f
C34 vdd.n23 vss 0.00115f
C35 vdd.n24 vss 0.00364f
C36 vdd.n25 vss 0.00364f
C37 vdd.n26 vss 0.00115f
C38 vdd.n27 vss 0.00288f
C39 vdd.n28 vss 0.02546f
C40 vdd.n29 vss 0.0368f
C41 vdd.n30 vss 0.02546f
C42 vdd.n31 vss 0.0029f
C43 vdd.n32 vss 0.00227f
C44 vdd.n33 vss 0.02687f
C45 vdd.n34 vss 0.04363f
C46 vdd.n35 vss 0.01362f
C47 vdd.n36 vss 0.0082f
C48 vdd.n37 vss 0.0029f
C49 vdd.n38 vss 0.00465f
C50 vdd.n39 vss 0.00465f
C51 vdd.n40 vss 0.00288f
C52 vdd.n41 vss 0.00115f
C53 vdd.n42 vss 0.00364f
C54 vdd.n43 vss 0.00364f
C55 vdd.n44 vss 0.00115f
C56 vdd.n45 vss 0.00288f
C57 vdd.n46 vss 0.02546f
C58 vdd.n47 vss 0.0368f
C59 vdd.n48 vss 0.02546f
C60 vdd.n49 vss 0.0029f
C61 vdd.n50 vss 0.00227f
C62 vdd.n51 vss 0.02687f
C63 vdd.n52 vss 0.15263f
C64 vss.n0 vss 0.00851f
C65 vss.n1 vss 0.00315f
C66 vss.n2 vss 0.00189f
C67 vss.n3 vss 0
C68 vss.n4 vss 0.00107f
C69 vss.n5 vss 0.00806f
C70 vss.n6 vss 0
C71 vss.n7 vss 0
C72 vss.n8 vss 0.00626f
C73 vss.n9 vss 0
C74 vss.n10 vss 0
C75 vss.n11 vss 0
C76 vss.n12 vss 0
C77 vss.n13 vss 0
C78 vss.n14 vss 0
C79 vss.n15 vss 0
C80 vss.n16 vss 0
C81 vss.n17 vss 0
C82 vss.n18 vss 0
C83 vss.n19 vss 0
C84 vss.n20 vss 0
C85 vss.n21 vss 0
C86 vss.n22 vss 0.00107f
C87 vss.n23 vss 0.00626f
C88 vss.n24 vss 0
C89 vss.n25 vss 0
C90 vss.n26 vss 0.01921f
C91 vss.n27 vss 0
C92 vss.n28 vss 0.00626f
C93 vss.n29 vss 0
C94 vss.n30 vss 0
C95 vss.n31 vss 0
C96 vss.n32 vss 0
C97 vss.n33 vss 0
C98 vss.n34 vss 0
C99 vss.n35 vss 0
C100 vss.n36 vss 0.01009f
C101 vss.n37 vss 0
C102 vss.n38 vss 0
C103 vss.n39 vss 0.00626f
C104 vss.n40 vss 0.00107f
C105 vss.n41 vss 0
C106 vss.n42 vss 0.00315f
C107 vss.n43 vss 0
C108 vss.n44 vss 0.00107f
C109 vss.n45 vss 0
C110 vss.n46 vss 0.00626f
C111 vss.n47 vss 0
C112 vss.n48 vss 0
C113 vss.n49 vss 0
C114 vss.n50 vss 0
C115 vss.n51 vss 0
C116 vss.n52 vss 0
C117 vss.n53 vss 0
C118 vss.n54 vss 0.00854f
C119 vss.n55 vss 0
C120 vss.n56 vss 0
C121 vss.n57 vss 0.01064f
C122 vss.n58 vss 0
C123 vss.n59 vss 0
C124 vss.n60 vss 0
C125 vss.n61 vss 0.00315f
C126 vss.n62 vss 0
C127 vss.n63 vss 0
C128 vss.n64 vss 0.00208f
C129 vss.n65 vss 0
C130 vss.n66 vss 0
C131 vss.n67 vss 0.01064f
C132 vss.n68 vss 0
C133 vss.n69 vss 0
C134 vss.n70 vss 0
C135 vss.n71 vss 0
C136 vss.n72 vss 0.00626f
C137 vss.n73 vss 0
C138 vss.n74 vss 0
C139 vss.n75 vss 0
C140 vss.n76 vss 0
C141 vss.n77 vss 0
C142 vss.n78 vss 0
C143 vss.n79 vss 0
C144 vss.n80 vss 0
C145 vss.n81 vss 0
C146 vss.n82 vss 0
C147 vss.n83 vss 0
C148 vss.n84 vss 0.00618f
C149 vss.n85 vss 0
C150 vss.n86 vss 0
C151 vss.n87 vss 0
C152 vss.n88 vss 0
C153 vss.n89 vss 0
C154 vss.n90 vss 0.01878f
C155 vss.n91 vss 0
C156 vss.n92 vss 0
C157 vss.n93 vss 0
C158 vss.n94 vss 0
C159 vss.n95 vss 0
C160 vss.n96 vss 0.01878f
C161 vss.n97 vss 0
C162 vss.n98 vss 0
C163 vss.n99 vss 0
C164 vss.n100 vss 0
C165 vss.n101 vss 0
C166 vss.n102 vss 0.01878f
C167 vss.n103 vss 0
C168 vss.n104 vss 0
C169 vss.n105 vss 0
C170 vss.n106 vss 0
C171 vss.n107 vss 0
C172 vss.n108 vss 0.01878f
C173 vss.n109 vss 0
C174 vss.n110 vss 0
C175 vss.n111 vss 0
C176 vss.n112 vss 0
C177 vss.n113 vss 0
C178 vss.n114 vss 0.01878f
C179 vss.n115 vss 0
C180 vss.n116 vss 0
C181 vss.n117 vss 0
C182 vss.n118 vss 0
C183 vss.n119 vss 0
C184 vss.n120 vss 0.01878f
C185 vss.n121 vss 0
C186 vss.n122 vss 0
C187 vss.n123 vss 0
C188 vss.n124 vss 0
C189 vss.n125 vss 0
C190 vss.n126 vss 0.01878f
C191 vss.n127 vss 0
C192 vss.n128 vss 0
C193 vss.n129 vss 0
C194 vss.n130 vss 0
C195 vss.n131 vss 0
C196 vss.n132 vss 0.01878f
C197 vss.n133 vss 0
C198 vss.n134 vss 0
C199 vss.n135 vss 0
C200 vss.n136 vss 0
C201 vss.n137 vss 0
C202 vss.n138 vss 0.01878f
C203 vss.n139 vss 0
C204 vss.n140 vss 0
C205 vss.n141 vss 0
C206 vss.n142 vss 0
C207 vss.n143 vss 0
C208 vss.n144 vss 0.01878f
C209 vss.n145 vss 0
C210 vss.n146 vss 0
C211 vss.n147 vss 0
C212 vss.n148 vss 0
C213 vss.n149 vss 0
C214 vss.n150 vss 0.01878f
C215 vss.n151 vss 0
C216 vss.n152 vss 0
C217 vss.n153 vss 0
C218 vss.n154 vss 0
C219 vss.n155 vss 0
C220 vss.n156 vss 0.01878f
C221 vss.n157 vss 0
C222 vss.n158 vss 0
C223 vss.n159 vss 0
C224 vss.n160 vss 0
C225 vss.n161 vss 0
C226 vss.n162 vss 0.01878f
C227 vss.n163 vss 0
C228 vss.n164 vss 0
C229 vss.n165 vss 0
C230 vss.n166 vss 0
C231 vss.n167 vss 0
C232 vss.n168 vss 0.01878f
C233 vss.n169 vss 0
C234 vss.n170 vss 0
C235 vss.n171 vss 0
C236 vss.n172 vss 0
C237 vss.n173 vss 0
C238 vss.n174 vss 0.01878f
C239 vss.n175 vss 0
C240 vss.n176 vss 0
C241 vss.n177 vss 0
C242 vss.n178 vss 0
C243 vss.n179 vss 0
C244 vss.n180 vss 0.01878f
C245 vss.n181 vss 0
C246 vss.n182 vss 0
C247 vss.n183 vss 0
C248 vss.n184 vss 0
C249 vss.n185 vss 0
C250 vss.n186 vss 0.01878f
C251 vss.n187 vss 0
C252 vss.n188 vss 0
C253 vss.n189 vss 0
C254 vss.n190 vss 0
C255 vss.n191 vss 0
C256 vss.n192 vss 0.01878f
C257 vss.n193 vss 0
C258 vss.n194 vss 0
C259 vss.n195 vss 0
C260 vss.n196 vss 0
C261 vss.n197 vss 0
C262 vss.n198 vss 0.01878f
C263 vss.n199 vss 0
C264 vss.n200 vss 0
C265 vss.n201 vss 0
C266 vss.n202 vss 0
C267 vss.n203 vss 0
C268 vss.n204 vss 0.01878f
C269 vss.n205 vss 0
C270 vss.n206 vss 0
C271 vss.n207 vss 0
C272 vss.n208 vss 0
C273 vss.n209 vss 0
C274 vss.n210 vss 0.01878f
C275 vss.n211 vss 0
C276 vss.n212 vss 0
C277 vss.n213 vss 0
C278 vss.n214 vss 0
C279 vss.n215 vss 0
C280 vss.n216 vss 0.01878f
C281 vss.n217 vss 0
C282 vss.n218 vss 0
C283 vss.n219 vss 0
C284 vss.n220 vss 0
C285 vss.n221 vss 0
C286 vss.n222 vss 0.02453f
C287 vss.n223 vss 0
C288 vss.n224 vss 0
C289 vss.n226 vss 0.0737f
C290 vss.n227 vss 0.00251f
C291 vss.n228 vss 0
C292 vss.n229 vss 0
C293 vss.n230 vss 0
C294 vss.n231 vss 0
C295 vss.n232 vss 0.01878f
C296 vss.n233 vss 0
C297 vss.n234 vss 0
C298 vss.n235 vss 0
C299 vss.n236 vss 0
C300 vss.n237 vss 0
C301 vss.n238 vss 0
C302 vss.n239 vss 0
C303 vss.n240 vss 0.01878f
C304 vss.n241 vss 0
C305 vss.n242 vss 0
C306 vss.n243 vss 0
C307 vss.n244 vss 0
C308 vss.n245 vss 0
C309 vss.n246 vss 0
C310 vss.n247 vss 0
C311 vss.n248 vss 0.01878f
C312 vss.n249 vss 0
C313 vss.n250 vss 0
C314 vss.n251 vss 0
C315 vss.n252 vss 0
C316 vss.n253 vss 0
C317 vss.n254 vss 0
C318 vss.n255 vss 0
C319 vss.n256 vss 0.01878f
C320 vss.n257 vss 0
C321 vss.n258 vss 0
C322 vss.n259 vss 0
C323 vss.n260 vss 0
C324 vss.n261 vss 0
C325 vss.n262 vss 0
C326 vss.n263 vss 0
C327 vss.n264 vss 0.01878f
C328 vss.n265 vss 0
C329 vss.n266 vss 0
C330 vss.n267 vss 0
C331 vss.n268 vss 0
C332 vss.n269 vss 0
C333 vss.n270 vss 0
C334 vss.n271 vss 0
C335 vss.n272 vss 0.01878f
C336 vss.n273 vss 0
C337 vss.n274 vss 0
C338 vss.n275 vss 0
C339 vss.n276 vss 0
C340 vss.n277 vss 0
C341 vss.n278 vss 0
C342 vss.n279 vss 0
C343 vss.n280 vss 0.01878f
C344 vss.n281 vss 0
C345 vss.n282 vss 0
C346 vss.n283 vss 0
C347 vss.n284 vss 0
C348 vss.n285 vss 0
C349 vss.n286 vss 0
C350 vss.n287 vss 0
C351 vss.n288 vss 0.01878f
C352 vss.n289 vss 0
C353 vss.n290 vss 0
C354 vss.n291 vss 0
C355 vss.n292 vss 0
C356 vss.n293 vss 0
C357 vss.n294 vss 0
C358 vss.n295 vss 0
C359 vss.n296 vss 0.01878f
C360 vss.n297 vss 0
C361 vss.n298 vss 0
C362 vss.n299 vss 0
C363 vss.n300 vss 0
C364 vss.n301 vss 0
C365 vss.n302 vss 0
C366 vss.n303 vss 0
C367 vss.n304 vss 0.01878f
C368 vss.n305 vss 0
C369 vss.n306 vss 0
C370 vss.n307 vss 0
C371 vss.n308 vss 0
C372 vss.n309 vss 0
C373 vss.n310 vss 0
C374 vss.n311 vss 0
C375 vss.n312 vss 0.01878f
C376 vss.n313 vss 0
C377 vss.n314 vss 0
C378 vss.n315 vss 0
C379 vss.n316 vss 0
C380 vss.n317 vss 0
C381 vss.n318 vss 0
C382 vss.n319 vss 0
C383 vss.n320 vss 0.01878f
C384 vss.n321 vss 0
C385 vss.n322 vss 0
C386 vss.n323 vss 0
C387 vss.n324 vss 0
C388 vss.n325 vss 0
C389 vss.n326 vss 0
C390 vss.n327 vss 0
C391 vss.n328 vss 0.01878f
C392 vss.n329 vss 0
C393 vss.n330 vss 0
C394 vss.n331 vss 0
C395 vss.n332 vss 0
C396 vss.n333 vss 0
C397 vss.n334 vss 0
C398 vss.n335 vss 0
C399 vss.n336 vss 0.01878f
C400 vss.n337 vss 0
C401 vss.n338 vss 0
C402 vss.n339 vss 0
C403 vss.n340 vss 0
C404 vss.n341 vss 0
C405 vss.n342 vss 0
C406 vss.n343 vss 0
C407 vss.n344 vss 0.01878f
C408 vss.n345 vss 0
C409 vss.n346 vss 0
C410 vss.n347 vss 0
C411 vss.n348 vss 0
C412 vss.n349 vss 0
C413 vss.n350 vss 0
C414 vss.n351 vss 0
C415 vss.n352 vss 0.01878f
C416 vss.n353 vss 0
C417 vss.n354 vss 0
C418 vss.n355 vss 0
C419 vss.n356 vss 0
C420 vss.n357 vss 0
C421 vss.n358 vss 0
C422 vss.n359 vss 0
C423 vss.n360 vss 0.01878f
C424 vss.n361 vss 0
C425 vss.n362 vss 0
C426 vss.n363 vss 0
C427 vss.n364 vss 0
C428 vss.n365 vss 0
C429 vss.n366 vss 0
C430 vss.n367 vss 0
C431 vss.n368 vss 0.01878f
C432 vss.n369 vss 0
C433 vss.n370 vss 0
C434 vss.n371 vss 0
C435 vss.n372 vss 0
C436 vss.n373 vss 0
C437 vss.n374 vss 0
C438 vss.n375 vss 0
C439 vss.n376 vss 0.01878f
C440 vss.n377 vss 0
C441 vss.n378 vss 0
C442 vss.n379 vss 0
C443 vss.n380 vss 0
C444 vss.n381 vss 0
C445 vss.n382 vss 0
C446 vss.n383 vss 0
C447 vss.n384 vss 0.01878f
C448 vss.n385 vss 0
C449 vss.n386 vss 0
C450 vss.n387 vss 0
C451 vss.n388 vss 0
C452 vss.n389 vss 0
C453 vss.n390 vss 0
C454 vss.n391 vss 0
C455 vss.n392 vss 0.01878f
C456 vss.n393 vss 0
C457 vss.n394 vss 0
C458 vss.n395 vss 0
C459 vss.n396 vss 0
C460 vss.n397 vss 0
C461 vss.n398 vss 0
C462 vss.n399 vss 0
C463 vss.n400 vss 0.01878f
C464 vss.n401 vss 0
C465 vss.n402 vss 0
C466 vss.n403 vss 0
C467 vss.n404 vss 0
C468 vss.n405 vss 0
C469 vss.n406 vss 0
C470 vss.n407 vss 0
C471 vss.n408 vss 0
C472 vss.n409 vss 0
C473 vss.n410 vss 0.01177f
C474 vss.n411 vss 0.00951f
C475 vss.n412 vss 0.01878f
C476 vss.n413 vss 0
C477 vss.n414 vss 0
C478 vss.n415 vss 0
C479 vss.n416 vss 0
C480 vss.n417 vss 0
C481 vss.n418 vss 0
C482 vss.n419 vss 0
C483 vss.n420 vss 0
C484 vss.n421 vss 0.00884f
C485 vss.n422 vss 0
C486 vss.n423 vss 0
C487 vss.n424 vss 0
C488 vss.n425 vss 0
C489 vss.n426 vss 0
C490 vss.n427 vss 0
C491 vss.n428 vss 0.01064f
C492 vss.n429 vss 0
C493 vss.n430 vss 0
C494 vss.n431 vss 0
C495 vss.n432 vss 0
C496 vss.n433 vss 0
C497 vss.n434 vss 0
C498 vss.n435 vss 0
C499 vss.n436 vss 0
C500 vss.n437 vss 0
C501 vss.n438 vss 0
C502 vss.n439 vss 0
C503 vss.n440 vss 0
C504 vss.n441 vss 0
C505 vss.n442 vss 0
C506 vss.n443 vss 0
C507 vss.n444 vss 0.00751f
C508 vss.n445 vss 0
C509 vss.n446 vss 0
C510 vss.n447 vss 0
C511 vss.n448 vss 0
C512 vss.n449 vss 0
C513 vss.n450 vss 0
C514 vss.n451 vss 0
C515 vss.n452 vss 0
C516 vss.n453 vss 0
C517 vss.n454 vss 0
C518 vss.n455 vss 0
C519 vss.n456 vss 0
C520 vss.n457 vss 0
C521 vss.n458 vss 0
C522 vss.n459 vss 0
C523 vss.n460 vss 0
C524 vss.n461 vss 0
C525 vss.n462 vss 0
C526 vss.n463 vss 0.00626f
C527 vss.n464 vss 0.00626f
C528 vss.n465 vss 0
C529 vss.n466 vss 0.00107f
C530 vss.n467 vss 0.03294f
C531 vss.n468 vss 0.05839f
C532 vss.n469 vss 0.0013f
C533 vss.n470 vss 0.02333f
C534 vss.n471 vss 0.00311f
C535 vss.n472 vss 0.01215f
C536 vss.n473 vss 0.00661f
C537 vss.n474 vss 0.00189f
C538 vss.n475 vss 0.00107f
C539 vss.n476 vss 0.00626f
C540 vss.n477 vss 0.00743f
C541 vss.n478 vss 0.00634f
C542 vss.n479 vss 0
C543 vss.n480 vss 0
C544 vss.n481 vss 0
C545 vss.n482 vss 0
C546 vss.n483 vss 0
C547 vss.n484 vss 0.01064f
C548 vss.n485 vss 0.00626f
C549 vss.n486 vss 0
C550 vss.n487 vss 0
C551 vss.n488 vss 0
C552 vss.n489 vss 0
C553 vss.n490 vss 0.00189f
C554 vss.n491 vss 0.00661f
C555 vss.n492 vss 0
C556 vss.n493 vss 0
C557 vss.n494 vss 0.00626f
C558 vss.n495 vss 0.00681f
C559 vss.n496 vss 0
C560 vss.n497 vss 0
C561 vss.n498 vss 0
C562 vss.n499 vss 0
C563 vss.n500 vss 0
C564 vss.n501 vss 0.00751f
C565 vss.n502 vss 0.00854f
C566 vss.n503 vss 0.00743f
C567 vss.n504 vss 0.00634f
C568 vss.n505 vss 0
C569 vss.n506 vss 0
C570 vss.n507 vss 0
C571 vss.n508 vss 0
C572 vss.n509 vss 0
C573 vss.n510 vss 0.00626f
C574 vss.n511 vss 0.00626f
C575 vss.n512 vss 0
C576 vss.n513 vss 0
C577 vss.n514 vss 0.00661f
C578 vss.n515 vss 0.07391f
C579 spike_neg.n0 vss 0.04339f
C580 spike_neg.n1 vss 0.04339f
C581 spike_neg.n2 vss 0.0087f
C582 spike_neg.n3 vss 0.29057f
C583 spike_neg.n4 vss 0.0087f
C584 spike_neg.n5 vss 0.58543f
C585 Iin.n0 vss 0
C586 Iin.n1 vss 0
C587 Iin.n2 vss 0
C588 Iin.n3 vss 0.01269f
C589 Iin.n4 vss 0.001f
C590 vdd vss -6.56005f
C591 Iin vss -0.7906f
C592 spike_neg vss -2.1388f
C593 m4_0/a_28_n131# vss -0.78247f
.ends
