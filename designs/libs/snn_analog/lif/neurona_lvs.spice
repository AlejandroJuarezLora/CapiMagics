* NGSPICE file created from neurona_lvs.ext - technology: gf180mcuD

.subckt Unnamed_6ef8fc62 a_n5000_n414# a_n5120_n205# a_n5330_n579# a_5000_n205#
X0 a_5000_n205# a_n5000_n414# a_n5120_n205# a_n5330_n579# nfet_03v3 ad=0.75p pd=3.7u as=0.75p ps=3.7u w=1.25u l=50u
C0 a_n5000_n414# a_5000_n205# 0.16313f
C1 a_n5000_n414# a_n5120_n205# 1.79587f
C2 a_n5120_n205# a_5000_n205# 4.41454f
C3 a_5000_n205# a_n5330_n579# 5.24766f
C4 a_n5120_n205# a_n5330_n579# 1.123f
C5 a_n5000_n414# a_n5330_n579# 21.826f
.ends

.subckt Unnamed_89a8896a a_64_n131# w_n450_n560# a_n64_n339# a_n184_n131# VSUBS
X0 a_64_n131# a_n64_n339# a_n184_n131# w_n450_n560# pfet_03v3 ad=0.3p pd=2.2u as=0.3p ps=2.2u w=0.5u l=0.64u
C0 w_n450_n560# a_n64_n339# 0.46029f
C1 a_n184_n131# a_64_n131# 0.33132f
C2 w_n450_n560# a_64_n131# 0.48547f
C3 a_64_n131# a_n64_n339# 0.01761f
C4 w_n450_n560# a_n184_n131# 0.22492f
C5 a_n184_n131# a_n64_n339# 0.04083f
C6 a_64_n131# VSUBS 0.04567f
C7 a_n184_n131# VSUBS 0.04433f
C8 a_n64_n339# VSUBS 0.0526f
C9 w_n450_n560# VSUBS 3.77582f
.ends

.subckt Unnamed_32beef5d a_64_n131# a_n394_n504# a_n64_n339# a_n184_n131#
X0 a_64_n131# a_n64_n339# a_n184_n131# a_n394_n504# nfet_03v3 ad=0.3p pd=2.2u as=0.3p ps=2.2u w=0.5u l=0.64u
C0 a_n64_n339# a_n184_n131# 0.04083f
C1 a_n64_n339# a_64_n131# 0.01761f
C2 a_64_n131# a_n184_n131# 0.33132f
C3 a_64_n131# a_n394_n504# 0.53111f
C4 a_n184_n131# a_n394_n504# 0.26925f
C5 a_n64_n339# a_n394_n504# 0.51289f
.ends

.subckt neurona_lvs vss
XUnnamed_6ef8fc62_0 vss vss vss vss Unnamed_6ef8fc62
XUnnamed_89a8896a_0 vss vss Unnamed_89a8896a_2/a_64_n131# vss vss Unnamed_89a8896a
XUnnamed_89a8896a_1 vss vss Unnamed_89a8896a_2/a_64_n131# vss vss Unnamed_89a8896a
XUnnamed_89a8896a_2 Unnamed_89a8896a_2/a_64_n131# vss Unnamed_89a8896a_2/a_n64_n339#
+ vss vss Unnamed_89a8896a
XUnnamed_32beef5d_0 vss vss Unnamed_89a8896a_2/a_64_n131# vss Unnamed_32beef5d
XUnnamed_32beef5d_1 vss vss Unnamed_89a8896a_2/a_64_n131# vss Unnamed_32beef5d
XUnnamed_32beef5d_2 Unnamed_89a8896a_2/a_64_n131# vss Unnamed_89a8896a_2/a_n64_n339#
+ vss Unnamed_32beef5d
R0 vss.n538 vss.n262 18200
R1 vss.n539 vss.n261 18200
R2 vss.n538 vss.n537 14243.8
R3 vss.n539 vss.n538 4468.75
R4 vss.n540 vss.n539 4062.5
R5 vss.n327 vss.n326 521.494
R6 vss.n326 vss.n325 521.494
R7 vss.n310 vss.n309 521.494
R8 vss.n309 vss.n308 521.494
R9 vss.n293 vss.n292 521.494
R10 vss.n292 vss.n284 521.494
R11 vss.n537 vss.n263 233.853
R12 vss.n440 vss.n389 147.31
R13 vss.n467 vss.n376 147.31
R14 vss.n488 vss.n335 147.31
R15 vss.n521 vss.n345 147.31
R16 vss.n481 vss.n480 143.626
R17 vss.n477 vss.n361 143.626
R18 vss.n370 vss.n261 141.786
R19 vss.n527 vss.n262 134.419
R20 vss.n451 vss.n450 132.578
R21 vss.n458 vss.n382 132.578
R22 vss.n520 vss.n347 130.738
R23 vss.n352 vss.n347 125.213
R24 vss.n513 vss.n510 125.213
R25 vss.n458 vss.n457 123.371
R26 vss.n481 vss.n369 112.323
R27 vss.n528 vss.n335 104.959
R28 vss.n102 vss.n94 95.4133
R29 vss.n111 vss.n94 95.4133
R30 vss.n111 vss.n88 95.4133
R31 vss.n119 vss.n88 95.4133
R32 vss.n119 vss.n82 95.4133
R33 vss.n127 vss.n82 95.4133
R34 vss.n127 vss.n76 95.4133
R35 vss.n135 vss.n76 95.4133
R36 vss.n135 vss.n70 95.4133
R37 vss.n143 vss.n70 95.4133
R38 vss.n143 vss.n64 95.4133
R39 vss.n151 vss.n64 95.4133
R40 vss.n151 vss.n58 95.4133
R41 vss.n159 vss.n58 95.4133
R42 vss.n159 vss.n52 95.4133
R43 vss.n167 vss.n52 95.4133
R44 vss.n167 vss.n46 95.4133
R45 vss.n175 vss.n46 95.4133
R46 vss.n175 vss.n40 95.4133
R47 vss.n183 vss.n40 95.4133
R48 vss.n183 vss.n34 95.4133
R49 vss.n191 vss.n34 95.4133
R50 vss.n191 vss.n28 95.4133
R51 vss.n199 vss.n28 95.4133
R52 vss.n199 vss.n22 95.4133
R53 vss.n207 vss.n22 95.4133
R54 vss.n207 vss.n16 95.4133
R55 vss.n215 vss.n16 95.4133
R56 vss.n215 vss.n8 95.4133
R57 vss.n572 vss.n8 95.4133
R58 vss.n572 vss.n9 95.4133
R59 vss.n566 vss.n9 95.4133
R60 vss.n566 vss.n565 95.4133
R61 vss.n565 vss.n564 95.4133
R62 vss.n564 vss.n228 95.4133
R63 vss.n558 vss.n228 95.4133
R64 vss.n558 vss.n557 95.4133
R65 vss.n557 vss.n556 95.4133
R66 vss.n556 vss.n239 95.4133
R67 vss.n550 vss.n239 95.4133
R68 vss.n550 vss.n549 95.4133
R69 vss.n549 vss.n548 95.4133
R70 vss.n548 vss.n250 95.4133
R71 vss.n542 vss.n250 95.4133
R72 vss.n542 vss.n541 95.4133
R73 vss.n440 vss.n429 93.9099
R74 vss.n541 vss.n540 75.1381
R75 vss.n536 vss.n265 73.9866
R76 vss.n536 vss.n266 73.9866
R77 vss.n101 vss.n98 73.9866
R78 vss.n514 vss.n264 69.0283
R79 vss.n512 vss.n264 69.0283
R80 vss.n519 vss.n349 69.0283
R81 vss.n519 vss.n348 69.0283
R82 vss.n529 vss.n333 69.0283
R83 vss.n529 vss.n334 69.0283
R84 vss.n479 vss.n478 69.0283
R85 vss.n478 vss.n476 69.0283
R86 vss.n393 vss.n388 69.0283
R87 vss.n452 vss.n388 69.0283
R88 vss.n456 vss.n384 69.0283
R89 vss.n456 vss.n385 69.0283
R90 vss.n328 vss.n317 62.1255
R91 vss.n324 vss.n317 62.1255
R92 vss.n319 vss.n318 62.1255
R93 vss.n318 vss.n316 62.1255
R94 vss.n311 vss.n300 62.1255
R95 vss.n307 vss.n300 62.1255
R96 vss.n302 vss.n301 62.1255
R97 vss.n301 vss.n299 62.1255
R98 vss.n291 vss.n282 62.1255
R99 vss.n291 vss.n290 62.1255
R100 vss.n285 vss.n283 62.1255
R101 vss.n294 vss.n283 62.1255
R102 vss.n429 vss.n260 53.3999
R103 vss.n103 vss.n98 48.6503
R104 vss.n528 vss.n527 42.3518
R105 vss.n370 vss.n369 34.9863
R106 vss.n540 vss.n260 31.3036
R107 vss.n457 vss.n376 23.9382
R108 vss.n510 vss.n352 22.0968
R109 vss.n513 vss.n263 22.0968
R110 vss.n267 vss.n1 17.2005
R111 vss vss.n1 17.0096
R112 vss.n521 vss.n520 16.5727
R113 vss.n514 vss.n348 15.5561
R114 vss.n104 vss.n95 15.5561
R115 vss.n110 vss.n95 15.5561
R116 vss.n110 vss.n87 15.5561
R117 vss.n120 vss.n87 15.5561
R118 vss.n120 vss.n83 15.5561
R119 vss.n126 vss.n83 15.5561
R120 vss.n126 vss.n75 15.5561
R121 vss.n136 vss.n75 15.5561
R122 vss.n136 vss.n71 15.5561
R123 vss.n142 vss.n71 15.5561
R124 vss.n142 vss.n63 15.5561
R125 vss.n152 vss.n63 15.5561
R126 vss.n152 vss.n59 15.5561
R127 vss.n158 vss.n59 15.5561
R128 vss.n158 vss.n51 15.5561
R129 vss.n168 vss.n51 15.5561
R130 vss.n168 vss.n47 15.5561
R131 vss.n174 vss.n47 15.5561
R132 vss.n174 vss.n39 15.5561
R133 vss.n184 vss.n39 15.5561
R134 vss.n184 vss.n35 15.5561
R135 vss.n190 vss.n35 15.5561
R136 vss.n190 vss.n27 15.5561
R137 vss.n200 vss.n27 15.5561
R138 vss.n200 vss.n23 15.5561
R139 vss.n206 vss.n23 15.5561
R140 vss.n206 vss.n15 15.5561
R141 vss.n216 vss.n15 15.5561
R142 vss.n216 vss.n10 15.5561
R143 vss.n571 vss.n10 15.5561
R144 vss.n571 vss.n11 15.5561
R145 vss.n567 vss.n11 15.5561
R146 vss.n567 vss.n224 15.5561
R147 vss.n563 vss.n224 15.5561
R148 vss.n563 vss.n229 15.5561
R149 vss.n559 vss.n229 15.5561
R150 vss.n559 vss.n235 15.5561
R151 vss.n555 vss.n235 15.5561
R152 vss.n555 vss.n240 15.5561
R153 vss.n551 vss.n240 15.5561
R154 vss.n551 vss.n246 15.5561
R155 vss.n547 vss.n246 15.5561
R156 vss.n547 vss.n251 15.5561
R157 vss.n543 vss.n251 15.5561
R158 vss.n543 vss.n257 15.5561
R159 vss.n430 vss.n257 15.5561
R160 vss.n439 vss.n430 15.5561
R161 vss.n439 vss.n431 15.5561
R162 vss.n431 vss.n381 15.5561
R163 vss.n459 vss.n381 15.5561
R164 vss.n459 vss.n377 15.5561
R165 vss.n466 vss.n377 15.5561
R166 vss.n466 vss.n368 15.5561
R167 vss.n482 vss.n368 15.5561
R168 vss.n482 vss.n362 15.5561
R169 vss.n487 vss.n362 15.5561
R170 vss.n487 vss.n337 15.5561
R171 vss.n526 vss.n337 15.5561
R172 vss.n526 vss.n338 15.5561
R173 vss.n522 vss.n338 15.5561
R174 vss.n522 vss.n344 15.5561
R175 vss.n509 vss.n344 15.5561
R176 vss.n509 vss.n266 15.5561
R177 vss.n101 vss.n93 15.5561
R178 vss.n112 vss.n93 15.5561
R179 vss.n112 vss.n89 15.5561
R180 vss.n118 vss.n89 15.5561
R181 vss.n118 vss.n81 15.5561
R182 vss.n128 vss.n81 15.5561
R183 vss.n128 vss.n77 15.5561
R184 vss.n134 vss.n77 15.5561
R185 vss.n134 vss.n69 15.5561
R186 vss.n144 vss.n69 15.5561
R187 vss.n144 vss.n65 15.5561
R188 vss.n150 vss.n65 15.5561
R189 vss.n150 vss.n57 15.5561
R190 vss.n160 vss.n57 15.5561
R191 vss.n160 vss.n53 15.5561
R192 vss.n166 vss.n53 15.5561
R193 vss.n166 vss.n45 15.5561
R194 vss.n176 vss.n45 15.5561
R195 vss.n176 vss.n41 15.5561
R196 vss.n182 vss.n41 15.5561
R197 vss.n182 vss.n33 15.5561
R198 vss.n192 vss.n33 15.5561
R199 vss.n192 vss.n29 15.5561
R200 vss.n198 vss.n29 15.5561
R201 vss.n198 vss.n21 15.5561
R202 vss.n208 vss.n21 15.5561
R203 vss.n208 vss.n17 15.5561
R204 vss.n214 vss.n17 15.5561
R205 vss.n214 vss.n6 15.5561
R206 vss.n573 vss.n6 15.5561
R207 vss.n573 vss.n7 15.5561
R208 vss.n225 vss.n7 15.5561
R209 vss.n226 vss.n225 15.5561
R210 vss.n227 vss.n226 15.5561
R211 vss.n407 vss.n227 15.5561
R212 vss.n407 vss.n236 15.5561
R213 vss.n237 vss.n236 15.5561
R214 vss.n238 vss.n237 15.5561
R215 vss.n414 vss.n238 15.5561
R216 vss.n414 vss.n247 15.5561
R217 vss.n248 vss.n247 15.5561
R218 vss.n249 vss.n248 15.5561
R219 vss.n421 vss.n249 15.5561
R220 vss.n421 vss.n258 15.5561
R221 vss.n259 vss.n258 15.5561
R222 vss.n428 vss.n259 15.5561
R223 vss.n441 vss.n428 15.5561
R224 vss.n441 vss.n394 15.5561
R225 vss.n449 vss.n394 15.5561
R226 vss.n449 vss.n383 15.5561
R227 vss.n383 vss.n375 15.5561
R228 vss.n468 vss.n375 15.5561
R229 vss.n468 vss.n371 15.5561
R230 vss.n474 vss.n371 15.5561
R231 vss.n474 vss.n359 15.5561
R232 vss.n489 vss.n359 15.5561
R233 vss.n489 vss.n360 15.5561
R234 vss.n360 vss.n336 15.5561
R235 vss.n495 vss.n336 15.5561
R236 vss.n495 vss.n346 15.5561
R237 vss.n353 vss.n346 15.5561
R238 vss.n504 vss.n353 15.5561
R239 vss.n504 vss.n265 15.5561
R240 vss.n393 vss.n384 15.5561
R241 vss.n451 vss.n389 14.7314
R242 vss.n450 vss.n382 14.7314
R243 vss.n345 vss.n262 12.89
R244 vss.n332 vss.n331 11.8522
R245 vss.n534 vss.n533 11.0435
R246 vss.n365 vss.n363 7.6287
R247 vss.n329 vss.n328 6.37187
R248 vss.n329 vss.n316 6.37187
R249 vss.n312 vss.n311 6.37187
R250 vss.n312 vss.n299 6.37187
R251 vss.n295 vss.n294 6.37187
R252 vss.n295 vss.n282 6.37187
R253 vss.n324 vss.n323 6.3005
R254 vss.n320 vss.n319 6.3005
R255 vss.n307 vss.n306 6.3005
R256 vss.n303 vss.n302 6.3005
R257 vss.n290 vss.n289 6.3005
R258 vss.n286 vss.n285 6.3005
R259 vss.n467 vss.n261 5.52458
R260 vss.n99 vss.n97 5.25278
R261 vss.n106 vss.n97 5.25278
R262 vss.n518 vss.n517 5.20101
R263 vss.n321 vss.n279 5.20101
R264 vss.n322 vss.n278 5.20101
R265 vss.n304 vss.n298 5.20101
R266 vss.n305 vss.n297 5.20101
R267 vss.n287 vss.n281 5.20101
R268 vss.n288 vss.n280 5.20101
R269 vss.n390 vss.n387 5.20101
R270 vss.n426 vss.n259 5.2005
R271 vss.n541 vss.n259 5.2005
R272 vss.n397 vss.n258 5.2005
R273 vss.n542 vss.n258 5.2005
R274 vss.n422 vss.n421 5.2005
R275 vss.n421 vss.n250 5.2005
R276 vss.n420 vss.n249 5.2005
R277 vss.n548 vss.n249 5.2005
R278 vss.n419 vss.n248 5.2005
R279 vss.n549 vss.n248 5.2005
R280 vss.n399 vss.n247 5.2005
R281 vss.n550 vss.n247 5.2005
R282 vss.n415 vss.n414 5.2005
R283 vss.n414 vss.n239 5.2005
R284 vss.n413 vss.n238 5.2005
R285 vss.n556 vss.n238 5.2005
R286 vss.n412 vss.n237 5.2005
R287 vss.n557 vss.n237 5.2005
R288 vss.n401 vss.n236 5.2005
R289 vss.n558 vss.n236 5.2005
R290 vss.n408 vss.n407 5.2005
R291 vss.n407 vss.n228 5.2005
R292 vss.n406 vss.n227 5.2005
R293 vss.n564 vss.n227 5.2005
R294 vss.n405 vss.n226 5.2005
R295 vss.n565 vss.n226 5.2005
R296 vss.n403 vss.n225 5.2005
R297 vss.n566 vss.n225 5.2005
R298 vss.n7 vss.n3 5.2005
R299 vss.n9 vss.n7 5.2005
R300 vss.n574 vss.n573 5.2005
R301 vss.n573 vss.n572 5.2005
R302 vss.n6 vss.n5 5.2005
R303 vss.n8 vss.n6 5.2005
R304 vss.n214 vss.n213 5.2005
R305 vss.n215 vss.n214 5.2005
R306 vss.n18 vss.n17 5.2005
R307 vss.n17 vss.n16 5.2005
R308 vss.n209 vss.n208 5.2005
R309 vss.n208 vss.n207 5.2005
R310 vss.n21 vss.n20 5.2005
R311 vss.n22 vss.n21 5.2005
R312 vss.n198 vss.n197 5.2005
R313 vss.n199 vss.n198 5.2005
R314 vss.n30 vss.n29 5.2005
R315 vss.n29 vss.n28 5.2005
R316 vss.n193 vss.n192 5.2005
R317 vss.n192 vss.n191 5.2005
R318 vss.n33 vss.n32 5.2005
R319 vss.n34 vss.n33 5.2005
R320 vss.n182 vss.n181 5.2005
R321 vss.n183 vss.n182 5.2005
R322 vss.n42 vss.n41 5.2005
R323 vss.n41 vss.n40 5.2005
R324 vss.n177 vss.n176 5.2005
R325 vss.n176 vss.n175 5.2005
R326 vss.n45 vss.n44 5.2005
R327 vss.n46 vss.n45 5.2005
R328 vss.n166 vss.n165 5.2005
R329 vss.n167 vss.n166 5.2005
R330 vss.n54 vss.n53 5.2005
R331 vss.n53 vss.n52 5.2005
R332 vss.n161 vss.n160 5.2005
R333 vss.n160 vss.n159 5.2005
R334 vss.n57 vss.n56 5.2005
R335 vss.n58 vss.n57 5.2005
R336 vss.n150 vss.n149 5.2005
R337 vss.n151 vss.n150 5.2005
R338 vss.n66 vss.n65 5.2005
R339 vss.n65 vss.n64 5.2005
R340 vss.n145 vss.n144 5.2005
R341 vss.n144 vss.n143 5.2005
R342 vss.n69 vss.n68 5.2005
R343 vss.n70 vss.n69 5.2005
R344 vss.n134 vss.n133 5.2005
R345 vss.n135 vss.n134 5.2005
R346 vss.n78 vss.n77 5.2005
R347 vss.n77 vss.n76 5.2005
R348 vss.n129 vss.n128 5.2005
R349 vss.n128 vss.n127 5.2005
R350 vss.n81 vss.n80 5.2005
R351 vss.n82 vss.n81 5.2005
R352 vss.n118 vss.n117 5.2005
R353 vss.n119 vss.n118 5.2005
R354 vss.n90 vss.n89 5.2005
R355 vss.n89 vss.n88 5.2005
R356 vss.n113 vss.n112 5.2005
R357 vss.n112 vss.n111 5.2005
R358 vss.n93 vss.n92 5.2005
R359 vss.n94 vss.n93 5.2005
R360 vss.n101 vss.n100 5.2005
R361 vss.n102 vss.n101 5.2005
R362 vss.n257 vss.n256 5.2005
R363 vss.n541 vss.n257 5.2005
R364 vss.n544 vss.n543 5.2005
R365 vss.n543 vss.n542 5.2005
R366 vss.n545 vss.n251 5.2005
R367 vss.n251 vss.n250 5.2005
R368 vss.n547 vss.n546 5.2005
R369 vss.n548 vss.n547 5.2005
R370 vss.n246 vss.n245 5.2005
R371 vss.n549 vss.n246 5.2005
R372 vss.n552 vss.n551 5.2005
R373 vss.n551 vss.n550 5.2005
R374 vss.n553 vss.n240 5.2005
R375 vss.n240 vss.n239 5.2005
R376 vss.n555 vss.n554 5.2005
R377 vss.n556 vss.n555 5.2005
R378 vss.n235 vss.n234 5.2005
R379 vss.n557 vss.n235 5.2005
R380 vss.n560 vss.n559 5.2005
R381 vss.n559 vss.n558 5.2005
R382 vss.n561 vss.n229 5.2005
R383 vss.n229 vss.n228 5.2005
R384 vss.n563 vss.n562 5.2005
R385 vss.n564 vss.n563 5.2005
R386 vss.n224 vss.n223 5.2005
R387 vss.n565 vss.n224 5.2005
R388 vss.n568 vss.n567 5.2005
R389 vss.n567 vss.n566 5.2005
R390 vss.n569 vss.n11 5.2005
R391 vss.n11 vss.n9 5.2005
R392 vss.n571 vss.n570 5.2005
R393 vss.n572 vss.n571 5.2005
R394 vss.n12 vss.n10 5.2005
R395 vss.n10 vss.n8 5.2005
R396 vss.n217 vss.n216 5.2005
R397 vss.n216 vss.n215 5.2005
R398 vss.n15 vss.n14 5.2005
R399 vss.n16 vss.n15 5.2005
R400 vss.n206 vss.n205 5.2005
R401 vss.n207 vss.n206 5.2005
R402 vss.n24 vss.n23 5.2005
R403 vss.n23 vss.n22 5.2005
R404 vss.n201 vss.n200 5.2005
R405 vss.n200 vss.n199 5.2005
R406 vss.n27 vss.n26 5.2005
R407 vss.n28 vss.n27 5.2005
R408 vss.n190 vss.n189 5.2005
R409 vss.n191 vss.n190 5.2005
R410 vss.n36 vss.n35 5.2005
R411 vss.n35 vss.n34 5.2005
R412 vss.n185 vss.n184 5.2005
R413 vss.n184 vss.n183 5.2005
R414 vss.n39 vss.n38 5.2005
R415 vss.n40 vss.n39 5.2005
R416 vss.n174 vss.n173 5.2005
R417 vss.n175 vss.n174 5.2005
R418 vss.n48 vss.n47 5.2005
R419 vss.n47 vss.n46 5.2005
R420 vss.n169 vss.n168 5.2005
R421 vss.n168 vss.n167 5.2005
R422 vss.n51 vss.n50 5.2005
R423 vss.n52 vss.n51 5.2005
R424 vss.n158 vss.n157 5.2005
R425 vss.n159 vss.n158 5.2005
R426 vss.n60 vss.n59 5.2005
R427 vss.n59 vss.n58 5.2005
R428 vss.n153 vss.n152 5.2005
R429 vss.n152 vss.n151 5.2005
R430 vss.n63 vss.n62 5.2005
R431 vss.n64 vss.n63 5.2005
R432 vss.n142 vss.n141 5.2005
R433 vss.n143 vss.n142 5.2005
R434 vss.n72 vss.n71 5.2005
R435 vss.n71 vss.n70 5.2005
R436 vss.n137 vss.n136 5.2005
R437 vss.n136 vss.n135 5.2005
R438 vss.n75 vss.n74 5.2005
R439 vss.n76 vss.n75 5.2005
R440 vss.n126 vss.n125 5.2005
R441 vss.n127 vss.n126 5.2005
R442 vss.n84 vss.n83 5.2005
R443 vss.n83 vss.n82 5.2005
R444 vss.n121 vss.n120 5.2005
R445 vss.n120 vss.n119 5.2005
R446 vss.n87 vss.n86 5.2005
R447 vss.n88 vss.n87 5.2005
R448 vss.n110 vss.n109 5.2005
R449 vss.n111 vss.n110 5.2005
R450 vss.n96 vss.n95 5.2005
R451 vss.n95 vss.n94 5.2005
R452 vss.n105 vss.n104 5.2005
R453 vss.n361 vss.n333 5.2005
R454 vss.n480 vss.n476 5.2005
R455 vss.n361 vss.n334 5.2005
R456 vss.n480 vss.n479 5.2005
R457 vss.n515 vss.n514 5.2005
R458 vss.n514 vss.n513 5.2005
R459 vss.n516 vss.n348 5.2005
R460 vss.n352 vss.n348 5.2005
R461 vss.n513 vss.n512 5.2005
R462 vss.n352 vss.n349 5.2005
R463 vss.n502 vss.n265 5.2005
R464 vss.n265 vss.n263 5.2005
R465 vss.n504 vss.n503 5.2005
R466 vss.n510 vss.n504 5.2005
R467 vss.n354 vss.n353 5.2005
R468 vss.n353 vss.n347 5.2005
R469 vss.n497 vss.n346 5.2005
R470 vss.n521 vss.n346 5.2005
R471 vss.n496 vss.n495 5.2005
R472 vss.n495 vss.n345 5.2005
R473 vss.n494 vss.n336 5.2005
R474 vss.n527 vss.n336 5.2005
R475 vss.n360 vss.n356 5.2005
R476 vss.n360 vss.n335 5.2005
R477 vss.n490 vss.n489 5.2005
R478 vss.n489 vss.n488 5.2005
R479 vss.n359 vss.n358 5.2005
R480 vss.n477 vss.n359 5.2005
R481 vss.n474 vss.n473 5.2005
R482 vss.n481 vss.n474 5.2005
R483 vss.n372 vss.n371 5.2005
R484 vss.n371 vss.n370 5.2005
R485 vss.n469 vss.n468 5.2005
R486 vss.n468 vss.n467 5.2005
R487 vss.n375 vss.n374 5.2005
R488 vss.n376 vss.n375 5.2005
R489 vss.n447 vss.n383 5.2005
R490 vss.n458 vss.n383 5.2005
R491 vss.n449 vss.n448 5.2005
R492 vss.n450 vss.n449 5.2005
R493 vss.n395 vss.n394 5.2005
R494 vss.n394 vss.n389 5.2005
R495 vss.n442 vss.n441 5.2005
R496 vss.n441 vss.n440 5.2005
R497 vss.n428 vss.n427 5.2005
R498 vss.n428 vss.n260 5.2005
R499 vss.n507 vss.n266 5.2005
R500 vss.n266 vss.n263 5.2005
R501 vss.n509 vss.n508 5.2005
R502 vss.n510 vss.n509 5.2005
R503 vss.n344 vss.n343 5.2005
R504 vss.n347 vss.n344 5.2005
R505 vss.n523 vss.n522 5.2005
R506 vss.n522 vss.n521 5.2005
R507 vss.n524 vss.n338 5.2005
R508 vss.n345 vss.n338 5.2005
R509 vss.n526 vss.n525 5.2005
R510 vss.n527 vss.n526 5.2005
R511 vss.n339 vss.n337 5.2005
R512 vss.n337 vss.n335 5.2005
R513 vss.n487 vss.n486 5.2005
R514 vss.n488 vss.n487 5.2005
R515 vss.n484 vss.n362 5.2005
R516 vss.n477 vss.n362 5.2005
R517 vss.n483 vss.n482 5.2005
R518 vss.n482 vss.n481 5.2005
R519 vss.n368 vss.n366 5.2005
R520 vss.n370 vss.n368 5.2005
R521 vss.n466 vss.n465 5.2005
R522 vss.n467 vss.n466 5.2005
R523 vss.n378 vss.n377 5.2005
R524 vss.n377 vss.n376 5.2005
R525 vss.n460 vss.n459 5.2005
R526 vss.n459 vss.n458 5.2005
R527 vss.n381 vss.n380 5.2005
R528 vss.n450 vss.n381 5.2005
R529 vss.n437 vss.n431 5.2005
R530 vss.n431 vss.n389 5.2005
R531 vss.n439 vss.n438 5.2005
R532 vss.n440 vss.n439 5.2005
R533 vss.n432 vss.n430 5.2005
R534 vss.n430 vss.n260 5.2005
R535 vss.n391 vss.n384 5.2005
R536 vss.n384 vss.n382 5.2005
R537 vss.n393 vss.n392 5.2005
R538 vss.n451 vss.n393 5.2005
R539 vss.n385 vss.n382 5.2005
R540 vss.n452 vss.n451 5.2005
R541 vss.n351 vss.n350 5.19319
R542 vss.n455 vss.n386 5.19319
R543 vss.n332 vss.n276 5.12001
R544 vss.n530 vss.n332 5.11219
R545 vss.n501 vss.n267 5.04833
R546 vss.n535 vss.n534 5.02778
R547 vss.n531 vss.n276 4.98321
R548 vss.n518 vss.n269 4.98321
R549 vss.n350 vss.n269 4.98321
R550 vss.n531 vss.n530 4.98321
R551 vss.n330 vss.n279 4.98321
R552 vss.n313 vss.n298 4.98321
R553 vss.n296 vss.n281 4.98321
R554 vss.n455 vss.n454 4.98321
R555 vss.n454 vss.n387 4.98321
R556 vss.n330 vss.n278 4.97539
R557 vss.n313 vss.n297 4.97539
R558 vss.n296 vss.n280 4.97539
R559 vss vss.n0 4.8929
R560 vss.n107 vss.n96 4.5005
R561 vss.n109 vss.n108 4.5005
R562 vss.n86 vss.n85 4.5005
R563 vss.n122 vss.n121 4.5005
R564 vss.n123 vss.n84 4.5005
R565 vss.n125 vss.n124 4.5005
R566 vss.n74 vss.n73 4.5005
R567 vss.n138 vss.n137 4.5005
R568 vss.n139 vss.n72 4.5005
R569 vss.n141 vss.n140 4.5005
R570 vss.n62 vss.n61 4.5005
R571 vss.n154 vss.n153 4.5005
R572 vss.n155 vss.n60 4.5005
R573 vss.n157 vss.n156 4.5005
R574 vss.n50 vss.n49 4.5005
R575 vss.n170 vss.n169 4.5005
R576 vss.n171 vss.n48 4.5005
R577 vss.n173 vss.n172 4.5005
R578 vss.n38 vss.n37 4.5005
R579 vss.n186 vss.n185 4.5005
R580 vss.n187 vss.n36 4.5005
R581 vss.n189 vss.n188 4.5005
R582 vss.n26 vss.n25 4.5005
R583 vss.n202 vss.n201 4.5005
R584 vss.n203 vss.n24 4.5005
R585 vss.n205 vss.n204 4.5005
R586 vss.n14 vss.n13 4.5005
R587 vss.n218 vss.n217 4.5005
R588 vss.n219 vss.n12 4.5005
R589 vss.n570 vss.n220 4.5005
R590 vss.n569 vss.n221 4.5005
R591 vss.n568 vss.n222 4.5005
R592 vss.n230 vss.n223 4.5005
R593 vss.n562 vss.n231 4.5005
R594 vss.n561 vss.n232 4.5005
R595 vss.n560 vss.n233 4.5005
R596 vss.n241 vss.n234 4.5005
R597 vss.n554 vss.n242 4.5005
R598 vss.n553 vss.n243 4.5005
R599 vss.n552 vss.n244 4.5005
R600 vss.n252 vss.n245 4.5005
R601 vss.n546 vss.n253 4.5005
R602 vss.n545 vss.n254 4.5005
R603 vss.n544 vss.n255 4.5005
R604 vss.n433 vss.n256 4.5005
R605 vss.n434 vss.n432 4.5005
R606 vss.n438 vss.n435 4.5005
R607 vss.n437 vss.n436 4.5005
R608 vss.n380 vss.n379 4.5005
R609 vss.n461 vss.n460 4.5005
R610 vss.n462 vss.n378 4.5005
R611 vss.n465 vss.n464 4.5005
R612 vss.n463 vss.n366 4.5005
R613 vss.n483 vss.n367 4.5005
R614 vss.n106 vss.n105 4.5005
R615 vss.n515 vss.n351 4.5005
R616 vss.n517 vss.n516 4.5005
R617 vss.n323 vss.n322 4.5005
R618 vss.n321 vss.n320 4.5005
R619 vss.n306 vss.n305 4.5005
R620 vss.n304 vss.n303 4.5005
R621 vss.n289 vss.n288 4.5005
R622 vss.n287 vss.n286 4.5005
R623 vss.n364 vss.n339 4.5005
R624 vss.n525 vss.n340 4.5005
R625 vss.n524 vss.n341 4.5005
R626 vss.n523 vss.n342 4.5005
R627 vss.n505 vss.n343 4.5005
R628 vss.n508 vss.n506 4.5005
R629 vss.n507 vss.n268 4.5005
R630 vss.n92 vss.n91 4.5005
R631 vss.n114 vss.n113 4.5005
R632 vss.n115 vss.n90 4.5005
R633 vss.n117 vss.n116 4.5005
R634 vss.n80 vss.n79 4.5005
R635 vss.n130 vss.n129 4.5005
R636 vss.n131 vss.n78 4.5005
R637 vss.n133 vss.n132 4.5005
R638 vss.n68 vss.n67 4.5005
R639 vss.n146 vss.n145 4.5005
R640 vss.n147 vss.n66 4.5005
R641 vss.n149 vss.n148 4.5005
R642 vss.n56 vss.n55 4.5005
R643 vss.n162 vss.n161 4.5005
R644 vss.n163 vss.n54 4.5005
R645 vss.n165 vss.n164 4.5005
R646 vss.n44 vss.n43 4.5005
R647 vss.n178 vss.n177 4.5005
R648 vss.n179 vss.n42 4.5005
R649 vss.n181 vss.n180 4.5005
R650 vss.n32 vss.n31 4.5005
R651 vss.n194 vss.n193 4.5005
R652 vss.n195 vss.n30 4.5005
R653 vss.n197 vss.n196 4.5005
R654 vss.n20 vss.n19 4.5005
R655 vss.n210 vss.n209 4.5005
R656 vss.n211 vss.n18 4.5005
R657 vss.n213 vss.n212 4.5005
R658 vss.n5 vss.n4 4.5005
R659 vss.n575 vss.n574 4.5005
R660 vss.n576 vss.n3 4.5005
R661 vss.n403 vss.n2 4.5005
R662 vss.n405 vss.n404 4.5005
R663 vss.n406 vss.n402 4.5005
R664 vss.n409 vss.n408 4.5005
R665 vss.n410 vss.n401 4.5005
R666 vss.n412 vss.n411 4.5005
R667 vss.n413 vss.n400 4.5005
R668 vss.n416 vss.n415 4.5005
R669 vss.n417 vss.n399 4.5005
R670 vss.n419 vss.n418 4.5005
R671 vss.n420 vss.n398 4.5005
R672 vss.n423 vss.n422 4.5005
R673 vss.n424 vss.n397 4.5005
R674 vss.n426 vss.n425 4.5005
R675 vss.n427 vss.n396 4.5005
R676 vss.n443 vss.n442 4.5005
R677 vss.n444 vss.n395 4.5005
R678 vss.n448 vss.n445 4.5005
R679 vss.n447 vss.n446 4.5005
R680 vss.n374 vss.n373 4.5005
R681 vss.n470 vss.n469 4.5005
R682 vss.n471 vss.n372 4.5005
R683 vss.n473 vss.n472 4.5005
R684 vss.n358 vss.n357 4.5005
R685 vss.n491 vss.n490 4.5005
R686 vss.n492 vss.n356 4.5005
R687 vss.n494 vss.n493 4.5005
R688 vss.n496 vss.n355 4.5005
R689 vss.n498 vss.n497 4.5005
R690 vss.n499 vss.n354 4.5005
R691 vss.n503 vss.n500 4.5005
R692 vss.n502 vss.n501 4.5005
R693 vss.n100 vss.n99 4.5005
R694 vss.n391 vss.n386 4.5005
R695 vss.n392 vss.n390 4.5005
R696 vss.n480 vss.n477 3.68322
R697 vss.n488 vss.n361 3.68322
R698 vss.n103 vss.n102 3.42024
R699 vss.n325 vss.n324 3.31679
R700 vss.n325 vss.n319 3.31679
R701 vss.n327 vss.n316 3.31679
R702 vss.n328 vss.n327 3.31679
R703 vss.n308 vss.n307 3.31679
R704 vss.n308 vss.n302 3.31679
R705 vss.n310 vss.n299 3.31679
R706 vss.n311 vss.n310 3.31679
R707 vss.n290 vss.n284 3.31679
R708 vss.n285 vss.n284 3.31679
R709 vss.n293 vss.n282 3.31679
R710 vss.n294 vss.n293 3.31679
R711 vss.n511 vss.n269 3.28078
R712 vss.n531 vss.n277 3.28078
R713 vss.n475 vss.n332 3.28078
R714 vss.n454 vss.n453 3.28078
R715 vss.n511 vss.n349 3.14293
R716 vss.n479 vss.n277 3.14293
R717 vss.n476 vss.n475 3.14293
R718 vss.n334 vss.n277 3.14293
R719 vss.n512 vss.n511 3.14293
R720 vss.n475 vss.n333 3.14293
R721 vss.n453 vss.n452 3.14293
R722 vss.n453 vss.n385 3.14293
R723 vss.n313 vss.n312 2.21557
R724 vss.n296 vss.n295 2.21557
R725 vss.n330 vss.n329 2.21557
R726 vss.n485 vss.n365 2.21557
R727 vss.n104 vss.n103 1.66482
R728 vss.n273 vss.n272 1.1255
R729 vss.n271 vss.n270 1.1255
R730 vss.n314 vss 1.0868
R731 vss.n317 vss.n278 0.9005
R732 vss.n326 vss.n317 0.9005
R733 vss.n318 vss.n279 0.9005
R734 vss.n326 vss.n318 0.9005
R735 vss.n300 vss.n297 0.9005
R736 vss.n309 vss.n300 0.9005
R737 vss.n301 vss.n298 0.9005
R738 vss.n309 vss.n301 0.9005
R739 vss.n291 vss.n280 0.9005
R740 vss.n292 vss.n291 0.9005
R741 vss.n283 vss.n281 0.9005
R742 vss.n292 vss.n283 0.9005
R743 vss.n478 vss.n276 0.743357
R744 vss.n478 vss.n369 0.743357
R745 vss.n530 vss.n529 0.743357
R746 vss.n529 vss.n528 0.743357
R747 vss.n519 vss.n518 0.743357
R748 vss.n520 vss.n519 0.743357
R749 vss.n350 vss.n264 0.743357
R750 vss.n537 vss.n264 0.743357
R751 vss.n388 vss.n387 0.743357
R752 vss.n429 vss.n388 0.743357
R753 vss.n456 vss.n455 0.743357
R754 vss.n457 vss.n456 0.743357
R755 vss.n98 vss.n97 0.578278
R756 vss.n536 vss.n535 0.578278
R757 vss.n537 vss.n536 0.578278
R758 vss.n315 vss.n296 0.316383
R759 vss.n275 vss.n274 0.236231
R760 vss.n534 vss.n268 0.2255
R761 vss.n271 vss 0.219897
R762 vss.n533 vss.n532 0.2057
R763 vss.n532 vss.n275 0.2057
R764 vss.n315 vss.n314 0.2057
R765 vss.n535 vss.n267 0.19713
R766 vss.n107 vss.n106 0.1445
R767 vss.n108 vss.n107 0.1445
R768 vss.n108 vss.n85 0.1445
R769 vss.n122 vss.n85 0.1445
R770 vss.n123 vss.n122 0.1445
R771 vss.n124 vss.n123 0.1445
R772 vss.n124 vss.n73 0.1445
R773 vss.n138 vss.n73 0.1445
R774 vss.n139 vss.n138 0.1445
R775 vss.n140 vss.n139 0.1445
R776 vss.n140 vss.n61 0.1445
R777 vss.n154 vss.n61 0.1445
R778 vss.n155 vss.n154 0.1445
R779 vss.n156 vss.n155 0.1445
R780 vss.n156 vss.n49 0.1445
R781 vss.n170 vss.n49 0.1445
R782 vss.n171 vss.n170 0.1445
R783 vss.n172 vss.n171 0.1445
R784 vss.n172 vss.n37 0.1445
R785 vss.n186 vss.n37 0.1445
R786 vss.n187 vss.n186 0.1445
R787 vss.n188 vss.n187 0.1445
R788 vss.n188 vss.n25 0.1445
R789 vss.n202 vss.n25 0.1445
R790 vss.n203 vss.n202 0.1445
R791 vss.n204 vss.n203 0.1445
R792 vss.n204 vss.n13 0.1445
R793 vss.n218 vss.n13 0.1445
R794 vss.n219 vss.n218 0.1445
R795 vss.n220 vss.n219 0.1445
R796 vss.n221 vss.n220 0.1445
R797 vss.n222 vss.n221 0.1445
R798 vss.n230 vss.n222 0.1445
R799 vss.n231 vss.n230 0.1445
R800 vss.n232 vss.n231 0.1445
R801 vss.n233 vss.n232 0.1445
R802 vss.n241 vss.n233 0.1445
R803 vss.n242 vss.n241 0.1445
R804 vss.n243 vss.n242 0.1445
R805 vss.n244 vss.n243 0.1445
R806 vss.n252 vss.n244 0.1445
R807 vss.n253 vss.n252 0.1445
R808 vss.n254 vss.n253 0.1445
R809 vss.n255 vss.n254 0.1445
R810 vss.n433 vss.n255 0.1445
R811 vss.n434 vss.n433 0.1445
R812 vss.n435 vss.n434 0.1445
R813 vss.n436 vss.n435 0.1445
R814 vss.n436 vss.n379 0.1445
R815 vss.n461 vss.n379 0.1445
R816 vss.n462 vss.n461 0.1445
R817 vss.n464 vss.n462 0.1445
R818 vss.n464 vss.n463 0.1445
R819 vss.n463 vss.n367 0.1445
R820 vss.n105 vss.n96 0.1445
R821 vss.n109 vss.n96 0.1445
R822 vss.n109 vss.n86 0.1445
R823 vss.n121 vss.n86 0.1445
R824 vss.n121 vss.n84 0.1445
R825 vss.n125 vss.n84 0.1445
R826 vss.n125 vss.n74 0.1445
R827 vss.n137 vss.n74 0.1445
R828 vss.n137 vss.n72 0.1445
R829 vss.n141 vss.n72 0.1445
R830 vss.n141 vss.n62 0.1445
R831 vss.n153 vss.n62 0.1445
R832 vss.n153 vss.n60 0.1445
R833 vss.n157 vss.n60 0.1445
R834 vss.n157 vss.n50 0.1445
R835 vss.n169 vss.n50 0.1445
R836 vss.n169 vss.n48 0.1445
R837 vss.n173 vss.n48 0.1445
R838 vss.n173 vss.n38 0.1445
R839 vss.n185 vss.n38 0.1445
R840 vss.n185 vss.n36 0.1445
R841 vss.n189 vss.n36 0.1445
R842 vss.n189 vss.n26 0.1445
R843 vss.n201 vss.n26 0.1445
R844 vss.n201 vss.n24 0.1445
R845 vss.n205 vss.n24 0.1445
R846 vss.n205 vss.n14 0.1445
R847 vss.n217 vss.n14 0.1445
R848 vss.n217 vss.n12 0.1445
R849 vss.n570 vss.n12 0.1445
R850 vss.n570 vss.n569 0.1445
R851 vss.n569 vss.n568 0.1445
R852 vss.n568 vss.n223 0.1445
R853 vss.n562 vss.n223 0.1445
R854 vss.n562 vss.n561 0.1445
R855 vss.n561 vss.n560 0.1445
R856 vss.n560 vss.n234 0.1445
R857 vss.n554 vss.n234 0.1445
R858 vss.n554 vss.n553 0.1445
R859 vss.n553 vss.n552 0.1445
R860 vss.n552 vss.n245 0.1445
R861 vss.n546 vss.n245 0.1445
R862 vss.n546 vss.n545 0.1445
R863 vss.n545 vss.n544 0.1445
R864 vss.n544 vss.n256 0.1445
R865 vss.n432 vss.n256 0.1445
R866 vss.n438 vss.n432 0.1445
R867 vss.n438 vss.n437 0.1445
R868 vss.n437 vss.n380 0.1445
R869 vss.n460 vss.n380 0.1445
R870 vss.n460 vss.n378 0.1445
R871 vss.n465 vss.n378 0.1445
R872 vss.n465 vss.n366 0.1445
R873 vss.n483 vss.n366 0.1445
R874 vss.n484 vss.n483 0.1445
R875 vss.n486 vss.n339 0.1445
R876 vss.n525 vss.n339 0.1445
R877 vss.n525 vss.n524 0.1445
R878 vss.n524 vss.n523 0.1445
R879 vss.n523 vss.n343 0.1445
R880 vss.n508 vss.n343 0.1445
R881 vss.n508 vss.n507 0.1445
R882 vss.n516 vss.n515 0.1445
R883 vss.n517 vss.n351 0.1445
R884 vss.n323 vss.n320 0.1445
R885 vss.n322 vss.n321 0.1445
R886 vss.n306 vss.n303 0.1445
R887 vss.n305 vss.n304 0.1445
R888 vss.n289 vss.n286 0.1445
R889 vss.n288 vss.n287 0.1445
R890 vss.n364 vss.n340 0.1445
R891 vss.n341 vss.n340 0.1445
R892 vss.n342 vss.n341 0.1445
R893 vss.n505 vss.n342 0.1445
R894 vss.n506 vss.n505 0.1445
R895 vss.n506 vss.n268 0.1445
R896 vss.n404 vss.n2 0.1445
R897 vss.n404 vss.n402 0.1445
R898 vss.n409 vss.n402 0.1445
R899 vss.n410 vss.n409 0.1445
R900 vss.n411 vss.n410 0.1445
R901 vss.n411 vss.n400 0.1445
R902 vss.n416 vss.n400 0.1445
R903 vss.n417 vss.n416 0.1445
R904 vss.n418 vss.n417 0.1445
R905 vss.n418 vss.n398 0.1445
R906 vss.n423 vss.n398 0.1445
R907 vss.n424 vss.n423 0.1445
R908 vss.n425 vss.n424 0.1445
R909 vss.n425 vss.n396 0.1445
R910 vss.n443 vss.n396 0.1445
R911 vss.n444 vss.n443 0.1445
R912 vss.n445 vss.n444 0.1445
R913 vss.n446 vss.n445 0.1445
R914 vss.n446 vss.n373 0.1445
R915 vss.n470 vss.n373 0.1445
R916 vss.n471 vss.n470 0.1445
R917 vss.n472 vss.n471 0.1445
R918 vss.n472 vss.n357 0.1445
R919 vss.n491 vss.n357 0.1445
R920 vss.n492 vss.n491 0.1445
R921 vss.n493 vss.n492 0.1445
R922 vss.n493 vss.n355 0.1445
R923 vss.n498 vss.n355 0.1445
R924 vss.n499 vss.n498 0.1445
R925 vss.n500 vss.n499 0.1445
R926 vss.n501 vss.n500 0.1445
R927 vss.n99 vss.n91 0.1445
R928 vss.n114 vss.n91 0.1445
R929 vss.n115 vss.n114 0.1445
R930 vss.n116 vss.n115 0.1445
R931 vss.n116 vss.n79 0.1445
R932 vss.n130 vss.n79 0.1445
R933 vss.n131 vss.n130 0.1445
R934 vss.n132 vss.n131 0.1445
R935 vss.n132 vss.n67 0.1445
R936 vss.n146 vss.n67 0.1445
R937 vss.n147 vss.n146 0.1445
R938 vss.n148 vss.n147 0.1445
R939 vss.n148 vss.n55 0.1445
R940 vss.n162 vss.n55 0.1445
R941 vss.n163 vss.n162 0.1445
R942 vss.n164 vss.n163 0.1445
R943 vss.n164 vss.n43 0.1445
R944 vss.n178 vss.n43 0.1445
R945 vss.n179 vss.n178 0.1445
R946 vss.n180 vss.n179 0.1445
R947 vss.n180 vss.n31 0.1445
R948 vss.n194 vss.n31 0.1445
R949 vss.n195 vss.n194 0.1445
R950 vss.n196 vss.n195 0.1445
R951 vss.n196 vss.n19 0.1445
R952 vss.n210 vss.n19 0.1445
R953 vss.n211 vss.n210 0.1445
R954 vss.n212 vss.n211 0.1445
R955 vss.n212 vss.n4 0.1445
R956 vss.n575 vss.n4 0.1445
R957 vss.n100 vss.n92 0.1445
R958 vss.n113 vss.n92 0.1445
R959 vss.n113 vss.n90 0.1445
R960 vss.n117 vss.n90 0.1445
R961 vss.n117 vss.n80 0.1445
R962 vss.n129 vss.n80 0.1445
R963 vss.n129 vss.n78 0.1445
R964 vss.n133 vss.n78 0.1445
R965 vss.n133 vss.n68 0.1445
R966 vss.n145 vss.n68 0.1445
R967 vss.n145 vss.n66 0.1445
R968 vss.n149 vss.n66 0.1445
R969 vss.n149 vss.n56 0.1445
R970 vss.n161 vss.n56 0.1445
R971 vss.n161 vss.n54 0.1445
R972 vss.n165 vss.n54 0.1445
R973 vss.n165 vss.n44 0.1445
R974 vss.n177 vss.n44 0.1445
R975 vss.n177 vss.n42 0.1445
R976 vss.n181 vss.n42 0.1445
R977 vss.n181 vss.n32 0.1445
R978 vss.n193 vss.n32 0.1445
R979 vss.n193 vss.n30 0.1445
R980 vss.n197 vss.n30 0.1445
R981 vss.n197 vss.n20 0.1445
R982 vss.n209 vss.n20 0.1445
R983 vss.n209 vss.n18 0.1445
R984 vss.n213 vss.n18 0.1445
R985 vss.n213 vss.n5 0.1445
R986 vss.n574 vss.n5 0.1445
R987 vss.n574 vss.n3 0.1445
R988 vss.n403 vss.n3 0.1445
R989 vss.n405 vss.n403 0.1445
R990 vss.n406 vss.n405 0.1445
R991 vss.n408 vss.n406 0.1445
R992 vss.n408 vss.n401 0.1445
R993 vss.n412 vss.n401 0.1445
R994 vss.n413 vss.n412 0.1445
R995 vss.n415 vss.n413 0.1445
R996 vss.n415 vss.n399 0.1445
R997 vss.n419 vss.n399 0.1445
R998 vss.n420 vss.n419 0.1445
R999 vss.n422 vss.n420 0.1445
R1000 vss.n422 vss.n397 0.1445
R1001 vss.n426 vss.n397 0.1445
R1002 vss.n427 vss.n426 0.1445
R1003 vss.n442 vss.n427 0.1445
R1004 vss.n442 vss.n395 0.1445
R1005 vss.n448 vss.n395 0.1445
R1006 vss.n448 vss.n447 0.1445
R1007 vss.n447 vss.n374 0.1445
R1008 vss.n469 vss.n374 0.1445
R1009 vss.n469 vss.n372 0.1445
R1010 vss.n473 vss.n372 0.1445
R1011 vss.n473 vss.n358 0.1445
R1012 vss.n490 vss.n358 0.1445
R1013 vss.n490 vss.n356 0.1445
R1014 vss.n494 vss.n356 0.1445
R1015 vss.n496 vss.n494 0.1445
R1016 vss.n497 vss.n496 0.1445
R1017 vss.n497 vss.n354 0.1445
R1018 vss.n503 vss.n354 0.1445
R1019 vss.n503 vss.n502 0.1445
R1020 vss.n392 vss.n391 0.1445
R1021 vss.n390 vss.n386 0.1445
R1022 vss.n274 vss.n0 0.130701
R1023 vss.n314 vss.n313 0.111183
R1024 vss.n330 vss.n315 0.111183
R1025 vss.n365 vss.n332 0.108765
R1026 vss.n533 vss.n269 0.102798
R1027 vss.n532 vss.n531 0.102798
R1028 vss.n454 vss.n275 0.102798
R1029 vss vss.n576 0.0806
R1030 vss.n576 vss.n2 0.0725
R1031 vss.n485 vss.n484 0.0718661
R1032 vss.n486 vss.n485 0.0718661
R1033 vss.n365 vss.n364 0.0671
R1034 vss.n367 vss.n365 0.0599
R1035 vss.n313 vss 0.0577669
R1036 vss.n331 vss 0.0507793
R1037 vss.n274 vss.n273 0.0365255
R1038 vss.n576 vss.n575 0.0365
R1039 vss.n273 vss.n270 0.0077
R1040 vss.n331 vss.n330 0.00748758
R1041 vss.n272 vss.n271 0.00641376
R1042 vss.n272 vss.n0 0.00641376
R1043 vss vss.n270 0.00347
R1044 vdd.n504 vdd.n54 18200
R1045 vdd.n503 vdd.n78 18200
R1046 vdd.n511 vdd.n504 14243.8
R1047 vdd.n504 vdd.n503 4468.75
R1048 vdd.n503 vdd.n502 4062.5
R1049 vdd.n15 vdd.n14 521.494
R1050 vdd.n14 vdd.n6 521.494
R1051 vdd.n32 vdd.n31 521.494
R1052 vdd.n31 vdd.n30 521.494
R1053 vdd.n573 vdd.n572 521.494
R1054 vdd.n572 vdd.n571 521.494
R1055 vdd.n512 vdd.n511 233.853
R1056 vdd.n495 vdd.n90 147.31
R1057 vdd.n478 vdd.n110 147.31
R1058 vdd.n469 vdd.n65 147.31
R1059 vdd.n542 vdd.n541 147.31
R1060 vdd.n554 vdd.n41 143.626
R1061 vdd.n553 vdd.n44 143.626
R1062 vdd.n113 vdd.n78 141.786
R1063 vdd.n529 vdd.n54 134.419
R1064 vdd.n494 vdd.n93 132.578
R1065 vdd.n485 vdd.n484 132.578
R1066 vdd.n540 vdd.n57 130.738
R1067 vdd.n74 vdd.n57 125.213
R1068 vdd.n521 vdd.n75 125.213
R1069 vdd.n484 vdd.n100 123.371
R1070 vdd.n112 vdd.n41 112.323
R1071 vdd.n530 vdd.n65 104.959
R1072 vdd.n269 vdd.n260 95.4133
R1073 vdd.n277 vdd.n260 95.4133
R1074 vdd.n277 vdd.n254 95.4133
R1075 vdd.n285 vdd.n254 95.4133
R1076 vdd.n285 vdd.n248 95.4133
R1077 vdd.n293 vdd.n248 95.4133
R1078 vdd.n293 vdd.n242 95.4133
R1079 vdd.n301 vdd.n242 95.4133
R1080 vdd.n301 vdd.n236 95.4133
R1081 vdd.n309 vdd.n236 95.4133
R1082 vdd.n309 vdd.n230 95.4133
R1083 vdd.n317 vdd.n230 95.4133
R1084 vdd.n317 vdd.n224 95.4133
R1085 vdd.n325 vdd.n224 95.4133
R1086 vdd.n325 vdd.n218 95.4133
R1087 vdd.n333 vdd.n218 95.4133
R1088 vdd.n333 vdd.n212 95.4133
R1089 vdd.n341 vdd.n212 95.4133
R1090 vdd.n341 vdd.n206 95.4133
R1091 vdd.n349 vdd.n206 95.4133
R1092 vdd.n349 vdd.n200 95.4133
R1093 vdd.n357 vdd.n200 95.4133
R1094 vdd.n357 vdd.n194 95.4133
R1095 vdd.n365 vdd.n194 95.4133
R1096 vdd.n365 vdd.n188 95.4133
R1097 vdd.n373 vdd.n188 95.4133
R1098 vdd.n373 vdd.n182 95.4133
R1099 vdd.n381 vdd.n182 95.4133
R1100 vdd.n381 vdd.n176 95.4133
R1101 vdd.n389 vdd.n176 95.4133
R1102 vdd.n389 vdd.n170 95.4133
R1103 vdd.n397 vdd.n170 95.4133
R1104 vdd.n397 vdd.n152 95.4133
R1105 vdd.n405 vdd.n152 95.4133
R1106 vdd.n405 vdd.n146 95.4133
R1107 vdd.n413 vdd.n146 95.4133
R1108 vdd.n413 vdd.n140 95.4133
R1109 vdd.n421 vdd.n140 95.4133
R1110 vdd.n421 vdd.n134 95.4133
R1111 vdd.n429 vdd.n134 95.4133
R1112 vdd.n429 vdd.n128 95.4133
R1113 vdd.n440 vdd.n128 95.4133
R1114 vdd.n440 vdd.n122 95.4133
R1115 vdd.n449 vdd.n122 95.4133
R1116 vdd.n449 vdd.n79 95.4133
R1117 vdd.n90 vdd.n81 93.9099
R1118 vdd.n502 vdd.n79 75.1381
R1119 vdd.n77 vdd.n73 73.9866
R1120 vdd.n513 vdd.n77 73.9866
R1121 vdd.n270 vdd.n264 73.9866
R1122 vdd.n486 vdd.n98 69.0283
R1123 vdd.n98 vdd.n95 69.0283
R1124 vdd.n493 vdd.n94 69.0283
R1125 vdd.n94 vdd.n92 69.0283
R1126 vdd.n539 vdd.n58 69.0283
R1127 vdd.n539 vdd.n59 69.0283
R1128 vdd.n510 vdd.n508 69.0283
R1129 vdd.n510 vdd.n509 69.0283
R1130 vdd.n531 vdd.n39 69.0283
R1131 vdd.n532 vdd.n531 69.0283
R1132 vdd.n42 vdd.n40 69.0283
R1133 vdd.n555 vdd.n40 69.0283
R1134 vdd.n13 vdd.n4 62.1255
R1135 vdd.n13 vdd.n12 62.1255
R1136 vdd.n7 vdd.n5 62.1255
R1137 vdd.n16 vdd.n5 62.1255
R1138 vdd.n33 vdd.n22 62.1255
R1139 vdd.n29 vdd.n22 62.1255
R1140 vdd.n24 vdd.n23 62.1255
R1141 vdd.n23 vdd.n21 62.1255
R1142 vdd.n574 vdd.n563 62.1255
R1143 vdd.n570 vdd.n563 62.1255
R1144 vdd.n565 vdd.n564 62.1255
R1145 vdd.n564 vdd.n562 62.1255
R1146 vdd.n501 vdd.n81 53.3999
R1147 vdd.n268 vdd.n264 48.6503
R1148 vdd.n530 vdd.n529 42.3518
R1149 vdd.n113 vdd.n112 34.9863
R1150 vdd.n502 vdd.n501 31.3036
R1151 vdd.n110 vdd.n100 23.9382
R1152 vdd.n521 vdd.n74 22.0968
R1153 vdd.n512 vdd.n75 22.0968
R1154 vdd.n166 vdd.n165 17.2005
R1155 vss vdd.n166 17.0096
R1156 vdd.n541 vdd.n540 16.5727
R1157 vdd.n486 vdd.n92 15.5561
R1158 vdd.n267 vdd.n259 15.5561
R1159 vdd.n278 vdd.n259 15.5561
R1160 vdd.n278 vdd.n255 15.5561
R1161 vdd.n284 vdd.n255 15.5561
R1162 vdd.n284 vdd.n247 15.5561
R1163 vdd.n294 vdd.n247 15.5561
R1164 vdd.n294 vdd.n243 15.5561
R1165 vdd.n300 vdd.n243 15.5561
R1166 vdd.n300 vdd.n235 15.5561
R1167 vdd.n310 vdd.n235 15.5561
R1168 vdd.n310 vdd.n231 15.5561
R1169 vdd.n316 vdd.n231 15.5561
R1170 vdd.n316 vdd.n223 15.5561
R1171 vdd.n326 vdd.n223 15.5561
R1172 vdd.n326 vdd.n219 15.5561
R1173 vdd.n332 vdd.n219 15.5561
R1174 vdd.n332 vdd.n211 15.5561
R1175 vdd.n342 vdd.n211 15.5561
R1176 vdd.n342 vdd.n207 15.5561
R1177 vdd.n348 vdd.n207 15.5561
R1178 vdd.n348 vdd.n199 15.5561
R1179 vdd.n358 vdd.n199 15.5561
R1180 vdd.n358 vdd.n195 15.5561
R1181 vdd.n364 vdd.n195 15.5561
R1182 vdd.n364 vdd.n187 15.5561
R1183 vdd.n374 vdd.n187 15.5561
R1184 vdd.n374 vdd.n183 15.5561
R1185 vdd.n380 vdd.n183 15.5561
R1186 vdd.n380 vdd.n175 15.5561
R1187 vdd.n390 vdd.n175 15.5561
R1188 vdd.n390 vdd.n171 15.5561
R1189 vdd.n396 vdd.n171 15.5561
R1190 vdd.n396 vdd.n151 15.5561
R1191 vdd.n406 vdd.n151 15.5561
R1192 vdd.n406 vdd.n147 15.5561
R1193 vdd.n412 vdd.n147 15.5561
R1194 vdd.n412 vdd.n139 15.5561
R1195 vdd.n422 vdd.n139 15.5561
R1196 vdd.n422 vdd.n135 15.5561
R1197 vdd.n428 vdd.n135 15.5561
R1198 vdd.n428 vdd.n127 15.5561
R1199 vdd.n441 vdd.n127 15.5561
R1200 vdd.n441 vdd.n123 15.5561
R1201 vdd.n448 vdd.n123 15.5561
R1202 vdd.n448 vdd.n82 15.5561
R1203 vdd.n500 vdd.n82 15.5561
R1204 vdd.n500 vdd.n83 15.5561
R1205 vdd.n496 vdd.n83 15.5561
R1206 vdd.n496 vdd.n89 15.5561
R1207 vdd.n483 vdd.n89 15.5561
R1208 vdd.n483 vdd.n101 15.5561
R1209 vdd.n479 vdd.n101 15.5561
R1210 vdd.n479 vdd.n109 15.5561
R1211 vdd.n109 vdd.n45 15.5561
R1212 vdd.n552 vdd.n45 15.5561
R1213 vdd.n552 vdd.n46 15.5561
R1214 vdd.n48 vdd.n46 15.5561
R1215 vdd.n52 vdd.n48 15.5561
R1216 vdd.n543 vdd.n52 15.5561
R1217 vdd.n543 vdd.n53 15.5561
R1218 vdd.n76 vdd.n53 15.5561
R1219 vdd.n520 vdd.n76 15.5561
R1220 vdd.n520 vdd.n513 15.5561
R1221 vdd.n270 vdd.n261 15.5561
R1222 vdd.n276 vdd.n261 15.5561
R1223 vdd.n276 vdd.n253 15.5561
R1224 vdd.n286 vdd.n253 15.5561
R1225 vdd.n286 vdd.n249 15.5561
R1226 vdd.n292 vdd.n249 15.5561
R1227 vdd.n292 vdd.n241 15.5561
R1228 vdd.n302 vdd.n241 15.5561
R1229 vdd.n302 vdd.n237 15.5561
R1230 vdd.n308 vdd.n237 15.5561
R1231 vdd.n308 vdd.n229 15.5561
R1232 vdd.n318 vdd.n229 15.5561
R1233 vdd.n318 vdd.n225 15.5561
R1234 vdd.n324 vdd.n225 15.5561
R1235 vdd.n324 vdd.n217 15.5561
R1236 vdd.n334 vdd.n217 15.5561
R1237 vdd.n334 vdd.n213 15.5561
R1238 vdd.n340 vdd.n213 15.5561
R1239 vdd.n340 vdd.n205 15.5561
R1240 vdd.n350 vdd.n205 15.5561
R1241 vdd.n350 vdd.n201 15.5561
R1242 vdd.n356 vdd.n201 15.5561
R1243 vdd.n356 vdd.n193 15.5561
R1244 vdd.n366 vdd.n193 15.5561
R1245 vdd.n366 vdd.n189 15.5561
R1246 vdd.n372 vdd.n189 15.5561
R1247 vdd.n372 vdd.n181 15.5561
R1248 vdd.n382 vdd.n181 15.5561
R1249 vdd.n382 vdd.n177 15.5561
R1250 vdd.n388 vdd.n177 15.5561
R1251 vdd.n388 vdd.n169 15.5561
R1252 vdd.n398 vdd.n169 15.5561
R1253 vdd.n398 vdd.n153 15.5561
R1254 vdd.n404 vdd.n153 15.5561
R1255 vdd.n404 vdd.n145 15.5561
R1256 vdd.n414 vdd.n145 15.5561
R1257 vdd.n414 vdd.n141 15.5561
R1258 vdd.n420 vdd.n141 15.5561
R1259 vdd.n420 vdd.n133 15.5561
R1260 vdd.n430 vdd.n133 15.5561
R1261 vdd.n430 vdd.n129 15.5561
R1262 vdd.n439 vdd.n129 15.5561
R1263 vdd.n439 vdd.n121 15.5561
R1264 vdd.n450 vdd.n121 15.5561
R1265 vdd.n451 vdd.n450 15.5561
R1266 vdd.n451 vdd.n80 15.5561
R1267 vdd.n117 vdd.n80 15.5561
R1268 vdd.n117 vdd.n91 15.5561
R1269 vdd.n458 vdd.n91 15.5561
R1270 vdd.n458 vdd.n99 15.5561
R1271 vdd.n111 vdd.n99 15.5561
R1272 vdd.n477 vdd.n111 15.5561
R1273 vdd.n477 vdd.n114 15.5561
R1274 vdd.n473 vdd.n114 15.5561
R1275 vdd.n473 vdd.n43 15.5561
R1276 vdd.n470 vdd.n43 15.5561
R1277 vdd.n470 vdd.n66 15.5561
R1278 vdd.n528 vdd.n66 15.5561
R1279 vdd.n528 vdd.n55 15.5561
R1280 vdd.n56 vdd.n55 15.5561
R1281 vdd.n523 vdd.n56 15.5561
R1282 vdd.n523 vdd.n522 15.5561
R1283 vdd.n522 vdd.n73 15.5561
R1284 vdd.n508 vdd.n58 15.5561
R1285 vdd.n495 vdd.n494 14.7314
R1286 vdd.n485 vdd.n93 14.7314
R1287 vdd.n542 vdd.n54 12.89
R1288 vdd.n558 vdd.n557 11.8522
R1289 vdd.n536 vdd.n63 11.0435
R1290 vdd.n38 vdd.n37 7.6287
R1291 vdd.n17 vdd.n16 6.37187
R1292 vdd.n17 vdd.n4 6.37187
R1293 vdd.n34 vdd.n33 6.37187
R1294 vdd.n34 vdd.n21 6.37187
R1295 vdd.n575 vdd.n574 6.37187
R1296 vdd.n575 vdd.n562 6.37187
R1297 vdd.n12 vdd.n11 6.3005
R1298 vdd.n8 vdd.n7 6.3005
R1299 vdd.n29 vdd.n28 6.3005
R1300 vdd.n25 vdd.n24 6.3005
R1301 vdd.n570 vdd.n569 6.3005
R1302 vdd.n566 vdd.n565 6.3005
R1303 vdd.n478 vdd.n78 5.52458
R1304 vdd.n272 vdd.n263 5.25278
R1305 vdd.n265 vdd.n263 5.25278
R1306 vdd.n9 vdd.n3 5.20101
R1307 vdd.n10 vdd.n2 5.20101
R1308 vdd.n26 vdd.n20 5.20101
R1309 vdd.n27 vdd.n19 5.20101
R1310 vdd.n490 vdd.n489 5.20101
R1311 vdd.n538 vdd.n60 5.20101
R1312 vdd.n567 vdd.n1 5.20101
R1313 vdd.n568 vdd.n0 5.20101
R1314 vdd.n452 vdd.n451 5.2005
R1315 vdd.n451 vdd.n79 5.2005
R1316 vdd.n450 vdd.n120 5.2005
R1317 vdd.n450 vdd.n449 5.2005
R1318 vdd.n437 vdd.n121 5.2005
R1319 vdd.n122 vdd.n121 5.2005
R1320 vdd.n439 vdd.n438 5.2005
R1321 vdd.n440 vdd.n439 5.2005
R1322 vdd.n130 vdd.n129 5.2005
R1323 vdd.n129 vdd.n128 5.2005
R1324 vdd.n431 vdd.n430 5.2005
R1325 vdd.n430 vdd.n429 5.2005
R1326 vdd.n133 vdd.n132 5.2005
R1327 vdd.n134 vdd.n133 5.2005
R1328 vdd.n420 vdd.n419 5.2005
R1329 vdd.n421 vdd.n420 5.2005
R1330 vdd.n142 vdd.n141 5.2005
R1331 vdd.n141 vdd.n140 5.2005
R1332 vdd.n415 vdd.n414 5.2005
R1333 vdd.n414 vdd.n413 5.2005
R1334 vdd.n145 vdd.n144 5.2005
R1335 vdd.n146 vdd.n145 5.2005
R1336 vdd.n404 vdd.n403 5.2005
R1337 vdd.n405 vdd.n404 5.2005
R1338 vdd.n154 vdd.n153 5.2005
R1339 vdd.n153 vdd.n152 5.2005
R1340 vdd.n399 vdd.n398 5.2005
R1341 vdd.n398 vdd.n397 5.2005
R1342 vdd.n169 vdd.n168 5.2005
R1343 vdd.n170 vdd.n169 5.2005
R1344 vdd.n388 vdd.n387 5.2005
R1345 vdd.n389 vdd.n388 5.2005
R1346 vdd.n178 vdd.n177 5.2005
R1347 vdd.n177 vdd.n176 5.2005
R1348 vdd.n383 vdd.n382 5.2005
R1349 vdd.n382 vdd.n381 5.2005
R1350 vdd.n181 vdd.n180 5.2005
R1351 vdd.n182 vdd.n181 5.2005
R1352 vdd.n372 vdd.n371 5.2005
R1353 vdd.n373 vdd.n372 5.2005
R1354 vdd.n190 vdd.n189 5.2005
R1355 vdd.n189 vdd.n188 5.2005
R1356 vdd.n367 vdd.n366 5.2005
R1357 vdd.n366 vdd.n365 5.2005
R1358 vdd.n193 vdd.n192 5.2005
R1359 vdd.n194 vdd.n193 5.2005
R1360 vdd.n356 vdd.n355 5.2005
R1361 vdd.n357 vdd.n356 5.2005
R1362 vdd.n202 vdd.n201 5.2005
R1363 vdd.n201 vdd.n200 5.2005
R1364 vdd.n351 vdd.n350 5.2005
R1365 vdd.n350 vdd.n349 5.2005
R1366 vdd.n205 vdd.n204 5.2005
R1367 vdd.n206 vdd.n205 5.2005
R1368 vdd.n340 vdd.n339 5.2005
R1369 vdd.n341 vdd.n340 5.2005
R1370 vdd.n214 vdd.n213 5.2005
R1371 vdd.n213 vdd.n212 5.2005
R1372 vdd.n335 vdd.n334 5.2005
R1373 vdd.n334 vdd.n333 5.2005
R1374 vdd.n217 vdd.n216 5.2005
R1375 vdd.n218 vdd.n217 5.2005
R1376 vdd.n324 vdd.n323 5.2005
R1377 vdd.n325 vdd.n324 5.2005
R1378 vdd.n226 vdd.n225 5.2005
R1379 vdd.n225 vdd.n224 5.2005
R1380 vdd.n319 vdd.n318 5.2005
R1381 vdd.n318 vdd.n317 5.2005
R1382 vdd.n229 vdd.n228 5.2005
R1383 vdd.n230 vdd.n229 5.2005
R1384 vdd.n308 vdd.n307 5.2005
R1385 vdd.n309 vdd.n308 5.2005
R1386 vdd.n238 vdd.n237 5.2005
R1387 vdd.n237 vdd.n236 5.2005
R1388 vdd.n303 vdd.n302 5.2005
R1389 vdd.n302 vdd.n301 5.2005
R1390 vdd.n241 vdd.n240 5.2005
R1391 vdd.n242 vdd.n241 5.2005
R1392 vdd.n292 vdd.n291 5.2005
R1393 vdd.n293 vdd.n292 5.2005
R1394 vdd.n250 vdd.n249 5.2005
R1395 vdd.n249 vdd.n248 5.2005
R1396 vdd.n287 vdd.n286 5.2005
R1397 vdd.n286 vdd.n285 5.2005
R1398 vdd.n253 vdd.n252 5.2005
R1399 vdd.n254 vdd.n253 5.2005
R1400 vdd.n276 vdd.n275 5.2005
R1401 vdd.n277 vdd.n276 5.2005
R1402 vdd.n262 vdd.n261 5.2005
R1403 vdd.n261 vdd.n260 5.2005
R1404 vdd.n271 vdd.n270 5.2005
R1405 vdd.n270 vdd.n269 5.2005
R1406 vdd.n84 vdd.n82 5.2005
R1407 vdd.n82 vdd.n79 5.2005
R1408 vdd.n448 vdd.n447 5.2005
R1409 vdd.n449 vdd.n448 5.2005
R1410 vdd.n124 vdd.n123 5.2005
R1411 vdd.n123 vdd.n122 5.2005
R1412 vdd.n442 vdd.n441 5.2005
R1413 vdd.n441 vdd.n440 5.2005
R1414 vdd.n127 vdd.n126 5.2005
R1415 vdd.n128 vdd.n127 5.2005
R1416 vdd.n428 vdd.n427 5.2005
R1417 vdd.n429 vdd.n428 5.2005
R1418 vdd.n136 vdd.n135 5.2005
R1419 vdd.n135 vdd.n134 5.2005
R1420 vdd.n423 vdd.n422 5.2005
R1421 vdd.n422 vdd.n421 5.2005
R1422 vdd.n139 vdd.n138 5.2005
R1423 vdd.n140 vdd.n139 5.2005
R1424 vdd.n412 vdd.n411 5.2005
R1425 vdd.n413 vdd.n412 5.2005
R1426 vdd.n148 vdd.n147 5.2005
R1427 vdd.n147 vdd.n146 5.2005
R1428 vdd.n407 vdd.n406 5.2005
R1429 vdd.n406 vdd.n405 5.2005
R1430 vdd.n151 vdd.n150 5.2005
R1431 vdd.n152 vdd.n151 5.2005
R1432 vdd.n396 vdd.n395 5.2005
R1433 vdd.n397 vdd.n396 5.2005
R1434 vdd.n172 vdd.n171 5.2005
R1435 vdd.n171 vdd.n170 5.2005
R1436 vdd.n391 vdd.n390 5.2005
R1437 vdd.n390 vdd.n389 5.2005
R1438 vdd.n175 vdd.n174 5.2005
R1439 vdd.n176 vdd.n175 5.2005
R1440 vdd.n380 vdd.n379 5.2005
R1441 vdd.n381 vdd.n380 5.2005
R1442 vdd.n184 vdd.n183 5.2005
R1443 vdd.n183 vdd.n182 5.2005
R1444 vdd.n375 vdd.n374 5.2005
R1445 vdd.n374 vdd.n373 5.2005
R1446 vdd.n187 vdd.n186 5.2005
R1447 vdd.n188 vdd.n187 5.2005
R1448 vdd.n364 vdd.n363 5.2005
R1449 vdd.n365 vdd.n364 5.2005
R1450 vdd.n196 vdd.n195 5.2005
R1451 vdd.n195 vdd.n194 5.2005
R1452 vdd.n359 vdd.n358 5.2005
R1453 vdd.n358 vdd.n357 5.2005
R1454 vdd.n199 vdd.n198 5.2005
R1455 vdd.n200 vdd.n199 5.2005
R1456 vdd.n348 vdd.n347 5.2005
R1457 vdd.n349 vdd.n348 5.2005
R1458 vdd.n208 vdd.n207 5.2005
R1459 vdd.n207 vdd.n206 5.2005
R1460 vdd.n343 vdd.n342 5.2005
R1461 vdd.n342 vdd.n341 5.2005
R1462 vdd.n211 vdd.n210 5.2005
R1463 vdd.n212 vdd.n211 5.2005
R1464 vdd.n332 vdd.n331 5.2005
R1465 vdd.n333 vdd.n332 5.2005
R1466 vdd.n220 vdd.n219 5.2005
R1467 vdd.n219 vdd.n218 5.2005
R1468 vdd.n327 vdd.n326 5.2005
R1469 vdd.n326 vdd.n325 5.2005
R1470 vdd.n223 vdd.n222 5.2005
R1471 vdd.n224 vdd.n223 5.2005
R1472 vdd.n316 vdd.n315 5.2005
R1473 vdd.n317 vdd.n316 5.2005
R1474 vdd.n232 vdd.n231 5.2005
R1475 vdd.n231 vdd.n230 5.2005
R1476 vdd.n311 vdd.n310 5.2005
R1477 vdd.n310 vdd.n309 5.2005
R1478 vdd.n235 vdd.n234 5.2005
R1479 vdd.n236 vdd.n235 5.2005
R1480 vdd.n300 vdd.n299 5.2005
R1481 vdd.n301 vdd.n300 5.2005
R1482 vdd.n244 vdd.n243 5.2005
R1483 vdd.n243 vdd.n242 5.2005
R1484 vdd.n295 vdd.n294 5.2005
R1485 vdd.n294 vdd.n293 5.2005
R1486 vdd.n247 vdd.n246 5.2005
R1487 vdd.n248 vdd.n247 5.2005
R1488 vdd.n284 vdd.n283 5.2005
R1489 vdd.n285 vdd.n284 5.2005
R1490 vdd.n256 vdd.n255 5.2005
R1491 vdd.n255 vdd.n254 5.2005
R1492 vdd.n279 vdd.n278 5.2005
R1493 vdd.n278 vdd.n277 5.2005
R1494 vdd.n259 vdd.n258 5.2005
R1495 vdd.n260 vdd.n259 5.2005
R1496 vdd.n267 vdd.n266 5.2005
R1497 vdd.n487 vdd.n486 5.2005
R1498 vdd.n486 vdd.n485 5.2005
R1499 vdd.n488 vdd.n92 5.2005
R1500 vdd.n494 vdd.n92 5.2005
R1501 vdd.n485 vdd.n95 5.2005
R1502 vdd.n494 vdd.n493 5.2005
R1503 vdd.n162 vdd.n73 5.2005
R1504 vdd.n512 vdd.n73 5.2005
R1505 vdd.n522 vdd.n72 5.2005
R1506 vdd.n522 vdd.n521 5.2005
R1507 vdd.n524 vdd.n523 5.2005
R1508 vdd.n523 vdd.n57 5.2005
R1509 vdd.n525 vdd.n56 5.2005
R1510 vdd.n541 vdd.n56 5.2005
R1511 vdd.n526 vdd.n55 5.2005
R1512 vdd.n542 vdd.n55 5.2005
R1513 vdd.n528 vdd.n527 5.2005
R1514 vdd.n529 vdd.n528 5.2005
R1515 vdd.n67 vdd.n66 5.2005
R1516 vdd.n66 vdd.n65 5.2005
R1517 vdd.n471 vdd.n470 5.2005
R1518 vdd.n470 vdd.n469 5.2005
R1519 vdd.n472 vdd.n43 5.2005
R1520 vdd.n553 vdd.n43 5.2005
R1521 vdd.n474 vdd.n473 5.2005
R1522 vdd.n473 vdd.n41 5.2005
R1523 vdd.n475 vdd.n114 5.2005
R1524 vdd.n114 vdd.n113 5.2005
R1525 vdd.n477 vdd.n476 5.2005
R1526 vdd.n478 vdd.n477 5.2005
R1527 vdd.n115 vdd.n111 5.2005
R1528 vdd.n111 vdd.n110 5.2005
R1529 vdd.n460 vdd.n99 5.2005
R1530 vdd.n484 vdd.n99 5.2005
R1531 vdd.n459 vdd.n458 5.2005
R1532 vdd.n458 vdd.n93 5.2005
R1533 vdd.n457 vdd.n91 5.2005
R1534 vdd.n495 vdd.n91 5.2005
R1535 vdd.n118 vdd.n117 5.2005
R1536 vdd.n117 vdd.n90 5.2005
R1537 vdd.n453 vdd.n80 5.2005
R1538 vdd.n501 vdd.n80 5.2005
R1539 vdd.n518 vdd.n513 5.2005
R1540 vdd.n513 vdd.n512 5.2005
R1541 vdd.n520 vdd.n519 5.2005
R1542 vdd.n521 vdd.n520 5.2005
R1543 vdd.n514 vdd.n76 5.2005
R1544 vdd.n76 vdd.n57 5.2005
R1545 vdd.n53 vdd.n51 5.2005
R1546 vdd.n541 vdd.n53 5.2005
R1547 vdd.n544 vdd.n543 5.2005
R1548 vdd.n543 vdd.n542 5.2005
R1549 vdd.n52 vdd.n49 5.2005
R1550 vdd.n529 vdd.n52 5.2005
R1551 vdd.n548 vdd.n48 5.2005
R1552 vdd.n65 vdd.n48 5.2005
R1553 vdd.n549 vdd.n46 5.2005
R1554 vdd.n469 vdd.n46 5.2005
R1555 vdd.n552 vdd.n551 5.2005
R1556 vdd.n553 vdd.n552 5.2005
R1557 vdd.n47 vdd.n45 5.2005
R1558 vdd.n45 vdd.n41 5.2005
R1559 vdd.n109 vdd.n108 5.2005
R1560 vdd.n113 vdd.n109 5.2005
R1561 vdd.n480 vdd.n479 5.2005
R1562 vdd.n479 vdd.n478 5.2005
R1563 vdd.n481 vdd.n101 5.2005
R1564 vdd.n110 vdd.n101 5.2005
R1565 vdd.n483 vdd.n482 5.2005
R1566 vdd.n484 vdd.n483 5.2005
R1567 vdd.n89 vdd.n88 5.2005
R1568 vdd.n93 vdd.n89 5.2005
R1569 vdd.n497 vdd.n496 5.2005
R1570 vdd.n496 vdd.n495 5.2005
R1571 vdd.n498 vdd.n83 5.2005
R1572 vdd.n90 vdd.n83 5.2005
R1573 vdd.n500 vdd.n499 5.2005
R1574 vdd.n501 vdd.n500 5.2005
R1575 vdd.n508 vdd.n507 5.2005
R1576 vdd.n508 vdd.n75 5.2005
R1577 vdd.n505 vdd.n58 5.2005
R1578 vdd.n74 vdd.n58 5.2005
R1579 vdd.n509 vdd.n75 5.2005
R1580 vdd.n74 vdd.n59 5.2005
R1581 vdd.n532 vdd.n44 5.2005
R1582 vdd.n554 vdd.n42 5.2005
R1583 vdd.n44 vdd.n39 5.2005
R1584 vdd.n555 vdd.n554 5.2005
R1585 vdd.n97 vdd.n96 5.19319
R1586 vdd.n506 vdd.n61 5.19319
R1587 vdd.n557 vdd.n36 5.12001
R1588 vdd.n557 vdd.n35 5.11219
R1589 vdd.n165 vdd.n163 5.04833
R1590 vdd.n164 vdd.n63 5.02778
R1591 vdd.n18 vdd.n3 4.98321
R1592 vdd.n559 vdd.n20 4.98321
R1593 vdd.n534 vdd.n36 4.98321
R1594 vdd.n491 vdd.n490 4.98321
R1595 vdd.n491 vdd.n96 4.98321
R1596 vdd.n537 vdd.n61 4.98321
R1597 vdd.n538 vdd.n537 4.98321
R1598 vdd.n534 vdd.n35 4.98321
R1599 vdd.n576 vdd.n1 4.98321
R1600 vdd.n18 vdd.n2 4.97539
R1601 vdd.n559 vdd.n19 4.97539
R1602 vdd.n576 vdd.n0 4.97539
R1603 vss vdd.n160 4.8929
R1604 vdd.n11 vdd.n10 4.5005
R1605 vdd.n9 vdd.n8 4.5005
R1606 vdd.n28 vdd.n27 4.5005
R1607 vdd.n26 vdd.n25 4.5005
R1608 vdd.n258 vdd.n257 4.5005
R1609 vdd.n280 vdd.n279 4.5005
R1610 vdd.n281 vdd.n256 4.5005
R1611 vdd.n283 vdd.n282 4.5005
R1612 vdd.n246 vdd.n245 4.5005
R1613 vdd.n296 vdd.n295 4.5005
R1614 vdd.n297 vdd.n244 4.5005
R1615 vdd.n299 vdd.n298 4.5005
R1616 vdd.n234 vdd.n233 4.5005
R1617 vdd.n312 vdd.n311 4.5005
R1618 vdd.n313 vdd.n232 4.5005
R1619 vdd.n315 vdd.n314 4.5005
R1620 vdd.n222 vdd.n221 4.5005
R1621 vdd.n328 vdd.n327 4.5005
R1622 vdd.n329 vdd.n220 4.5005
R1623 vdd.n331 vdd.n330 4.5005
R1624 vdd.n210 vdd.n209 4.5005
R1625 vdd.n344 vdd.n343 4.5005
R1626 vdd.n345 vdd.n208 4.5005
R1627 vdd.n347 vdd.n346 4.5005
R1628 vdd.n198 vdd.n197 4.5005
R1629 vdd.n360 vdd.n359 4.5005
R1630 vdd.n361 vdd.n196 4.5005
R1631 vdd.n363 vdd.n362 4.5005
R1632 vdd.n186 vdd.n185 4.5005
R1633 vdd.n376 vdd.n375 4.5005
R1634 vdd.n377 vdd.n184 4.5005
R1635 vdd.n379 vdd.n378 4.5005
R1636 vdd.n174 vdd.n173 4.5005
R1637 vdd.n392 vdd.n391 4.5005
R1638 vdd.n393 vdd.n172 4.5005
R1639 vdd.n395 vdd.n394 4.5005
R1640 vdd.n150 vdd.n149 4.5005
R1641 vdd.n408 vdd.n407 4.5005
R1642 vdd.n409 vdd.n148 4.5005
R1643 vdd.n411 vdd.n410 4.5005
R1644 vdd.n138 vdd.n137 4.5005
R1645 vdd.n424 vdd.n423 4.5005
R1646 vdd.n425 vdd.n136 4.5005
R1647 vdd.n427 vdd.n426 4.5005
R1648 vdd.n126 vdd.n125 4.5005
R1649 vdd.n443 vdd.n442 4.5005
R1650 vdd.n444 vdd.n124 4.5005
R1651 vdd.n447 vdd.n446 4.5005
R1652 vdd.n445 vdd.n84 4.5005
R1653 vdd.n499 vdd.n85 4.5005
R1654 vdd.n498 vdd.n86 4.5005
R1655 vdd.n497 vdd.n87 4.5005
R1656 vdd.n102 vdd.n88 4.5005
R1657 vdd.n482 vdd.n103 4.5005
R1658 vdd.n481 vdd.n104 4.5005
R1659 vdd.n480 vdd.n105 4.5005
R1660 vdd.n108 vdd.n107 4.5005
R1661 vdd.n106 vdd.n47 4.5005
R1662 vdd.n266 vdd.n265 4.5005
R1663 vdd.n548 vdd.n547 4.5005
R1664 vdd.n546 vdd.n49 4.5005
R1665 vdd.n545 vdd.n544 4.5005
R1666 vdd.n51 vdd.n50 4.5005
R1667 vdd.n515 vdd.n514 4.5005
R1668 vdd.n519 vdd.n516 4.5005
R1669 vdd.n518 vdd.n517 4.5005
R1670 vdd.n487 vdd.n97 4.5005
R1671 vdd.n489 vdd.n488 4.5005
R1672 vdd.n273 vdd.n262 4.5005
R1673 vdd.n275 vdd.n274 4.5005
R1674 vdd.n252 vdd.n251 4.5005
R1675 vdd.n288 vdd.n287 4.5005
R1676 vdd.n289 vdd.n250 4.5005
R1677 vdd.n291 vdd.n290 4.5005
R1678 vdd.n240 vdd.n239 4.5005
R1679 vdd.n304 vdd.n303 4.5005
R1680 vdd.n305 vdd.n238 4.5005
R1681 vdd.n307 vdd.n306 4.5005
R1682 vdd.n228 vdd.n227 4.5005
R1683 vdd.n320 vdd.n319 4.5005
R1684 vdd.n321 vdd.n226 4.5005
R1685 vdd.n323 vdd.n322 4.5005
R1686 vdd.n216 vdd.n215 4.5005
R1687 vdd.n336 vdd.n335 4.5005
R1688 vdd.n337 vdd.n214 4.5005
R1689 vdd.n339 vdd.n338 4.5005
R1690 vdd.n204 vdd.n203 4.5005
R1691 vdd.n352 vdd.n351 4.5005
R1692 vdd.n353 vdd.n202 4.5005
R1693 vdd.n355 vdd.n354 4.5005
R1694 vdd.n192 vdd.n191 4.5005
R1695 vdd.n368 vdd.n367 4.5005
R1696 vdd.n369 vdd.n190 4.5005
R1697 vdd.n371 vdd.n370 4.5005
R1698 vdd.n180 vdd.n179 4.5005
R1699 vdd.n384 vdd.n383 4.5005
R1700 vdd.n385 vdd.n178 4.5005
R1701 vdd.n387 vdd.n386 4.5005
R1702 vdd.n168 vdd.n167 4.5005
R1703 vdd.n400 vdd.n399 4.5005
R1704 vdd.n401 vdd.n154 4.5005
R1705 vdd.n403 vdd.n402 4.5005
R1706 vdd.n144 vdd.n143 4.5005
R1707 vdd.n416 vdd.n415 4.5005
R1708 vdd.n417 vdd.n142 4.5005
R1709 vdd.n419 vdd.n418 4.5005
R1710 vdd.n132 vdd.n131 4.5005
R1711 vdd.n432 vdd.n431 4.5005
R1712 vdd.n433 vdd.n130 4.5005
R1713 vdd.n438 vdd.n434 4.5005
R1714 vdd.n437 vdd.n436 4.5005
R1715 vdd.n435 vdd.n120 4.5005
R1716 vdd.n452 vdd.n119 4.5005
R1717 vdd.n454 vdd.n453 4.5005
R1718 vdd.n455 vdd.n118 4.5005
R1719 vdd.n457 vdd.n456 4.5005
R1720 vdd.n459 vdd.n116 4.5005
R1721 vdd.n461 vdd.n460 4.5005
R1722 vdd.n462 vdd.n115 4.5005
R1723 vdd.n476 vdd.n463 4.5005
R1724 vdd.n475 vdd.n464 4.5005
R1725 vdd.n474 vdd.n465 4.5005
R1726 vdd.n472 vdd.n466 4.5005
R1727 vdd.n471 vdd.n468 4.5005
R1728 vdd.n467 vdd.n67 4.5005
R1729 vdd.n527 vdd.n68 4.5005
R1730 vdd.n526 vdd.n69 4.5005
R1731 vdd.n525 vdd.n70 4.5005
R1732 vdd.n524 vdd.n71 4.5005
R1733 vdd.n161 vdd.n72 4.5005
R1734 vdd.n163 vdd.n162 4.5005
R1735 vdd.n272 vdd.n271 4.5005
R1736 vdd.n507 vdd.n506 4.5005
R1737 vdd.n505 vdd.n60 4.5005
R1738 vdd.n569 vdd.n568 4.5005
R1739 vdd.n567 vdd.n566 4.5005
R1740 vdd.n554 vdd.n553 3.68322
R1741 vdd.n469 vdd.n44 3.68322
R1742 vdd.n269 vdd.n268 3.42024
R1743 vdd.n12 vdd.n6 3.31679
R1744 vdd.n7 vdd.n6 3.31679
R1745 vdd.n15 vdd.n4 3.31679
R1746 vdd.n16 vdd.n15 3.31679
R1747 vdd.n30 vdd.n29 3.31679
R1748 vdd.n30 vdd.n24 3.31679
R1749 vdd.n32 vdd.n21 3.31679
R1750 vdd.n33 vdd.n32 3.31679
R1751 vdd.n571 vdd.n570 3.31679
R1752 vdd.n571 vdd.n565 3.31679
R1753 vdd.n573 vdd.n562 3.31679
R1754 vdd.n574 vdd.n573 3.31679
R1755 vdd.n492 vdd.n491 3.28078
R1756 vdd.n537 vdd.n62 3.28078
R1757 vdd.n534 vdd.n533 3.28078
R1758 vdd.n557 vdd.n556 3.28078
R1759 vdd.n533 vdd.n532 3.14293
R1760 vdd.n493 vdd.n492 3.14293
R1761 vdd.n492 vdd.n95 3.14293
R1762 vdd.n62 vdd.n59 3.14293
R1763 vdd.n509 vdd.n62 3.14293
R1764 vdd.n533 vdd.n42 3.14293
R1765 vdd.n556 vdd.n555 3.14293
R1766 vdd.n556 vdd.n39 3.14293
R1767 vdd.n18 vdd.n17 2.21557
R1768 vdd.n550 vdd.n38 2.21557
R1769 vdd.n559 vdd.n34 2.21557
R1770 vdd.n576 vdd.n575 2.21557
R1771 vdd.n268 vdd.n267 1.66482
R1772 vdd.n158 vdd.n155 1.1255
R1773 vdd.n157 vdd.n156 1.1255
R1774 vdd.n561 vss 1.0868
R1775 vdd.n13 vdd.n2 0.9005
R1776 vdd.n14 vdd.n13 0.9005
R1777 vdd.n5 vdd.n3 0.9005
R1778 vdd.n14 vdd.n5 0.9005
R1779 vdd.n22 vdd.n19 0.9005
R1780 vdd.n31 vdd.n22 0.9005
R1781 vdd.n23 vdd.n20 0.9005
R1782 vdd.n31 vdd.n23 0.9005
R1783 vdd.n563 vdd.n0 0.9005
R1784 vdd.n572 vdd.n563 0.9005
R1785 vdd.n564 vdd.n1 0.9005
R1786 vdd.n572 vdd.n564 0.9005
R1787 vdd.n490 vdd.n94 0.743357
R1788 vdd.n94 vdd.n81 0.743357
R1789 vdd.n98 vdd.n96 0.743357
R1790 vdd.n100 vdd.n98 0.743357
R1791 vdd.n539 vdd.n538 0.743357
R1792 vdd.n540 vdd.n539 0.743357
R1793 vdd.n510 vdd.n61 0.743357
R1794 vdd.n511 vdd.n510 0.743357
R1795 vdd.n531 vdd.n35 0.743357
R1796 vdd.n531 vdd.n530 0.743357
R1797 vdd.n40 vdd.n36 0.743357
R1798 vdd.n112 vdd.n40 0.743357
R1799 vdd.n264 vdd.n263 0.578278
R1800 vdd.n164 vdd.n77 0.578278
R1801 vdd.n511 vdd.n77 0.578278
R1802 vdd.n560 vdd.n18 0.316383
R1803 vdd.n159 vdd.n64 0.23353
R1804 vdd.n517 vdd.n63 0.2255
R1805 vdd.n156 vss 0.219897
R1806 vdd.n536 vdd.n535 0.2057
R1807 vdd.n535 vdd.n64 0.2057
R1808 vdd.n561 vdd.n560 0.2057
R1809 vdd.n165 vdd.n164 0.19713
R1810 vdd.n11 vdd.n8 0.1445
R1811 vdd.n10 vdd.n9 0.1445
R1812 vdd.n28 vdd.n25 0.1445
R1813 vdd.n27 vdd.n26 0.1445
R1814 vdd.n265 vdd.n257 0.1445
R1815 vdd.n280 vdd.n257 0.1445
R1816 vdd.n281 vdd.n280 0.1445
R1817 vdd.n282 vdd.n281 0.1445
R1818 vdd.n282 vdd.n245 0.1445
R1819 vdd.n296 vdd.n245 0.1445
R1820 vdd.n297 vdd.n296 0.1445
R1821 vdd.n298 vdd.n297 0.1445
R1822 vdd.n298 vdd.n233 0.1445
R1823 vdd.n312 vdd.n233 0.1445
R1824 vdd.n313 vdd.n312 0.1445
R1825 vdd.n314 vdd.n313 0.1445
R1826 vdd.n314 vdd.n221 0.1445
R1827 vdd.n328 vdd.n221 0.1445
R1828 vdd.n329 vdd.n328 0.1445
R1829 vdd.n330 vdd.n329 0.1445
R1830 vdd.n330 vdd.n209 0.1445
R1831 vdd.n344 vdd.n209 0.1445
R1832 vdd.n345 vdd.n344 0.1445
R1833 vdd.n346 vdd.n345 0.1445
R1834 vdd.n346 vdd.n197 0.1445
R1835 vdd.n360 vdd.n197 0.1445
R1836 vdd.n361 vdd.n360 0.1445
R1837 vdd.n362 vdd.n361 0.1445
R1838 vdd.n362 vdd.n185 0.1445
R1839 vdd.n376 vdd.n185 0.1445
R1840 vdd.n377 vdd.n376 0.1445
R1841 vdd.n378 vdd.n377 0.1445
R1842 vdd.n378 vdd.n173 0.1445
R1843 vdd.n392 vdd.n173 0.1445
R1844 vdd.n393 vdd.n392 0.1445
R1845 vdd.n394 vdd.n393 0.1445
R1846 vdd.n394 vdd.n149 0.1445
R1847 vdd.n408 vdd.n149 0.1445
R1848 vdd.n409 vdd.n408 0.1445
R1849 vdd.n410 vdd.n409 0.1445
R1850 vdd.n410 vdd.n137 0.1445
R1851 vdd.n424 vdd.n137 0.1445
R1852 vdd.n425 vdd.n424 0.1445
R1853 vdd.n426 vdd.n425 0.1445
R1854 vdd.n426 vdd.n125 0.1445
R1855 vdd.n443 vdd.n125 0.1445
R1856 vdd.n444 vdd.n443 0.1445
R1857 vdd.n446 vdd.n444 0.1445
R1858 vdd.n446 vdd.n445 0.1445
R1859 vdd.n445 vdd.n85 0.1445
R1860 vdd.n86 vdd.n85 0.1445
R1861 vdd.n87 vdd.n86 0.1445
R1862 vdd.n102 vdd.n87 0.1445
R1863 vdd.n103 vdd.n102 0.1445
R1864 vdd.n104 vdd.n103 0.1445
R1865 vdd.n105 vdd.n104 0.1445
R1866 vdd.n107 vdd.n105 0.1445
R1867 vdd.n107 vdd.n106 0.1445
R1868 vdd.n266 vdd.n258 0.1445
R1869 vdd.n279 vdd.n258 0.1445
R1870 vdd.n279 vdd.n256 0.1445
R1871 vdd.n283 vdd.n256 0.1445
R1872 vdd.n283 vdd.n246 0.1445
R1873 vdd.n295 vdd.n246 0.1445
R1874 vdd.n295 vdd.n244 0.1445
R1875 vdd.n299 vdd.n244 0.1445
R1876 vdd.n299 vdd.n234 0.1445
R1877 vdd.n311 vdd.n234 0.1445
R1878 vdd.n311 vdd.n232 0.1445
R1879 vdd.n315 vdd.n232 0.1445
R1880 vdd.n315 vdd.n222 0.1445
R1881 vdd.n327 vdd.n222 0.1445
R1882 vdd.n327 vdd.n220 0.1445
R1883 vdd.n331 vdd.n220 0.1445
R1884 vdd.n331 vdd.n210 0.1445
R1885 vdd.n343 vdd.n210 0.1445
R1886 vdd.n343 vdd.n208 0.1445
R1887 vdd.n347 vdd.n208 0.1445
R1888 vdd.n347 vdd.n198 0.1445
R1889 vdd.n359 vdd.n198 0.1445
R1890 vdd.n359 vdd.n196 0.1445
R1891 vdd.n363 vdd.n196 0.1445
R1892 vdd.n363 vdd.n186 0.1445
R1893 vdd.n375 vdd.n186 0.1445
R1894 vdd.n375 vdd.n184 0.1445
R1895 vdd.n379 vdd.n184 0.1445
R1896 vdd.n379 vdd.n174 0.1445
R1897 vdd.n391 vdd.n174 0.1445
R1898 vdd.n391 vdd.n172 0.1445
R1899 vdd.n395 vdd.n172 0.1445
R1900 vdd.n395 vdd.n150 0.1445
R1901 vdd.n407 vdd.n150 0.1445
R1902 vdd.n407 vdd.n148 0.1445
R1903 vdd.n411 vdd.n148 0.1445
R1904 vdd.n411 vdd.n138 0.1445
R1905 vdd.n423 vdd.n138 0.1445
R1906 vdd.n423 vdd.n136 0.1445
R1907 vdd.n427 vdd.n136 0.1445
R1908 vdd.n427 vdd.n126 0.1445
R1909 vdd.n442 vdd.n126 0.1445
R1910 vdd.n442 vdd.n124 0.1445
R1911 vdd.n447 vdd.n124 0.1445
R1912 vdd.n447 vdd.n84 0.1445
R1913 vdd.n499 vdd.n84 0.1445
R1914 vdd.n499 vdd.n498 0.1445
R1915 vdd.n498 vdd.n497 0.1445
R1916 vdd.n497 vdd.n88 0.1445
R1917 vdd.n482 vdd.n88 0.1445
R1918 vdd.n482 vdd.n481 0.1445
R1919 vdd.n481 vdd.n480 0.1445
R1920 vdd.n480 vdd.n108 0.1445
R1921 vdd.n108 vdd.n47 0.1445
R1922 vdd.n551 vdd.n47 0.1445
R1923 vdd.n549 vdd.n548 0.1445
R1924 vdd.n548 vdd.n49 0.1445
R1925 vdd.n544 vdd.n49 0.1445
R1926 vdd.n544 vdd.n51 0.1445
R1927 vdd.n514 vdd.n51 0.1445
R1928 vdd.n519 vdd.n514 0.1445
R1929 vdd.n519 vdd.n518 0.1445
R1930 vdd.n547 vdd.n546 0.1445
R1931 vdd.n546 vdd.n545 0.1445
R1932 vdd.n545 vdd.n50 0.1445
R1933 vdd.n515 vdd.n50 0.1445
R1934 vdd.n516 vdd.n515 0.1445
R1935 vdd.n517 vdd.n516 0.1445
R1936 vdd.n401 vdd.n400 0.1445
R1937 vdd.n402 vdd.n401 0.1445
R1938 vdd.n402 vdd.n143 0.1445
R1939 vdd.n416 vdd.n143 0.1445
R1940 vdd.n417 vdd.n416 0.1445
R1941 vdd.n418 vdd.n417 0.1445
R1942 vdd.n418 vdd.n131 0.1445
R1943 vdd.n432 vdd.n131 0.1445
R1944 vdd.n433 vdd.n432 0.1445
R1945 vdd.n434 vdd.n433 0.1445
R1946 vdd.n436 vdd.n434 0.1445
R1947 vdd.n436 vdd.n435 0.1445
R1948 vdd.n435 vdd.n119 0.1445
R1949 vdd.n454 vdd.n119 0.1445
R1950 vdd.n455 vdd.n454 0.1445
R1951 vdd.n456 vdd.n455 0.1445
R1952 vdd.n456 vdd.n116 0.1445
R1953 vdd.n461 vdd.n116 0.1445
R1954 vdd.n462 vdd.n461 0.1445
R1955 vdd.n463 vdd.n462 0.1445
R1956 vdd.n464 vdd.n463 0.1445
R1957 vdd.n465 vdd.n464 0.1445
R1958 vdd.n466 vdd.n465 0.1445
R1959 vdd.n468 vdd.n466 0.1445
R1960 vdd.n468 vdd.n467 0.1445
R1961 vdd.n467 vdd.n68 0.1445
R1962 vdd.n69 vdd.n68 0.1445
R1963 vdd.n70 vdd.n69 0.1445
R1964 vdd.n71 vdd.n70 0.1445
R1965 vdd.n161 vdd.n71 0.1445
R1966 vdd.n163 vdd.n161 0.1445
R1967 vdd.n488 vdd.n487 0.1445
R1968 vdd.n489 vdd.n97 0.1445
R1969 vdd.n273 vdd.n272 0.1445
R1970 vdd.n274 vdd.n273 0.1445
R1971 vdd.n274 vdd.n251 0.1445
R1972 vdd.n288 vdd.n251 0.1445
R1973 vdd.n289 vdd.n288 0.1445
R1974 vdd.n290 vdd.n289 0.1445
R1975 vdd.n290 vdd.n239 0.1445
R1976 vdd.n304 vdd.n239 0.1445
R1977 vdd.n305 vdd.n304 0.1445
R1978 vdd.n306 vdd.n305 0.1445
R1979 vdd.n306 vdd.n227 0.1445
R1980 vdd.n320 vdd.n227 0.1445
R1981 vdd.n321 vdd.n320 0.1445
R1982 vdd.n322 vdd.n321 0.1445
R1983 vdd.n322 vdd.n215 0.1445
R1984 vdd.n336 vdd.n215 0.1445
R1985 vdd.n337 vdd.n336 0.1445
R1986 vdd.n338 vdd.n337 0.1445
R1987 vdd.n338 vdd.n203 0.1445
R1988 vdd.n352 vdd.n203 0.1445
R1989 vdd.n353 vdd.n352 0.1445
R1990 vdd.n354 vdd.n353 0.1445
R1991 vdd.n354 vdd.n191 0.1445
R1992 vdd.n368 vdd.n191 0.1445
R1993 vdd.n369 vdd.n368 0.1445
R1994 vdd.n370 vdd.n369 0.1445
R1995 vdd.n370 vdd.n179 0.1445
R1996 vdd.n384 vdd.n179 0.1445
R1997 vdd.n385 vdd.n384 0.1445
R1998 vdd.n386 vdd.n385 0.1445
R1999 vdd.n271 vdd.n262 0.1445
R2000 vdd.n275 vdd.n262 0.1445
R2001 vdd.n275 vdd.n252 0.1445
R2002 vdd.n287 vdd.n252 0.1445
R2003 vdd.n287 vdd.n250 0.1445
R2004 vdd.n291 vdd.n250 0.1445
R2005 vdd.n291 vdd.n240 0.1445
R2006 vdd.n303 vdd.n240 0.1445
R2007 vdd.n303 vdd.n238 0.1445
R2008 vdd.n307 vdd.n238 0.1445
R2009 vdd.n307 vdd.n228 0.1445
R2010 vdd.n319 vdd.n228 0.1445
R2011 vdd.n319 vdd.n226 0.1445
R2012 vdd.n323 vdd.n226 0.1445
R2013 vdd.n323 vdd.n216 0.1445
R2014 vdd.n335 vdd.n216 0.1445
R2015 vdd.n335 vdd.n214 0.1445
R2016 vdd.n339 vdd.n214 0.1445
R2017 vdd.n339 vdd.n204 0.1445
R2018 vdd.n351 vdd.n204 0.1445
R2019 vdd.n351 vdd.n202 0.1445
R2020 vdd.n355 vdd.n202 0.1445
R2021 vdd.n355 vdd.n192 0.1445
R2022 vdd.n367 vdd.n192 0.1445
R2023 vdd.n367 vdd.n190 0.1445
R2024 vdd.n371 vdd.n190 0.1445
R2025 vdd.n371 vdd.n180 0.1445
R2026 vdd.n383 vdd.n180 0.1445
R2027 vdd.n383 vdd.n178 0.1445
R2028 vdd.n387 vdd.n178 0.1445
R2029 vdd.n387 vdd.n168 0.1445
R2030 vdd.n399 vdd.n168 0.1445
R2031 vdd.n399 vdd.n154 0.1445
R2032 vdd.n403 vdd.n154 0.1445
R2033 vdd.n403 vdd.n144 0.1445
R2034 vdd.n415 vdd.n144 0.1445
R2035 vdd.n415 vdd.n142 0.1445
R2036 vdd.n419 vdd.n142 0.1445
R2037 vdd.n419 vdd.n132 0.1445
R2038 vdd.n431 vdd.n132 0.1445
R2039 vdd.n431 vdd.n130 0.1445
R2040 vdd.n438 vdd.n130 0.1445
R2041 vdd.n438 vdd.n437 0.1445
R2042 vdd.n437 vdd.n120 0.1445
R2043 vdd.n452 vdd.n120 0.1445
R2044 vdd.n453 vdd.n452 0.1445
R2045 vdd.n453 vdd.n118 0.1445
R2046 vdd.n457 vdd.n118 0.1445
R2047 vdd.n459 vdd.n457 0.1445
R2048 vdd.n460 vdd.n459 0.1445
R2049 vdd.n460 vdd.n115 0.1445
R2050 vdd.n476 vdd.n115 0.1445
R2051 vdd.n476 vdd.n475 0.1445
R2052 vdd.n475 vdd.n474 0.1445
R2053 vdd.n474 vdd.n472 0.1445
R2054 vdd.n472 vdd.n471 0.1445
R2055 vdd.n471 vdd.n67 0.1445
R2056 vdd.n527 vdd.n67 0.1445
R2057 vdd.n527 vdd.n526 0.1445
R2058 vdd.n526 vdd.n525 0.1445
R2059 vdd.n525 vdd.n524 0.1445
R2060 vdd.n524 vdd.n72 0.1445
R2061 vdd.n162 vdd.n72 0.1445
R2062 vdd.n507 vdd.n505 0.1445
R2063 vdd.n506 vdd.n60 0.1445
R2064 vdd.n569 vdd.n566 0.1445
R2065 vdd.n568 vdd.n567 0.1445
R2066 vdd.n160 vdd.n159 0.130837
R2067 vdd.n560 vdd.n559 0.111183
R2068 vdd.n576 vdd.n561 0.111183
R2069 vdd.n557 vdd.n38 0.108765
R2070 vdd.n491 vdd.n64 0.102798
R2071 vdd.n537 vdd.n536 0.102798
R2072 vdd.n535 vdd.n534 0.102798
R2073 vdd.n167 vss 0.0806
R2074 vdd.n400 vdd.n167 0.0725
R2075 vdd.n551 vdd.n550 0.0718661
R2076 vdd.n550 vdd.n549 0.0718661
R2077 vdd.n547 vdd.n38 0.0671
R2078 vdd.n106 vdd.n38 0.0599
R2079 vss vdd.n576 0.0577669
R2080 vdd.n558 vss 0.0507793
R2081 vdd.n386 vdd.n167 0.0365
R2082 vdd.n159 vdd.n158 0.0363271
R2083 vdd.n158 vdd.n157 0.0077
R2084 vdd.n559 vdd.n558 0.00748758
R2085 vdd.n156 vdd.n155 0.00641376
R2086 vdd.n160 vdd.n155 0.00641376
R2087 vdd.n157 vss 0.00347
R2088 Iin.n391 Iin.n340 18200
R2089 Iin.n394 Iin.n392 18200
R2090 Iin.n391 Iin.n364 14243.8
R2091 Iin.n392 Iin.n391 4468.75
R2092 Iin.n392 Iin.n270 4062.5
R2093 Iin.n330 Iin.n329 521.494
R2094 Iin.n329 Iin.n328 521.494
R2095 Iin.n313 Iin.n312 521.494
R2096 Iin.n312 Iin.n311 521.494
R2097 Iin.n296 Iin.n295 521.494
R2098 Iin.n295 Iin.n287 521.494
R2099 Iin.n512 Iin.n364 233.853
R2100 Iin.n442 Iin.n272 147.31
R2101 Iin.n465 Iin.n390 147.31
R2102 Iin.n490 Iin.n338 147.31
R2103 Iin.n520 Iin.n349 147.31
R2104 Iin.n482 Iin.n481 143.626
R2105 Iin.n478 Iin.n376 143.626
R2106 Iin.n394 Iin.n393 141.786
R2107 Iin.n526 Iin.n340 134.419
R2108 Iin.n437 Iin.n436 132.578
R2109 Iin.n457 Iin.n400 132.578
R2110 Iin.n519 Iin.n351 130.738
R2111 Iin.n357 Iin.n351 125.213
R2112 Iin.n513 Iin.n358 125.213
R2113 Iin.n457 Iin.n456 123.371
R2114 Iin.n482 Iin.n384 112.323
R2115 Iin.n527 Iin.n338 104.959
R2116 Iin.n112 Iin.n102 95.4133
R2117 Iin.n112 Iin.n96 95.4133
R2118 Iin.n120 Iin.n96 95.4133
R2119 Iin.n120 Iin.n90 95.4133
R2120 Iin.n128 Iin.n90 95.4133
R2121 Iin.n128 Iin.n84 95.4133
R2122 Iin.n136 Iin.n84 95.4133
R2123 Iin.n136 Iin.n78 95.4133
R2124 Iin.n144 Iin.n78 95.4133
R2125 Iin.n144 Iin.n72 95.4133
R2126 Iin.n152 Iin.n72 95.4133
R2127 Iin.n152 Iin.n66 95.4133
R2128 Iin.n160 Iin.n66 95.4133
R2129 Iin.n160 Iin.n60 95.4133
R2130 Iin.n168 Iin.n60 95.4133
R2131 Iin.n168 Iin.n54 95.4133
R2132 Iin.n176 Iin.n54 95.4133
R2133 Iin.n176 Iin.n48 95.4133
R2134 Iin.n184 Iin.n48 95.4133
R2135 Iin.n184 Iin.n42 95.4133
R2136 Iin.n192 Iin.n42 95.4133
R2137 Iin.n192 Iin.n36 95.4133
R2138 Iin.n200 Iin.n36 95.4133
R2139 Iin.n200 Iin.n30 95.4133
R2140 Iin.n208 Iin.n30 95.4133
R2141 Iin.n208 Iin.n22 95.4133
R2142 Iin.n218 Iin.n22 95.4133
R2143 Iin.n218 Iin.n23 95.4133
R2144 Iin.n23 Iin.n16 95.4133
R2145 Iin.n227 Iin.n16 95.4133
R2146 Iin.n227 Iin.n8 95.4133
R2147 Iin.n572 Iin.n8 95.4133
R2148 Iin.n572 Iin.n9 95.4133
R2149 Iin.n566 Iin.n9 95.4133
R2150 Iin.n566 Iin.n565 95.4133
R2151 Iin.n565 Iin.n564 95.4133
R2152 Iin.n564 Iin.n240 95.4133
R2153 Iin.n558 Iin.n240 95.4133
R2154 Iin.n558 Iin.n557 95.4133
R2155 Iin.n557 Iin.n556 95.4133
R2156 Iin.n556 Iin.n251 95.4133
R2157 Iin.n550 Iin.n251 95.4133
R2158 Iin.n550 Iin.n549 95.4133
R2159 Iin.n549 Iin.n548 95.4133
R2160 Iin.n548 Iin.n262 95.4133
R2161 Iin.n541 Iin.n272 93.9099
R2162 Iin.n270 Iin.n262 75.1381
R2163 Iin.n366 Iin.n363 73.9866
R2164 Iin.n511 Iin.n366 73.9866
R2165 Iin.n106 Iin.n103 73.9866
R2166 Iin.n362 Iin.n356 69.0283
R2167 Iin.n514 Iin.n356 69.0283
R2168 Iin.n518 Iin.n353 69.0283
R2169 Iin.n518 Iin.n352 69.0283
R2170 Iin.n528 Iin.n336 69.0283
R2171 Iin.n528 Iin.n337 69.0283
R2172 Iin.n480 Iin.n479 69.0283
R2173 Iin.n479 Iin.n477 69.0283
R2174 Iin.n540 Iin.n273 69.0283
R2175 Iin.n540 Iin.n274 69.0283
R2176 Iin.n455 Iin.n453 69.0283
R2177 Iin.n455 Iin.n454 69.0283
R2178 Iin.n331 Iin.n320 62.1255
R2179 Iin.n327 Iin.n320 62.1255
R2180 Iin.n322 Iin.n321 62.1255
R2181 Iin.n321 Iin.n319 62.1255
R2182 Iin.n314 Iin.n303 62.1255
R2183 Iin.n310 Iin.n303 62.1255
R2184 Iin.n305 Iin.n304 62.1255
R2185 Iin.n304 Iin.n302 62.1255
R2186 Iin.n294 Iin.n285 62.1255
R2187 Iin.n294 Iin.n293 62.1255
R2188 Iin.n288 Iin.n286 62.1255
R2189 Iin.n297 Iin.n286 62.1255
R2190 Iin.n542 Iin.n541 53.3999
R2191 Iin.n106 Iin.n105 48.6503
R2192 Iin.n527 Iin.n526 42.3518
R2193 Iin.n393 Iin.n384 34.9863
R2194 Iin.n542 Iin.n270 31.3036
R2195 Iin.n456 Iin.n390 23.9382
R2196 Iin.n358 Iin.n357 22.0968
R2197 Iin.n513 Iin.n512 22.0968
R2198 Iin.n506 Iin.n1 17.2005
R2199 vss Iin.n1 17.0096
R2200 Iin.n520 Iin.n519 16.5727
R2201 Iin.n362 Iin.n352 15.5561
R2202 Iin.n113 Iin.n101 15.5561
R2203 Iin.n113 Iin.n97 15.5561
R2204 Iin.n119 Iin.n97 15.5561
R2205 Iin.n119 Iin.n89 15.5561
R2206 Iin.n129 Iin.n89 15.5561
R2207 Iin.n129 Iin.n85 15.5561
R2208 Iin.n135 Iin.n85 15.5561
R2209 Iin.n135 Iin.n77 15.5561
R2210 Iin.n145 Iin.n77 15.5561
R2211 Iin.n145 Iin.n73 15.5561
R2212 Iin.n151 Iin.n73 15.5561
R2213 Iin.n151 Iin.n65 15.5561
R2214 Iin.n161 Iin.n65 15.5561
R2215 Iin.n161 Iin.n61 15.5561
R2216 Iin.n167 Iin.n61 15.5561
R2217 Iin.n167 Iin.n53 15.5561
R2218 Iin.n177 Iin.n53 15.5561
R2219 Iin.n177 Iin.n49 15.5561
R2220 Iin.n183 Iin.n49 15.5561
R2221 Iin.n183 Iin.n41 15.5561
R2222 Iin.n193 Iin.n41 15.5561
R2223 Iin.n193 Iin.n37 15.5561
R2224 Iin.n199 Iin.n37 15.5561
R2225 Iin.n199 Iin.n29 15.5561
R2226 Iin.n209 Iin.n29 15.5561
R2227 Iin.n209 Iin.n24 15.5561
R2228 Iin.n217 Iin.n24 15.5561
R2229 Iin.n217 Iin.n25 15.5561
R2230 Iin.n25 Iin.n15 15.5561
R2231 Iin.n228 Iin.n15 15.5561
R2232 Iin.n228 Iin.n10 15.5561
R2233 Iin.n571 Iin.n10 15.5561
R2234 Iin.n571 Iin.n11 15.5561
R2235 Iin.n567 Iin.n11 15.5561
R2236 Iin.n567 Iin.n236 15.5561
R2237 Iin.n563 Iin.n236 15.5561
R2238 Iin.n563 Iin.n241 15.5561
R2239 Iin.n559 Iin.n241 15.5561
R2240 Iin.n559 Iin.n247 15.5561
R2241 Iin.n555 Iin.n247 15.5561
R2242 Iin.n555 Iin.n252 15.5561
R2243 Iin.n551 Iin.n252 15.5561
R2244 Iin.n551 Iin.n258 15.5561
R2245 Iin.n547 Iin.n258 15.5561
R2246 Iin.n547 Iin.n263 15.5561
R2247 Iin.n543 Iin.n263 15.5561
R2248 Iin.n543 Iin.n269 15.5561
R2249 Iin.n441 Iin.n269 15.5561
R2250 Iin.n441 Iin.n399 15.5561
R2251 Iin.n458 Iin.n399 15.5561
R2252 Iin.n458 Iin.n395 15.5561
R2253 Iin.n464 Iin.n395 15.5561
R2254 Iin.n464 Iin.n383 15.5561
R2255 Iin.n483 Iin.n383 15.5561
R2256 Iin.n483 Iin.n377 15.5561
R2257 Iin.n489 Iin.n377 15.5561
R2258 Iin.n489 Iin.n341 15.5561
R2259 Iin.n525 Iin.n341 15.5561
R2260 Iin.n525 Iin.n342 15.5561
R2261 Iin.n521 Iin.n342 15.5561
R2262 Iin.n521 Iin.n348 15.5561
R2263 Iin.n365 Iin.n348 15.5561
R2264 Iin.n511 Iin.n365 15.5561
R2265 Iin.n111 Iin.n103 15.5561
R2266 Iin.n111 Iin.n95 15.5561
R2267 Iin.n121 Iin.n95 15.5561
R2268 Iin.n121 Iin.n91 15.5561
R2269 Iin.n127 Iin.n91 15.5561
R2270 Iin.n127 Iin.n83 15.5561
R2271 Iin.n137 Iin.n83 15.5561
R2272 Iin.n137 Iin.n79 15.5561
R2273 Iin.n143 Iin.n79 15.5561
R2274 Iin.n143 Iin.n71 15.5561
R2275 Iin.n153 Iin.n71 15.5561
R2276 Iin.n153 Iin.n67 15.5561
R2277 Iin.n159 Iin.n67 15.5561
R2278 Iin.n159 Iin.n59 15.5561
R2279 Iin.n169 Iin.n59 15.5561
R2280 Iin.n169 Iin.n55 15.5561
R2281 Iin.n175 Iin.n55 15.5561
R2282 Iin.n175 Iin.n47 15.5561
R2283 Iin.n185 Iin.n47 15.5561
R2284 Iin.n185 Iin.n43 15.5561
R2285 Iin.n191 Iin.n43 15.5561
R2286 Iin.n191 Iin.n35 15.5561
R2287 Iin.n201 Iin.n35 15.5561
R2288 Iin.n201 Iin.n31 15.5561
R2289 Iin.n207 Iin.n31 15.5561
R2290 Iin.n207 Iin.n21 15.5561
R2291 Iin.n219 Iin.n21 15.5561
R2292 Iin.n219 Iin.n17 15.5561
R2293 Iin.n225 Iin.n17 15.5561
R2294 Iin.n226 Iin.n225 15.5561
R2295 Iin.n226 Iin.n5 15.5561
R2296 Iin.n573 Iin.n5 15.5561
R2297 Iin.n573 Iin.n7 15.5561
R2298 Iin.n237 Iin.n7 15.5561
R2299 Iin.n238 Iin.n237 15.5561
R2300 Iin.n239 Iin.n238 15.5561
R2301 Iin.n410 Iin.n239 15.5561
R2302 Iin.n410 Iin.n248 15.5561
R2303 Iin.n249 Iin.n248 15.5561
R2304 Iin.n250 Iin.n249 15.5561
R2305 Iin.n407 Iin.n250 15.5561
R2306 Iin.n407 Iin.n259 15.5561
R2307 Iin.n260 Iin.n259 15.5561
R2308 Iin.n261 Iin.n260 15.5561
R2309 Iin.n404 Iin.n261 15.5561
R2310 Iin.n404 Iin.n271 15.5561
R2311 Iin.n435 Iin.n271 15.5561
R2312 Iin.n443 Iin.n435 15.5561
R2313 Iin.n443 Iin.n401 15.5561
R2314 Iin.n449 Iin.n401 15.5561
R2315 Iin.n449 Iin.n389 15.5561
R2316 Iin.n466 Iin.n389 15.5561
R2317 Iin.n466 Iin.n385 15.5561
R2318 Iin.n475 Iin.n385 15.5561
R2319 Iin.n475 Iin.n375 15.5561
R2320 Iin.n491 Iin.n375 15.5561
R2321 Iin.n492 Iin.n491 15.5561
R2322 Iin.n492 Iin.n339 15.5561
R2323 Iin.n495 Iin.n339 15.5561
R2324 Iin.n495 Iin.n350 15.5561
R2325 Iin.n501 Iin.n350 15.5561
R2326 Iin.n502 Iin.n501 15.5561
R2327 Iin.n502 Iin.n363 15.5561
R2328 Iin.n453 Iin.n273 15.5561
R2329 Iin.n442 Iin.n437 14.7314
R2330 Iin.n436 Iin.n400 14.7314
R2331 Iin.n349 Iin.n340 12.89
R2332 Iin.n335 Iin.n334 11.8522
R2333 Iin.n508 Iin.n278 11.0435
R2334 Iin.n486 Iin.n380 7.6287
R2335 Iin.n332 Iin.n331 6.37187
R2336 Iin.n332 Iin.n319 6.37187
R2337 Iin.n315 Iin.n314 6.37187
R2338 Iin.n315 Iin.n302 6.37187
R2339 Iin.n298 Iin.n297 6.37187
R2340 Iin.n298 Iin.n285 6.37187
R2341 Iin.n327 Iin.n326 6.3005
R2342 Iin.n323 Iin.n322 6.3005
R2343 Iin.n310 Iin.n309 6.3005
R2344 Iin.n306 Iin.n305 6.3005
R2345 Iin.n293 Iin.n292 6.3005
R2346 Iin.n289 Iin.n288 6.3005
R2347 Iin.n465 Iin.n394 5.52458
R2348 Iin.n107 Iin.n99 5.25278
R2349 Iin.n108 Iin.n107 5.25278
R2350 Iin.n517 Iin.n354 5.20101
R2351 Iin.n324 Iin.n282 5.20101
R2352 Iin.n325 Iin.n281 5.20101
R2353 Iin.n307 Iin.n301 5.20101
R2354 Iin.n308 Iin.n300 5.20101
R2355 Iin.n290 Iin.n284 5.20101
R2356 Iin.n291 Iin.n283 5.20101
R2357 Iin.n539 Iin.n275 5.20101
R2358 Iin.n405 Iin.n404 5.2005
R2359 Iin.n404 Iin.n262 5.2005
R2360 Iin.n429 Iin.n261 5.2005
R2361 Iin.n548 Iin.n261 5.2005
R2362 Iin.n428 Iin.n260 5.2005
R2363 Iin.n549 Iin.n260 5.2005
R2364 Iin.n427 Iin.n259 5.2005
R2365 Iin.n550 Iin.n259 5.2005
R2366 Iin.n408 Iin.n407 5.2005
R2367 Iin.n407 Iin.n251 5.2005
R2368 Iin.n423 Iin.n250 5.2005
R2369 Iin.n556 Iin.n250 5.2005
R2370 Iin.n422 Iin.n249 5.2005
R2371 Iin.n557 Iin.n249 5.2005
R2372 Iin.n421 Iin.n248 5.2005
R2373 Iin.n558 Iin.n248 5.2005
R2374 Iin.n411 Iin.n410 5.2005
R2375 Iin.n410 Iin.n240 5.2005
R2376 Iin.n417 Iin.n239 5.2005
R2377 Iin.n564 Iin.n239 5.2005
R2378 Iin.n416 Iin.n238 5.2005
R2379 Iin.n565 Iin.n238 5.2005
R2380 Iin.n415 Iin.n237 5.2005
R2381 Iin.n566 Iin.n237 5.2005
R2382 Iin.n7 Iin.n6 5.2005
R2383 Iin.n9 Iin.n7 5.2005
R2384 Iin.n574 Iin.n573 5.2005
R2385 Iin.n573 Iin.n572 5.2005
R2386 Iin.n575 Iin.n5 5.2005
R2387 Iin.n8 Iin.n5 5.2005
R2388 Iin.n226 Iin.n4 5.2005
R2389 Iin.n227 Iin.n226 5.2005
R2390 Iin.n225 Iin.n224 5.2005
R2391 Iin.n225 Iin.n16 5.2005
R2392 Iin.n18 Iin.n17 5.2005
R2393 Iin.n23 Iin.n17 5.2005
R2394 Iin.n220 Iin.n219 5.2005
R2395 Iin.n219 Iin.n218 5.2005
R2396 Iin.n21 Iin.n20 5.2005
R2397 Iin.n22 Iin.n21 5.2005
R2398 Iin.n207 Iin.n206 5.2005
R2399 Iin.n208 Iin.n207 5.2005
R2400 Iin.n32 Iin.n31 5.2005
R2401 Iin.n31 Iin.n30 5.2005
R2402 Iin.n202 Iin.n201 5.2005
R2403 Iin.n201 Iin.n200 5.2005
R2404 Iin.n35 Iin.n34 5.2005
R2405 Iin.n36 Iin.n35 5.2005
R2406 Iin.n191 Iin.n190 5.2005
R2407 Iin.n192 Iin.n191 5.2005
R2408 Iin.n44 Iin.n43 5.2005
R2409 Iin.n43 Iin.n42 5.2005
R2410 Iin.n186 Iin.n185 5.2005
R2411 Iin.n185 Iin.n184 5.2005
R2412 Iin.n47 Iin.n46 5.2005
R2413 Iin.n48 Iin.n47 5.2005
R2414 Iin.n175 Iin.n174 5.2005
R2415 Iin.n176 Iin.n175 5.2005
R2416 Iin.n56 Iin.n55 5.2005
R2417 Iin.n55 Iin.n54 5.2005
R2418 Iin.n170 Iin.n169 5.2005
R2419 Iin.n169 Iin.n168 5.2005
R2420 Iin.n59 Iin.n58 5.2005
R2421 Iin.n60 Iin.n59 5.2005
R2422 Iin.n159 Iin.n158 5.2005
R2423 Iin.n160 Iin.n159 5.2005
R2424 Iin.n68 Iin.n67 5.2005
R2425 Iin.n67 Iin.n66 5.2005
R2426 Iin.n154 Iin.n153 5.2005
R2427 Iin.n153 Iin.n152 5.2005
R2428 Iin.n71 Iin.n70 5.2005
R2429 Iin.n72 Iin.n71 5.2005
R2430 Iin.n143 Iin.n142 5.2005
R2431 Iin.n144 Iin.n143 5.2005
R2432 Iin.n80 Iin.n79 5.2005
R2433 Iin.n79 Iin.n78 5.2005
R2434 Iin.n138 Iin.n137 5.2005
R2435 Iin.n137 Iin.n136 5.2005
R2436 Iin.n83 Iin.n82 5.2005
R2437 Iin.n84 Iin.n83 5.2005
R2438 Iin.n127 Iin.n126 5.2005
R2439 Iin.n128 Iin.n127 5.2005
R2440 Iin.n92 Iin.n91 5.2005
R2441 Iin.n91 Iin.n90 5.2005
R2442 Iin.n122 Iin.n121 5.2005
R2443 Iin.n121 Iin.n120 5.2005
R2444 Iin.n95 Iin.n94 5.2005
R2445 Iin.n96 Iin.n95 5.2005
R2446 Iin.n111 Iin.n110 5.2005
R2447 Iin.n112 Iin.n111 5.2005
R2448 Iin.n104 Iin.n103 5.2005
R2449 Iin.n103 Iin.n102 5.2005
R2450 Iin.n545 Iin.n263 5.2005
R2451 Iin.n263 Iin.n262 5.2005
R2452 Iin.n547 Iin.n546 5.2005
R2453 Iin.n548 Iin.n547 5.2005
R2454 Iin.n258 Iin.n257 5.2005
R2455 Iin.n549 Iin.n258 5.2005
R2456 Iin.n552 Iin.n551 5.2005
R2457 Iin.n551 Iin.n550 5.2005
R2458 Iin.n553 Iin.n252 5.2005
R2459 Iin.n252 Iin.n251 5.2005
R2460 Iin.n555 Iin.n554 5.2005
R2461 Iin.n556 Iin.n555 5.2005
R2462 Iin.n247 Iin.n246 5.2005
R2463 Iin.n557 Iin.n247 5.2005
R2464 Iin.n560 Iin.n559 5.2005
R2465 Iin.n559 Iin.n558 5.2005
R2466 Iin.n561 Iin.n241 5.2005
R2467 Iin.n241 Iin.n240 5.2005
R2468 Iin.n563 Iin.n562 5.2005
R2469 Iin.n564 Iin.n563 5.2005
R2470 Iin.n236 Iin.n235 5.2005
R2471 Iin.n565 Iin.n236 5.2005
R2472 Iin.n568 Iin.n567 5.2005
R2473 Iin.n567 Iin.n566 5.2005
R2474 Iin.n569 Iin.n11 5.2005
R2475 Iin.n11 Iin.n9 5.2005
R2476 Iin.n571 Iin.n570 5.2005
R2477 Iin.n572 Iin.n571 5.2005
R2478 Iin.n12 Iin.n10 5.2005
R2479 Iin.n10 Iin.n8 5.2005
R2480 Iin.n229 Iin.n228 5.2005
R2481 Iin.n228 Iin.n227 5.2005
R2482 Iin.n15 Iin.n14 5.2005
R2483 Iin.n16 Iin.n15 5.2005
R2484 Iin.n215 Iin.n25 5.2005
R2485 Iin.n25 Iin.n23 5.2005
R2486 Iin.n217 Iin.n216 5.2005
R2487 Iin.n218 Iin.n217 5.2005
R2488 Iin.n26 Iin.n24 5.2005
R2489 Iin.n24 Iin.n22 5.2005
R2490 Iin.n210 Iin.n209 5.2005
R2491 Iin.n209 Iin.n208 5.2005
R2492 Iin.n29 Iin.n28 5.2005
R2493 Iin.n30 Iin.n29 5.2005
R2494 Iin.n199 Iin.n198 5.2005
R2495 Iin.n200 Iin.n199 5.2005
R2496 Iin.n38 Iin.n37 5.2005
R2497 Iin.n37 Iin.n36 5.2005
R2498 Iin.n194 Iin.n193 5.2005
R2499 Iin.n193 Iin.n192 5.2005
R2500 Iin.n41 Iin.n40 5.2005
R2501 Iin.n42 Iin.n41 5.2005
R2502 Iin.n183 Iin.n182 5.2005
R2503 Iin.n184 Iin.n183 5.2005
R2504 Iin.n50 Iin.n49 5.2005
R2505 Iin.n49 Iin.n48 5.2005
R2506 Iin.n178 Iin.n177 5.2005
R2507 Iin.n177 Iin.n176 5.2005
R2508 Iin.n53 Iin.n52 5.2005
R2509 Iin.n54 Iin.n53 5.2005
R2510 Iin.n167 Iin.n166 5.2005
R2511 Iin.n168 Iin.n167 5.2005
R2512 Iin.n62 Iin.n61 5.2005
R2513 Iin.n61 Iin.n60 5.2005
R2514 Iin.n162 Iin.n161 5.2005
R2515 Iin.n161 Iin.n160 5.2005
R2516 Iin.n65 Iin.n64 5.2005
R2517 Iin.n66 Iin.n65 5.2005
R2518 Iin.n151 Iin.n150 5.2005
R2519 Iin.n152 Iin.n151 5.2005
R2520 Iin.n74 Iin.n73 5.2005
R2521 Iin.n73 Iin.n72 5.2005
R2522 Iin.n146 Iin.n145 5.2005
R2523 Iin.n145 Iin.n144 5.2005
R2524 Iin.n77 Iin.n76 5.2005
R2525 Iin.n78 Iin.n77 5.2005
R2526 Iin.n135 Iin.n134 5.2005
R2527 Iin.n136 Iin.n135 5.2005
R2528 Iin.n86 Iin.n85 5.2005
R2529 Iin.n85 Iin.n84 5.2005
R2530 Iin.n130 Iin.n129 5.2005
R2531 Iin.n129 Iin.n128 5.2005
R2532 Iin.n89 Iin.n88 5.2005
R2533 Iin.n90 Iin.n89 5.2005
R2534 Iin.n119 Iin.n118 5.2005
R2535 Iin.n120 Iin.n119 5.2005
R2536 Iin.n98 Iin.n97 5.2005
R2537 Iin.n97 Iin.n96 5.2005
R2538 Iin.n114 Iin.n113 5.2005
R2539 Iin.n113 Iin.n112 5.2005
R2540 Iin.n101 Iin.n100 5.2005
R2541 Iin.n376 Iin.n336 5.2005
R2542 Iin.n481 Iin.n477 5.2005
R2543 Iin.n376 Iin.n337 5.2005
R2544 Iin.n481 Iin.n480 5.2005
R2545 Iin.n362 Iin.n361 5.2005
R2546 Iin.n513 Iin.n362 5.2005
R2547 Iin.n359 Iin.n352 5.2005
R2548 Iin.n357 Iin.n352 5.2005
R2549 Iin.n514 Iin.n513 5.2005
R2550 Iin.n357 Iin.n353 5.2005
R2551 Iin.n504 Iin.n363 5.2005
R2552 Iin.n512 Iin.n363 5.2005
R2553 Iin.n503 Iin.n502 5.2005
R2554 Iin.n502 Iin.n358 5.2005
R2555 Iin.n501 Iin.n500 5.2005
R2556 Iin.n501 Iin.n351 5.2005
R2557 Iin.n371 Iin.n350 5.2005
R2558 Iin.n520 Iin.n350 5.2005
R2559 Iin.n496 Iin.n495 5.2005
R2560 Iin.n495 Iin.n349 5.2005
R2561 Iin.n494 Iin.n339 5.2005
R2562 Iin.n526 Iin.n339 5.2005
R2563 Iin.n493 Iin.n492 5.2005
R2564 Iin.n492 Iin.n338 5.2005
R2565 Iin.n491 Iin.n373 5.2005
R2566 Iin.n491 Iin.n490 5.2005
R2567 Iin.n473 Iin.n375 5.2005
R2568 Iin.n478 Iin.n375 5.2005
R2569 Iin.n475 Iin.n474 5.2005
R2570 Iin.n482 Iin.n475 5.2005
R2571 Iin.n386 Iin.n385 5.2005
R2572 Iin.n393 Iin.n385 5.2005
R2573 Iin.n467 Iin.n466 5.2005
R2574 Iin.n466 Iin.n465 5.2005
R2575 Iin.n389 Iin.n388 5.2005
R2576 Iin.n390 Iin.n389 5.2005
R2577 Iin.n449 Iin.n448 5.2005
R2578 Iin.n457 Iin.n449 5.2005
R2579 Iin.n402 Iin.n401 5.2005
R2580 Iin.n436 Iin.n401 5.2005
R2581 Iin.n444 Iin.n443 5.2005
R2582 Iin.n443 Iin.n442 5.2005
R2583 Iin.n435 Iin.n434 5.2005
R2584 Iin.n435 Iin.n272 5.2005
R2585 Iin.n433 Iin.n271 5.2005
R2586 Iin.n542 Iin.n271 5.2005
R2587 Iin.n511 Iin.n510 5.2005
R2588 Iin.n512 Iin.n511 5.2005
R2589 Iin.n367 Iin.n365 5.2005
R2590 Iin.n365 Iin.n358 5.2005
R2591 Iin.n348 Iin.n347 5.2005
R2592 Iin.n351 Iin.n348 5.2005
R2593 Iin.n522 Iin.n521 5.2005
R2594 Iin.n521 Iin.n520 5.2005
R2595 Iin.n523 Iin.n342 5.2005
R2596 Iin.n349 Iin.n342 5.2005
R2597 Iin.n525 Iin.n524 5.2005
R2598 Iin.n526 Iin.n525 5.2005
R2599 Iin.n343 Iin.n341 5.2005
R2600 Iin.n341 Iin.n338 5.2005
R2601 Iin.n489 Iin.n488 5.2005
R2602 Iin.n490 Iin.n489 5.2005
R2603 Iin.n378 Iin.n377 5.2005
R2604 Iin.n478 Iin.n377 5.2005
R2605 Iin.n484 Iin.n483 5.2005
R2606 Iin.n483 Iin.n482 5.2005
R2607 Iin.n383 Iin.n382 5.2005
R2608 Iin.n393 Iin.n383 5.2005
R2609 Iin.n464 Iin.n463 5.2005
R2610 Iin.n465 Iin.n464 5.2005
R2611 Iin.n396 Iin.n395 5.2005
R2612 Iin.n395 Iin.n390 5.2005
R2613 Iin.n459 Iin.n458 5.2005
R2614 Iin.n458 Iin.n457 5.2005
R2615 Iin.n399 Iin.n398 5.2005
R2616 Iin.n436 Iin.n399 5.2005
R2617 Iin.n441 Iin.n440 5.2005
R2618 Iin.n442 Iin.n441 5.2005
R2619 Iin.n269 Iin.n268 5.2005
R2620 Iin.n272 Iin.n269 5.2005
R2621 Iin.n544 Iin.n543 5.2005
R2622 Iin.n543 Iin.n542 5.2005
R2623 Iin.n453 Iin.n452 5.2005
R2624 Iin.n453 Iin.n400 5.2005
R2625 Iin.n450 Iin.n273 5.2005
R2626 Iin.n437 Iin.n273 5.2005
R2627 Iin.n454 Iin.n400 5.2005
R2628 Iin.n437 Iin.n274 5.2005
R2629 Iin.n360 Iin.n355 5.19319
R2630 Iin.n451 Iin.n276 5.19319
R2631 Iin.n335 Iin.n279 5.12001
R2632 Iin.n529 Iin.n335 5.11219
R2633 Iin.n506 Iin.n505 5.04833
R2634 Iin.n508 Iin.n507 5.02778
R2635 Iin.n530 Iin.n279 4.98321
R2636 Iin.n517 Iin.n516 4.98321
R2637 Iin.n516 Iin.n355 4.98321
R2638 Iin.n530 Iin.n529 4.98321
R2639 Iin.n333 Iin.n282 4.98321
R2640 Iin.n316 Iin.n301 4.98321
R2641 Iin.n299 Iin.n284 4.98321
R2642 Iin.n538 Iin.n276 4.98321
R2643 Iin.n539 Iin.n538 4.98321
R2644 Iin.n333 Iin.n281 4.97539
R2645 Iin.n316 Iin.n300 4.97539
R2646 Iin.n299 Iin.n283 4.97539
R2647 vss Iin.n0 4.8929
R2648 Iin.n379 Iin.n343 4.5005
R2649 Iin.n524 Iin.n344 4.5005
R2650 Iin.n523 Iin.n345 4.5005
R2651 Iin.n522 Iin.n346 4.5005
R2652 Iin.n368 Iin.n347 4.5005
R2653 Iin.n369 Iin.n367 4.5005
R2654 Iin.n510 Iin.n509 4.5005
R2655 Iin.n361 Iin.n360 4.5005
R2656 Iin.n359 Iin.n354 4.5005
R2657 Iin.n326 Iin.n325 4.5005
R2658 Iin.n324 Iin.n323 4.5005
R2659 Iin.n309 Iin.n308 4.5005
R2660 Iin.n307 Iin.n306 4.5005
R2661 Iin.n292 Iin.n291 4.5005
R2662 Iin.n290 Iin.n289 4.5005
R2663 Iin.n115 Iin.n114 4.5005
R2664 Iin.n116 Iin.n98 4.5005
R2665 Iin.n118 Iin.n117 4.5005
R2666 Iin.n88 Iin.n87 4.5005
R2667 Iin.n131 Iin.n130 4.5005
R2668 Iin.n132 Iin.n86 4.5005
R2669 Iin.n134 Iin.n133 4.5005
R2670 Iin.n76 Iin.n75 4.5005
R2671 Iin.n147 Iin.n146 4.5005
R2672 Iin.n148 Iin.n74 4.5005
R2673 Iin.n150 Iin.n149 4.5005
R2674 Iin.n64 Iin.n63 4.5005
R2675 Iin.n163 Iin.n162 4.5005
R2676 Iin.n164 Iin.n62 4.5005
R2677 Iin.n166 Iin.n165 4.5005
R2678 Iin.n52 Iin.n51 4.5005
R2679 Iin.n179 Iin.n178 4.5005
R2680 Iin.n180 Iin.n50 4.5005
R2681 Iin.n182 Iin.n181 4.5005
R2682 Iin.n40 Iin.n39 4.5005
R2683 Iin.n195 Iin.n194 4.5005
R2684 Iin.n196 Iin.n38 4.5005
R2685 Iin.n198 Iin.n197 4.5005
R2686 Iin.n28 Iin.n27 4.5005
R2687 Iin.n211 Iin.n210 4.5005
R2688 Iin.n212 Iin.n26 4.5005
R2689 Iin.n216 Iin.n213 4.5005
R2690 Iin.n215 Iin.n214 4.5005
R2691 Iin.n14 Iin.n13 4.5005
R2692 Iin.n230 Iin.n229 4.5005
R2693 Iin.n231 Iin.n12 4.5005
R2694 Iin.n570 Iin.n232 4.5005
R2695 Iin.n569 Iin.n233 4.5005
R2696 Iin.n568 Iin.n234 4.5005
R2697 Iin.n242 Iin.n235 4.5005
R2698 Iin.n562 Iin.n243 4.5005
R2699 Iin.n561 Iin.n244 4.5005
R2700 Iin.n560 Iin.n245 4.5005
R2701 Iin.n253 Iin.n246 4.5005
R2702 Iin.n554 Iin.n254 4.5005
R2703 Iin.n553 Iin.n255 4.5005
R2704 Iin.n552 Iin.n256 4.5005
R2705 Iin.n264 Iin.n257 4.5005
R2706 Iin.n546 Iin.n265 4.5005
R2707 Iin.n545 Iin.n266 4.5005
R2708 Iin.n544 Iin.n267 4.5005
R2709 Iin.n438 Iin.n268 4.5005
R2710 Iin.n440 Iin.n439 4.5005
R2711 Iin.n398 Iin.n397 4.5005
R2712 Iin.n460 Iin.n459 4.5005
R2713 Iin.n461 Iin.n396 4.5005
R2714 Iin.n463 Iin.n462 4.5005
R2715 Iin.n382 Iin.n381 4.5005
R2716 Iin.n485 Iin.n484 4.5005
R2717 Iin.n100 Iin.n99 4.5005
R2718 Iin.n110 Iin.n109 4.5005
R2719 Iin.n94 Iin.n93 4.5005
R2720 Iin.n123 Iin.n122 4.5005
R2721 Iin.n124 Iin.n92 4.5005
R2722 Iin.n126 Iin.n125 4.5005
R2723 Iin.n82 Iin.n81 4.5005
R2724 Iin.n139 Iin.n138 4.5005
R2725 Iin.n140 Iin.n80 4.5005
R2726 Iin.n142 Iin.n141 4.5005
R2727 Iin.n70 Iin.n69 4.5005
R2728 Iin.n155 Iin.n154 4.5005
R2729 Iin.n156 Iin.n68 4.5005
R2730 Iin.n158 Iin.n157 4.5005
R2731 Iin.n58 Iin.n57 4.5005
R2732 Iin.n171 Iin.n170 4.5005
R2733 Iin.n172 Iin.n56 4.5005
R2734 Iin.n174 Iin.n173 4.5005
R2735 Iin.n46 Iin.n45 4.5005
R2736 Iin.n187 Iin.n186 4.5005
R2737 Iin.n188 Iin.n44 4.5005
R2738 Iin.n190 Iin.n189 4.5005
R2739 Iin.n34 Iin.n33 4.5005
R2740 Iin.n203 Iin.n202 4.5005
R2741 Iin.n204 Iin.n32 4.5005
R2742 Iin.n206 Iin.n205 4.5005
R2743 Iin.n20 Iin.n19 4.5005
R2744 Iin.n221 Iin.n220 4.5005
R2745 Iin.n222 Iin.n18 4.5005
R2746 Iin.n224 Iin.n223 4.5005
R2747 Iin.n4 Iin.n3 4.5005
R2748 Iin.n574 Iin.n2 4.5005
R2749 Iin.n413 Iin.n6 4.5005
R2750 Iin.n415 Iin.n414 4.5005
R2751 Iin.n416 Iin.n412 4.5005
R2752 Iin.n418 Iin.n417 4.5005
R2753 Iin.n419 Iin.n411 4.5005
R2754 Iin.n421 Iin.n420 4.5005
R2755 Iin.n422 Iin.n409 4.5005
R2756 Iin.n424 Iin.n423 4.5005
R2757 Iin.n425 Iin.n408 4.5005
R2758 Iin.n427 Iin.n426 4.5005
R2759 Iin.n428 Iin.n406 4.5005
R2760 Iin.n430 Iin.n429 4.5005
R2761 Iin.n431 Iin.n405 4.5005
R2762 Iin.n433 Iin.n432 4.5005
R2763 Iin.n434 Iin.n403 4.5005
R2764 Iin.n445 Iin.n444 4.5005
R2765 Iin.n446 Iin.n402 4.5005
R2766 Iin.n448 Iin.n447 4.5005
R2767 Iin.n388 Iin.n387 4.5005
R2768 Iin.n468 Iin.n467 4.5005
R2769 Iin.n469 Iin.n386 4.5005
R2770 Iin.n474 Iin.n470 4.5005
R2771 Iin.n473 Iin.n472 4.5005
R2772 Iin.n471 Iin.n373 4.5005
R2773 Iin.n493 Iin.n374 4.5005
R2774 Iin.n494 Iin.n372 4.5005
R2775 Iin.n497 Iin.n496 4.5005
R2776 Iin.n498 Iin.n371 4.5005
R2777 Iin.n500 Iin.n499 4.5005
R2778 Iin.n503 Iin.n370 4.5005
R2779 Iin.n505 Iin.n504 4.5005
R2780 Iin.n108 Iin.n104 4.5005
R2781 Iin.n452 Iin.n451 4.5005
R2782 Iin.n450 Iin.n275 4.5005
R2783 Iin.n576 Iin.n575 4.5005
R2784 Iin.n481 Iin.n478 3.68322
R2785 Iin.n490 Iin.n376 3.68322
R2786 Iin.n105 Iin.n102 3.42024
R2787 Iin.n328 Iin.n327 3.31679
R2788 Iin.n328 Iin.n322 3.31679
R2789 Iin.n330 Iin.n319 3.31679
R2790 Iin.n331 Iin.n330 3.31679
R2791 Iin.n311 Iin.n310 3.31679
R2792 Iin.n311 Iin.n305 3.31679
R2793 Iin.n313 Iin.n302 3.31679
R2794 Iin.n314 Iin.n313 3.31679
R2795 Iin.n293 Iin.n287 3.31679
R2796 Iin.n288 Iin.n287 3.31679
R2797 Iin.n296 Iin.n285 3.31679
R2798 Iin.n297 Iin.n296 3.31679
R2799 Iin.n516 Iin.n515 3.28078
R2800 Iin.n530 Iin.n280 3.28078
R2801 Iin.n476 Iin.n335 3.28078
R2802 Iin.n538 Iin.n277 3.28078
R2803 Iin.n515 Iin.n353 3.14293
R2804 Iin.n480 Iin.n280 3.14293
R2805 Iin.n477 Iin.n476 3.14293
R2806 Iin.n337 Iin.n280 3.14293
R2807 Iin.n515 Iin.n514 3.14293
R2808 Iin.n476 Iin.n336 3.14293
R2809 Iin.n277 Iin.n274 3.14293
R2810 Iin.n454 Iin.n277 3.14293
R2811 Iin.n316 Iin.n315 2.21557
R2812 Iin.n299 Iin.n298 2.21557
R2813 Iin.n333 Iin.n332 2.21557
R2814 Iin.n487 Iin.n486 2.21557
R2815 Iin.n105 Iin.n101 1.66482
R2816 Iin.n535 Iin.n534 1.1255
R2817 Iin.n533 Iin.n532 1.1255
R2818 Iin.n317 vss 1.0868
R2819 Iin.n320 Iin.n281 0.9005
R2820 Iin.n329 Iin.n320 0.9005
R2821 Iin.n321 Iin.n282 0.9005
R2822 Iin.n329 Iin.n321 0.9005
R2823 Iin.n303 Iin.n300 0.9005
R2824 Iin.n312 Iin.n303 0.9005
R2825 Iin.n304 Iin.n301 0.9005
R2826 Iin.n312 Iin.n304 0.9005
R2827 Iin.n294 Iin.n283 0.9005
R2828 Iin.n295 Iin.n294 0.9005
R2829 Iin.n286 Iin.n284 0.9005
R2830 Iin.n295 Iin.n286 0.9005
R2831 Iin.n479 Iin.n279 0.743357
R2832 Iin.n479 Iin.n384 0.743357
R2833 Iin.n529 Iin.n528 0.743357
R2834 Iin.n528 Iin.n527 0.743357
R2835 Iin.n518 Iin.n517 0.743357
R2836 Iin.n519 Iin.n518 0.743357
R2837 Iin.n356 Iin.n355 0.743357
R2838 Iin.n364 Iin.n356 0.743357
R2839 Iin.n540 Iin.n539 0.743357
R2840 Iin.n541 Iin.n540 0.743357
R2841 Iin.n455 Iin.n276 0.743357
R2842 Iin.n456 Iin.n455 0.743357
R2843 Iin.n107 Iin.n106 0.578278
R2844 Iin.n507 Iin.n366 0.578278
R2845 Iin.n366 Iin.n364 0.578278
R2846 Iin.n318 Iin.n299 0.316383
R2847 Iin.n537 Iin.n536 0.23353
R2848 Iin.n509 Iin.n508 0.2255
R2849 Iin.n533 vss 0.219897
R2850 Iin.n531 Iin.n278 0.2057
R2851 Iin.n537 Iin.n531 0.2057
R2852 Iin.n318 Iin.n317 0.2057
R2853 Iin.n507 Iin.n506 0.19713
R2854 Iin.n114 Iin.n100 0.1445
R2855 Iin.n114 Iin.n98 0.1445
R2856 Iin.n118 Iin.n98 0.1445
R2857 Iin.n118 Iin.n88 0.1445
R2858 Iin.n130 Iin.n88 0.1445
R2859 Iin.n130 Iin.n86 0.1445
R2860 Iin.n134 Iin.n86 0.1445
R2861 Iin.n134 Iin.n76 0.1445
R2862 Iin.n146 Iin.n76 0.1445
R2863 Iin.n146 Iin.n74 0.1445
R2864 Iin.n150 Iin.n74 0.1445
R2865 Iin.n150 Iin.n64 0.1445
R2866 Iin.n162 Iin.n64 0.1445
R2867 Iin.n162 Iin.n62 0.1445
R2868 Iin.n166 Iin.n62 0.1445
R2869 Iin.n166 Iin.n52 0.1445
R2870 Iin.n178 Iin.n52 0.1445
R2871 Iin.n178 Iin.n50 0.1445
R2872 Iin.n182 Iin.n50 0.1445
R2873 Iin.n182 Iin.n40 0.1445
R2874 Iin.n194 Iin.n40 0.1445
R2875 Iin.n194 Iin.n38 0.1445
R2876 Iin.n198 Iin.n38 0.1445
R2877 Iin.n198 Iin.n28 0.1445
R2878 Iin.n210 Iin.n28 0.1445
R2879 Iin.n210 Iin.n26 0.1445
R2880 Iin.n216 Iin.n26 0.1445
R2881 Iin.n216 Iin.n215 0.1445
R2882 Iin.n215 Iin.n14 0.1445
R2883 Iin.n229 Iin.n14 0.1445
R2884 Iin.n229 Iin.n12 0.1445
R2885 Iin.n570 Iin.n12 0.1445
R2886 Iin.n570 Iin.n569 0.1445
R2887 Iin.n569 Iin.n568 0.1445
R2888 Iin.n568 Iin.n235 0.1445
R2889 Iin.n562 Iin.n235 0.1445
R2890 Iin.n562 Iin.n561 0.1445
R2891 Iin.n561 Iin.n560 0.1445
R2892 Iin.n560 Iin.n246 0.1445
R2893 Iin.n554 Iin.n246 0.1445
R2894 Iin.n554 Iin.n553 0.1445
R2895 Iin.n553 Iin.n552 0.1445
R2896 Iin.n552 Iin.n257 0.1445
R2897 Iin.n546 Iin.n257 0.1445
R2898 Iin.n546 Iin.n545 0.1445
R2899 Iin.n545 Iin.n544 0.1445
R2900 Iin.n544 Iin.n268 0.1445
R2901 Iin.n440 Iin.n268 0.1445
R2902 Iin.n440 Iin.n398 0.1445
R2903 Iin.n459 Iin.n398 0.1445
R2904 Iin.n459 Iin.n396 0.1445
R2905 Iin.n463 Iin.n396 0.1445
R2906 Iin.n463 Iin.n382 0.1445
R2907 Iin.n484 Iin.n382 0.1445
R2908 Iin.n484 Iin.n378 0.1445
R2909 Iin.n488 Iin.n343 0.1445
R2910 Iin.n524 Iin.n343 0.1445
R2911 Iin.n524 Iin.n523 0.1445
R2912 Iin.n523 Iin.n522 0.1445
R2913 Iin.n522 Iin.n347 0.1445
R2914 Iin.n367 Iin.n347 0.1445
R2915 Iin.n510 Iin.n367 0.1445
R2916 Iin.n413 Iin.n2 0.1445
R2917 Iin.n414 Iin.n413 0.1445
R2918 Iin.n414 Iin.n412 0.1445
R2919 Iin.n418 Iin.n412 0.1445
R2920 Iin.n419 Iin.n418 0.1445
R2921 Iin.n420 Iin.n419 0.1445
R2922 Iin.n420 Iin.n409 0.1445
R2923 Iin.n424 Iin.n409 0.1445
R2924 Iin.n425 Iin.n424 0.1445
R2925 Iin.n426 Iin.n425 0.1445
R2926 Iin.n426 Iin.n406 0.1445
R2927 Iin.n430 Iin.n406 0.1445
R2928 Iin.n431 Iin.n430 0.1445
R2929 Iin.n432 Iin.n431 0.1445
R2930 Iin.n432 Iin.n403 0.1445
R2931 Iin.n445 Iin.n403 0.1445
R2932 Iin.n446 Iin.n445 0.1445
R2933 Iin.n447 Iin.n446 0.1445
R2934 Iin.n447 Iin.n387 0.1445
R2935 Iin.n468 Iin.n387 0.1445
R2936 Iin.n469 Iin.n468 0.1445
R2937 Iin.n470 Iin.n469 0.1445
R2938 Iin.n472 Iin.n470 0.1445
R2939 Iin.n472 Iin.n471 0.1445
R2940 Iin.n471 Iin.n374 0.1445
R2941 Iin.n374 Iin.n372 0.1445
R2942 Iin.n497 Iin.n372 0.1445
R2943 Iin.n498 Iin.n497 0.1445
R2944 Iin.n499 Iin.n498 0.1445
R2945 Iin.n499 Iin.n370 0.1445
R2946 Iin.n505 Iin.n370 0.1445
R2947 Iin.n379 Iin.n344 0.1445
R2948 Iin.n345 Iin.n344 0.1445
R2949 Iin.n346 Iin.n345 0.1445
R2950 Iin.n368 Iin.n346 0.1445
R2951 Iin.n369 Iin.n368 0.1445
R2952 Iin.n509 Iin.n369 0.1445
R2953 Iin.n361 Iin.n359 0.1445
R2954 Iin.n360 Iin.n354 0.1445
R2955 Iin.n326 Iin.n323 0.1445
R2956 Iin.n325 Iin.n324 0.1445
R2957 Iin.n309 Iin.n306 0.1445
R2958 Iin.n308 Iin.n307 0.1445
R2959 Iin.n292 Iin.n289 0.1445
R2960 Iin.n291 Iin.n290 0.1445
R2961 Iin.n115 Iin.n99 0.1445
R2962 Iin.n116 Iin.n115 0.1445
R2963 Iin.n117 Iin.n116 0.1445
R2964 Iin.n117 Iin.n87 0.1445
R2965 Iin.n131 Iin.n87 0.1445
R2966 Iin.n132 Iin.n131 0.1445
R2967 Iin.n133 Iin.n132 0.1445
R2968 Iin.n133 Iin.n75 0.1445
R2969 Iin.n147 Iin.n75 0.1445
R2970 Iin.n148 Iin.n147 0.1445
R2971 Iin.n149 Iin.n148 0.1445
R2972 Iin.n149 Iin.n63 0.1445
R2973 Iin.n163 Iin.n63 0.1445
R2974 Iin.n164 Iin.n163 0.1445
R2975 Iin.n165 Iin.n164 0.1445
R2976 Iin.n165 Iin.n51 0.1445
R2977 Iin.n179 Iin.n51 0.1445
R2978 Iin.n180 Iin.n179 0.1445
R2979 Iin.n181 Iin.n180 0.1445
R2980 Iin.n181 Iin.n39 0.1445
R2981 Iin.n195 Iin.n39 0.1445
R2982 Iin.n196 Iin.n195 0.1445
R2983 Iin.n197 Iin.n196 0.1445
R2984 Iin.n197 Iin.n27 0.1445
R2985 Iin.n211 Iin.n27 0.1445
R2986 Iin.n212 Iin.n211 0.1445
R2987 Iin.n213 Iin.n212 0.1445
R2988 Iin.n214 Iin.n213 0.1445
R2989 Iin.n214 Iin.n13 0.1445
R2990 Iin.n230 Iin.n13 0.1445
R2991 Iin.n231 Iin.n230 0.1445
R2992 Iin.n232 Iin.n231 0.1445
R2993 Iin.n233 Iin.n232 0.1445
R2994 Iin.n234 Iin.n233 0.1445
R2995 Iin.n242 Iin.n234 0.1445
R2996 Iin.n243 Iin.n242 0.1445
R2997 Iin.n244 Iin.n243 0.1445
R2998 Iin.n245 Iin.n244 0.1445
R2999 Iin.n253 Iin.n245 0.1445
R3000 Iin.n254 Iin.n253 0.1445
R3001 Iin.n255 Iin.n254 0.1445
R3002 Iin.n256 Iin.n255 0.1445
R3003 Iin.n264 Iin.n256 0.1445
R3004 Iin.n265 Iin.n264 0.1445
R3005 Iin.n266 Iin.n265 0.1445
R3006 Iin.n267 Iin.n266 0.1445
R3007 Iin.n438 Iin.n267 0.1445
R3008 Iin.n439 Iin.n438 0.1445
R3009 Iin.n439 Iin.n397 0.1445
R3010 Iin.n460 Iin.n397 0.1445
R3011 Iin.n461 Iin.n460 0.1445
R3012 Iin.n462 Iin.n461 0.1445
R3013 Iin.n462 Iin.n381 0.1445
R3014 Iin.n485 Iin.n381 0.1445
R3015 Iin.n109 Iin.n108 0.1445
R3016 Iin.n109 Iin.n93 0.1445
R3017 Iin.n123 Iin.n93 0.1445
R3018 Iin.n124 Iin.n123 0.1445
R3019 Iin.n125 Iin.n124 0.1445
R3020 Iin.n125 Iin.n81 0.1445
R3021 Iin.n139 Iin.n81 0.1445
R3022 Iin.n140 Iin.n139 0.1445
R3023 Iin.n141 Iin.n140 0.1445
R3024 Iin.n141 Iin.n69 0.1445
R3025 Iin.n155 Iin.n69 0.1445
R3026 Iin.n156 Iin.n155 0.1445
R3027 Iin.n157 Iin.n156 0.1445
R3028 Iin.n157 Iin.n57 0.1445
R3029 Iin.n171 Iin.n57 0.1445
R3030 Iin.n172 Iin.n171 0.1445
R3031 Iin.n173 Iin.n172 0.1445
R3032 Iin.n173 Iin.n45 0.1445
R3033 Iin.n187 Iin.n45 0.1445
R3034 Iin.n188 Iin.n187 0.1445
R3035 Iin.n189 Iin.n188 0.1445
R3036 Iin.n189 Iin.n33 0.1445
R3037 Iin.n203 Iin.n33 0.1445
R3038 Iin.n204 Iin.n203 0.1445
R3039 Iin.n205 Iin.n204 0.1445
R3040 Iin.n205 Iin.n19 0.1445
R3041 Iin.n221 Iin.n19 0.1445
R3042 Iin.n222 Iin.n221 0.1445
R3043 Iin.n223 Iin.n222 0.1445
R3044 Iin.n223 Iin.n3 0.1445
R3045 Iin.n110 Iin.n104 0.1445
R3046 Iin.n110 Iin.n94 0.1445
R3047 Iin.n122 Iin.n94 0.1445
R3048 Iin.n122 Iin.n92 0.1445
R3049 Iin.n126 Iin.n92 0.1445
R3050 Iin.n126 Iin.n82 0.1445
R3051 Iin.n138 Iin.n82 0.1445
R3052 Iin.n138 Iin.n80 0.1445
R3053 Iin.n142 Iin.n80 0.1445
R3054 Iin.n142 Iin.n70 0.1445
R3055 Iin.n154 Iin.n70 0.1445
R3056 Iin.n154 Iin.n68 0.1445
R3057 Iin.n158 Iin.n68 0.1445
R3058 Iin.n158 Iin.n58 0.1445
R3059 Iin.n170 Iin.n58 0.1445
R3060 Iin.n170 Iin.n56 0.1445
R3061 Iin.n174 Iin.n56 0.1445
R3062 Iin.n174 Iin.n46 0.1445
R3063 Iin.n186 Iin.n46 0.1445
R3064 Iin.n186 Iin.n44 0.1445
R3065 Iin.n190 Iin.n44 0.1445
R3066 Iin.n190 Iin.n34 0.1445
R3067 Iin.n202 Iin.n34 0.1445
R3068 Iin.n202 Iin.n32 0.1445
R3069 Iin.n206 Iin.n32 0.1445
R3070 Iin.n206 Iin.n20 0.1445
R3071 Iin.n220 Iin.n20 0.1445
R3072 Iin.n220 Iin.n18 0.1445
R3073 Iin.n224 Iin.n18 0.1445
R3074 Iin.n224 Iin.n4 0.1445
R3075 Iin.n575 Iin.n4 0.1445
R3076 Iin.n575 Iin.n574 0.1445
R3077 Iin.n574 Iin.n6 0.1445
R3078 Iin.n415 Iin.n6 0.1445
R3079 Iin.n416 Iin.n415 0.1445
R3080 Iin.n417 Iin.n416 0.1445
R3081 Iin.n417 Iin.n411 0.1445
R3082 Iin.n421 Iin.n411 0.1445
R3083 Iin.n422 Iin.n421 0.1445
R3084 Iin.n423 Iin.n422 0.1445
R3085 Iin.n423 Iin.n408 0.1445
R3086 Iin.n427 Iin.n408 0.1445
R3087 Iin.n428 Iin.n427 0.1445
R3088 Iin.n429 Iin.n428 0.1445
R3089 Iin.n429 Iin.n405 0.1445
R3090 Iin.n433 Iin.n405 0.1445
R3091 Iin.n434 Iin.n433 0.1445
R3092 Iin.n444 Iin.n434 0.1445
R3093 Iin.n444 Iin.n402 0.1445
R3094 Iin.n448 Iin.n402 0.1445
R3095 Iin.n448 Iin.n388 0.1445
R3096 Iin.n467 Iin.n388 0.1445
R3097 Iin.n467 Iin.n386 0.1445
R3098 Iin.n474 Iin.n386 0.1445
R3099 Iin.n474 Iin.n473 0.1445
R3100 Iin.n473 Iin.n373 0.1445
R3101 Iin.n493 Iin.n373 0.1445
R3102 Iin.n494 Iin.n493 0.1445
R3103 Iin.n496 Iin.n494 0.1445
R3104 Iin.n496 Iin.n371 0.1445
R3105 Iin.n500 Iin.n371 0.1445
R3106 Iin.n503 Iin.n500 0.1445
R3107 Iin.n504 Iin.n503 0.1445
R3108 Iin.n452 Iin.n450 0.1445
R3109 Iin.n451 Iin.n275 0.1445
R3110 Iin.n536 Iin.n0 0.130837
R3111 Iin.n317 Iin.n316 0.111183
R3112 Iin.n333 Iin.n318 0.111183
R3113 Iin.n486 Iin.n335 0.108765
R3114 Iin.n516 Iin.n278 0.102798
R3115 Iin.n531 Iin.n530 0.102798
R3116 Iin.n538 Iin.n537 0.102798
R3117 vss Iin.n576 0.0806
R3118 Iin.n576 Iin.n2 0.0725
R3119 Iin.n488 Iin.n487 0.0718661
R3120 Iin.n487 Iin.n378 0.0718661
R3121 Iin.n486 Iin.n379 0.0671
R3122 Iin.n486 Iin.n485 0.0599
R3123 Iin.n316 vss 0.0577669
R3124 Iin.n334 vss 0.0507793
R3125 Iin.n576 Iin.n3 0.0365
R3126 Iin.n536 Iin.n535 0.0363271
R3127 Iin.n535 Iin.n532 0.0077
R3128 Iin.n334 Iin.n333 0.00748758
R3129 Iin.n534 Iin.n533 0.00641376
R3130 Iin.n534 Iin.n0 0.00641376
R3131 vss Iin.n532 0.00347
R3132 spike_neg.n504 spike_neg.n54 18200
R3133 spike_neg.n503 spike_neg.n78 18200
R3134 spike_neg.n511 spike_neg.n504 14243.8
R3135 spike_neg.n504 spike_neg.n503 4468.75
R3136 spike_neg.n503 spike_neg.n502 4062.5
R3137 spike_neg.n32 spike_neg.n31 521.494
R3138 spike_neg.n31 spike_neg.n30 521.494
R3139 spike_neg.n573 spike_neg.n572 521.494
R3140 spike_neg.n572 spike_neg.n571 521.494
R3141 spike_neg.n15 spike_neg.n14 521.494
R3142 spike_neg.n14 spike_neg.n6 521.494
R3143 spike_neg.n512 spike_neg.n511 233.853
R3144 spike_neg.n495 spike_neg.n90 147.31
R3145 spike_neg.n478 spike_neg.n110 147.31
R3146 spike_neg.n469 spike_neg.n65 147.31
R3147 spike_neg.n542 spike_neg.n541 147.31
R3148 spike_neg.n554 spike_neg.n41 143.626
R3149 spike_neg.n553 spike_neg.n44 143.626
R3150 spike_neg.n113 spike_neg.n78 141.786
R3151 spike_neg.n529 spike_neg.n54 134.419
R3152 spike_neg.n494 spike_neg.n93 132.578
R3153 spike_neg.n485 spike_neg.n484 132.578
R3154 spike_neg.n540 spike_neg.n57 130.738
R3155 spike_neg.n74 spike_neg.n57 125.213
R3156 spike_neg.n521 spike_neg.n75 125.213
R3157 spike_neg.n484 spike_neg.n100 123.371
R3158 spike_neg.n112 spike_neg.n41 112.323
R3159 spike_neg.n530 spike_neg.n65 104.959
R3160 spike_neg.n269 spike_neg.n260 95.4133
R3161 spike_neg.n277 spike_neg.n260 95.4133
R3162 spike_neg.n277 spike_neg.n254 95.4133
R3163 spike_neg.n285 spike_neg.n254 95.4133
R3164 spike_neg.n285 spike_neg.n248 95.4133
R3165 spike_neg.n293 spike_neg.n248 95.4133
R3166 spike_neg.n293 spike_neg.n242 95.4133
R3167 spike_neg.n301 spike_neg.n242 95.4133
R3168 spike_neg.n301 spike_neg.n236 95.4133
R3169 spike_neg.n309 spike_neg.n236 95.4133
R3170 spike_neg.n309 spike_neg.n230 95.4133
R3171 spike_neg.n317 spike_neg.n230 95.4133
R3172 spike_neg.n317 spike_neg.n224 95.4133
R3173 spike_neg.n325 spike_neg.n224 95.4133
R3174 spike_neg.n325 spike_neg.n218 95.4133
R3175 spike_neg.n333 spike_neg.n218 95.4133
R3176 spike_neg.n333 spike_neg.n212 95.4133
R3177 spike_neg.n341 spike_neg.n212 95.4133
R3178 spike_neg.n341 spike_neg.n206 95.4133
R3179 spike_neg.n349 spike_neg.n206 95.4133
R3180 spike_neg.n349 spike_neg.n200 95.4133
R3181 spike_neg.n357 spike_neg.n200 95.4133
R3182 spike_neg.n357 spike_neg.n194 95.4133
R3183 spike_neg.n365 spike_neg.n194 95.4133
R3184 spike_neg.n365 spike_neg.n188 95.4133
R3185 spike_neg.n373 spike_neg.n188 95.4133
R3186 spike_neg.n373 spike_neg.n182 95.4133
R3187 spike_neg.n381 spike_neg.n182 95.4133
R3188 spike_neg.n381 spike_neg.n176 95.4133
R3189 spike_neg.n389 spike_neg.n176 95.4133
R3190 spike_neg.n389 spike_neg.n170 95.4133
R3191 spike_neg.n397 spike_neg.n170 95.4133
R3192 spike_neg.n397 spike_neg.n152 95.4133
R3193 spike_neg.n405 spike_neg.n152 95.4133
R3194 spike_neg.n405 spike_neg.n146 95.4133
R3195 spike_neg.n413 spike_neg.n146 95.4133
R3196 spike_neg.n413 spike_neg.n140 95.4133
R3197 spike_neg.n421 spike_neg.n140 95.4133
R3198 spike_neg.n421 spike_neg.n134 95.4133
R3199 spike_neg.n429 spike_neg.n134 95.4133
R3200 spike_neg.n429 spike_neg.n128 95.4133
R3201 spike_neg.n440 spike_neg.n128 95.4133
R3202 spike_neg.n440 spike_neg.n122 95.4133
R3203 spike_neg.n449 spike_neg.n122 95.4133
R3204 spike_neg.n449 spike_neg.n79 95.4133
R3205 spike_neg.n90 spike_neg.n81 93.9099
R3206 spike_neg.n502 spike_neg.n79 75.1381
R3207 spike_neg.n77 spike_neg.n73 73.9866
R3208 spike_neg.n513 spike_neg.n77 73.9866
R3209 spike_neg.n270 spike_neg.n264 73.9866
R3210 spike_neg.n486 spike_neg.n98 69.0283
R3211 spike_neg.n98 spike_neg.n95 69.0283
R3212 spike_neg.n493 spike_neg.n94 69.0283
R3213 spike_neg.n94 spike_neg.n92 69.0283
R3214 spike_neg.n539 spike_neg.n58 69.0283
R3215 spike_neg.n539 spike_neg.n59 69.0283
R3216 spike_neg.n510 spike_neg.n508 69.0283
R3217 spike_neg.n510 spike_neg.n509 69.0283
R3218 spike_neg.n531 spike_neg.n39 69.0283
R3219 spike_neg.n532 spike_neg.n531 69.0283
R3220 spike_neg.n42 spike_neg.n40 69.0283
R3221 spike_neg.n555 spike_neg.n40 69.0283
R3222 spike_neg.n33 spike_neg.n22 62.1255
R3223 spike_neg.n29 spike_neg.n22 62.1255
R3224 spike_neg.n24 spike_neg.n23 62.1255
R3225 spike_neg.n23 spike_neg.n21 62.1255
R3226 spike_neg.n574 spike_neg.n563 62.1255
R3227 spike_neg.n570 spike_neg.n563 62.1255
R3228 spike_neg.n565 spike_neg.n564 62.1255
R3229 spike_neg.n564 spike_neg.n562 62.1255
R3230 spike_neg.n13 spike_neg.n4 62.1255
R3231 spike_neg.n13 spike_neg.n12 62.1255
R3232 spike_neg.n7 spike_neg.n5 62.1255
R3233 spike_neg.n16 spike_neg.n5 62.1255
R3234 spike_neg.n501 spike_neg.n81 53.3999
R3235 spike_neg.n268 spike_neg.n264 48.6503
R3236 spike_neg.n530 spike_neg.n529 42.3518
R3237 spike_neg.n113 spike_neg.n112 34.9863
R3238 spike_neg.n502 spike_neg.n501 31.3036
R3239 spike_neg.n110 spike_neg.n100 23.9382
R3240 spike_neg.n521 spike_neg.n74 22.0968
R3241 spike_neg.n512 spike_neg.n75 22.0968
R3242 spike_neg.n166 spike_neg.n165 17.2005
R3243 vss spike_neg.n166 17.0096
R3244 spike_neg.n541 spike_neg.n540 16.5727
R3245 spike_neg.n486 spike_neg.n92 15.5561
R3246 spike_neg.n267 spike_neg.n259 15.5561
R3247 spike_neg.n278 spike_neg.n259 15.5561
R3248 spike_neg.n278 spike_neg.n255 15.5561
R3249 spike_neg.n284 spike_neg.n255 15.5561
R3250 spike_neg.n284 spike_neg.n247 15.5561
R3251 spike_neg.n294 spike_neg.n247 15.5561
R3252 spike_neg.n294 spike_neg.n243 15.5561
R3253 spike_neg.n300 spike_neg.n243 15.5561
R3254 spike_neg.n300 spike_neg.n235 15.5561
R3255 spike_neg.n310 spike_neg.n235 15.5561
R3256 spike_neg.n310 spike_neg.n231 15.5561
R3257 spike_neg.n316 spike_neg.n231 15.5561
R3258 spike_neg.n316 spike_neg.n223 15.5561
R3259 spike_neg.n326 spike_neg.n223 15.5561
R3260 spike_neg.n326 spike_neg.n219 15.5561
R3261 spike_neg.n332 spike_neg.n219 15.5561
R3262 spike_neg.n332 spike_neg.n211 15.5561
R3263 spike_neg.n342 spike_neg.n211 15.5561
R3264 spike_neg.n342 spike_neg.n207 15.5561
R3265 spike_neg.n348 spike_neg.n207 15.5561
R3266 spike_neg.n348 spike_neg.n199 15.5561
R3267 spike_neg.n358 spike_neg.n199 15.5561
R3268 spike_neg.n358 spike_neg.n195 15.5561
R3269 spike_neg.n364 spike_neg.n195 15.5561
R3270 spike_neg.n364 spike_neg.n187 15.5561
R3271 spike_neg.n374 spike_neg.n187 15.5561
R3272 spike_neg.n374 spike_neg.n183 15.5561
R3273 spike_neg.n380 spike_neg.n183 15.5561
R3274 spike_neg.n380 spike_neg.n175 15.5561
R3275 spike_neg.n390 spike_neg.n175 15.5561
R3276 spike_neg.n390 spike_neg.n171 15.5561
R3277 spike_neg.n396 spike_neg.n171 15.5561
R3278 spike_neg.n396 spike_neg.n151 15.5561
R3279 spike_neg.n406 spike_neg.n151 15.5561
R3280 spike_neg.n406 spike_neg.n147 15.5561
R3281 spike_neg.n412 spike_neg.n147 15.5561
R3282 spike_neg.n412 spike_neg.n139 15.5561
R3283 spike_neg.n422 spike_neg.n139 15.5561
R3284 spike_neg.n422 spike_neg.n135 15.5561
R3285 spike_neg.n428 spike_neg.n135 15.5561
R3286 spike_neg.n428 spike_neg.n127 15.5561
R3287 spike_neg.n441 spike_neg.n127 15.5561
R3288 spike_neg.n441 spike_neg.n123 15.5561
R3289 spike_neg.n448 spike_neg.n123 15.5561
R3290 spike_neg.n448 spike_neg.n82 15.5561
R3291 spike_neg.n500 spike_neg.n82 15.5561
R3292 spike_neg.n500 spike_neg.n83 15.5561
R3293 spike_neg.n496 spike_neg.n83 15.5561
R3294 spike_neg.n496 spike_neg.n89 15.5561
R3295 spike_neg.n483 spike_neg.n89 15.5561
R3296 spike_neg.n483 spike_neg.n101 15.5561
R3297 spike_neg.n479 spike_neg.n101 15.5561
R3298 spike_neg.n479 spike_neg.n109 15.5561
R3299 spike_neg.n109 spike_neg.n45 15.5561
R3300 spike_neg.n552 spike_neg.n45 15.5561
R3301 spike_neg.n552 spike_neg.n46 15.5561
R3302 spike_neg.n48 spike_neg.n46 15.5561
R3303 spike_neg.n52 spike_neg.n48 15.5561
R3304 spike_neg.n543 spike_neg.n52 15.5561
R3305 spike_neg.n543 spike_neg.n53 15.5561
R3306 spike_neg.n76 spike_neg.n53 15.5561
R3307 spike_neg.n520 spike_neg.n76 15.5561
R3308 spike_neg.n520 spike_neg.n513 15.5561
R3309 spike_neg.n270 spike_neg.n261 15.5561
R3310 spike_neg.n276 spike_neg.n261 15.5561
R3311 spike_neg.n276 spike_neg.n253 15.5561
R3312 spike_neg.n286 spike_neg.n253 15.5561
R3313 spike_neg.n286 spike_neg.n249 15.5561
R3314 spike_neg.n292 spike_neg.n249 15.5561
R3315 spike_neg.n292 spike_neg.n241 15.5561
R3316 spike_neg.n302 spike_neg.n241 15.5561
R3317 spike_neg.n302 spike_neg.n237 15.5561
R3318 spike_neg.n308 spike_neg.n237 15.5561
R3319 spike_neg.n308 spike_neg.n229 15.5561
R3320 spike_neg.n318 spike_neg.n229 15.5561
R3321 spike_neg.n318 spike_neg.n225 15.5561
R3322 spike_neg.n324 spike_neg.n225 15.5561
R3323 spike_neg.n324 spike_neg.n217 15.5561
R3324 spike_neg.n334 spike_neg.n217 15.5561
R3325 spike_neg.n334 spike_neg.n213 15.5561
R3326 spike_neg.n340 spike_neg.n213 15.5561
R3327 spike_neg.n340 spike_neg.n205 15.5561
R3328 spike_neg.n350 spike_neg.n205 15.5561
R3329 spike_neg.n350 spike_neg.n201 15.5561
R3330 spike_neg.n356 spike_neg.n201 15.5561
R3331 spike_neg.n356 spike_neg.n193 15.5561
R3332 spike_neg.n366 spike_neg.n193 15.5561
R3333 spike_neg.n366 spike_neg.n189 15.5561
R3334 spike_neg.n372 spike_neg.n189 15.5561
R3335 spike_neg.n372 spike_neg.n181 15.5561
R3336 spike_neg.n382 spike_neg.n181 15.5561
R3337 spike_neg.n382 spike_neg.n177 15.5561
R3338 spike_neg.n388 spike_neg.n177 15.5561
R3339 spike_neg.n388 spike_neg.n169 15.5561
R3340 spike_neg.n398 spike_neg.n169 15.5561
R3341 spike_neg.n398 spike_neg.n153 15.5561
R3342 spike_neg.n404 spike_neg.n153 15.5561
R3343 spike_neg.n404 spike_neg.n145 15.5561
R3344 spike_neg.n414 spike_neg.n145 15.5561
R3345 spike_neg.n414 spike_neg.n141 15.5561
R3346 spike_neg.n420 spike_neg.n141 15.5561
R3347 spike_neg.n420 spike_neg.n133 15.5561
R3348 spike_neg.n430 spike_neg.n133 15.5561
R3349 spike_neg.n430 spike_neg.n129 15.5561
R3350 spike_neg.n439 spike_neg.n129 15.5561
R3351 spike_neg.n439 spike_neg.n121 15.5561
R3352 spike_neg.n450 spike_neg.n121 15.5561
R3353 spike_neg.n451 spike_neg.n450 15.5561
R3354 spike_neg.n451 spike_neg.n80 15.5561
R3355 spike_neg.n117 spike_neg.n80 15.5561
R3356 spike_neg.n117 spike_neg.n91 15.5561
R3357 spike_neg.n458 spike_neg.n91 15.5561
R3358 spike_neg.n458 spike_neg.n99 15.5561
R3359 spike_neg.n111 spike_neg.n99 15.5561
R3360 spike_neg.n477 spike_neg.n111 15.5561
R3361 spike_neg.n477 spike_neg.n114 15.5561
R3362 spike_neg.n473 spike_neg.n114 15.5561
R3363 spike_neg.n473 spike_neg.n43 15.5561
R3364 spike_neg.n470 spike_neg.n43 15.5561
R3365 spike_neg.n470 spike_neg.n66 15.5561
R3366 spike_neg.n528 spike_neg.n66 15.5561
R3367 spike_neg.n528 spike_neg.n55 15.5561
R3368 spike_neg.n56 spike_neg.n55 15.5561
R3369 spike_neg.n523 spike_neg.n56 15.5561
R3370 spike_neg.n523 spike_neg.n522 15.5561
R3371 spike_neg.n522 spike_neg.n73 15.5561
R3372 spike_neg.n508 spike_neg.n58 15.5561
R3373 spike_neg.n495 spike_neg.n494 14.7314
R3374 spike_neg.n485 spike_neg.n93 14.7314
R3375 spike_neg.n542 spike_neg.n54 12.89
R3376 spike_neg.n558 spike_neg.n557 11.8522
R3377 spike_neg.n536 spike_neg.n63 11.0435
R3378 spike_neg.n38 spike_neg.n37 7.6287
R3379 spike_neg.n34 spike_neg.n33 6.37187
R3380 spike_neg.n34 spike_neg.n21 6.37187
R3381 spike_neg.n575 spike_neg.n574 6.37187
R3382 spike_neg.n575 spike_neg.n562 6.37187
R3383 spike_neg.n17 spike_neg.n16 6.37187
R3384 spike_neg.n17 spike_neg.n4 6.37187
R3385 spike_neg.n29 spike_neg.n28 6.3005
R3386 spike_neg.n25 spike_neg.n24 6.3005
R3387 spike_neg.n570 spike_neg.n569 6.3005
R3388 spike_neg.n566 spike_neg.n565 6.3005
R3389 spike_neg.n12 spike_neg.n11 6.3005
R3390 spike_neg.n8 spike_neg.n7 6.3005
R3391 spike_neg.n478 spike_neg.n78 5.52458
R3392 spike_neg.n272 spike_neg.n263 5.25278
R3393 spike_neg.n265 spike_neg.n263 5.25278
R3394 spike_neg.n490 spike_neg.n489 5.20101
R3395 spike_neg.n538 spike_neg.n60 5.20101
R3396 spike_neg.n26 spike_neg.n20 5.20101
R3397 spike_neg.n27 spike_neg.n19 5.20101
R3398 spike_neg.n567 spike_neg.n1 5.20101
R3399 spike_neg.n568 spike_neg.n0 5.20101
R3400 spike_neg.n9 spike_neg.n3 5.20101
R3401 spike_neg.n10 spike_neg.n2 5.20101
R3402 spike_neg.n452 spike_neg.n451 5.2005
R3403 spike_neg.n451 spike_neg.n79 5.2005
R3404 spike_neg.n450 spike_neg.n120 5.2005
R3405 spike_neg.n450 spike_neg.n449 5.2005
R3406 spike_neg.n437 spike_neg.n121 5.2005
R3407 spike_neg.n122 spike_neg.n121 5.2005
R3408 spike_neg.n439 spike_neg.n438 5.2005
R3409 spike_neg.n440 spike_neg.n439 5.2005
R3410 spike_neg.n130 spike_neg.n129 5.2005
R3411 spike_neg.n129 spike_neg.n128 5.2005
R3412 spike_neg.n431 spike_neg.n430 5.2005
R3413 spike_neg.n430 spike_neg.n429 5.2005
R3414 spike_neg.n133 spike_neg.n132 5.2005
R3415 spike_neg.n134 spike_neg.n133 5.2005
R3416 spike_neg.n420 spike_neg.n419 5.2005
R3417 spike_neg.n421 spike_neg.n420 5.2005
R3418 spike_neg.n142 spike_neg.n141 5.2005
R3419 spike_neg.n141 spike_neg.n140 5.2005
R3420 spike_neg.n415 spike_neg.n414 5.2005
R3421 spike_neg.n414 spike_neg.n413 5.2005
R3422 spike_neg.n145 spike_neg.n144 5.2005
R3423 spike_neg.n146 spike_neg.n145 5.2005
R3424 spike_neg.n404 spike_neg.n403 5.2005
R3425 spike_neg.n405 spike_neg.n404 5.2005
R3426 spike_neg.n154 spike_neg.n153 5.2005
R3427 spike_neg.n153 spike_neg.n152 5.2005
R3428 spike_neg.n399 spike_neg.n398 5.2005
R3429 spike_neg.n398 spike_neg.n397 5.2005
R3430 spike_neg.n169 spike_neg.n168 5.2005
R3431 spike_neg.n170 spike_neg.n169 5.2005
R3432 spike_neg.n388 spike_neg.n387 5.2005
R3433 spike_neg.n389 spike_neg.n388 5.2005
R3434 spike_neg.n178 spike_neg.n177 5.2005
R3435 spike_neg.n177 spike_neg.n176 5.2005
R3436 spike_neg.n383 spike_neg.n382 5.2005
R3437 spike_neg.n382 spike_neg.n381 5.2005
R3438 spike_neg.n181 spike_neg.n180 5.2005
R3439 spike_neg.n182 spike_neg.n181 5.2005
R3440 spike_neg.n372 spike_neg.n371 5.2005
R3441 spike_neg.n373 spike_neg.n372 5.2005
R3442 spike_neg.n190 spike_neg.n189 5.2005
R3443 spike_neg.n189 spike_neg.n188 5.2005
R3444 spike_neg.n367 spike_neg.n366 5.2005
R3445 spike_neg.n366 spike_neg.n365 5.2005
R3446 spike_neg.n193 spike_neg.n192 5.2005
R3447 spike_neg.n194 spike_neg.n193 5.2005
R3448 spike_neg.n356 spike_neg.n355 5.2005
R3449 spike_neg.n357 spike_neg.n356 5.2005
R3450 spike_neg.n202 spike_neg.n201 5.2005
R3451 spike_neg.n201 spike_neg.n200 5.2005
R3452 spike_neg.n351 spike_neg.n350 5.2005
R3453 spike_neg.n350 spike_neg.n349 5.2005
R3454 spike_neg.n205 spike_neg.n204 5.2005
R3455 spike_neg.n206 spike_neg.n205 5.2005
R3456 spike_neg.n340 spike_neg.n339 5.2005
R3457 spike_neg.n341 spike_neg.n340 5.2005
R3458 spike_neg.n214 spike_neg.n213 5.2005
R3459 spike_neg.n213 spike_neg.n212 5.2005
R3460 spike_neg.n335 spike_neg.n334 5.2005
R3461 spike_neg.n334 spike_neg.n333 5.2005
R3462 spike_neg.n217 spike_neg.n216 5.2005
R3463 spike_neg.n218 spike_neg.n217 5.2005
R3464 spike_neg.n324 spike_neg.n323 5.2005
R3465 spike_neg.n325 spike_neg.n324 5.2005
R3466 spike_neg.n226 spike_neg.n225 5.2005
R3467 spike_neg.n225 spike_neg.n224 5.2005
R3468 spike_neg.n319 spike_neg.n318 5.2005
R3469 spike_neg.n318 spike_neg.n317 5.2005
R3470 spike_neg.n229 spike_neg.n228 5.2005
R3471 spike_neg.n230 spike_neg.n229 5.2005
R3472 spike_neg.n308 spike_neg.n307 5.2005
R3473 spike_neg.n309 spike_neg.n308 5.2005
R3474 spike_neg.n238 spike_neg.n237 5.2005
R3475 spike_neg.n237 spike_neg.n236 5.2005
R3476 spike_neg.n303 spike_neg.n302 5.2005
R3477 spike_neg.n302 spike_neg.n301 5.2005
R3478 spike_neg.n241 spike_neg.n240 5.2005
R3479 spike_neg.n242 spike_neg.n241 5.2005
R3480 spike_neg.n292 spike_neg.n291 5.2005
R3481 spike_neg.n293 spike_neg.n292 5.2005
R3482 spike_neg.n250 spike_neg.n249 5.2005
R3483 spike_neg.n249 spike_neg.n248 5.2005
R3484 spike_neg.n287 spike_neg.n286 5.2005
R3485 spike_neg.n286 spike_neg.n285 5.2005
R3486 spike_neg.n253 spike_neg.n252 5.2005
R3487 spike_neg.n254 spike_neg.n253 5.2005
R3488 spike_neg.n276 spike_neg.n275 5.2005
R3489 spike_neg.n277 spike_neg.n276 5.2005
R3490 spike_neg.n262 spike_neg.n261 5.2005
R3491 spike_neg.n261 spike_neg.n260 5.2005
R3492 spike_neg.n271 spike_neg.n270 5.2005
R3493 spike_neg.n270 spike_neg.n269 5.2005
R3494 spike_neg.n84 spike_neg.n82 5.2005
R3495 spike_neg.n82 spike_neg.n79 5.2005
R3496 spike_neg.n448 spike_neg.n447 5.2005
R3497 spike_neg.n449 spike_neg.n448 5.2005
R3498 spike_neg.n124 spike_neg.n123 5.2005
R3499 spike_neg.n123 spike_neg.n122 5.2005
R3500 spike_neg.n442 spike_neg.n441 5.2005
R3501 spike_neg.n441 spike_neg.n440 5.2005
R3502 spike_neg.n127 spike_neg.n126 5.2005
R3503 spike_neg.n128 spike_neg.n127 5.2005
R3504 spike_neg.n428 spike_neg.n427 5.2005
R3505 spike_neg.n429 spike_neg.n428 5.2005
R3506 spike_neg.n136 spike_neg.n135 5.2005
R3507 spike_neg.n135 spike_neg.n134 5.2005
R3508 spike_neg.n423 spike_neg.n422 5.2005
R3509 spike_neg.n422 spike_neg.n421 5.2005
R3510 spike_neg.n139 spike_neg.n138 5.2005
R3511 spike_neg.n140 spike_neg.n139 5.2005
R3512 spike_neg.n412 spike_neg.n411 5.2005
R3513 spike_neg.n413 spike_neg.n412 5.2005
R3514 spike_neg.n148 spike_neg.n147 5.2005
R3515 spike_neg.n147 spike_neg.n146 5.2005
R3516 spike_neg.n407 spike_neg.n406 5.2005
R3517 spike_neg.n406 spike_neg.n405 5.2005
R3518 spike_neg.n151 spike_neg.n150 5.2005
R3519 spike_neg.n152 spike_neg.n151 5.2005
R3520 spike_neg.n396 spike_neg.n395 5.2005
R3521 spike_neg.n397 spike_neg.n396 5.2005
R3522 spike_neg.n172 spike_neg.n171 5.2005
R3523 spike_neg.n171 spike_neg.n170 5.2005
R3524 spike_neg.n391 spike_neg.n390 5.2005
R3525 spike_neg.n390 spike_neg.n389 5.2005
R3526 spike_neg.n175 spike_neg.n174 5.2005
R3527 spike_neg.n176 spike_neg.n175 5.2005
R3528 spike_neg.n380 spike_neg.n379 5.2005
R3529 spike_neg.n381 spike_neg.n380 5.2005
R3530 spike_neg.n184 spike_neg.n183 5.2005
R3531 spike_neg.n183 spike_neg.n182 5.2005
R3532 spike_neg.n375 spike_neg.n374 5.2005
R3533 spike_neg.n374 spike_neg.n373 5.2005
R3534 spike_neg.n187 spike_neg.n186 5.2005
R3535 spike_neg.n188 spike_neg.n187 5.2005
R3536 spike_neg.n364 spike_neg.n363 5.2005
R3537 spike_neg.n365 spike_neg.n364 5.2005
R3538 spike_neg.n196 spike_neg.n195 5.2005
R3539 spike_neg.n195 spike_neg.n194 5.2005
R3540 spike_neg.n359 spike_neg.n358 5.2005
R3541 spike_neg.n358 spike_neg.n357 5.2005
R3542 spike_neg.n199 spike_neg.n198 5.2005
R3543 spike_neg.n200 spike_neg.n199 5.2005
R3544 spike_neg.n348 spike_neg.n347 5.2005
R3545 spike_neg.n349 spike_neg.n348 5.2005
R3546 spike_neg.n208 spike_neg.n207 5.2005
R3547 spike_neg.n207 spike_neg.n206 5.2005
R3548 spike_neg.n343 spike_neg.n342 5.2005
R3549 spike_neg.n342 spike_neg.n341 5.2005
R3550 spike_neg.n211 spike_neg.n210 5.2005
R3551 spike_neg.n212 spike_neg.n211 5.2005
R3552 spike_neg.n332 spike_neg.n331 5.2005
R3553 spike_neg.n333 spike_neg.n332 5.2005
R3554 spike_neg.n220 spike_neg.n219 5.2005
R3555 spike_neg.n219 spike_neg.n218 5.2005
R3556 spike_neg.n327 spike_neg.n326 5.2005
R3557 spike_neg.n326 spike_neg.n325 5.2005
R3558 spike_neg.n223 spike_neg.n222 5.2005
R3559 spike_neg.n224 spike_neg.n223 5.2005
R3560 spike_neg.n316 spike_neg.n315 5.2005
R3561 spike_neg.n317 spike_neg.n316 5.2005
R3562 spike_neg.n232 spike_neg.n231 5.2005
R3563 spike_neg.n231 spike_neg.n230 5.2005
R3564 spike_neg.n311 spike_neg.n310 5.2005
R3565 spike_neg.n310 spike_neg.n309 5.2005
R3566 spike_neg.n235 spike_neg.n234 5.2005
R3567 spike_neg.n236 spike_neg.n235 5.2005
R3568 spike_neg.n300 spike_neg.n299 5.2005
R3569 spike_neg.n301 spike_neg.n300 5.2005
R3570 spike_neg.n244 spike_neg.n243 5.2005
R3571 spike_neg.n243 spike_neg.n242 5.2005
R3572 spike_neg.n295 spike_neg.n294 5.2005
R3573 spike_neg.n294 spike_neg.n293 5.2005
R3574 spike_neg.n247 spike_neg.n246 5.2005
R3575 spike_neg.n248 spike_neg.n247 5.2005
R3576 spike_neg.n284 spike_neg.n283 5.2005
R3577 spike_neg.n285 spike_neg.n284 5.2005
R3578 spike_neg.n256 spike_neg.n255 5.2005
R3579 spike_neg.n255 spike_neg.n254 5.2005
R3580 spike_neg.n279 spike_neg.n278 5.2005
R3581 spike_neg.n278 spike_neg.n277 5.2005
R3582 spike_neg.n259 spike_neg.n258 5.2005
R3583 spike_neg.n260 spike_neg.n259 5.2005
R3584 spike_neg.n267 spike_neg.n266 5.2005
R3585 spike_neg.n487 spike_neg.n486 5.2005
R3586 spike_neg.n486 spike_neg.n485 5.2005
R3587 spike_neg.n488 spike_neg.n92 5.2005
R3588 spike_neg.n494 spike_neg.n92 5.2005
R3589 spike_neg.n485 spike_neg.n95 5.2005
R3590 spike_neg.n494 spike_neg.n493 5.2005
R3591 spike_neg.n162 spike_neg.n73 5.2005
R3592 spike_neg.n512 spike_neg.n73 5.2005
R3593 spike_neg.n522 spike_neg.n72 5.2005
R3594 spike_neg.n522 spike_neg.n521 5.2005
R3595 spike_neg.n524 spike_neg.n523 5.2005
R3596 spike_neg.n523 spike_neg.n57 5.2005
R3597 spike_neg.n525 spike_neg.n56 5.2005
R3598 spike_neg.n541 spike_neg.n56 5.2005
R3599 spike_neg.n526 spike_neg.n55 5.2005
R3600 spike_neg.n542 spike_neg.n55 5.2005
R3601 spike_neg.n528 spike_neg.n527 5.2005
R3602 spike_neg.n529 spike_neg.n528 5.2005
R3603 spike_neg.n67 spike_neg.n66 5.2005
R3604 spike_neg.n66 spike_neg.n65 5.2005
R3605 spike_neg.n471 spike_neg.n470 5.2005
R3606 spike_neg.n470 spike_neg.n469 5.2005
R3607 spike_neg.n472 spike_neg.n43 5.2005
R3608 spike_neg.n553 spike_neg.n43 5.2005
R3609 spike_neg.n474 spike_neg.n473 5.2005
R3610 spike_neg.n473 spike_neg.n41 5.2005
R3611 spike_neg.n475 spike_neg.n114 5.2005
R3612 spike_neg.n114 spike_neg.n113 5.2005
R3613 spike_neg.n477 spike_neg.n476 5.2005
R3614 spike_neg.n478 spike_neg.n477 5.2005
R3615 spike_neg.n115 spike_neg.n111 5.2005
R3616 spike_neg.n111 spike_neg.n110 5.2005
R3617 spike_neg.n460 spike_neg.n99 5.2005
R3618 spike_neg.n484 spike_neg.n99 5.2005
R3619 spike_neg.n459 spike_neg.n458 5.2005
R3620 spike_neg.n458 spike_neg.n93 5.2005
R3621 spike_neg.n457 spike_neg.n91 5.2005
R3622 spike_neg.n495 spike_neg.n91 5.2005
R3623 spike_neg.n118 spike_neg.n117 5.2005
R3624 spike_neg.n117 spike_neg.n90 5.2005
R3625 spike_neg.n453 spike_neg.n80 5.2005
R3626 spike_neg.n501 spike_neg.n80 5.2005
R3627 spike_neg.n518 spike_neg.n513 5.2005
R3628 spike_neg.n513 spike_neg.n512 5.2005
R3629 spike_neg.n520 spike_neg.n519 5.2005
R3630 spike_neg.n521 spike_neg.n520 5.2005
R3631 spike_neg.n514 spike_neg.n76 5.2005
R3632 spike_neg.n76 spike_neg.n57 5.2005
R3633 spike_neg.n53 spike_neg.n51 5.2005
R3634 spike_neg.n541 spike_neg.n53 5.2005
R3635 spike_neg.n544 spike_neg.n543 5.2005
R3636 spike_neg.n543 spike_neg.n542 5.2005
R3637 spike_neg.n52 spike_neg.n49 5.2005
R3638 spike_neg.n529 spike_neg.n52 5.2005
R3639 spike_neg.n548 spike_neg.n48 5.2005
R3640 spike_neg.n65 spike_neg.n48 5.2005
R3641 spike_neg.n549 spike_neg.n46 5.2005
R3642 spike_neg.n469 spike_neg.n46 5.2005
R3643 spike_neg.n552 spike_neg.n551 5.2005
R3644 spike_neg.n553 spike_neg.n552 5.2005
R3645 spike_neg.n47 spike_neg.n45 5.2005
R3646 spike_neg.n45 spike_neg.n41 5.2005
R3647 spike_neg.n109 spike_neg.n108 5.2005
R3648 spike_neg.n113 spike_neg.n109 5.2005
R3649 spike_neg.n480 spike_neg.n479 5.2005
R3650 spike_neg.n479 spike_neg.n478 5.2005
R3651 spike_neg.n481 spike_neg.n101 5.2005
R3652 spike_neg.n110 spike_neg.n101 5.2005
R3653 spike_neg.n483 spike_neg.n482 5.2005
R3654 spike_neg.n484 spike_neg.n483 5.2005
R3655 spike_neg.n89 spike_neg.n88 5.2005
R3656 spike_neg.n93 spike_neg.n89 5.2005
R3657 spike_neg.n497 spike_neg.n496 5.2005
R3658 spike_neg.n496 spike_neg.n495 5.2005
R3659 spike_neg.n498 spike_neg.n83 5.2005
R3660 spike_neg.n90 spike_neg.n83 5.2005
R3661 spike_neg.n500 spike_neg.n499 5.2005
R3662 spike_neg.n501 spike_neg.n500 5.2005
R3663 spike_neg.n508 spike_neg.n507 5.2005
R3664 spike_neg.n508 spike_neg.n75 5.2005
R3665 spike_neg.n505 spike_neg.n58 5.2005
R3666 spike_neg.n74 spike_neg.n58 5.2005
R3667 spike_neg.n509 spike_neg.n75 5.2005
R3668 spike_neg.n74 spike_neg.n59 5.2005
R3669 spike_neg.n532 spike_neg.n44 5.2005
R3670 spike_neg.n554 spike_neg.n42 5.2005
R3671 spike_neg.n44 spike_neg.n39 5.2005
R3672 spike_neg.n555 spike_neg.n554 5.2005
R3673 spike_neg.n97 spike_neg.n96 5.19319
R3674 spike_neg.n506 spike_neg.n61 5.19319
R3675 spike_neg.n557 spike_neg.n36 5.12001
R3676 spike_neg.n557 spike_neg.n35 5.11219
R3677 spike_neg.n165 spike_neg.n163 5.04833
R3678 spike_neg.n164 spike_neg.n63 5.02778
R3679 spike_neg.n534 spike_neg.n36 4.98321
R3680 spike_neg.n491 spike_neg.n490 4.98321
R3681 spike_neg.n491 spike_neg.n96 4.98321
R3682 spike_neg.n537 spike_neg.n61 4.98321
R3683 spike_neg.n538 spike_neg.n537 4.98321
R3684 spike_neg.n534 spike_neg.n35 4.98321
R3685 spike_neg.n559 spike_neg.n20 4.98321
R3686 spike_neg.n576 spike_neg.n1 4.98321
R3687 spike_neg.n18 spike_neg.n3 4.98321
R3688 spike_neg.n559 spike_neg.n19 4.97539
R3689 spike_neg.n576 spike_neg.n0 4.97539
R3690 spike_neg.n18 spike_neg.n2 4.97539
R3691 vss spike_neg.n160 4.8929
R3692 spike_neg.n258 spike_neg.n257 4.5005
R3693 spike_neg.n280 spike_neg.n279 4.5005
R3694 spike_neg.n281 spike_neg.n256 4.5005
R3695 spike_neg.n283 spike_neg.n282 4.5005
R3696 spike_neg.n246 spike_neg.n245 4.5005
R3697 spike_neg.n296 spike_neg.n295 4.5005
R3698 spike_neg.n297 spike_neg.n244 4.5005
R3699 spike_neg.n299 spike_neg.n298 4.5005
R3700 spike_neg.n234 spike_neg.n233 4.5005
R3701 spike_neg.n312 spike_neg.n311 4.5005
R3702 spike_neg.n313 spike_neg.n232 4.5005
R3703 spike_neg.n315 spike_neg.n314 4.5005
R3704 spike_neg.n222 spike_neg.n221 4.5005
R3705 spike_neg.n328 spike_neg.n327 4.5005
R3706 spike_neg.n329 spike_neg.n220 4.5005
R3707 spike_neg.n331 spike_neg.n330 4.5005
R3708 spike_neg.n210 spike_neg.n209 4.5005
R3709 spike_neg.n344 spike_neg.n343 4.5005
R3710 spike_neg.n345 spike_neg.n208 4.5005
R3711 spike_neg.n347 spike_neg.n346 4.5005
R3712 spike_neg.n198 spike_neg.n197 4.5005
R3713 spike_neg.n360 spike_neg.n359 4.5005
R3714 spike_neg.n361 spike_neg.n196 4.5005
R3715 spike_neg.n363 spike_neg.n362 4.5005
R3716 spike_neg.n186 spike_neg.n185 4.5005
R3717 spike_neg.n376 spike_neg.n375 4.5005
R3718 spike_neg.n377 spike_neg.n184 4.5005
R3719 spike_neg.n379 spike_neg.n378 4.5005
R3720 spike_neg.n174 spike_neg.n173 4.5005
R3721 spike_neg.n392 spike_neg.n391 4.5005
R3722 spike_neg.n393 spike_neg.n172 4.5005
R3723 spike_neg.n395 spike_neg.n394 4.5005
R3724 spike_neg.n150 spike_neg.n149 4.5005
R3725 spike_neg.n408 spike_neg.n407 4.5005
R3726 spike_neg.n409 spike_neg.n148 4.5005
R3727 spike_neg.n411 spike_neg.n410 4.5005
R3728 spike_neg.n138 spike_neg.n137 4.5005
R3729 spike_neg.n424 spike_neg.n423 4.5005
R3730 spike_neg.n425 spike_neg.n136 4.5005
R3731 spike_neg.n427 spike_neg.n426 4.5005
R3732 spike_neg.n126 spike_neg.n125 4.5005
R3733 spike_neg.n443 spike_neg.n442 4.5005
R3734 spike_neg.n444 spike_neg.n124 4.5005
R3735 spike_neg.n447 spike_neg.n446 4.5005
R3736 spike_neg.n445 spike_neg.n84 4.5005
R3737 spike_neg.n499 spike_neg.n85 4.5005
R3738 spike_neg.n498 spike_neg.n86 4.5005
R3739 spike_neg.n497 spike_neg.n87 4.5005
R3740 spike_neg.n102 spike_neg.n88 4.5005
R3741 spike_neg.n482 spike_neg.n103 4.5005
R3742 spike_neg.n481 spike_neg.n104 4.5005
R3743 spike_neg.n480 spike_neg.n105 4.5005
R3744 spike_neg.n108 spike_neg.n107 4.5005
R3745 spike_neg.n106 spike_neg.n47 4.5005
R3746 spike_neg.n266 spike_neg.n265 4.5005
R3747 spike_neg.n548 spike_neg.n547 4.5005
R3748 spike_neg.n546 spike_neg.n49 4.5005
R3749 spike_neg.n545 spike_neg.n544 4.5005
R3750 spike_neg.n51 spike_neg.n50 4.5005
R3751 spike_neg.n515 spike_neg.n514 4.5005
R3752 spike_neg.n519 spike_neg.n516 4.5005
R3753 spike_neg.n518 spike_neg.n517 4.5005
R3754 spike_neg.n487 spike_neg.n97 4.5005
R3755 spike_neg.n489 spike_neg.n488 4.5005
R3756 spike_neg.n273 spike_neg.n262 4.5005
R3757 spike_neg.n275 spike_neg.n274 4.5005
R3758 spike_neg.n252 spike_neg.n251 4.5005
R3759 spike_neg.n288 spike_neg.n287 4.5005
R3760 spike_neg.n289 spike_neg.n250 4.5005
R3761 spike_neg.n291 spike_neg.n290 4.5005
R3762 spike_neg.n240 spike_neg.n239 4.5005
R3763 spike_neg.n304 spike_neg.n303 4.5005
R3764 spike_neg.n305 spike_neg.n238 4.5005
R3765 spike_neg.n307 spike_neg.n306 4.5005
R3766 spike_neg.n228 spike_neg.n227 4.5005
R3767 spike_neg.n320 spike_neg.n319 4.5005
R3768 spike_neg.n321 spike_neg.n226 4.5005
R3769 spike_neg.n323 spike_neg.n322 4.5005
R3770 spike_neg.n216 spike_neg.n215 4.5005
R3771 spike_neg.n336 spike_neg.n335 4.5005
R3772 spike_neg.n337 spike_neg.n214 4.5005
R3773 spike_neg.n339 spike_neg.n338 4.5005
R3774 spike_neg.n204 spike_neg.n203 4.5005
R3775 spike_neg.n352 spike_neg.n351 4.5005
R3776 spike_neg.n353 spike_neg.n202 4.5005
R3777 spike_neg.n355 spike_neg.n354 4.5005
R3778 spike_neg.n192 spike_neg.n191 4.5005
R3779 spike_neg.n368 spike_neg.n367 4.5005
R3780 spike_neg.n369 spike_neg.n190 4.5005
R3781 spike_neg.n371 spike_neg.n370 4.5005
R3782 spike_neg.n180 spike_neg.n179 4.5005
R3783 spike_neg.n384 spike_neg.n383 4.5005
R3784 spike_neg.n385 spike_neg.n178 4.5005
R3785 spike_neg.n387 spike_neg.n386 4.5005
R3786 spike_neg.n168 spike_neg.n167 4.5005
R3787 spike_neg.n400 spike_neg.n399 4.5005
R3788 spike_neg.n401 spike_neg.n154 4.5005
R3789 spike_neg.n403 spike_neg.n402 4.5005
R3790 spike_neg.n144 spike_neg.n143 4.5005
R3791 spike_neg.n416 spike_neg.n415 4.5005
R3792 spike_neg.n417 spike_neg.n142 4.5005
R3793 spike_neg.n419 spike_neg.n418 4.5005
R3794 spike_neg.n132 spike_neg.n131 4.5005
R3795 spike_neg.n432 spike_neg.n431 4.5005
R3796 spike_neg.n433 spike_neg.n130 4.5005
R3797 spike_neg.n438 spike_neg.n434 4.5005
R3798 spike_neg.n437 spike_neg.n436 4.5005
R3799 spike_neg.n435 spike_neg.n120 4.5005
R3800 spike_neg.n452 spike_neg.n119 4.5005
R3801 spike_neg.n454 spike_neg.n453 4.5005
R3802 spike_neg.n455 spike_neg.n118 4.5005
R3803 spike_neg.n457 spike_neg.n456 4.5005
R3804 spike_neg.n459 spike_neg.n116 4.5005
R3805 spike_neg.n461 spike_neg.n460 4.5005
R3806 spike_neg.n462 spike_neg.n115 4.5005
R3807 spike_neg.n476 spike_neg.n463 4.5005
R3808 spike_neg.n475 spike_neg.n464 4.5005
R3809 spike_neg.n474 spike_neg.n465 4.5005
R3810 spike_neg.n472 spike_neg.n466 4.5005
R3811 spike_neg.n471 spike_neg.n468 4.5005
R3812 spike_neg.n467 spike_neg.n67 4.5005
R3813 spike_neg.n527 spike_neg.n68 4.5005
R3814 spike_neg.n526 spike_neg.n69 4.5005
R3815 spike_neg.n525 spike_neg.n70 4.5005
R3816 spike_neg.n524 spike_neg.n71 4.5005
R3817 spike_neg.n161 spike_neg.n72 4.5005
R3818 spike_neg.n163 spike_neg.n162 4.5005
R3819 spike_neg.n272 spike_neg.n271 4.5005
R3820 spike_neg.n507 spike_neg.n506 4.5005
R3821 spike_neg.n505 spike_neg.n60 4.5005
R3822 spike_neg.n28 spike_neg.n27 4.5005
R3823 spike_neg.n26 spike_neg.n25 4.5005
R3824 spike_neg.n569 spike_neg.n568 4.5005
R3825 spike_neg.n567 spike_neg.n566 4.5005
R3826 spike_neg.n11 spike_neg.n10 4.5005
R3827 spike_neg.n9 spike_neg.n8 4.5005
R3828 spike_neg.n554 spike_neg.n553 3.68322
R3829 spike_neg.n469 spike_neg.n44 3.68322
R3830 spike_neg.n269 spike_neg.n268 3.42024
R3831 spike_neg.n30 spike_neg.n29 3.31679
R3832 spike_neg.n30 spike_neg.n24 3.31679
R3833 spike_neg.n32 spike_neg.n21 3.31679
R3834 spike_neg.n33 spike_neg.n32 3.31679
R3835 spike_neg.n571 spike_neg.n570 3.31679
R3836 spike_neg.n571 spike_neg.n565 3.31679
R3837 spike_neg.n573 spike_neg.n562 3.31679
R3838 spike_neg.n574 spike_neg.n573 3.31679
R3839 spike_neg.n12 spike_neg.n6 3.31679
R3840 spike_neg.n7 spike_neg.n6 3.31679
R3841 spike_neg.n15 spike_neg.n4 3.31679
R3842 spike_neg.n16 spike_neg.n15 3.31679
R3843 spike_neg.n492 spike_neg.n491 3.28078
R3844 spike_neg.n537 spike_neg.n62 3.28078
R3845 spike_neg.n534 spike_neg.n533 3.28078
R3846 spike_neg.n557 spike_neg.n556 3.28078
R3847 spike_neg.n533 spike_neg.n532 3.14293
R3848 spike_neg.n493 spike_neg.n492 3.14293
R3849 spike_neg.n492 spike_neg.n95 3.14293
R3850 spike_neg.n62 spike_neg.n59 3.14293
R3851 spike_neg.n509 spike_neg.n62 3.14293
R3852 spike_neg.n533 spike_neg.n42 3.14293
R3853 spike_neg.n556 spike_neg.n555 3.14293
R3854 spike_neg.n556 spike_neg.n39 3.14293
R3855 spike_neg.n550 spike_neg.n38 2.21557
R3856 spike_neg.n576 spike_neg.n575 2.21557
R3857 spike_neg.n18 spike_neg.n17 2.21557
R3858 spike_neg.n559 spike_neg.n34 2.21557
R3859 spike_neg.n268 spike_neg.n267 1.66482
R3860 spike_neg.n158 spike_neg.n155 1.1255
R3861 spike_neg.n157 spike_neg.n156 1.1255
R3862 spike_neg.n561 vss 1.0868
R3863 spike_neg.n22 spike_neg.n19 0.9005
R3864 spike_neg.n31 spike_neg.n22 0.9005
R3865 spike_neg.n23 spike_neg.n20 0.9005
R3866 spike_neg.n31 spike_neg.n23 0.9005
R3867 spike_neg.n563 spike_neg.n0 0.9005
R3868 spike_neg.n572 spike_neg.n563 0.9005
R3869 spike_neg.n564 spike_neg.n1 0.9005
R3870 spike_neg.n572 spike_neg.n564 0.9005
R3871 spike_neg.n13 spike_neg.n2 0.9005
R3872 spike_neg.n14 spike_neg.n13 0.9005
R3873 spike_neg.n5 spike_neg.n3 0.9005
R3874 spike_neg.n14 spike_neg.n5 0.9005
R3875 spike_neg.n490 spike_neg.n94 0.743357
R3876 spike_neg.n94 spike_neg.n81 0.743357
R3877 spike_neg.n98 spike_neg.n96 0.743357
R3878 spike_neg.n100 spike_neg.n98 0.743357
R3879 spike_neg.n539 spike_neg.n538 0.743357
R3880 spike_neg.n540 spike_neg.n539 0.743357
R3881 spike_neg.n510 spike_neg.n61 0.743357
R3882 spike_neg.n511 spike_neg.n510 0.743357
R3883 spike_neg.n531 spike_neg.n35 0.743357
R3884 spike_neg.n531 spike_neg.n530 0.743357
R3885 spike_neg.n40 spike_neg.n36 0.743357
R3886 spike_neg.n112 spike_neg.n40 0.743357
R3887 spike_neg.n264 spike_neg.n263 0.578278
R3888 spike_neg.n164 spike_neg.n77 0.578278
R3889 spike_neg.n511 spike_neg.n77 0.578278
R3890 spike_neg.n560 spike_neg.n18 0.316383
R3891 spike_neg.n159 spike_neg.n64 0.23353
R3892 spike_neg.n517 spike_neg.n63 0.2255
R3893 spike_neg.n156 vss 0.219897
R3894 spike_neg.n536 spike_neg.n535 0.2057
R3895 spike_neg.n535 spike_neg.n64 0.2057
R3896 spike_neg.n561 spike_neg.n560 0.2057
R3897 spike_neg.n165 spike_neg.n164 0.19713
R3898 spike_neg.n265 spike_neg.n257 0.1445
R3899 spike_neg.n280 spike_neg.n257 0.1445
R3900 spike_neg.n281 spike_neg.n280 0.1445
R3901 spike_neg.n282 spike_neg.n281 0.1445
R3902 spike_neg.n282 spike_neg.n245 0.1445
R3903 spike_neg.n296 spike_neg.n245 0.1445
R3904 spike_neg.n297 spike_neg.n296 0.1445
R3905 spike_neg.n298 spike_neg.n297 0.1445
R3906 spike_neg.n298 spike_neg.n233 0.1445
R3907 spike_neg.n312 spike_neg.n233 0.1445
R3908 spike_neg.n313 spike_neg.n312 0.1445
R3909 spike_neg.n314 spike_neg.n313 0.1445
R3910 spike_neg.n314 spike_neg.n221 0.1445
R3911 spike_neg.n328 spike_neg.n221 0.1445
R3912 spike_neg.n329 spike_neg.n328 0.1445
R3913 spike_neg.n330 spike_neg.n329 0.1445
R3914 spike_neg.n330 spike_neg.n209 0.1445
R3915 spike_neg.n344 spike_neg.n209 0.1445
R3916 spike_neg.n345 spike_neg.n344 0.1445
R3917 spike_neg.n346 spike_neg.n345 0.1445
R3918 spike_neg.n346 spike_neg.n197 0.1445
R3919 spike_neg.n360 spike_neg.n197 0.1445
R3920 spike_neg.n361 spike_neg.n360 0.1445
R3921 spike_neg.n362 spike_neg.n361 0.1445
R3922 spike_neg.n362 spike_neg.n185 0.1445
R3923 spike_neg.n376 spike_neg.n185 0.1445
R3924 spike_neg.n377 spike_neg.n376 0.1445
R3925 spike_neg.n378 spike_neg.n377 0.1445
R3926 spike_neg.n378 spike_neg.n173 0.1445
R3927 spike_neg.n392 spike_neg.n173 0.1445
R3928 spike_neg.n393 spike_neg.n392 0.1445
R3929 spike_neg.n394 spike_neg.n393 0.1445
R3930 spike_neg.n394 spike_neg.n149 0.1445
R3931 spike_neg.n408 spike_neg.n149 0.1445
R3932 spike_neg.n409 spike_neg.n408 0.1445
R3933 spike_neg.n410 spike_neg.n409 0.1445
R3934 spike_neg.n410 spike_neg.n137 0.1445
R3935 spike_neg.n424 spike_neg.n137 0.1445
R3936 spike_neg.n425 spike_neg.n424 0.1445
R3937 spike_neg.n426 spike_neg.n425 0.1445
R3938 spike_neg.n426 spike_neg.n125 0.1445
R3939 spike_neg.n443 spike_neg.n125 0.1445
R3940 spike_neg.n444 spike_neg.n443 0.1445
R3941 spike_neg.n446 spike_neg.n444 0.1445
R3942 spike_neg.n446 spike_neg.n445 0.1445
R3943 spike_neg.n445 spike_neg.n85 0.1445
R3944 spike_neg.n86 spike_neg.n85 0.1445
R3945 spike_neg.n87 spike_neg.n86 0.1445
R3946 spike_neg.n102 spike_neg.n87 0.1445
R3947 spike_neg.n103 spike_neg.n102 0.1445
R3948 spike_neg.n104 spike_neg.n103 0.1445
R3949 spike_neg.n105 spike_neg.n104 0.1445
R3950 spike_neg.n107 spike_neg.n105 0.1445
R3951 spike_neg.n107 spike_neg.n106 0.1445
R3952 spike_neg.n266 spike_neg.n258 0.1445
R3953 spike_neg.n279 spike_neg.n258 0.1445
R3954 spike_neg.n279 spike_neg.n256 0.1445
R3955 spike_neg.n283 spike_neg.n256 0.1445
R3956 spike_neg.n283 spike_neg.n246 0.1445
R3957 spike_neg.n295 spike_neg.n246 0.1445
R3958 spike_neg.n295 spike_neg.n244 0.1445
R3959 spike_neg.n299 spike_neg.n244 0.1445
R3960 spike_neg.n299 spike_neg.n234 0.1445
R3961 spike_neg.n311 spike_neg.n234 0.1445
R3962 spike_neg.n311 spike_neg.n232 0.1445
R3963 spike_neg.n315 spike_neg.n232 0.1445
R3964 spike_neg.n315 spike_neg.n222 0.1445
R3965 spike_neg.n327 spike_neg.n222 0.1445
R3966 spike_neg.n327 spike_neg.n220 0.1445
R3967 spike_neg.n331 spike_neg.n220 0.1445
R3968 spike_neg.n331 spike_neg.n210 0.1445
R3969 spike_neg.n343 spike_neg.n210 0.1445
R3970 spike_neg.n343 spike_neg.n208 0.1445
R3971 spike_neg.n347 spike_neg.n208 0.1445
R3972 spike_neg.n347 spike_neg.n198 0.1445
R3973 spike_neg.n359 spike_neg.n198 0.1445
R3974 spike_neg.n359 spike_neg.n196 0.1445
R3975 spike_neg.n363 spike_neg.n196 0.1445
R3976 spike_neg.n363 spike_neg.n186 0.1445
R3977 spike_neg.n375 spike_neg.n186 0.1445
R3978 spike_neg.n375 spike_neg.n184 0.1445
R3979 spike_neg.n379 spike_neg.n184 0.1445
R3980 spike_neg.n379 spike_neg.n174 0.1445
R3981 spike_neg.n391 spike_neg.n174 0.1445
R3982 spike_neg.n391 spike_neg.n172 0.1445
R3983 spike_neg.n395 spike_neg.n172 0.1445
R3984 spike_neg.n395 spike_neg.n150 0.1445
R3985 spike_neg.n407 spike_neg.n150 0.1445
R3986 spike_neg.n407 spike_neg.n148 0.1445
R3987 spike_neg.n411 spike_neg.n148 0.1445
R3988 spike_neg.n411 spike_neg.n138 0.1445
R3989 spike_neg.n423 spike_neg.n138 0.1445
R3990 spike_neg.n423 spike_neg.n136 0.1445
R3991 spike_neg.n427 spike_neg.n136 0.1445
R3992 spike_neg.n427 spike_neg.n126 0.1445
R3993 spike_neg.n442 spike_neg.n126 0.1445
R3994 spike_neg.n442 spike_neg.n124 0.1445
R3995 spike_neg.n447 spike_neg.n124 0.1445
R3996 spike_neg.n447 spike_neg.n84 0.1445
R3997 spike_neg.n499 spike_neg.n84 0.1445
R3998 spike_neg.n499 spike_neg.n498 0.1445
R3999 spike_neg.n498 spike_neg.n497 0.1445
R4000 spike_neg.n497 spike_neg.n88 0.1445
R4001 spike_neg.n482 spike_neg.n88 0.1445
R4002 spike_neg.n482 spike_neg.n481 0.1445
R4003 spike_neg.n481 spike_neg.n480 0.1445
R4004 spike_neg.n480 spike_neg.n108 0.1445
R4005 spike_neg.n108 spike_neg.n47 0.1445
R4006 spike_neg.n551 spike_neg.n47 0.1445
R4007 spike_neg.n549 spike_neg.n548 0.1445
R4008 spike_neg.n548 spike_neg.n49 0.1445
R4009 spike_neg.n544 spike_neg.n49 0.1445
R4010 spike_neg.n544 spike_neg.n51 0.1445
R4011 spike_neg.n514 spike_neg.n51 0.1445
R4012 spike_neg.n519 spike_neg.n514 0.1445
R4013 spike_neg.n519 spike_neg.n518 0.1445
R4014 spike_neg.n547 spike_neg.n546 0.1445
R4015 spike_neg.n546 spike_neg.n545 0.1445
R4016 spike_neg.n545 spike_neg.n50 0.1445
R4017 spike_neg.n515 spike_neg.n50 0.1445
R4018 spike_neg.n516 spike_neg.n515 0.1445
R4019 spike_neg.n517 spike_neg.n516 0.1445
R4020 spike_neg.n401 spike_neg.n400 0.1445
R4021 spike_neg.n402 spike_neg.n401 0.1445
R4022 spike_neg.n402 spike_neg.n143 0.1445
R4023 spike_neg.n416 spike_neg.n143 0.1445
R4024 spike_neg.n417 spike_neg.n416 0.1445
R4025 spike_neg.n418 spike_neg.n417 0.1445
R4026 spike_neg.n418 spike_neg.n131 0.1445
R4027 spike_neg.n432 spike_neg.n131 0.1445
R4028 spike_neg.n433 spike_neg.n432 0.1445
R4029 spike_neg.n434 spike_neg.n433 0.1445
R4030 spike_neg.n436 spike_neg.n434 0.1445
R4031 spike_neg.n436 spike_neg.n435 0.1445
R4032 spike_neg.n435 spike_neg.n119 0.1445
R4033 spike_neg.n454 spike_neg.n119 0.1445
R4034 spike_neg.n455 spike_neg.n454 0.1445
R4035 spike_neg.n456 spike_neg.n455 0.1445
R4036 spike_neg.n456 spike_neg.n116 0.1445
R4037 spike_neg.n461 spike_neg.n116 0.1445
R4038 spike_neg.n462 spike_neg.n461 0.1445
R4039 spike_neg.n463 spike_neg.n462 0.1445
R4040 spike_neg.n464 spike_neg.n463 0.1445
R4041 spike_neg.n465 spike_neg.n464 0.1445
R4042 spike_neg.n466 spike_neg.n465 0.1445
R4043 spike_neg.n468 spike_neg.n466 0.1445
R4044 spike_neg.n468 spike_neg.n467 0.1445
R4045 spike_neg.n467 spike_neg.n68 0.1445
R4046 spike_neg.n69 spike_neg.n68 0.1445
R4047 spike_neg.n70 spike_neg.n69 0.1445
R4048 spike_neg.n71 spike_neg.n70 0.1445
R4049 spike_neg.n161 spike_neg.n71 0.1445
R4050 spike_neg.n163 spike_neg.n161 0.1445
R4051 spike_neg.n488 spike_neg.n487 0.1445
R4052 spike_neg.n489 spike_neg.n97 0.1445
R4053 spike_neg.n273 spike_neg.n272 0.1445
R4054 spike_neg.n274 spike_neg.n273 0.1445
R4055 spike_neg.n274 spike_neg.n251 0.1445
R4056 spike_neg.n288 spike_neg.n251 0.1445
R4057 spike_neg.n289 spike_neg.n288 0.1445
R4058 spike_neg.n290 spike_neg.n289 0.1445
R4059 spike_neg.n290 spike_neg.n239 0.1445
R4060 spike_neg.n304 spike_neg.n239 0.1445
R4061 spike_neg.n305 spike_neg.n304 0.1445
R4062 spike_neg.n306 spike_neg.n305 0.1445
R4063 spike_neg.n306 spike_neg.n227 0.1445
R4064 spike_neg.n320 spike_neg.n227 0.1445
R4065 spike_neg.n321 spike_neg.n320 0.1445
R4066 spike_neg.n322 spike_neg.n321 0.1445
R4067 spike_neg.n322 spike_neg.n215 0.1445
R4068 spike_neg.n336 spike_neg.n215 0.1445
R4069 spike_neg.n337 spike_neg.n336 0.1445
R4070 spike_neg.n338 spike_neg.n337 0.1445
R4071 spike_neg.n338 spike_neg.n203 0.1445
R4072 spike_neg.n352 spike_neg.n203 0.1445
R4073 spike_neg.n353 spike_neg.n352 0.1445
R4074 spike_neg.n354 spike_neg.n353 0.1445
R4075 spike_neg.n354 spike_neg.n191 0.1445
R4076 spike_neg.n368 spike_neg.n191 0.1445
R4077 spike_neg.n369 spike_neg.n368 0.1445
R4078 spike_neg.n370 spike_neg.n369 0.1445
R4079 spike_neg.n370 spike_neg.n179 0.1445
R4080 spike_neg.n384 spike_neg.n179 0.1445
R4081 spike_neg.n385 spike_neg.n384 0.1445
R4082 spike_neg.n386 spike_neg.n385 0.1445
R4083 spike_neg.n271 spike_neg.n262 0.1445
R4084 spike_neg.n275 spike_neg.n262 0.1445
R4085 spike_neg.n275 spike_neg.n252 0.1445
R4086 spike_neg.n287 spike_neg.n252 0.1445
R4087 spike_neg.n287 spike_neg.n250 0.1445
R4088 spike_neg.n291 spike_neg.n250 0.1445
R4089 spike_neg.n291 spike_neg.n240 0.1445
R4090 spike_neg.n303 spike_neg.n240 0.1445
R4091 spike_neg.n303 spike_neg.n238 0.1445
R4092 spike_neg.n307 spike_neg.n238 0.1445
R4093 spike_neg.n307 spike_neg.n228 0.1445
R4094 spike_neg.n319 spike_neg.n228 0.1445
R4095 spike_neg.n319 spike_neg.n226 0.1445
R4096 spike_neg.n323 spike_neg.n226 0.1445
R4097 spike_neg.n323 spike_neg.n216 0.1445
R4098 spike_neg.n335 spike_neg.n216 0.1445
R4099 spike_neg.n335 spike_neg.n214 0.1445
R4100 spike_neg.n339 spike_neg.n214 0.1445
R4101 spike_neg.n339 spike_neg.n204 0.1445
R4102 spike_neg.n351 spike_neg.n204 0.1445
R4103 spike_neg.n351 spike_neg.n202 0.1445
R4104 spike_neg.n355 spike_neg.n202 0.1445
R4105 spike_neg.n355 spike_neg.n192 0.1445
R4106 spike_neg.n367 spike_neg.n192 0.1445
R4107 spike_neg.n367 spike_neg.n190 0.1445
R4108 spike_neg.n371 spike_neg.n190 0.1445
R4109 spike_neg.n371 spike_neg.n180 0.1445
R4110 spike_neg.n383 spike_neg.n180 0.1445
R4111 spike_neg.n383 spike_neg.n178 0.1445
R4112 spike_neg.n387 spike_neg.n178 0.1445
R4113 spike_neg.n387 spike_neg.n168 0.1445
R4114 spike_neg.n399 spike_neg.n168 0.1445
R4115 spike_neg.n399 spike_neg.n154 0.1445
R4116 spike_neg.n403 spike_neg.n154 0.1445
R4117 spike_neg.n403 spike_neg.n144 0.1445
R4118 spike_neg.n415 spike_neg.n144 0.1445
R4119 spike_neg.n415 spike_neg.n142 0.1445
R4120 spike_neg.n419 spike_neg.n142 0.1445
R4121 spike_neg.n419 spike_neg.n132 0.1445
R4122 spike_neg.n431 spike_neg.n132 0.1445
R4123 spike_neg.n431 spike_neg.n130 0.1445
R4124 spike_neg.n438 spike_neg.n130 0.1445
R4125 spike_neg.n438 spike_neg.n437 0.1445
R4126 spike_neg.n437 spike_neg.n120 0.1445
R4127 spike_neg.n452 spike_neg.n120 0.1445
R4128 spike_neg.n453 spike_neg.n452 0.1445
R4129 spike_neg.n453 spike_neg.n118 0.1445
R4130 spike_neg.n457 spike_neg.n118 0.1445
R4131 spike_neg.n459 spike_neg.n457 0.1445
R4132 spike_neg.n460 spike_neg.n459 0.1445
R4133 spike_neg.n460 spike_neg.n115 0.1445
R4134 spike_neg.n476 spike_neg.n115 0.1445
R4135 spike_neg.n476 spike_neg.n475 0.1445
R4136 spike_neg.n475 spike_neg.n474 0.1445
R4137 spike_neg.n474 spike_neg.n472 0.1445
R4138 spike_neg.n472 spike_neg.n471 0.1445
R4139 spike_neg.n471 spike_neg.n67 0.1445
R4140 spike_neg.n527 spike_neg.n67 0.1445
R4141 spike_neg.n527 spike_neg.n526 0.1445
R4142 spike_neg.n526 spike_neg.n525 0.1445
R4143 spike_neg.n525 spike_neg.n524 0.1445
R4144 spike_neg.n524 spike_neg.n72 0.1445
R4145 spike_neg.n162 spike_neg.n72 0.1445
R4146 spike_neg.n507 spike_neg.n505 0.1445
R4147 spike_neg.n506 spike_neg.n60 0.1445
R4148 spike_neg.n28 spike_neg.n25 0.1445
R4149 spike_neg.n27 spike_neg.n26 0.1445
R4150 spike_neg.n569 spike_neg.n566 0.1445
R4151 spike_neg.n568 spike_neg.n567 0.1445
R4152 spike_neg.n11 spike_neg.n8 0.1445
R4153 spike_neg.n10 spike_neg.n9 0.1445
R4154 spike_neg.n160 spike_neg.n159 0.130837
R4155 spike_neg.n576 spike_neg.n561 0.111183
R4156 spike_neg.n560 spike_neg.n559 0.111183
R4157 spike_neg.n557 spike_neg.n38 0.108765
R4158 spike_neg.n491 spike_neg.n64 0.102798
R4159 spike_neg.n537 spike_neg.n536 0.102798
R4160 spike_neg.n535 spike_neg.n534 0.102798
R4161 spike_neg.n167 vss 0.0806
R4162 spike_neg.n400 spike_neg.n167 0.0725
R4163 spike_neg.n551 spike_neg.n550 0.0718661
R4164 spike_neg.n550 spike_neg.n549 0.0718661
R4165 spike_neg.n547 spike_neg.n38 0.0671
R4166 spike_neg.n106 spike_neg.n38 0.0599
R4167 vss spike_neg.n576 0.0577669
R4168 spike_neg.n558 vss 0.0507793
R4169 spike_neg.n386 spike_neg.n167 0.0365
R4170 spike_neg.n159 spike_neg.n158 0.0363271
R4171 spike_neg.n158 spike_neg.n157 0.0077
R4172 spike_neg.n559 spike_neg.n558 0.00748758
R4173 spike_neg.n156 spike_neg.n155 0.00641376
R4174 spike_neg.n160 spike_neg.n155 0.00641376
R4175 spike_neg.n157 vss 0.00347
R4176 spike.n469 spike.n19 18200
R4177 spike.n468 spike.n43 18200
R4178 spike.n476 spike.n469 14243.8
R4179 spike.n469 spike.n468 4468.75
R4180 spike.n468 spike.n467 4062.5
R4181 spike.n555 spike.n554 521.494
R4182 spike.n554 spike.n553 521.494
R4183 spike.n538 spike.n537 521.494
R4184 spike.n537 spike.n529 521.494
R4185 spike.n572 spike.n571 521.494
R4186 spike.n571 spike.n570 521.494
R4187 spike.n477 spike.n476 233.853
R4188 spike.n460 spike.n55 147.31
R4189 spike.n443 spike.n75 147.31
R4190 spike.n434 spike.n30 147.31
R4191 spike.n507 spike.n506 147.31
R4192 spike.n519 spike.n6 143.626
R4193 spike.n518 spike.n9 143.626
R4194 spike.n78 spike.n43 141.786
R4195 spike.n494 spike.n19 134.419
R4196 spike.n459 spike.n58 132.578
R4197 spike.n450 spike.n449 132.578
R4198 spike.n505 spike.n22 130.738
R4199 spike.n39 spike.n22 125.213
R4200 spike.n486 spike.n40 125.213
R4201 spike.n449 spike.n65 123.371
R4202 spike.n77 spike.n6 112.323
R4203 spike.n495 spike.n30 104.959
R4204 spike.n234 spike.n225 95.4133
R4205 spike.n242 spike.n225 95.4133
R4206 spike.n242 spike.n219 95.4133
R4207 spike.n250 spike.n219 95.4133
R4208 spike.n250 spike.n213 95.4133
R4209 spike.n258 spike.n213 95.4133
R4210 spike.n258 spike.n207 95.4133
R4211 spike.n266 spike.n207 95.4133
R4212 spike.n266 spike.n201 95.4133
R4213 spike.n274 spike.n201 95.4133
R4214 spike.n274 spike.n195 95.4133
R4215 spike.n282 spike.n195 95.4133
R4216 spike.n282 spike.n189 95.4133
R4217 spike.n290 spike.n189 95.4133
R4218 spike.n290 spike.n183 95.4133
R4219 spike.n298 spike.n183 95.4133
R4220 spike.n298 spike.n177 95.4133
R4221 spike.n306 spike.n177 95.4133
R4222 spike.n306 spike.n171 95.4133
R4223 spike.n314 spike.n171 95.4133
R4224 spike.n314 spike.n165 95.4133
R4225 spike.n322 spike.n165 95.4133
R4226 spike.n322 spike.n159 95.4133
R4227 spike.n330 spike.n159 95.4133
R4228 spike.n330 spike.n153 95.4133
R4229 spike.n338 spike.n153 95.4133
R4230 spike.n338 spike.n147 95.4133
R4231 spike.n346 spike.n147 95.4133
R4232 spike.n346 spike.n141 95.4133
R4233 spike.n354 spike.n141 95.4133
R4234 spike.n354 spike.n135 95.4133
R4235 spike.n362 spike.n135 95.4133
R4236 spike.n362 spike.n117 95.4133
R4237 spike.n370 spike.n117 95.4133
R4238 spike.n370 spike.n111 95.4133
R4239 spike.n378 spike.n111 95.4133
R4240 spike.n378 spike.n105 95.4133
R4241 spike.n386 spike.n105 95.4133
R4242 spike.n386 spike.n99 95.4133
R4243 spike.n394 spike.n99 95.4133
R4244 spike.n394 spike.n93 95.4133
R4245 spike.n405 spike.n93 95.4133
R4246 spike.n405 spike.n87 95.4133
R4247 spike.n414 spike.n87 95.4133
R4248 spike.n414 spike.n44 95.4133
R4249 spike.n55 spike.n46 93.9099
R4250 spike.n467 spike.n44 75.1381
R4251 spike.n42 spike.n38 73.9866
R4252 spike.n478 spike.n42 73.9866
R4253 spike.n235 spike.n229 73.9866
R4254 spike.n451 spike.n63 69.0283
R4255 spike.n63 spike.n60 69.0283
R4256 spike.n458 spike.n59 69.0283
R4257 spike.n59 spike.n57 69.0283
R4258 spike.n504 spike.n23 69.0283
R4259 spike.n504 spike.n24 69.0283
R4260 spike.n475 spike.n473 69.0283
R4261 spike.n475 spike.n474 69.0283
R4262 spike.n496 spike.n4 69.0283
R4263 spike.n497 spike.n496 69.0283
R4264 spike.n7 spike.n5 69.0283
R4265 spike.n520 spike.n5 69.0283
R4266 spike.n556 spike.n545 62.1255
R4267 spike.n552 spike.n545 62.1255
R4268 spike.n547 spike.n546 62.1255
R4269 spike.n546 spike.n544 62.1255
R4270 spike.n536 spike.n527 62.1255
R4271 spike.n536 spike.n535 62.1255
R4272 spike.n530 spike.n528 62.1255
R4273 spike.n539 spike.n528 62.1255
R4274 spike.n573 spike.n562 62.1255
R4275 spike.n569 spike.n562 62.1255
R4276 spike.n564 spike.n563 62.1255
R4277 spike.n563 spike.n561 62.1255
R4278 spike.n466 spike.n46 53.3999
R4279 spike.n233 spike.n229 48.6503
R4280 spike.n495 spike.n494 42.3518
R4281 spike.n78 spike.n77 34.9863
R4282 spike.n467 spike.n466 31.3036
R4283 spike.n75 spike.n65 23.9382
R4284 spike.n486 spike.n39 22.0968
R4285 spike.n477 spike.n40 22.0968
R4286 spike.n131 spike.n130 17.2005
R4287 vss spike.n131 17.0096
R4288 spike.n506 spike.n505 16.5727
R4289 spike.n451 spike.n57 15.5561
R4290 spike.n232 spike.n224 15.5561
R4291 spike.n243 spike.n224 15.5561
R4292 spike.n243 spike.n220 15.5561
R4293 spike.n249 spike.n220 15.5561
R4294 spike.n249 spike.n212 15.5561
R4295 spike.n259 spike.n212 15.5561
R4296 spike.n259 spike.n208 15.5561
R4297 spike.n265 spike.n208 15.5561
R4298 spike.n265 spike.n200 15.5561
R4299 spike.n275 spike.n200 15.5561
R4300 spike.n275 spike.n196 15.5561
R4301 spike.n281 spike.n196 15.5561
R4302 spike.n281 spike.n188 15.5561
R4303 spike.n291 spike.n188 15.5561
R4304 spike.n291 spike.n184 15.5561
R4305 spike.n297 spike.n184 15.5561
R4306 spike.n297 spike.n176 15.5561
R4307 spike.n307 spike.n176 15.5561
R4308 spike.n307 spike.n172 15.5561
R4309 spike.n313 spike.n172 15.5561
R4310 spike.n313 spike.n164 15.5561
R4311 spike.n323 spike.n164 15.5561
R4312 spike.n323 spike.n160 15.5561
R4313 spike.n329 spike.n160 15.5561
R4314 spike.n329 spike.n152 15.5561
R4315 spike.n339 spike.n152 15.5561
R4316 spike.n339 spike.n148 15.5561
R4317 spike.n345 spike.n148 15.5561
R4318 spike.n345 spike.n140 15.5561
R4319 spike.n355 spike.n140 15.5561
R4320 spike.n355 spike.n136 15.5561
R4321 spike.n361 spike.n136 15.5561
R4322 spike.n361 spike.n116 15.5561
R4323 spike.n371 spike.n116 15.5561
R4324 spike.n371 spike.n112 15.5561
R4325 spike.n377 spike.n112 15.5561
R4326 spike.n377 spike.n104 15.5561
R4327 spike.n387 spike.n104 15.5561
R4328 spike.n387 spike.n100 15.5561
R4329 spike.n393 spike.n100 15.5561
R4330 spike.n393 spike.n92 15.5561
R4331 spike.n406 spike.n92 15.5561
R4332 spike.n406 spike.n88 15.5561
R4333 spike.n413 spike.n88 15.5561
R4334 spike.n413 spike.n47 15.5561
R4335 spike.n465 spike.n47 15.5561
R4336 spike.n465 spike.n48 15.5561
R4337 spike.n461 spike.n48 15.5561
R4338 spike.n461 spike.n54 15.5561
R4339 spike.n448 spike.n54 15.5561
R4340 spike.n448 spike.n66 15.5561
R4341 spike.n444 spike.n66 15.5561
R4342 spike.n444 spike.n74 15.5561
R4343 spike.n74 spike.n10 15.5561
R4344 spike.n517 spike.n10 15.5561
R4345 spike.n517 spike.n11 15.5561
R4346 spike.n13 spike.n11 15.5561
R4347 spike.n17 spike.n13 15.5561
R4348 spike.n508 spike.n17 15.5561
R4349 spike.n508 spike.n18 15.5561
R4350 spike.n41 spike.n18 15.5561
R4351 spike.n485 spike.n41 15.5561
R4352 spike.n485 spike.n478 15.5561
R4353 spike.n235 spike.n226 15.5561
R4354 spike.n241 spike.n226 15.5561
R4355 spike.n241 spike.n218 15.5561
R4356 spike.n251 spike.n218 15.5561
R4357 spike.n251 spike.n214 15.5561
R4358 spike.n257 spike.n214 15.5561
R4359 spike.n257 spike.n206 15.5561
R4360 spike.n267 spike.n206 15.5561
R4361 spike.n267 spike.n202 15.5561
R4362 spike.n273 spike.n202 15.5561
R4363 spike.n273 spike.n194 15.5561
R4364 spike.n283 spike.n194 15.5561
R4365 spike.n283 spike.n190 15.5561
R4366 spike.n289 spike.n190 15.5561
R4367 spike.n289 spike.n182 15.5561
R4368 spike.n299 spike.n182 15.5561
R4369 spike.n299 spike.n178 15.5561
R4370 spike.n305 spike.n178 15.5561
R4371 spike.n305 spike.n170 15.5561
R4372 spike.n315 spike.n170 15.5561
R4373 spike.n315 spike.n166 15.5561
R4374 spike.n321 spike.n166 15.5561
R4375 spike.n321 spike.n158 15.5561
R4376 spike.n331 spike.n158 15.5561
R4377 spike.n331 spike.n154 15.5561
R4378 spike.n337 spike.n154 15.5561
R4379 spike.n337 spike.n146 15.5561
R4380 spike.n347 spike.n146 15.5561
R4381 spike.n347 spike.n142 15.5561
R4382 spike.n353 spike.n142 15.5561
R4383 spike.n353 spike.n134 15.5561
R4384 spike.n363 spike.n134 15.5561
R4385 spike.n363 spike.n118 15.5561
R4386 spike.n369 spike.n118 15.5561
R4387 spike.n369 spike.n110 15.5561
R4388 spike.n379 spike.n110 15.5561
R4389 spike.n379 spike.n106 15.5561
R4390 spike.n385 spike.n106 15.5561
R4391 spike.n385 spike.n98 15.5561
R4392 spike.n395 spike.n98 15.5561
R4393 spike.n395 spike.n94 15.5561
R4394 spike.n404 spike.n94 15.5561
R4395 spike.n404 spike.n86 15.5561
R4396 spike.n415 spike.n86 15.5561
R4397 spike.n416 spike.n415 15.5561
R4398 spike.n416 spike.n45 15.5561
R4399 spike.n82 spike.n45 15.5561
R4400 spike.n82 spike.n56 15.5561
R4401 spike.n423 spike.n56 15.5561
R4402 spike.n423 spike.n64 15.5561
R4403 spike.n76 spike.n64 15.5561
R4404 spike.n442 spike.n76 15.5561
R4405 spike.n442 spike.n79 15.5561
R4406 spike.n438 spike.n79 15.5561
R4407 spike.n438 spike.n8 15.5561
R4408 spike.n435 spike.n8 15.5561
R4409 spike.n435 spike.n31 15.5561
R4410 spike.n493 spike.n31 15.5561
R4411 spike.n493 spike.n20 15.5561
R4412 spike.n21 spike.n20 15.5561
R4413 spike.n488 spike.n21 15.5561
R4414 spike.n488 spike.n487 15.5561
R4415 spike.n487 spike.n38 15.5561
R4416 spike.n473 spike.n23 15.5561
R4417 spike.n460 spike.n459 14.7314
R4418 spike.n450 spike.n58 14.7314
R4419 spike.n507 spike.n19 12.89
R4420 spike.n576 spike.n522 11.8522
R4421 spike.n501 spike.n28 11.0435
R4422 spike.n3 spike.n2 7.6287
R4423 spike.n557 spike.n556 6.37187
R4424 spike.n557 spike.n544 6.37187
R4425 spike.n540 spike.n539 6.37187
R4426 spike.n540 spike.n527 6.37187
R4427 spike.n574 spike.n573 6.37187
R4428 spike.n574 spike.n561 6.37187
R4429 spike.n552 spike.n551 6.3005
R4430 spike.n548 spike.n547 6.3005
R4431 spike.n535 spike.n534 6.3005
R4432 spike.n531 spike.n530 6.3005
R4433 spike.n569 spike.n568 6.3005
R4434 spike.n565 spike.n564 6.3005
R4435 spike.n443 spike.n43 5.52458
R4436 spike.n237 spike.n228 5.25278
R4437 spike.n230 spike.n228 5.25278
R4438 spike.n549 spike.n543 5.20101
R4439 spike.n550 spike.n542 5.20101
R4440 spike.n532 spike.n526 5.20101
R4441 spike.n533 spike.n525 5.20101
R4442 spike.n566 spike.n524 5.20101
R4443 spike.n567 spike.n523 5.20101
R4444 spike.n455 spike.n454 5.20101
R4445 spike.n503 spike.n25 5.20101
R4446 spike.n417 spike.n416 5.2005
R4447 spike.n416 spike.n44 5.2005
R4448 spike.n415 spike.n85 5.2005
R4449 spike.n415 spike.n414 5.2005
R4450 spike.n402 spike.n86 5.2005
R4451 spike.n87 spike.n86 5.2005
R4452 spike.n404 spike.n403 5.2005
R4453 spike.n405 spike.n404 5.2005
R4454 spike.n95 spike.n94 5.2005
R4455 spike.n94 spike.n93 5.2005
R4456 spike.n396 spike.n395 5.2005
R4457 spike.n395 spike.n394 5.2005
R4458 spike.n98 spike.n97 5.2005
R4459 spike.n99 spike.n98 5.2005
R4460 spike.n385 spike.n384 5.2005
R4461 spike.n386 spike.n385 5.2005
R4462 spike.n107 spike.n106 5.2005
R4463 spike.n106 spike.n105 5.2005
R4464 spike.n380 spike.n379 5.2005
R4465 spike.n379 spike.n378 5.2005
R4466 spike.n110 spike.n109 5.2005
R4467 spike.n111 spike.n110 5.2005
R4468 spike.n369 spike.n368 5.2005
R4469 spike.n370 spike.n369 5.2005
R4470 spike.n119 spike.n118 5.2005
R4471 spike.n118 spike.n117 5.2005
R4472 spike.n364 spike.n363 5.2005
R4473 spike.n363 spike.n362 5.2005
R4474 spike.n134 spike.n133 5.2005
R4475 spike.n135 spike.n134 5.2005
R4476 spike.n353 spike.n352 5.2005
R4477 spike.n354 spike.n353 5.2005
R4478 spike.n143 spike.n142 5.2005
R4479 spike.n142 spike.n141 5.2005
R4480 spike.n348 spike.n347 5.2005
R4481 spike.n347 spike.n346 5.2005
R4482 spike.n146 spike.n145 5.2005
R4483 spike.n147 spike.n146 5.2005
R4484 spike.n337 spike.n336 5.2005
R4485 spike.n338 spike.n337 5.2005
R4486 spike.n155 spike.n154 5.2005
R4487 spike.n154 spike.n153 5.2005
R4488 spike.n332 spike.n331 5.2005
R4489 spike.n331 spike.n330 5.2005
R4490 spike.n158 spike.n157 5.2005
R4491 spike.n159 spike.n158 5.2005
R4492 spike.n321 spike.n320 5.2005
R4493 spike.n322 spike.n321 5.2005
R4494 spike.n167 spike.n166 5.2005
R4495 spike.n166 spike.n165 5.2005
R4496 spike.n316 spike.n315 5.2005
R4497 spike.n315 spike.n314 5.2005
R4498 spike.n170 spike.n169 5.2005
R4499 spike.n171 spike.n170 5.2005
R4500 spike.n305 spike.n304 5.2005
R4501 spike.n306 spike.n305 5.2005
R4502 spike.n179 spike.n178 5.2005
R4503 spike.n178 spike.n177 5.2005
R4504 spike.n300 spike.n299 5.2005
R4505 spike.n299 spike.n298 5.2005
R4506 spike.n182 spike.n181 5.2005
R4507 spike.n183 spike.n182 5.2005
R4508 spike.n289 spike.n288 5.2005
R4509 spike.n290 spike.n289 5.2005
R4510 spike.n191 spike.n190 5.2005
R4511 spike.n190 spike.n189 5.2005
R4512 spike.n284 spike.n283 5.2005
R4513 spike.n283 spike.n282 5.2005
R4514 spike.n194 spike.n193 5.2005
R4515 spike.n195 spike.n194 5.2005
R4516 spike.n273 spike.n272 5.2005
R4517 spike.n274 spike.n273 5.2005
R4518 spike.n203 spike.n202 5.2005
R4519 spike.n202 spike.n201 5.2005
R4520 spike.n268 spike.n267 5.2005
R4521 spike.n267 spike.n266 5.2005
R4522 spike.n206 spike.n205 5.2005
R4523 spike.n207 spike.n206 5.2005
R4524 spike.n257 spike.n256 5.2005
R4525 spike.n258 spike.n257 5.2005
R4526 spike.n215 spike.n214 5.2005
R4527 spike.n214 spike.n213 5.2005
R4528 spike.n252 spike.n251 5.2005
R4529 spike.n251 spike.n250 5.2005
R4530 spike.n218 spike.n217 5.2005
R4531 spike.n219 spike.n218 5.2005
R4532 spike.n241 spike.n240 5.2005
R4533 spike.n242 spike.n241 5.2005
R4534 spike.n227 spike.n226 5.2005
R4535 spike.n226 spike.n225 5.2005
R4536 spike.n236 spike.n235 5.2005
R4537 spike.n235 spike.n234 5.2005
R4538 spike.n49 spike.n47 5.2005
R4539 spike.n47 spike.n44 5.2005
R4540 spike.n413 spike.n412 5.2005
R4541 spike.n414 spike.n413 5.2005
R4542 spike.n89 spike.n88 5.2005
R4543 spike.n88 spike.n87 5.2005
R4544 spike.n407 spike.n406 5.2005
R4545 spike.n406 spike.n405 5.2005
R4546 spike.n92 spike.n91 5.2005
R4547 spike.n93 spike.n92 5.2005
R4548 spike.n393 spike.n392 5.2005
R4549 spike.n394 spike.n393 5.2005
R4550 spike.n101 spike.n100 5.2005
R4551 spike.n100 spike.n99 5.2005
R4552 spike.n388 spike.n387 5.2005
R4553 spike.n387 spike.n386 5.2005
R4554 spike.n104 spike.n103 5.2005
R4555 spike.n105 spike.n104 5.2005
R4556 spike.n377 spike.n376 5.2005
R4557 spike.n378 spike.n377 5.2005
R4558 spike.n113 spike.n112 5.2005
R4559 spike.n112 spike.n111 5.2005
R4560 spike.n372 spike.n371 5.2005
R4561 spike.n371 spike.n370 5.2005
R4562 spike.n116 spike.n115 5.2005
R4563 spike.n117 spike.n116 5.2005
R4564 spike.n361 spike.n360 5.2005
R4565 spike.n362 spike.n361 5.2005
R4566 spike.n137 spike.n136 5.2005
R4567 spike.n136 spike.n135 5.2005
R4568 spike.n356 spike.n355 5.2005
R4569 spike.n355 spike.n354 5.2005
R4570 spike.n140 spike.n139 5.2005
R4571 spike.n141 spike.n140 5.2005
R4572 spike.n345 spike.n344 5.2005
R4573 spike.n346 spike.n345 5.2005
R4574 spike.n149 spike.n148 5.2005
R4575 spike.n148 spike.n147 5.2005
R4576 spike.n340 spike.n339 5.2005
R4577 spike.n339 spike.n338 5.2005
R4578 spike.n152 spike.n151 5.2005
R4579 spike.n153 spike.n152 5.2005
R4580 spike.n329 spike.n328 5.2005
R4581 spike.n330 spike.n329 5.2005
R4582 spike.n161 spike.n160 5.2005
R4583 spike.n160 spike.n159 5.2005
R4584 spike.n324 spike.n323 5.2005
R4585 spike.n323 spike.n322 5.2005
R4586 spike.n164 spike.n163 5.2005
R4587 spike.n165 spike.n164 5.2005
R4588 spike.n313 spike.n312 5.2005
R4589 spike.n314 spike.n313 5.2005
R4590 spike.n173 spike.n172 5.2005
R4591 spike.n172 spike.n171 5.2005
R4592 spike.n308 spike.n307 5.2005
R4593 spike.n307 spike.n306 5.2005
R4594 spike.n176 spike.n175 5.2005
R4595 spike.n177 spike.n176 5.2005
R4596 spike.n297 spike.n296 5.2005
R4597 spike.n298 spike.n297 5.2005
R4598 spike.n185 spike.n184 5.2005
R4599 spike.n184 spike.n183 5.2005
R4600 spike.n292 spike.n291 5.2005
R4601 spike.n291 spike.n290 5.2005
R4602 spike.n188 spike.n187 5.2005
R4603 spike.n189 spike.n188 5.2005
R4604 spike.n281 spike.n280 5.2005
R4605 spike.n282 spike.n281 5.2005
R4606 spike.n197 spike.n196 5.2005
R4607 spike.n196 spike.n195 5.2005
R4608 spike.n276 spike.n275 5.2005
R4609 spike.n275 spike.n274 5.2005
R4610 spike.n200 spike.n199 5.2005
R4611 spike.n201 spike.n200 5.2005
R4612 spike.n265 spike.n264 5.2005
R4613 spike.n266 spike.n265 5.2005
R4614 spike.n209 spike.n208 5.2005
R4615 spike.n208 spike.n207 5.2005
R4616 spike.n260 spike.n259 5.2005
R4617 spike.n259 spike.n258 5.2005
R4618 spike.n212 spike.n211 5.2005
R4619 spike.n213 spike.n212 5.2005
R4620 spike.n249 spike.n248 5.2005
R4621 spike.n250 spike.n249 5.2005
R4622 spike.n221 spike.n220 5.2005
R4623 spike.n220 spike.n219 5.2005
R4624 spike.n244 spike.n243 5.2005
R4625 spike.n243 spike.n242 5.2005
R4626 spike.n224 spike.n223 5.2005
R4627 spike.n225 spike.n224 5.2005
R4628 spike.n232 spike.n231 5.2005
R4629 spike.n452 spike.n451 5.2005
R4630 spike.n451 spike.n450 5.2005
R4631 spike.n453 spike.n57 5.2005
R4632 spike.n459 spike.n57 5.2005
R4633 spike.n450 spike.n60 5.2005
R4634 spike.n459 spike.n458 5.2005
R4635 spike.n127 spike.n38 5.2005
R4636 spike.n477 spike.n38 5.2005
R4637 spike.n487 spike.n37 5.2005
R4638 spike.n487 spike.n486 5.2005
R4639 spike.n489 spike.n488 5.2005
R4640 spike.n488 spike.n22 5.2005
R4641 spike.n490 spike.n21 5.2005
R4642 spike.n506 spike.n21 5.2005
R4643 spike.n491 spike.n20 5.2005
R4644 spike.n507 spike.n20 5.2005
R4645 spike.n493 spike.n492 5.2005
R4646 spike.n494 spike.n493 5.2005
R4647 spike.n32 spike.n31 5.2005
R4648 spike.n31 spike.n30 5.2005
R4649 spike.n436 spike.n435 5.2005
R4650 spike.n435 spike.n434 5.2005
R4651 spike.n437 spike.n8 5.2005
R4652 spike.n518 spike.n8 5.2005
R4653 spike.n439 spike.n438 5.2005
R4654 spike.n438 spike.n6 5.2005
R4655 spike.n440 spike.n79 5.2005
R4656 spike.n79 spike.n78 5.2005
R4657 spike.n442 spike.n441 5.2005
R4658 spike.n443 spike.n442 5.2005
R4659 spike.n80 spike.n76 5.2005
R4660 spike.n76 spike.n75 5.2005
R4661 spike.n425 spike.n64 5.2005
R4662 spike.n449 spike.n64 5.2005
R4663 spike.n424 spike.n423 5.2005
R4664 spike.n423 spike.n58 5.2005
R4665 spike.n422 spike.n56 5.2005
R4666 spike.n460 spike.n56 5.2005
R4667 spike.n83 spike.n82 5.2005
R4668 spike.n82 spike.n55 5.2005
R4669 spike.n418 spike.n45 5.2005
R4670 spike.n466 spike.n45 5.2005
R4671 spike.n483 spike.n478 5.2005
R4672 spike.n478 spike.n477 5.2005
R4673 spike.n485 spike.n484 5.2005
R4674 spike.n486 spike.n485 5.2005
R4675 spike.n479 spike.n41 5.2005
R4676 spike.n41 spike.n22 5.2005
R4677 spike.n18 spike.n16 5.2005
R4678 spike.n506 spike.n18 5.2005
R4679 spike.n509 spike.n508 5.2005
R4680 spike.n508 spike.n507 5.2005
R4681 spike.n17 spike.n14 5.2005
R4682 spike.n494 spike.n17 5.2005
R4683 spike.n513 spike.n13 5.2005
R4684 spike.n30 spike.n13 5.2005
R4685 spike.n514 spike.n11 5.2005
R4686 spike.n434 spike.n11 5.2005
R4687 spike.n517 spike.n516 5.2005
R4688 spike.n518 spike.n517 5.2005
R4689 spike.n12 spike.n10 5.2005
R4690 spike.n10 spike.n6 5.2005
R4691 spike.n74 spike.n73 5.2005
R4692 spike.n78 spike.n74 5.2005
R4693 spike.n445 spike.n444 5.2005
R4694 spike.n444 spike.n443 5.2005
R4695 spike.n446 spike.n66 5.2005
R4696 spike.n75 spike.n66 5.2005
R4697 spike.n448 spike.n447 5.2005
R4698 spike.n449 spike.n448 5.2005
R4699 spike.n54 spike.n53 5.2005
R4700 spike.n58 spike.n54 5.2005
R4701 spike.n462 spike.n461 5.2005
R4702 spike.n461 spike.n460 5.2005
R4703 spike.n463 spike.n48 5.2005
R4704 spike.n55 spike.n48 5.2005
R4705 spike.n465 spike.n464 5.2005
R4706 spike.n466 spike.n465 5.2005
R4707 spike.n473 spike.n472 5.2005
R4708 spike.n473 spike.n40 5.2005
R4709 spike.n470 spike.n23 5.2005
R4710 spike.n39 spike.n23 5.2005
R4711 spike.n474 spike.n40 5.2005
R4712 spike.n39 spike.n24 5.2005
R4713 spike.n497 spike.n9 5.2005
R4714 spike.n519 spike.n7 5.2005
R4715 spike.n9 spike.n4 5.2005
R4716 spike.n520 spike.n519 5.2005
R4717 spike.n62 spike.n61 5.19319
R4718 spike.n471 spike.n26 5.19319
R4719 spike.n522 spike.n1 5.12001
R4720 spike.n522 spike.n0 5.11219
R4721 spike.n130 spike.n128 5.04833
R4722 spike.n129 spike.n28 5.02778
R4723 spike.n558 spike.n543 4.98321
R4724 spike.n541 spike.n526 4.98321
R4725 spike.n575 spike.n524 4.98321
R4726 spike.n499 spike.n1 4.98321
R4727 spike.n456 spike.n455 4.98321
R4728 spike.n456 spike.n61 4.98321
R4729 spike.n502 spike.n26 4.98321
R4730 spike.n503 spike.n502 4.98321
R4731 spike.n499 spike.n0 4.98321
R4732 spike.n558 spike.n542 4.97539
R4733 spike.n541 spike.n525 4.97539
R4734 spike.n575 spike.n523 4.97539
R4735 vss spike.n125 4.8929
R4736 spike.n551 spike.n550 4.5005
R4737 spike.n549 spike.n548 4.5005
R4738 spike.n534 spike.n533 4.5005
R4739 spike.n532 spike.n531 4.5005
R4740 spike.n568 spike.n567 4.5005
R4741 spike.n566 spike.n565 4.5005
R4742 spike.n223 spike.n222 4.5005
R4743 spike.n245 spike.n244 4.5005
R4744 spike.n246 spike.n221 4.5005
R4745 spike.n248 spike.n247 4.5005
R4746 spike.n211 spike.n210 4.5005
R4747 spike.n261 spike.n260 4.5005
R4748 spike.n262 spike.n209 4.5005
R4749 spike.n264 spike.n263 4.5005
R4750 spike.n199 spike.n198 4.5005
R4751 spike.n277 spike.n276 4.5005
R4752 spike.n278 spike.n197 4.5005
R4753 spike.n280 spike.n279 4.5005
R4754 spike.n187 spike.n186 4.5005
R4755 spike.n293 spike.n292 4.5005
R4756 spike.n294 spike.n185 4.5005
R4757 spike.n296 spike.n295 4.5005
R4758 spike.n175 spike.n174 4.5005
R4759 spike.n309 spike.n308 4.5005
R4760 spike.n310 spike.n173 4.5005
R4761 spike.n312 spike.n311 4.5005
R4762 spike.n163 spike.n162 4.5005
R4763 spike.n325 spike.n324 4.5005
R4764 spike.n326 spike.n161 4.5005
R4765 spike.n328 spike.n327 4.5005
R4766 spike.n151 spike.n150 4.5005
R4767 spike.n341 spike.n340 4.5005
R4768 spike.n342 spike.n149 4.5005
R4769 spike.n344 spike.n343 4.5005
R4770 spike.n139 spike.n138 4.5005
R4771 spike.n357 spike.n356 4.5005
R4772 spike.n358 spike.n137 4.5005
R4773 spike.n360 spike.n359 4.5005
R4774 spike.n115 spike.n114 4.5005
R4775 spike.n373 spike.n372 4.5005
R4776 spike.n374 spike.n113 4.5005
R4777 spike.n376 spike.n375 4.5005
R4778 spike.n103 spike.n102 4.5005
R4779 spike.n389 spike.n388 4.5005
R4780 spike.n390 spike.n101 4.5005
R4781 spike.n392 spike.n391 4.5005
R4782 spike.n91 spike.n90 4.5005
R4783 spike.n408 spike.n407 4.5005
R4784 spike.n409 spike.n89 4.5005
R4785 spike.n412 spike.n411 4.5005
R4786 spike.n410 spike.n49 4.5005
R4787 spike.n464 spike.n50 4.5005
R4788 spike.n463 spike.n51 4.5005
R4789 spike.n462 spike.n52 4.5005
R4790 spike.n67 spike.n53 4.5005
R4791 spike.n447 spike.n68 4.5005
R4792 spike.n446 spike.n69 4.5005
R4793 spike.n445 spike.n70 4.5005
R4794 spike.n73 spike.n72 4.5005
R4795 spike.n71 spike.n12 4.5005
R4796 spike.n231 spike.n230 4.5005
R4797 spike.n513 spike.n512 4.5005
R4798 spike.n511 spike.n14 4.5005
R4799 spike.n510 spike.n509 4.5005
R4800 spike.n16 spike.n15 4.5005
R4801 spike.n480 spike.n479 4.5005
R4802 spike.n484 spike.n481 4.5005
R4803 spike.n483 spike.n482 4.5005
R4804 spike.n452 spike.n62 4.5005
R4805 spike.n454 spike.n453 4.5005
R4806 spike.n238 spike.n227 4.5005
R4807 spike.n240 spike.n239 4.5005
R4808 spike.n217 spike.n216 4.5005
R4809 spike.n253 spike.n252 4.5005
R4810 spike.n254 spike.n215 4.5005
R4811 spike.n256 spike.n255 4.5005
R4812 spike.n205 spike.n204 4.5005
R4813 spike.n269 spike.n268 4.5005
R4814 spike.n270 spike.n203 4.5005
R4815 spike.n272 spike.n271 4.5005
R4816 spike.n193 spike.n192 4.5005
R4817 spike.n285 spike.n284 4.5005
R4818 spike.n286 spike.n191 4.5005
R4819 spike.n288 spike.n287 4.5005
R4820 spike.n181 spike.n180 4.5005
R4821 spike.n301 spike.n300 4.5005
R4822 spike.n302 spike.n179 4.5005
R4823 spike.n304 spike.n303 4.5005
R4824 spike.n169 spike.n168 4.5005
R4825 spike.n317 spike.n316 4.5005
R4826 spike.n318 spike.n167 4.5005
R4827 spike.n320 spike.n319 4.5005
R4828 spike.n157 spike.n156 4.5005
R4829 spike.n333 spike.n332 4.5005
R4830 spike.n334 spike.n155 4.5005
R4831 spike.n336 spike.n335 4.5005
R4832 spike.n145 spike.n144 4.5005
R4833 spike.n349 spike.n348 4.5005
R4834 spike.n350 spike.n143 4.5005
R4835 spike.n352 spike.n351 4.5005
R4836 spike.n133 spike.n132 4.5005
R4837 spike.n365 spike.n364 4.5005
R4838 spike.n366 spike.n119 4.5005
R4839 spike.n368 spike.n367 4.5005
R4840 spike.n109 spike.n108 4.5005
R4841 spike.n381 spike.n380 4.5005
R4842 spike.n382 spike.n107 4.5005
R4843 spike.n384 spike.n383 4.5005
R4844 spike.n97 spike.n96 4.5005
R4845 spike.n397 spike.n396 4.5005
R4846 spike.n398 spike.n95 4.5005
R4847 spike.n403 spike.n399 4.5005
R4848 spike.n402 spike.n401 4.5005
R4849 spike.n400 spike.n85 4.5005
R4850 spike.n417 spike.n84 4.5005
R4851 spike.n419 spike.n418 4.5005
R4852 spike.n420 spike.n83 4.5005
R4853 spike.n422 spike.n421 4.5005
R4854 spike.n424 spike.n81 4.5005
R4855 spike.n426 spike.n425 4.5005
R4856 spike.n427 spike.n80 4.5005
R4857 spike.n441 spike.n428 4.5005
R4858 spike.n440 spike.n429 4.5005
R4859 spike.n439 spike.n430 4.5005
R4860 spike.n437 spike.n431 4.5005
R4861 spike.n436 spike.n433 4.5005
R4862 spike.n432 spike.n32 4.5005
R4863 spike.n492 spike.n33 4.5005
R4864 spike.n491 spike.n34 4.5005
R4865 spike.n490 spike.n35 4.5005
R4866 spike.n489 spike.n36 4.5005
R4867 spike.n126 spike.n37 4.5005
R4868 spike.n128 spike.n127 4.5005
R4869 spike.n237 spike.n236 4.5005
R4870 spike.n472 spike.n471 4.5005
R4871 spike.n470 spike.n25 4.5005
R4872 spike.n519 spike.n518 3.68322
R4873 spike.n434 spike.n9 3.68322
R4874 spike.n234 spike.n233 3.42024
R4875 spike.n553 spike.n552 3.31679
R4876 spike.n553 spike.n547 3.31679
R4877 spike.n555 spike.n544 3.31679
R4878 spike.n556 spike.n555 3.31679
R4879 spike.n535 spike.n529 3.31679
R4880 spike.n530 spike.n529 3.31679
R4881 spike.n538 spike.n527 3.31679
R4882 spike.n539 spike.n538 3.31679
R4883 spike.n570 spike.n569 3.31679
R4884 spike.n570 spike.n564 3.31679
R4885 spike.n572 spike.n561 3.31679
R4886 spike.n573 spike.n572 3.31679
R4887 spike.n457 spike.n456 3.28078
R4888 spike.n502 spike.n27 3.28078
R4889 spike.n499 spike.n498 3.28078
R4890 spike.n522 spike.n521 3.28078
R4891 spike.n498 spike.n497 3.14293
R4892 spike.n458 spike.n457 3.14293
R4893 spike.n457 spike.n60 3.14293
R4894 spike.n27 spike.n24 3.14293
R4895 spike.n474 spike.n27 3.14293
R4896 spike.n498 spike.n7 3.14293
R4897 spike.n521 spike.n520 3.14293
R4898 spike.n521 spike.n4 3.14293
R4899 spike.n541 spike.n540 2.21557
R4900 spike.n515 spike.n3 2.21557
R4901 spike.n575 spike.n574 2.21557
R4902 spike.n558 spike.n557 2.21557
R4903 spike.n233 spike.n232 1.66482
R4904 spike.n123 spike.n120 1.1255
R4905 spike.n122 spike.n121 1.1255
R4906 spike.n559 vss 1.0868
R4907 spike.n545 spike.n542 0.9005
R4908 spike.n554 spike.n545 0.9005
R4909 spike.n546 spike.n543 0.9005
R4910 spike.n554 spike.n546 0.9005
R4911 spike.n536 spike.n525 0.9005
R4912 spike.n537 spike.n536 0.9005
R4913 spike.n528 spike.n526 0.9005
R4914 spike.n537 spike.n528 0.9005
R4915 spike.n562 spike.n523 0.9005
R4916 spike.n571 spike.n562 0.9005
R4917 spike.n563 spike.n524 0.9005
R4918 spike.n571 spike.n563 0.9005
R4919 spike.n455 spike.n59 0.743357
R4920 spike.n59 spike.n46 0.743357
R4921 spike.n63 spike.n61 0.743357
R4922 spike.n65 spike.n63 0.743357
R4923 spike.n504 spike.n503 0.743357
R4924 spike.n505 spike.n504 0.743357
R4925 spike.n475 spike.n26 0.743357
R4926 spike.n476 spike.n475 0.743357
R4927 spike.n496 spike.n0 0.743357
R4928 spike.n496 spike.n495 0.743357
R4929 spike.n5 spike.n1 0.743357
R4930 spike.n77 spike.n5 0.743357
R4931 spike.n229 spike.n228 0.578278
R4932 spike.n129 spike.n42 0.578278
R4933 spike.n476 spike.n42 0.578278
R4934 spike.n560 spike.n541 0.316383
R4935 spike.n124 spike.n29 0.23353
R4936 spike.n482 spike.n28 0.2255
R4937 spike.n121 vss 0.219897
R4938 spike.n501 spike.n500 0.2057
R4939 spike.n500 spike.n29 0.2057
R4940 spike.n560 spike.n559 0.2057
R4941 spike.n130 spike.n129 0.19713
R4942 spike.n551 spike.n548 0.1445
R4943 spike.n550 spike.n549 0.1445
R4944 spike.n534 spike.n531 0.1445
R4945 spike.n533 spike.n532 0.1445
R4946 spike.n568 spike.n565 0.1445
R4947 spike.n567 spike.n566 0.1445
R4948 spike.n230 spike.n222 0.1445
R4949 spike.n245 spike.n222 0.1445
R4950 spike.n246 spike.n245 0.1445
R4951 spike.n247 spike.n246 0.1445
R4952 spike.n247 spike.n210 0.1445
R4953 spike.n261 spike.n210 0.1445
R4954 spike.n262 spike.n261 0.1445
R4955 spike.n263 spike.n262 0.1445
R4956 spike.n263 spike.n198 0.1445
R4957 spike.n277 spike.n198 0.1445
R4958 spike.n278 spike.n277 0.1445
R4959 spike.n279 spike.n278 0.1445
R4960 spike.n279 spike.n186 0.1445
R4961 spike.n293 spike.n186 0.1445
R4962 spike.n294 spike.n293 0.1445
R4963 spike.n295 spike.n294 0.1445
R4964 spike.n295 spike.n174 0.1445
R4965 spike.n309 spike.n174 0.1445
R4966 spike.n310 spike.n309 0.1445
R4967 spike.n311 spike.n310 0.1445
R4968 spike.n311 spike.n162 0.1445
R4969 spike.n325 spike.n162 0.1445
R4970 spike.n326 spike.n325 0.1445
R4971 spike.n327 spike.n326 0.1445
R4972 spike.n327 spike.n150 0.1445
R4973 spike.n341 spike.n150 0.1445
R4974 spike.n342 spike.n341 0.1445
R4975 spike.n343 spike.n342 0.1445
R4976 spike.n343 spike.n138 0.1445
R4977 spike.n357 spike.n138 0.1445
R4978 spike.n358 spike.n357 0.1445
R4979 spike.n359 spike.n358 0.1445
R4980 spike.n359 spike.n114 0.1445
R4981 spike.n373 spike.n114 0.1445
R4982 spike.n374 spike.n373 0.1445
R4983 spike.n375 spike.n374 0.1445
R4984 spike.n375 spike.n102 0.1445
R4985 spike.n389 spike.n102 0.1445
R4986 spike.n390 spike.n389 0.1445
R4987 spike.n391 spike.n390 0.1445
R4988 spike.n391 spike.n90 0.1445
R4989 spike.n408 spike.n90 0.1445
R4990 spike.n409 spike.n408 0.1445
R4991 spike.n411 spike.n409 0.1445
R4992 spike.n411 spike.n410 0.1445
R4993 spike.n410 spike.n50 0.1445
R4994 spike.n51 spike.n50 0.1445
R4995 spike.n52 spike.n51 0.1445
R4996 spike.n67 spike.n52 0.1445
R4997 spike.n68 spike.n67 0.1445
R4998 spike.n69 spike.n68 0.1445
R4999 spike.n70 spike.n69 0.1445
R5000 spike.n72 spike.n70 0.1445
R5001 spike.n72 spike.n71 0.1445
R5002 spike.n231 spike.n223 0.1445
R5003 spike.n244 spike.n223 0.1445
R5004 spike.n244 spike.n221 0.1445
R5005 spike.n248 spike.n221 0.1445
R5006 spike.n248 spike.n211 0.1445
R5007 spike.n260 spike.n211 0.1445
R5008 spike.n260 spike.n209 0.1445
R5009 spike.n264 spike.n209 0.1445
R5010 spike.n264 spike.n199 0.1445
R5011 spike.n276 spike.n199 0.1445
R5012 spike.n276 spike.n197 0.1445
R5013 spike.n280 spike.n197 0.1445
R5014 spike.n280 spike.n187 0.1445
R5015 spike.n292 spike.n187 0.1445
R5016 spike.n292 spike.n185 0.1445
R5017 spike.n296 spike.n185 0.1445
R5018 spike.n296 spike.n175 0.1445
R5019 spike.n308 spike.n175 0.1445
R5020 spike.n308 spike.n173 0.1445
R5021 spike.n312 spike.n173 0.1445
R5022 spike.n312 spike.n163 0.1445
R5023 spike.n324 spike.n163 0.1445
R5024 spike.n324 spike.n161 0.1445
R5025 spike.n328 spike.n161 0.1445
R5026 spike.n328 spike.n151 0.1445
R5027 spike.n340 spike.n151 0.1445
R5028 spike.n340 spike.n149 0.1445
R5029 spike.n344 spike.n149 0.1445
R5030 spike.n344 spike.n139 0.1445
R5031 spike.n356 spike.n139 0.1445
R5032 spike.n356 spike.n137 0.1445
R5033 spike.n360 spike.n137 0.1445
R5034 spike.n360 spike.n115 0.1445
R5035 spike.n372 spike.n115 0.1445
R5036 spike.n372 spike.n113 0.1445
R5037 spike.n376 spike.n113 0.1445
R5038 spike.n376 spike.n103 0.1445
R5039 spike.n388 spike.n103 0.1445
R5040 spike.n388 spike.n101 0.1445
R5041 spike.n392 spike.n101 0.1445
R5042 spike.n392 spike.n91 0.1445
R5043 spike.n407 spike.n91 0.1445
R5044 spike.n407 spike.n89 0.1445
R5045 spike.n412 spike.n89 0.1445
R5046 spike.n412 spike.n49 0.1445
R5047 spike.n464 spike.n49 0.1445
R5048 spike.n464 spike.n463 0.1445
R5049 spike.n463 spike.n462 0.1445
R5050 spike.n462 spike.n53 0.1445
R5051 spike.n447 spike.n53 0.1445
R5052 spike.n447 spike.n446 0.1445
R5053 spike.n446 spike.n445 0.1445
R5054 spike.n445 spike.n73 0.1445
R5055 spike.n73 spike.n12 0.1445
R5056 spike.n516 spike.n12 0.1445
R5057 spike.n514 spike.n513 0.1445
R5058 spike.n513 spike.n14 0.1445
R5059 spike.n509 spike.n14 0.1445
R5060 spike.n509 spike.n16 0.1445
R5061 spike.n479 spike.n16 0.1445
R5062 spike.n484 spike.n479 0.1445
R5063 spike.n484 spike.n483 0.1445
R5064 spike.n512 spike.n511 0.1445
R5065 spike.n511 spike.n510 0.1445
R5066 spike.n510 spike.n15 0.1445
R5067 spike.n480 spike.n15 0.1445
R5068 spike.n481 spike.n480 0.1445
R5069 spike.n482 spike.n481 0.1445
R5070 spike.n366 spike.n365 0.1445
R5071 spike.n367 spike.n366 0.1445
R5072 spike.n367 spike.n108 0.1445
R5073 spike.n381 spike.n108 0.1445
R5074 spike.n382 spike.n381 0.1445
R5075 spike.n383 spike.n382 0.1445
R5076 spike.n383 spike.n96 0.1445
R5077 spike.n397 spike.n96 0.1445
R5078 spike.n398 spike.n397 0.1445
R5079 spike.n399 spike.n398 0.1445
R5080 spike.n401 spike.n399 0.1445
R5081 spike.n401 spike.n400 0.1445
R5082 spike.n400 spike.n84 0.1445
R5083 spike.n419 spike.n84 0.1445
R5084 spike.n420 spike.n419 0.1445
R5085 spike.n421 spike.n420 0.1445
R5086 spike.n421 spike.n81 0.1445
R5087 spike.n426 spike.n81 0.1445
R5088 spike.n427 spike.n426 0.1445
R5089 spike.n428 spike.n427 0.1445
R5090 spike.n429 spike.n428 0.1445
R5091 spike.n430 spike.n429 0.1445
R5092 spike.n431 spike.n430 0.1445
R5093 spike.n433 spike.n431 0.1445
R5094 spike.n433 spike.n432 0.1445
R5095 spike.n432 spike.n33 0.1445
R5096 spike.n34 spike.n33 0.1445
R5097 spike.n35 spike.n34 0.1445
R5098 spike.n36 spike.n35 0.1445
R5099 spike.n126 spike.n36 0.1445
R5100 spike.n128 spike.n126 0.1445
R5101 spike.n453 spike.n452 0.1445
R5102 spike.n454 spike.n62 0.1445
R5103 spike.n238 spike.n237 0.1445
R5104 spike.n239 spike.n238 0.1445
R5105 spike.n239 spike.n216 0.1445
R5106 spike.n253 spike.n216 0.1445
R5107 spike.n254 spike.n253 0.1445
R5108 spike.n255 spike.n254 0.1445
R5109 spike.n255 spike.n204 0.1445
R5110 spike.n269 spike.n204 0.1445
R5111 spike.n270 spike.n269 0.1445
R5112 spike.n271 spike.n270 0.1445
R5113 spike.n271 spike.n192 0.1445
R5114 spike.n285 spike.n192 0.1445
R5115 spike.n286 spike.n285 0.1445
R5116 spike.n287 spike.n286 0.1445
R5117 spike.n287 spike.n180 0.1445
R5118 spike.n301 spike.n180 0.1445
R5119 spike.n302 spike.n301 0.1445
R5120 spike.n303 spike.n302 0.1445
R5121 spike.n303 spike.n168 0.1445
R5122 spike.n317 spike.n168 0.1445
R5123 spike.n318 spike.n317 0.1445
R5124 spike.n319 spike.n318 0.1445
R5125 spike.n319 spike.n156 0.1445
R5126 spike.n333 spike.n156 0.1445
R5127 spike.n334 spike.n333 0.1445
R5128 spike.n335 spike.n334 0.1445
R5129 spike.n335 spike.n144 0.1445
R5130 spike.n349 spike.n144 0.1445
R5131 spike.n350 spike.n349 0.1445
R5132 spike.n351 spike.n350 0.1445
R5133 spike.n236 spike.n227 0.1445
R5134 spike.n240 spike.n227 0.1445
R5135 spike.n240 spike.n217 0.1445
R5136 spike.n252 spike.n217 0.1445
R5137 spike.n252 spike.n215 0.1445
R5138 spike.n256 spike.n215 0.1445
R5139 spike.n256 spike.n205 0.1445
R5140 spike.n268 spike.n205 0.1445
R5141 spike.n268 spike.n203 0.1445
R5142 spike.n272 spike.n203 0.1445
R5143 spike.n272 spike.n193 0.1445
R5144 spike.n284 spike.n193 0.1445
R5145 spike.n284 spike.n191 0.1445
R5146 spike.n288 spike.n191 0.1445
R5147 spike.n288 spike.n181 0.1445
R5148 spike.n300 spike.n181 0.1445
R5149 spike.n300 spike.n179 0.1445
R5150 spike.n304 spike.n179 0.1445
R5151 spike.n304 spike.n169 0.1445
R5152 spike.n316 spike.n169 0.1445
R5153 spike.n316 spike.n167 0.1445
R5154 spike.n320 spike.n167 0.1445
R5155 spike.n320 spike.n157 0.1445
R5156 spike.n332 spike.n157 0.1445
R5157 spike.n332 spike.n155 0.1445
R5158 spike.n336 spike.n155 0.1445
R5159 spike.n336 spike.n145 0.1445
R5160 spike.n348 spike.n145 0.1445
R5161 spike.n348 spike.n143 0.1445
R5162 spike.n352 spike.n143 0.1445
R5163 spike.n352 spike.n133 0.1445
R5164 spike.n364 spike.n133 0.1445
R5165 spike.n364 spike.n119 0.1445
R5166 spike.n368 spike.n119 0.1445
R5167 spike.n368 spike.n109 0.1445
R5168 spike.n380 spike.n109 0.1445
R5169 spike.n380 spike.n107 0.1445
R5170 spike.n384 spike.n107 0.1445
R5171 spike.n384 spike.n97 0.1445
R5172 spike.n396 spike.n97 0.1445
R5173 spike.n396 spike.n95 0.1445
R5174 spike.n403 spike.n95 0.1445
R5175 spike.n403 spike.n402 0.1445
R5176 spike.n402 spike.n85 0.1445
R5177 spike.n417 spike.n85 0.1445
R5178 spike.n418 spike.n417 0.1445
R5179 spike.n418 spike.n83 0.1445
R5180 spike.n422 spike.n83 0.1445
R5181 spike.n424 spike.n422 0.1445
R5182 spike.n425 spike.n424 0.1445
R5183 spike.n425 spike.n80 0.1445
R5184 spike.n441 spike.n80 0.1445
R5185 spike.n441 spike.n440 0.1445
R5186 spike.n440 spike.n439 0.1445
R5187 spike.n439 spike.n437 0.1445
R5188 spike.n437 spike.n436 0.1445
R5189 spike.n436 spike.n32 0.1445
R5190 spike.n492 spike.n32 0.1445
R5191 spike.n492 spike.n491 0.1445
R5192 spike.n491 spike.n490 0.1445
R5193 spike.n490 spike.n489 0.1445
R5194 spike.n489 spike.n37 0.1445
R5195 spike.n127 spike.n37 0.1445
R5196 spike.n472 spike.n470 0.1445
R5197 spike.n471 spike.n25 0.1445
R5198 spike.n125 spike.n124 0.130837
R5199 spike.n575 spike.n560 0.111183
R5200 spike.n559 spike.n558 0.111183
R5201 spike.n522 spike.n3 0.108765
R5202 spike.n456 spike.n29 0.102798
R5203 spike.n502 spike.n501 0.102798
R5204 spike.n500 spike.n499 0.102798
R5205 spike.n132 vss 0.0806
R5206 spike.n365 spike.n132 0.0725
R5207 spike.n516 spike.n515 0.0718661
R5208 spike.n515 spike.n514 0.0718661
R5209 spike.n512 spike.n3 0.0671
R5210 spike.n71 spike.n3 0.0599
R5211 spike.n558 vss 0.0577669
R5212 vss spike.n576 0.0507793
R5213 spike.n351 spike.n132 0.0365
R5214 spike.n124 spike.n123 0.0363271
R5215 spike.n123 spike.n122 0.0077
R5216 spike.n576 spike.n575 0.00748758
R5217 spike.n121 spike.n120 0.00641376
R5218 spike.n125 spike.n120 0.00641376
R5219 spike.n122 vss 0.00347
C0 Unnamed_89a8896a_2/a_64_n131# Unnamed_89a8896a_2/a_n64_n339# 0.67458f
C1 spike.n0 vss 0.00363f
C2 spike.n1 vss 0.00213f
C3 spike.n2 vss 0.0729f
C4 spike.n3 vss 0.06147f
C5 spike.n4 vss 0
C6 spike.n5 vss 0.00122f
C7 spike.n6 vss 0.01127f
C8 spike.n7 vss 0
C9 spike.n8 vss 0
C10 spike.n9 vss 0.00649f
C11 spike.n10 vss 0
C12 spike.n11 vss 0
C13 spike.n12 vss 0
C14 spike.n13 vss 0
C15 spike.n14 vss 0
C16 spike.n15 vss 0
C17 spike.n16 vss 0
C18 spike.n17 vss 0
C19 spike.n18 vss 0
C20 spike.n19 vss 0.00906f
C21 spike.n20 vss 0
C22 spike.n21 vss 0
C23 spike.n22 vss 0.01127f
C24 spike.n23 vss 0
C25 spike.n24 vss 0
C26 spike.n25 vss 0
C27 spike.n26 vss 0.00364f
C28 spike.n27 vss 0
C29 spike.n28 vss 0.00325f
C30 spike.n29 vss 0.01479f
C31 spike.n30 vss 0.01111f
C32 spike.n31 vss 0
C33 spike.n32 vss 0
C34 spike.n33 vss 0
C35 spike.n34 vss 0
C36 spike.n35 vss 0
C37 spike.n36 vss 0
C38 spike.n37 vss 0
C39 spike.n38 vss 0
C40 spike.n39 vss 0.00649f
C41 spike.n40 vss 0.00649f
C42 spike.n41 vss 0
C43 spike.n42 vss 0.0013f
C44 spike.n43 vss 0.00906f
C45 spike.n44 vss 0.0179f
C46 spike.n45 vss 0
C47 spike.n46 vss 0.00649f
C48 spike.n47 vss 0
C49 spike.n48 vss 0
C50 spike.n49 vss 0
C51 spike.n50 vss 0
C52 spike.n51 vss 0
C53 spike.n52 vss 0
C54 spike.n53 vss 0
C55 spike.n54 vss 0
C56 spike.n55 vss 0.01062f
C57 spike.n56 vss 0
C58 spike.n57 vss 0
C59 spike.n58 vss 0.00649f
C60 spike.n59 vss 0.00122f
C61 spike.n60 vss 0
C62 spike.n61 vss 0.00364f
C63 spike.n62 vss 0
C64 spike.n63 vss 0.00122f
C65 spike.n64 vss 0
C66 spike.n65 vss 0.00649f
C67 spike.n66 vss 0
C68 spike.n67 vss 0
C69 spike.n68 vss 0
C70 spike.n69 vss 0
C71 spike.n70 vss 0
C72 spike.n71 vss 0
C73 spike.n72 vss 0
C74 spike.n73 vss 0
C75 spike.n74 vss 0
C76 spike.n75 vss 0.00754f
C77 spike.n76 vss 0
C78 spike.n77 vss 0.00649f
C79 spike.n78 vss 0.00778f
C80 spike.n79 vss 0
C81 spike.n80 vss 0
C82 spike.n81 vss 0
C83 spike.n82 vss 0
C84 spike.n83 vss 0
C85 spike.n84 vss 0
C86 spike.n85 vss 0
C87 spike.n86 vss 0
C88 spike.n87 vss 0.02003f
C89 spike.n88 vss 0
C90 spike.n89 vss 0
C91 spike.n90 vss 0
C92 spike.n91 vss 0
C93 spike.n92 vss 0
C94 spike.n93 vss 0.02003f
C95 spike.n94 vss 0
C96 spike.n95 vss 0
C97 spike.n96 vss 0
C98 spike.n97 vss 0
C99 spike.n98 vss 0
C100 spike.n99 vss 0.02003f
C101 spike.n100 vss 0
C102 spike.n101 vss 0
C103 spike.n102 vss 0
C104 spike.n103 vss 0
C105 spike.n104 vss 0
C106 spike.n105 vss 0.02003f
C107 spike.n106 vss 0
C108 spike.n107 vss 0
C109 spike.n108 vss 0
C110 spike.n109 vss 0
C111 spike.n110 vss 0
C112 spike.n111 vss 0.02003f
C113 spike.n112 vss 0
C114 spike.n113 vss 0
C115 spike.n114 vss 0
C116 spike.n115 vss 0
C117 spike.n116 vss 0
C118 spike.n117 vss 0.02003f
C119 spike.n118 vss 0
C120 spike.n119 vss 0
C121 spike.n120 vss 0.00895f
C122 spike.n121 vss 0.0622f
C123 spike.n122 vss 0.00519f
C124 spike.n123 vss 0.02728f
C125 spike.n124 vss 0.05946f
C126 spike.n125 vss 0.07412f
C127 spike.n126 vss 0
C128 spike.n127 vss 0
C129 spike.n128 vss 0
C130 spike.n129 vss 0.00141f
C131 spike.n130 vss 0.0186f
C132 spike.n131 vss 0.00963f
C133 spike.n132 vss 0
C134 spike.n133 vss 0
C135 spike.n134 vss 0
C136 spike.n135 vss 0.02003f
C137 spike.n136 vss 0
C138 spike.n137 vss 0
C139 spike.n138 vss 0
C140 spike.n139 vss 0
C141 spike.n140 vss 0
C142 spike.n141 vss 0.02003f
C143 spike.n142 vss 0
C144 spike.n143 vss 0
C145 spike.n144 vss 0
C146 spike.n145 vss 0
C147 spike.n146 vss 0
C148 spike.n147 vss 0.02003f
C149 spike.n148 vss 0
C150 spike.n149 vss 0
C151 spike.n150 vss 0
C152 spike.n151 vss 0
C153 spike.n152 vss 0
C154 spike.n153 vss 0.02003f
C155 spike.n154 vss 0
C156 spike.n155 vss 0
C157 spike.n156 vss 0
C158 spike.n157 vss 0
C159 spike.n158 vss 0
C160 spike.n159 vss 0.02003f
C161 spike.n160 vss 0
C162 spike.n161 vss 0
C163 spike.n162 vss 0
C164 spike.n163 vss 0
C165 spike.n164 vss 0
C166 spike.n165 vss 0.02003f
C167 spike.n166 vss 0
C168 spike.n167 vss 0
C169 spike.n168 vss 0
C170 spike.n169 vss 0
C171 spike.n170 vss 0
C172 spike.n171 vss 0.02003f
C173 spike.n172 vss 0
C174 spike.n173 vss 0
C175 spike.n174 vss 0
C176 spike.n175 vss 0
C177 spike.n176 vss 0
C178 spike.n177 vss 0.02003f
C179 spike.n178 vss 0
C180 spike.n179 vss 0
C181 spike.n180 vss 0
C182 spike.n181 vss 0
C183 spike.n182 vss 0
C184 spike.n183 vss 0.02003f
C185 spike.n184 vss 0
C186 spike.n185 vss 0
C187 spike.n186 vss 0
C188 spike.n187 vss 0
C189 spike.n188 vss 0
C190 spike.n189 vss 0.02003f
C191 spike.n190 vss 0
C192 spike.n191 vss 0
C193 spike.n192 vss 0
C194 spike.n193 vss 0
C195 spike.n194 vss 0
C196 spike.n195 vss 0.02003f
C197 spike.n196 vss 0
C198 spike.n197 vss 0
C199 spike.n198 vss 0
C200 spike.n199 vss 0
C201 spike.n200 vss 0
C202 spike.n201 vss 0.02003f
C203 spike.n202 vss 0
C204 spike.n203 vss 0
C205 spike.n204 vss 0
C206 spike.n205 vss 0
C207 spike.n206 vss 0
C208 spike.n207 vss 0.02003f
C209 spike.n208 vss 0
C210 spike.n209 vss 0
C211 spike.n210 vss 0
C212 spike.n211 vss 0
C213 spike.n212 vss 0
C214 spike.n213 vss 0.02003f
C215 spike.n214 vss 0
C216 spike.n215 vss 0
C217 spike.n216 vss 0
C218 spike.n217 vss 0
C219 spike.n218 vss 0
C220 spike.n219 vss 0.02003f
C221 spike.n220 vss 0
C222 spike.n221 vss 0
C223 spike.n222 vss 0
C224 spike.n223 vss 0
C225 spike.n224 vss 0
C226 spike.n225 vss 0.02003f
C227 spike.n226 vss 0
C228 spike.n227 vss 0
C229 spike.n228 vss 0.00244f
C230 spike.n229 vss 0.07849f
C231 spike.n230 vss 0
C232 spike.n231 vss 0
C233 spike.n232 vss 0
C234 spike.n234 vss 0.02621f
C235 spike.n235 vss 0
C236 spike.n236 vss 0
C237 spike.n237 vss 0
C238 spike.n238 vss 0
C239 spike.n239 vss 0
C240 spike.n240 vss 0
C241 spike.n241 vss 0
C242 spike.n242 vss 0.02003f
C243 spike.n243 vss 0
C244 spike.n244 vss 0
C245 spike.n245 vss 0
C246 spike.n246 vss 0
C247 spike.n247 vss 0
C248 spike.n248 vss 0
C249 spike.n249 vss 0
C250 spike.n250 vss 0.02003f
C251 spike.n251 vss 0
C252 spike.n252 vss 0
C253 spike.n253 vss 0
C254 spike.n254 vss 0
C255 spike.n255 vss 0
C256 spike.n256 vss 0
C257 spike.n257 vss 0
C258 spike.n258 vss 0.02003f
C259 spike.n259 vss 0
C260 spike.n260 vss 0
C261 spike.n261 vss 0
C262 spike.n262 vss 0
C263 spike.n263 vss 0
C264 spike.n264 vss 0
C265 spike.n265 vss 0
C266 spike.n266 vss 0.02003f
C267 spike.n267 vss 0
C268 spike.n268 vss 0
C269 spike.n269 vss 0
C270 spike.n270 vss 0
C271 spike.n271 vss 0
C272 spike.n272 vss 0
C273 spike.n273 vss 0
C274 spike.n274 vss 0.02003f
C275 spike.n275 vss 0
C276 spike.n276 vss 0
C277 spike.n277 vss 0
C278 spike.n278 vss 0
C279 spike.n279 vss 0
C280 spike.n280 vss 0
C281 spike.n281 vss 0
C282 spike.n282 vss 0.02003f
C283 spike.n283 vss 0
C284 spike.n284 vss 0
C285 spike.n285 vss 0
C286 spike.n286 vss 0
C287 spike.n287 vss 0
C288 spike.n288 vss 0
C289 spike.n289 vss 0
C290 spike.n290 vss 0.02003f
C291 spike.n291 vss 0
C292 spike.n292 vss 0
C293 spike.n293 vss 0
C294 spike.n294 vss 0
C295 spike.n295 vss 0
C296 spike.n296 vss 0
C297 spike.n297 vss 0
C298 spike.n298 vss 0.02003f
C299 spike.n299 vss 0
C300 spike.n300 vss 0
C301 spike.n301 vss 0
C302 spike.n302 vss 0
C303 spike.n303 vss 0
C304 spike.n304 vss 0
C305 spike.n305 vss 0
C306 spike.n306 vss 0.02003f
C307 spike.n307 vss 0
C308 spike.n308 vss 0
C309 spike.n309 vss 0
C310 spike.n310 vss 0
C311 spike.n311 vss 0
C312 spike.n312 vss 0
C313 spike.n313 vss 0
C314 spike.n314 vss 0.02003f
C315 spike.n315 vss 0
C316 spike.n316 vss 0
C317 spike.n317 vss 0
C318 spike.n318 vss 0
C319 spike.n319 vss 0
C320 spike.n320 vss 0
C321 spike.n321 vss 0
C322 spike.n322 vss 0.02003f
C323 spike.n323 vss 0
C324 spike.n324 vss 0
C325 spike.n325 vss 0
C326 spike.n326 vss 0
C327 spike.n327 vss 0
C328 spike.n328 vss 0
C329 spike.n329 vss 0
C330 spike.n330 vss 0.02003f
C331 spike.n331 vss 0
C332 spike.n332 vss 0
C333 spike.n333 vss 0
C334 spike.n334 vss 0
C335 spike.n335 vss 0
C336 spike.n336 vss 0
C337 spike.n337 vss 0
C338 spike.n338 vss 0.02003f
C339 spike.n339 vss 0
C340 spike.n340 vss 0
C341 spike.n341 vss 0
C342 spike.n342 vss 0
C343 spike.n343 vss 0
C344 spike.n344 vss 0
C345 spike.n345 vss 0
C346 spike.n346 vss 0.02003f
C347 spike.n347 vss 0
C348 spike.n348 vss 0
C349 spike.n349 vss 0
C350 spike.n350 vss 0
C351 spike.n351 vss 0
C352 spike.n352 vss 0
C353 spike.n353 vss 0
C354 spike.n354 vss 0.02003f
C355 spike.n355 vss 0
C356 spike.n356 vss 0
C357 spike.n357 vss 0
C358 spike.n358 vss 0
C359 spike.n359 vss 0
C360 spike.n360 vss 0
C361 spike.n361 vss 0
C362 spike.n362 vss 0.02003f
C363 spike.n363 vss 0
C364 spike.n364 vss 0
C365 spike.n365 vss 0
C366 spike.n366 vss 0
C367 spike.n367 vss 0
C368 spike.n368 vss 0
C369 spike.n369 vss 0
C370 spike.n370 vss 0.02003f
C371 spike.n371 vss 0
C372 spike.n372 vss 0
C373 spike.n373 vss 0
C374 spike.n374 vss 0
C375 spike.n375 vss 0
C376 spike.n376 vss 0
C377 spike.n377 vss 0
C378 spike.n378 vss 0.02003f
C379 spike.n379 vss 0
C380 spike.n380 vss 0
C381 spike.n381 vss 0
C382 spike.n382 vss 0
C383 spike.n383 vss 0
C384 spike.n384 vss 0
C385 spike.n385 vss 0
C386 spike.n386 vss 0.02003f
C387 spike.n387 vss 0
C388 spike.n388 vss 0
C389 spike.n389 vss 0
C390 spike.n390 vss 0
C391 spike.n391 vss 0
C392 spike.n392 vss 0
C393 spike.n393 vss 0
C394 spike.n394 vss 0.02003f
C395 spike.n395 vss 0
C396 spike.n396 vss 0
C397 spike.n397 vss 0
C398 spike.n398 vss 0
C399 spike.n399 vss 0
C400 spike.n400 vss 0
C401 spike.n401 vss 0
C402 spike.n402 vss 0
C403 spike.n403 vss 0
C404 spike.n404 vss 0
C405 spike.n405 vss 0.02003f
C406 spike.n406 vss 0
C407 spike.n407 vss 0
C408 spike.n408 vss 0
C409 spike.n409 vss 0
C410 spike.n410 vss 0
C411 spike.n411 vss 0
C412 spike.n412 vss 0
C413 spike.n413 vss 0
C414 spike.n414 vss 0.02003f
C415 spike.n415 vss 0
C416 spike.n416 vss 0
C417 spike.n417 vss 0
C418 spike.n418 vss 0
C419 spike.n419 vss 0
C420 spike.n420 vss 0
C421 spike.n421 vss 0
C422 spike.n422 vss 0
C423 spike.n423 vss 0
C424 spike.n424 vss 0
C425 spike.n425 vss 0
C426 spike.n426 vss 0
C427 spike.n427 vss 0
C428 spike.n428 vss 0
C429 spike.n429 vss 0
C430 spike.n430 vss 0
C431 spike.n431 vss 0
C432 spike.n432 vss 0
C433 spike.n433 vss 0
C434 spike.n434 vss 0.00665f
C435 spike.n435 vss 0
C436 spike.n436 vss 0
C437 spike.n437 vss 0
C438 spike.n438 vss 0
C439 spike.n439 vss 0
C440 spike.n440 vss 0
C441 spike.n441 vss 0
C442 spike.n442 vss 0
C443 spike.n443 vss 0.00673f
C444 spike.n444 vss 0
C445 spike.n445 vss 0
C446 spike.n446 vss 0
C447 spike.n447 vss 0
C448 spike.n448 vss 0
C449 spike.n449 vss 0.01127f
C450 spike.n450 vss 0.00649f
C451 spike.n451 vss 0
C452 spike.n452 vss 0
C453 spike.n453 vss 0
C454 spike.n454 vss 0
C455 spike.n455 vss 0.00214f
C456 spike.n456 vss 0.00683f
C457 spike.n457 vss 0
C458 spike.n458 vss 0
C459 spike.n459 vss 0.00649f
C460 spike.n460 vss 0.00713f
C461 spike.n461 vss 0
C462 spike.n462 vss 0
C463 spike.n463 vss 0
C464 spike.n464 vss 0
C465 spike.n465 vss 0
C466 spike.n466 vss 0.00373f
C467 spike.n467 vss 0.01845f
C468 spike.n468 vss 0.02187f
C469 spike.n469 vss 0.03738f
C470 spike.n470 vss 0
C471 spike.n471 vss 0
C472 spike.n472 vss 0
C473 spike.n473 vss 0
C474 spike.n474 vss 0
C475 spike.n475 vss 0.00122f
C476 spike.n476 vss 0.0615f
C477 spike.n477 vss 0.01127f
C478 spike.n478 vss 0
C479 spike.n479 vss 0
C480 spike.n480 vss 0
C481 spike.n481 vss 0
C482 spike.n482 vss 0
C483 spike.n483 vss 0
C484 spike.n484 vss 0
C485 spike.n485 vss 0
C486 spike.n486 vss 0.00649f
C487 spike.n487 vss 0
C488 spike.n488 vss 0
C489 spike.n489 vss 0
C490 spike.n490 vss 0
C491 spike.n491 vss 0
C492 spike.n492 vss 0
C493 spike.n493 vss 0
C494 spike.n494 vss 0.00778f
C495 spike.n495 vss 0.00649f
C496 spike.n496 vss 0.00122f
C497 spike.n497 vss 0
C498 spike.n498 vss 0
C499 spike.n499 vss 0.00683f
C500 spike.n500 vss 0.00899f
C501 spike.n501 vss 0.01286f
C502 spike.n502 vss 0.00683f
C503 spike.n503 vss 0.00214f
C504 spike.n504 vss 0.00122f
C505 spike.n505 vss 0.00649f
C506 spike.n506 vss 0.00722f
C507 spike.n507 vss 0.00705f
C508 spike.n508 vss 0
C509 spike.n509 vss 0
C510 spike.n510 vss 0
C511 spike.n511 vss 0
C512 spike.n512 vss 0
C513 spike.n513 vss 0
C514 spike.n514 vss 0
C515 spike.n516 vss 0
C516 spike.n517 vss 0
C517 spike.n518 vss 0.00649f
C518 spike.n519 vss 0.00649f
C519 spike.n520 vss 0
C520 spike.n521 vss 0
C521 spike.n522 vss 0.00907f
C522 spike.n523 vss 0.00364f
C523 spike.n524 vss 0.00214f
C524 spike.n525 vss 0.00364f
C525 spike.n526 vss 0.00214f
C526 spike.n527 vss 0
C527 spike.n528 vss 0.00122f
C528 spike.n529 vss 0.00672f
C529 spike.n530 vss 0
C530 spike.n531 vss 0
C531 spike.n532 vss 0
C532 spike.n533 vss 0
C533 spike.n534 vss 0
C534 spike.n535 vss 0
C535 spike.n536 vss 0.00122f
C536 spike.n537 vss 0.00971f
C537 spike.n538 vss 0.00672f
C538 spike.n539 vss 0
C539 spike.n540 vss 0
C540 spike.n541 vss 0.01099f
C541 spike.n542 vss 0.00364f
C542 spike.n543 vss 0.00214f
C543 spike.n544 vss 0
C544 spike.n545 vss 0.00122f
C545 spike.n546 vss 0.00122f
C546 spike.n547 vss 0
C547 spike.n548 vss 0
C548 spike.n549 vss 0
C549 spike.n550 vss 0
C550 spike.n551 vss 0
C551 spike.n552 vss 0
C552 spike.n553 vss 0.00672f
C553 spike.n554 vss 0.00971f
C554 spike.n555 vss 0.00672f
C555 spike.n556 vss 0
C556 spike.n557 vss 0
C557 spike.n558 vss 0.0158f
C558 spike.n559 vss 0.01393f
C559 spike.n560 vss 0.01152f
C560 spike.n561 vss 0
C561 spike.n562 vss 0.00122f
C562 spike.n563 vss 0.00122f
C563 spike.n564 vss 0
C564 spike.n565 vss 0
C565 spike.n566 vss 0
C566 spike.n567 vss 0
C567 spike.n568 vss 0
C568 spike.n569 vss 0
C569 spike.n570 vss 0.00672f
C570 spike.n571 vss 0.00971f
C571 spike.n572 vss 0.00672f
C572 spike.n573 vss 0
C573 spike.n574 vss 0
C574 spike.n575 vss 0.00675f
C575 spike.n576 vss 0.00523f
C576 spike_neg.n0 vss 0.00558f
C577 spike_neg.n1 vss 0.00327f
C578 spike_neg.n2 vss 0.00558f
C579 spike_neg.n3 vss 0.00327f
C580 spike_neg.n4 vss 0.00116f
C581 spike_neg.n5 vss 0.00187f
C582 spike_neg.n6 vss 0.01029f
C583 spike_neg.n7 vss 0.00116f
C584 spike_neg.n8 vss 0
C585 spike_neg.n9 vss 0.00147f
C586 spike_neg.n10 vss 0.00147f
C587 spike_neg.n11 vss 0
C588 spike_neg.n12 vss 0.00116f
C589 spike_neg.n13 vss 0.00187f
C590 spike_neg.n14 vss 0.01488f
C591 spike_neg.n15 vss 0.01029f
C592 spike_neg.n16 vss 0.00116f
C593 spike_neg.n17 vss 0
C594 spike_neg.n18 vss 0.01684f
C595 spike_neg.n19 vss 0.00558f
C596 spike_neg.n20 vss 0.00327f
C597 spike_neg.n21 vss 0.00116f
C598 spike_neg.n22 vss 0.00187f
C599 spike_neg.n23 vss 0.00187f
C600 spike_neg.n24 vss 0.00116f
C601 spike_neg.n25 vss 0
C602 spike_neg.n26 vss 0.00147f
C603 spike_neg.n27 vss 0.00147f
C604 spike_neg.n28 vss 0
C605 spike_neg.n29 vss 0.00116f
C606 spike_neg.n30 vss 0.01029f
C607 spike_neg.n31 vss 0.01488f
C608 spike_neg.n32 vss 0.01029f
C609 spike_neg.n33 vss 0.00116f
C610 spike_neg.n34 vss 0
C611 spike_neg.n35 vss 0.00556f
C612 spike_neg.n36 vss 0.00326f
C613 spike_neg.n37 vss 0.11168f
C614 spike_neg.n38 vss 0.09417f
C615 spike_neg.n39 vss 0.00116f
C616 spike_neg.n40 vss 0.00187f
C617 spike_neg.n41 vss 0.01726f
C618 spike_neg.n42 vss 0.00116f
C619 spike_neg.n43 vss 0
C620 spike_neg.n44 vss 0.00994f
C621 spike_neg.n45 vss 0
C622 spike_neg.n46 vss 0
C623 spike_neg.n47 vss 0
C624 spike_neg.n48 vss 0
C625 spike_neg.n49 vss 0
C626 spike_neg.n50 vss 0
C627 spike_neg.n51 vss 0
C628 spike_neg.n52 vss 0
C629 spike_neg.n53 vss 0
C630 spike_neg.n54 vss 0.01388f
C631 spike_neg.n55 vss 0
C632 spike_neg.n56 vss 0
C633 spike_neg.n57 vss 0.01726f
C634 spike_neg.n58 vss 0.00116f
C635 spike_neg.n59 vss 0.00116f
C636 spike_neg.n60 vss 0.00147f
C637 spike_neg.n61 vss 0.00558f
C638 spike_neg.n62 vss 0
C639 spike_neg.n63 vss 0.00498f
C640 spike_neg.n64 vss 0.02265f
C641 spike_neg.n65 vss 0.01702f
C642 spike_neg.n66 vss 0
C643 spike_neg.n67 vss 0
C644 spike_neg.n68 vss 0
C645 spike_neg.n69 vss 0
C646 spike_neg.n70 vss 0
C647 spike_neg.n71 vss 0
C648 spike_neg.n72 vss 0
C649 spike_neg.n73 vss 0.00123f
C650 spike_neg.n74 vss 0.00994f
C651 spike_neg.n75 vss 0.00994f
C652 spike_neg.n76 vss 0
C653 spike_neg.n77 vss 0.00199f
C654 spike_neg.n78 vss 0.01388f
C655 spike_neg.n79 vss 0.02742f
C656 spike_neg.n80 vss 0
C657 spike_neg.n81 vss 0.00994f
C658 spike_neg.n82 vss 0
C659 spike_neg.n83 vss 0
C660 spike_neg.n84 vss 0
C661 spike_neg.n85 vss 0
C662 spike_neg.n86 vss 0
C663 spike_neg.n87 vss 0
C664 spike_neg.n88 vss 0
C665 spike_neg.n89 vss 0
C666 spike_neg.n90 vss 0.01627f
C667 spike_neg.n91 vss 0
C668 spike_neg.n92 vss 0.00116f
C669 spike_neg.n93 vss 0.00994f
C670 spike_neg.n94 vss 0.00187f
C671 spike_neg.n95 vss 0.00116f
C672 spike_neg.n96 vss 0.00558f
C673 spike_neg.n97 vss 0.00153f
C674 spike_neg.n98 vss 0.00187f
C675 spike_neg.n99 vss 0
C676 spike_neg.n100 vss 0.00994f
C677 spike_neg.n101 vss 0
C678 spike_neg.n102 vss 0
C679 spike_neg.n103 vss 0
C680 spike_neg.n104 vss 0
C681 spike_neg.n105 vss 0
C682 spike_neg.n106 vss 0
C683 spike_neg.n107 vss 0
C684 spike_neg.n108 vss 0
C685 spike_neg.n109 vss 0
C686 spike_neg.n110 vss 0.01155f
C687 spike_neg.n111 vss 0
C688 spike_neg.n112 vss 0.00994f
C689 spike_neg.n113 vss 0.01192f
C690 spike_neg.n114 vss 0
C691 spike_neg.n115 vss 0
C692 spike_neg.n116 vss 0
C693 spike_neg.n117 vss 0
C694 spike_neg.n118 vss 0
C695 spike_neg.n119 vss 0
C696 spike_neg.n120 vss 0
C697 spike_neg.n121 vss 0
C698 spike_neg.n122 vss 0.03068f
C699 spike_neg.n123 vss 0
C700 spike_neg.n124 vss 0
C701 spike_neg.n125 vss 0
C702 spike_neg.n126 vss 0
C703 spike_neg.n127 vss 0
C704 spike_neg.n128 vss 0.03068f
C705 spike_neg.n129 vss 0
C706 spike_neg.n130 vss 0
C707 spike_neg.n131 vss 0
C708 spike_neg.n132 vss 0
C709 spike_neg.n133 vss 0
C710 spike_neg.n134 vss 0.03068f
C711 spike_neg.n135 vss 0
C712 spike_neg.n136 vss 0
C713 spike_neg.n137 vss 0
C714 spike_neg.n138 vss 0
C715 spike_neg.n139 vss 0
C716 spike_neg.n140 vss 0.03068f
C717 spike_neg.n141 vss 0
C718 spike_neg.n142 vss 0
C719 spike_neg.n143 vss 0
C720 spike_neg.n144 vss 0
C721 spike_neg.n145 vss 0
C722 spike_neg.n146 vss 0.03068f
C723 spike_neg.n147 vss 0
C724 spike_neg.n148 vss 0
C725 spike_neg.n149 vss 0
C726 spike_neg.n150 vss 0
C727 spike_neg.n151 vss 0
C728 spike_neg.n152 vss 0.03068f
C729 spike_neg.n153 vss 0
C730 spike_neg.n154 vss 0
C731 spike_neg.n155 vss 0.01371f
C732 spike_neg.n156 vss 0.09529f
C733 spike_neg.n157 vss 0.00795f
C734 spike_neg.n158 vss 0.0418f
C735 spike_neg.n159 vss 0.09109f
C736 spike_neg.n160 vss 0.11355f
C737 spike_neg.n161 vss 0
C738 spike_neg.n162 vss 0
C739 spike_neg.n163 vss 0.00136f
C740 spike_neg.n164 vss 0.00216f
C741 spike_neg.n165 vss 0.02849f
C742 spike_neg.n166 vss 0.01475f
C743 spike_neg.n167 vss 0.00119f
C744 spike_neg.n168 vss 0
C745 spike_neg.n169 vss 0
C746 spike_neg.n170 vss 0.03068f
C747 spike_neg.n171 vss 0
C748 spike_neg.n172 vss 0
C749 spike_neg.n173 vss 0
C750 spike_neg.n174 vss 0
C751 spike_neg.n175 vss 0
C752 spike_neg.n176 vss 0.03068f
C753 spike_neg.n177 vss 0
C754 spike_neg.n178 vss 0
C755 spike_neg.n179 vss 0
C756 spike_neg.n180 vss 0
C757 spike_neg.n181 vss 0
C758 spike_neg.n182 vss 0.03068f
C759 spike_neg.n183 vss 0
C760 spike_neg.n184 vss 0
C761 spike_neg.n185 vss 0
C762 spike_neg.n186 vss 0
C763 spike_neg.n187 vss 0
C764 spike_neg.n188 vss 0.03068f
C765 spike_neg.n189 vss 0
C766 spike_neg.n190 vss 0
C767 spike_neg.n191 vss 0
C768 spike_neg.n192 vss 0
C769 spike_neg.n193 vss 0
C770 spike_neg.n194 vss 0.03068f
C771 spike_neg.n195 vss 0
C772 spike_neg.n196 vss 0
C773 spike_neg.n197 vss 0
C774 spike_neg.n198 vss 0
C775 spike_neg.n199 vss 0
C776 spike_neg.n200 vss 0.03068f
C777 spike_neg.n201 vss 0
C778 spike_neg.n202 vss 0
C779 spike_neg.n203 vss 0
C780 spike_neg.n204 vss 0
C781 spike_neg.n205 vss 0
C782 spike_neg.n206 vss 0.03068f
C783 spike_neg.n207 vss 0
C784 spike_neg.n208 vss 0
C785 spike_neg.n209 vss 0
C786 spike_neg.n210 vss 0
C787 spike_neg.n211 vss 0
C788 spike_neg.n212 vss 0.03068f
C789 spike_neg.n213 vss 0
C790 spike_neg.n214 vss 0
C791 spike_neg.n215 vss 0
C792 spike_neg.n216 vss 0
C793 spike_neg.n217 vss 0
C794 spike_neg.n218 vss 0.03068f
C795 spike_neg.n219 vss 0
C796 spike_neg.n220 vss 0
C797 spike_neg.n221 vss 0
C798 spike_neg.n222 vss 0
C799 spike_neg.n223 vss 0
C800 spike_neg.n224 vss 0.03068f
C801 spike_neg.n225 vss 0
C802 spike_neg.n226 vss 0
C803 spike_neg.n227 vss 0
C804 spike_neg.n228 vss 0
C805 spike_neg.n229 vss 0
C806 spike_neg.n230 vss 0.03068f
C807 spike_neg.n231 vss 0
C808 spike_neg.n232 vss 0
C809 spike_neg.n233 vss 0
C810 spike_neg.n234 vss 0
C811 spike_neg.n235 vss 0
C812 spike_neg.n236 vss 0.03068f
C813 spike_neg.n237 vss 0
C814 spike_neg.n238 vss 0
C815 spike_neg.n239 vss 0
C816 spike_neg.n240 vss 0
C817 spike_neg.n241 vss 0
C818 spike_neg.n242 vss 0.03068f
C819 spike_neg.n243 vss 0
C820 spike_neg.n244 vss 0
C821 spike_neg.n245 vss 0
C822 spike_neg.n246 vss 0
C823 spike_neg.n247 vss 0
C824 spike_neg.n248 vss 0.03068f
C825 spike_neg.n249 vss 0
C826 spike_neg.n250 vss 0
C827 spike_neg.n251 vss 0
C828 spike_neg.n252 vss 0
C829 spike_neg.n253 vss 0
C830 spike_neg.n254 vss 0.03068f
C831 spike_neg.n255 vss 0
C832 spike_neg.n256 vss 0
C833 spike_neg.n257 vss 0
C834 spike_neg.n258 vss 0
C835 spike_neg.n259 vss 0
C836 spike_neg.n260 vss 0.03068f
C837 spike_neg.n261 vss 0
C838 spike_neg.n262 vss 0
C839 spike_neg.n263 vss 0.00373f
C840 spike_neg.n264 vss 0.12024f
C841 spike_neg.n265 vss 0.00142f
C842 spike_neg.n266 vss 0
C843 spike_neg.n267 vss 0.00123f
C844 spike_neg.n269 vss 0.04015f
C845 spike_neg.n270 vss 0.00123f
C846 spike_neg.n271 vss 0
C847 spike_neg.n272 vss 0.00142f
C848 spike_neg.n273 vss 0
C849 spike_neg.n274 vss 0
C850 spike_neg.n275 vss 0
C851 spike_neg.n276 vss 0
C852 spike_neg.n277 vss 0.03068f
C853 spike_neg.n278 vss 0
C854 spike_neg.n279 vss 0
C855 spike_neg.n280 vss 0
C856 spike_neg.n281 vss 0
C857 spike_neg.n282 vss 0
C858 spike_neg.n283 vss 0
C859 spike_neg.n284 vss 0
C860 spike_neg.n285 vss 0.03068f
C861 spike_neg.n286 vss 0
C862 spike_neg.n287 vss 0
C863 spike_neg.n288 vss 0
C864 spike_neg.n289 vss 0
C865 spike_neg.n290 vss 0
C866 spike_neg.n291 vss 0
C867 spike_neg.n292 vss 0
C868 spike_neg.n293 vss 0.03068f
C869 spike_neg.n294 vss 0
C870 spike_neg.n295 vss 0
C871 spike_neg.n296 vss 0
C872 spike_neg.n297 vss 0
C873 spike_neg.n298 vss 0
C874 spike_neg.n299 vss 0
C875 spike_neg.n300 vss 0
C876 spike_neg.n301 vss 0.03068f
C877 spike_neg.n302 vss 0
C878 spike_neg.n303 vss 0
C879 spike_neg.n304 vss 0
C880 spike_neg.n305 vss 0
C881 spike_neg.n306 vss 0
C882 spike_neg.n307 vss 0
C883 spike_neg.n308 vss 0
C884 spike_neg.n309 vss 0.03068f
C885 spike_neg.n310 vss 0
C886 spike_neg.n311 vss 0
C887 spike_neg.n312 vss 0
C888 spike_neg.n313 vss 0
C889 spike_neg.n314 vss 0
C890 spike_neg.n315 vss 0
C891 spike_neg.n316 vss 0
C892 spike_neg.n317 vss 0.03068f
C893 spike_neg.n318 vss 0
C894 spike_neg.n319 vss 0
C895 spike_neg.n320 vss 0
C896 spike_neg.n321 vss 0
C897 spike_neg.n322 vss 0
C898 spike_neg.n323 vss 0
C899 spike_neg.n324 vss 0
C900 spike_neg.n325 vss 0.03068f
C901 spike_neg.n326 vss 0
C902 spike_neg.n327 vss 0
C903 spike_neg.n328 vss 0
C904 spike_neg.n329 vss 0
C905 spike_neg.n330 vss 0
C906 spike_neg.n331 vss 0
C907 spike_neg.n332 vss 0
C908 spike_neg.n333 vss 0.03068f
C909 spike_neg.n334 vss 0
C910 spike_neg.n335 vss 0
C911 spike_neg.n336 vss 0
C912 spike_neg.n337 vss 0
C913 spike_neg.n338 vss 0
C914 spike_neg.n339 vss 0
C915 spike_neg.n340 vss 0
C916 spike_neg.n341 vss 0.03068f
C917 spike_neg.n342 vss 0
C918 spike_neg.n343 vss 0
C919 spike_neg.n344 vss 0
C920 spike_neg.n345 vss 0
C921 spike_neg.n346 vss 0
C922 spike_neg.n347 vss 0
C923 spike_neg.n348 vss 0
C924 spike_neg.n349 vss 0.03068f
C925 spike_neg.n350 vss 0
C926 spike_neg.n351 vss 0
C927 spike_neg.n352 vss 0
C928 spike_neg.n353 vss 0
C929 spike_neg.n354 vss 0
C930 spike_neg.n355 vss 0
C931 spike_neg.n356 vss 0
C932 spike_neg.n357 vss 0.03068f
C933 spike_neg.n358 vss 0
C934 spike_neg.n359 vss 0
C935 spike_neg.n360 vss 0
C936 spike_neg.n361 vss 0
C937 spike_neg.n362 vss 0
C938 spike_neg.n363 vss 0
C939 spike_neg.n364 vss 0
C940 spike_neg.n365 vss 0.03068f
C941 spike_neg.n366 vss 0
C942 spike_neg.n367 vss 0
C943 spike_neg.n368 vss 0
C944 spike_neg.n369 vss 0
C945 spike_neg.n370 vss 0
C946 spike_neg.n371 vss 0
C947 spike_neg.n372 vss 0
C948 spike_neg.n373 vss 0.03068f
C949 spike_neg.n374 vss 0
C950 spike_neg.n375 vss 0
C951 spike_neg.n376 vss 0
C952 spike_neg.n377 vss 0
C953 spike_neg.n378 vss 0
C954 spike_neg.n379 vss 0
C955 spike_neg.n380 vss 0
C956 spike_neg.n381 vss 0.03068f
C957 spike_neg.n382 vss 0
C958 spike_neg.n383 vss 0
C959 spike_neg.n384 vss 0
C960 spike_neg.n385 vss 0
C961 spike_neg.n386 vss 0
C962 spike_neg.n387 vss 0
C963 spike_neg.n388 vss 0
C964 spike_neg.n389 vss 0.03068f
C965 spike_neg.n390 vss 0
C966 spike_neg.n391 vss 0
C967 spike_neg.n392 vss 0
C968 spike_neg.n393 vss 0
C969 spike_neg.n394 vss 0
C970 spike_neg.n395 vss 0
C971 spike_neg.n396 vss 0
C972 spike_neg.n397 vss 0.03068f
C973 spike_neg.n398 vss 0
C974 spike_neg.n399 vss 0
C975 spike_neg.n400 vss 0
C976 spike_neg.n401 vss 0
C977 spike_neg.n402 vss 0
C978 spike_neg.n403 vss 0
C979 spike_neg.n404 vss 0
C980 spike_neg.n405 vss 0.03068f
C981 spike_neg.n406 vss 0
C982 spike_neg.n407 vss 0
C983 spike_neg.n408 vss 0
C984 spike_neg.n409 vss 0
C985 spike_neg.n410 vss 0
C986 spike_neg.n411 vss 0
C987 spike_neg.n412 vss 0
C988 spike_neg.n413 vss 0.03068f
C989 spike_neg.n414 vss 0
C990 spike_neg.n415 vss 0
C991 spike_neg.n416 vss 0
C992 spike_neg.n417 vss 0
C993 spike_neg.n418 vss 0
C994 spike_neg.n419 vss 0
C995 spike_neg.n420 vss 0
C996 spike_neg.n421 vss 0.03068f
C997 spike_neg.n422 vss 0
C998 spike_neg.n423 vss 0
C999 spike_neg.n424 vss 0
C1000 spike_neg.n425 vss 0
C1001 spike_neg.n426 vss 0
C1002 spike_neg.n427 vss 0
C1003 spike_neg.n428 vss 0
C1004 spike_neg.n429 vss 0.03068f
C1005 spike_neg.n430 vss 0
C1006 spike_neg.n431 vss 0
C1007 spike_neg.n432 vss 0
C1008 spike_neg.n433 vss 0
C1009 spike_neg.n434 vss 0
C1010 spike_neg.n435 vss 0
C1011 spike_neg.n436 vss 0
C1012 spike_neg.n437 vss 0
C1013 spike_neg.n438 vss 0
C1014 spike_neg.n439 vss 0
C1015 spike_neg.n440 vss 0.03068f
C1016 spike_neg.n441 vss 0
C1017 spike_neg.n442 vss 0
C1018 spike_neg.n443 vss 0
C1019 spike_neg.n444 vss 0
C1020 spike_neg.n445 vss 0
C1021 spike_neg.n446 vss 0
C1022 spike_neg.n447 vss 0
C1023 spike_neg.n448 vss 0
C1024 spike_neg.n449 vss 0.03068f
C1025 spike_neg.n450 vss 0
C1026 spike_neg.n451 vss 0
C1027 spike_neg.n452 vss 0
C1028 spike_neg.n453 vss 0
C1029 spike_neg.n454 vss 0
C1030 spike_neg.n455 vss 0
C1031 spike_neg.n456 vss 0
C1032 spike_neg.n457 vss 0
C1033 spike_neg.n458 vss 0
C1034 spike_neg.n459 vss 0
C1035 spike_neg.n460 vss 0
C1036 spike_neg.n461 vss 0
C1037 spike_neg.n462 vss 0
C1038 spike_neg.n463 vss 0
C1039 spike_neg.n464 vss 0
C1040 spike_neg.n465 vss 0
C1041 spike_neg.n466 vss 0
C1042 spike_neg.n467 vss 0
C1043 spike_neg.n468 vss 0
C1044 spike_neg.n469 vss 0.01019f
C1045 spike_neg.n470 vss 0
C1046 spike_neg.n471 vss 0
C1047 spike_neg.n472 vss 0
C1048 spike_neg.n473 vss 0
C1049 spike_neg.n474 vss 0
C1050 spike_neg.n475 vss 0
C1051 spike_neg.n476 vss 0
C1052 spike_neg.n477 vss 0
C1053 spike_neg.n478 vss 0.01031f
C1054 spike_neg.n479 vss 0
C1055 spike_neg.n480 vss 0
C1056 spike_neg.n481 vss 0
C1057 spike_neg.n482 vss 0
C1058 spike_neg.n483 vss 0
C1059 spike_neg.n484 vss 0.01726f
C1060 spike_neg.n485 vss 0.00994f
C1061 spike_neg.n486 vss 0.00116f
C1062 spike_neg.n487 vss 0
C1063 spike_neg.n488 vss 0
C1064 spike_neg.n489 vss 0.00147f
C1065 spike_neg.n490 vss 0.00327f
C1066 spike_neg.n491 vss 0.01047f
C1067 spike_neg.n492 vss 0
C1068 spike_neg.n493 vss 0.00116f
C1069 spike_neg.n494 vss 0.00994f
C1070 spike_neg.n495 vss 0.01093f
C1071 spike_neg.n496 vss 0
C1072 spike_neg.n497 vss 0
C1073 spike_neg.n498 vss 0
C1074 spike_neg.n499 vss 0
C1075 spike_neg.n500 vss 0
C1076 spike_neg.n501 vss 0.00571f
C1077 spike_neg.n502 vss 0.02827f
C1078 spike_neg.n503 vss 0.0335f
C1079 spike_neg.n504 vss 0.05727f
C1080 spike_neg.n505 vss 0
C1081 spike_neg.n506 vss 0.00153f
C1082 spike_neg.n507 vss 0
C1083 spike_neg.n508 vss 0.00116f
C1084 spike_neg.n509 vss 0.00116f
C1085 spike_neg.n510 vss 0.00187f
C1086 spike_neg.n511 vss 0.09421f
C1087 spike_neg.n512 vss 0.01726f
C1088 spike_neg.n513 vss 0.00123f
C1089 spike_neg.n514 vss 0
C1090 spike_neg.n515 vss 0
C1091 spike_neg.n516 vss 0
C1092 spike_neg.n517 vss 0
C1093 spike_neg.n518 vss 0
C1094 spike_neg.n519 vss 0
C1095 spike_neg.n520 vss 0
C1096 spike_neg.n521 vss 0.00994f
C1097 spike_neg.n522 vss 0
C1098 spike_neg.n523 vss 0
C1099 spike_neg.n524 vss 0
C1100 spike_neg.n525 vss 0
C1101 spike_neg.n526 vss 0
C1102 spike_neg.n527 vss 0
C1103 spike_neg.n528 vss 0
C1104 spike_neg.n529 vss 0.01192f
C1105 spike_neg.n530 vss 0.00994f
C1106 spike_neg.n531 vss 0.00187f
C1107 spike_neg.n532 vss 0.00116f
C1108 spike_neg.n533 vss 0
C1109 spike_neg.n534 vss 0.01047f
C1110 spike_neg.n535 vss 0.01377f
C1111 spike_neg.n536 vss 0.01971f
C1112 spike_neg.n537 vss 0.01047f
C1113 spike_neg.n538 vss 0.00327f
C1114 spike_neg.n539 vss 0.00187f
C1115 spike_neg.n540 vss 0.00994f
C1116 spike_neg.n541 vss 0.01105f
C1117 spike_neg.n542 vss 0.01081f
C1118 spike_neg.n543 vss 0
C1119 spike_neg.n544 vss 0
C1120 spike_neg.n545 vss 0
C1121 spike_neg.n546 vss 0
C1122 spike_neg.n547 vss 0
C1123 spike_neg.n548 vss 0
C1124 spike_neg.n549 vss 0
C1125 spike_neg.n551 vss 0
C1126 spike_neg.n552 vss 0
C1127 spike_neg.n553 vss 0.00994f
C1128 spike_neg.n554 vss 0.00994f
C1129 spike_neg.n555 vss 0.00116f
C1130 spike_neg.n556 vss 0
C1131 spike_neg.n557 vss 0.01389f
C1132 spike_neg.n558 vss 0.00802f
C1133 spike_neg.n559 vss 0.01034f
C1134 spike_neg.n560 vss 0.01765f
C1135 spike_neg.n561 vss 0.02134f
C1136 spike_neg.n562 vss 0.00116f
C1137 spike_neg.n563 vss 0.00187f
C1138 spike_neg.n564 vss 0.00187f
C1139 spike_neg.n565 vss 0.00116f
C1140 spike_neg.n566 vss 0
C1141 spike_neg.n567 vss 0.00147f
C1142 spike_neg.n568 vss 0.00147f
C1143 spike_neg.n569 vss 0
C1144 spike_neg.n570 vss 0.00116f
C1145 spike_neg.n571 vss 0.01029f
C1146 spike_neg.n572 vss 0.01488f
C1147 spike_neg.n573 vss 0.01029f
C1148 spike_neg.n574 vss 0.00116f
C1149 spike_neg.n575 vss 0
C1150 spike_neg.n576 vss 0.0242f
C1151 Iin.n0 vss 0.07786f
C1152 Iin.n1 vss 0.01011f
C1153 Iin.n2 vss 0
C1154 Iin.n3 vss 0
C1155 Iin.n4 vss 0
C1156 Iin.n5 vss 0
C1157 Iin.n6 vss 0
C1158 Iin.n7 vss 0
C1159 Iin.n8 vss 0.02104f
C1160 Iin.n9 vss 0.02104f
C1161 Iin.n10 vss 0
C1162 Iin.n11 vss 0
C1163 Iin.n12 vss 0
C1164 Iin.n13 vss 0
C1165 Iin.n14 vss 0
C1166 Iin.n15 vss 0
C1167 Iin.n16 vss 0.02104f
C1168 Iin.n17 vss 0
C1169 Iin.n18 vss 0
C1170 Iin.n19 vss 0
C1171 Iin.n20 vss 0
C1172 Iin.n21 vss 0
C1173 Iin.n22 vss 0.02104f
C1174 Iin.n23 vss 0.02104f
C1175 Iin.n24 vss 0
C1176 Iin.n25 vss 0
C1177 Iin.n26 vss 0
C1178 Iin.n27 vss 0
C1179 Iin.n28 vss 0
C1180 Iin.n29 vss 0
C1181 Iin.n30 vss 0.02104f
C1182 Iin.n31 vss 0
C1183 Iin.n32 vss 0
C1184 Iin.n33 vss 0
C1185 Iin.n34 vss 0
C1186 Iin.n35 vss 0
C1187 Iin.n36 vss 0.02104f
C1188 Iin.n37 vss 0
C1189 Iin.n38 vss 0
C1190 Iin.n39 vss 0
C1191 Iin.n40 vss 0
C1192 Iin.n41 vss 0
C1193 Iin.n42 vss 0.02104f
C1194 Iin.n43 vss 0
C1195 Iin.n44 vss 0
C1196 Iin.n45 vss 0
C1197 Iin.n46 vss 0
C1198 Iin.n47 vss 0
C1199 Iin.n48 vss 0.02104f
C1200 Iin.n49 vss 0
C1201 Iin.n50 vss 0
C1202 Iin.n51 vss 0
C1203 Iin.n52 vss 0
C1204 Iin.n53 vss 0
C1205 Iin.n54 vss 0.02104f
C1206 Iin.n55 vss 0
C1207 Iin.n56 vss 0
C1208 Iin.n57 vss 0
C1209 Iin.n58 vss 0
C1210 Iin.n59 vss 0
C1211 Iin.n60 vss 0.02104f
C1212 Iin.n61 vss 0
C1213 Iin.n62 vss 0
C1214 Iin.n63 vss 0
C1215 Iin.n64 vss 0
C1216 Iin.n65 vss 0
C1217 Iin.n66 vss 0.02104f
C1218 Iin.n67 vss 0
C1219 Iin.n68 vss 0
C1220 Iin.n69 vss 0
C1221 Iin.n70 vss 0
C1222 Iin.n71 vss 0
C1223 Iin.n72 vss 0.02104f
C1224 Iin.n73 vss 0
C1225 Iin.n74 vss 0
C1226 Iin.n75 vss 0
C1227 Iin.n76 vss 0
C1228 Iin.n77 vss 0
C1229 Iin.n78 vss 0.02104f
C1230 Iin.n79 vss 0
C1231 Iin.n80 vss 0
C1232 Iin.n81 vss 0
C1233 Iin.n82 vss 0
C1234 Iin.n83 vss 0
C1235 Iin.n84 vss 0.02104f
C1236 Iin.n85 vss 0
C1237 Iin.n86 vss 0
C1238 Iin.n87 vss 0
C1239 Iin.n88 vss 0
C1240 Iin.n89 vss 0
C1241 Iin.n90 vss 0.02104f
C1242 Iin.n91 vss 0
C1243 Iin.n92 vss 0
C1244 Iin.n93 vss 0
C1245 Iin.n94 vss 0
C1246 Iin.n95 vss 0
C1247 Iin.n96 vss 0.02104f
C1248 Iin.n97 vss 0
C1249 Iin.n98 vss 0
C1250 Iin.n99 vss 0
C1251 Iin.n100 vss 0
C1252 Iin.n101 vss 0
C1253 Iin.n102 vss 0.02753f
C1254 Iin.n103 vss 0
C1255 Iin.n104 vss 0
C1256 Iin.n106 vss 0.08245f
C1257 Iin.n107 vss 0.00256f
C1258 Iin.n108 vss 0
C1259 Iin.n109 vss 0
C1260 Iin.n110 vss 0
C1261 Iin.n111 vss 0
C1262 Iin.n112 vss 0.02104f
C1263 Iin.n113 vss 0
C1264 Iin.n114 vss 0
C1265 Iin.n115 vss 0
C1266 Iin.n116 vss 0
C1267 Iin.n117 vss 0
C1268 Iin.n118 vss 0
C1269 Iin.n119 vss 0
C1270 Iin.n120 vss 0.02104f
C1271 Iin.n121 vss 0
C1272 Iin.n122 vss 0
C1273 Iin.n123 vss 0
C1274 Iin.n124 vss 0
C1275 Iin.n125 vss 0
C1276 Iin.n126 vss 0
C1277 Iin.n127 vss 0
C1278 Iin.n128 vss 0.02104f
C1279 Iin.n129 vss 0
C1280 Iin.n130 vss 0
C1281 Iin.n131 vss 0
C1282 Iin.n132 vss 0
C1283 Iin.n133 vss 0
C1284 Iin.n134 vss 0
C1285 Iin.n135 vss 0
C1286 Iin.n136 vss 0.02104f
C1287 Iin.n137 vss 0
C1288 Iin.n138 vss 0
C1289 Iin.n139 vss 0
C1290 Iin.n140 vss 0
C1291 Iin.n141 vss 0
C1292 Iin.n142 vss 0
C1293 Iin.n143 vss 0
C1294 Iin.n144 vss 0.02104f
C1295 Iin.n145 vss 0
C1296 Iin.n146 vss 0
C1297 Iin.n147 vss 0
C1298 Iin.n148 vss 0
C1299 Iin.n149 vss 0
C1300 Iin.n150 vss 0
C1301 Iin.n151 vss 0
C1302 Iin.n152 vss 0.02104f
C1303 Iin.n153 vss 0
C1304 Iin.n154 vss 0
C1305 Iin.n155 vss 0
C1306 Iin.n156 vss 0
C1307 Iin.n157 vss 0
C1308 Iin.n158 vss 0
C1309 Iin.n159 vss 0
C1310 Iin.n160 vss 0.02104f
C1311 Iin.n161 vss 0
C1312 Iin.n162 vss 0
C1313 Iin.n163 vss 0
C1314 Iin.n164 vss 0
C1315 Iin.n165 vss 0
C1316 Iin.n166 vss 0
C1317 Iin.n167 vss 0
C1318 Iin.n168 vss 0.02104f
C1319 Iin.n169 vss 0
C1320 Iin.n170 vss 0
C1321 Iin.n171 vss 0
C1322 Iin.n172 vss 0
C1323 Iin.n173 vss 0
C1324 Iin.n174 vss 0
C1325 Iin.n175 vss 0
C1326 Iin.n176 vss 0.02104f
C1327 Iin.n177 vss 0
C1328 Iin.n178 vss 0
C1329 Iin.n179 vss 0
C1330 Iin.n180 vss 0
C1331 Iin.n181 vss 0
C1332 Iin.n182 vss 0
C1333 Iin.n183 vss 0
C1334 Iin.n184 vss 0.02104f
C1335 Iin.n185 vss 0
C1336 Iin.n186 vss 0
C1337 Iin.n187 vss 0
C1338 Iin.n188 vss 0
C1339 Iin.n189 vss 0
C1340 Iin.n190 vss 0
C1341 Iin.n191 vss 0
C1342 Iin.n192 vss 0.02104f
C1343 Iin.n193 vss 0
C1344 Iin.n194 vss 0
C1345 Iin.n195 vss 0
C1346 Iin.n196 vss 0
C1347 Iin.n197 vss 0
C1348 Iin.n198 vss 0
C1349 Iin.n199 vss 0
C1350 Iin.n200 vss 0.02104f
C1351 Iin.n201 vss 0
C1352 Iin.n202 vss 0
C1353 Iin.n203 vss 0
C1354 Iin.n204 vss 0
C1355 Iin.n205 vss 0
C1356 Iin.n206 vss 0
C1357 Iin.n207 vss 0
C1358 Iin.n208 vss 0.02104f
C1359 Iin.n209 vss 0
C1360 Iin.n210 vss 0
C1361 Iin.n211 vss 0
C1362 Iin.n212 vss 0
C1363 Iin.n213 vss 0
C1364 Iin.n214 vss 0
C1365 Iin.n215 vss 0
C1366 Iin.n216 vss 0
C1367 Iin.n217 vss 0
C1368 Iin.n218 vss 0.02104f
C1369 Iin.n219 vss 0
C1370 Iin.n220 vss 0
C1371 Iin.n221 vss 0
C1372 Iin.n222 vss 0
C1373 Iin.n223 vss 0
C1374 Iin.n224 vss 0
C1375 Iin.n225 vss 0
C1376 Iin.n226 vss 0
C1377 Iin.n227 vss 0.02104f
C1378 Iin.n228 vss 0
C1379 Iin.n229 vss 0
C1380 Iin.n230 vss 0
C1381 Iin.n231 vss 0
C1382 Iin.n232 vss 0
C1383 Iin.n233 vss 0
C1384 Iin.n234 vss 0
C1385 Iin.n235 vss 0
C1386 Iin.n236 vss 0
C1387 Iin.n237 vss 0
C1388 Iin.n238 vss 0
C1389 Iin.n239 vss 0
C1390 Iin.n240 vss 0.02104f
C1391 Iin.n241 vss 0
C1392 Iin.n242 vss 0
C1393 Iin.n243 vss 0
C1394 Iin.n244 vss 0
C1395 Iin.n245 vss 0
C1396 Iin.n246 vss 0
C1397 Iin.n247 vss 0
C1398 Iin.n248 vss 0
C1399 Iin.n249 vss 0
C1400 Iin.n250 vss 0
C1401 Iin.n251 vss 0.02104f
C1402 Iin.n252 vss 0
C1403 Iin.n253 vss 0
C1404 Iin.n254 vss 0
C1405 Iin.n255 vss 0
C1406 Iin.n256 vss 0
C1407 Iin.n257 vss 0
C1408 Iin.n258 vss 0
C1409 Iin.n259 vss 0
C1410 Iin.n260 vss 0
C1411 Iin.n261 vss 0
C1412 Iin.n262 vss 0.0188f
C1413 Iin.n263 vss 0
C1414 Iin.n264 vss 0
C1415 Iin.n265 vss 0
C1416 Iin.n266 vss 0
C1417 Iin.n267 vss 0
C1418 Iin.n268 vss 0
C1419 Iin.n269 vss 0
C1420 Iin.n270 vss 0.01938f
C1421 Iin.n271 vss 0
C1422 Iin.n272 vss 0.01116f
C1423 Iin.n273 vss 0
C1424 Iin.n274 vss 0
C1425 Iin.n275 vss 0.00101f
C1426 Iin.n276 vss 0.00383f
C1427 Iin.n277 vss 0
C1428 Iin.n278 vss 0.01351f
C1429 Iin.n279 vss 0.00223f
C1430 Iin.n280 vss 0
C1431 Iin.n281 vss 0.00383f
C1432 Iin.n282 vss 0.00224f
C1433 Iin.n283 vss 0.00383f
C1434 Iin.n284 vss 0.00224f
C1435 Iin.n285 vss 0
C1436 Iin.n286 vss 0.00128f
C1437 Iin.n287 vss 0.00706f
C1438 Iin.n288 vss 0
C1439 Iin.n289 vss 0
C1440 Iin.n290 vss 0.00101f
C1441 Iin.n291 vss 0.00101f
C1442 Iin.n292 vss 0
C1443 Iin.n293 vss 0
C1444 Iin.n294 vss 0.00128f
C1445 Iin.n295 vss 0.0102f
C1446 Iin.n296 vss 0.00706f
C1447 Iin.n297 vss 0
C1448 Iin.n298 vss 0
C1449 Iin.n299 vss 0.01155f
C1450 Iin.n300 vss 0.00383f
C1451 Iin.n301 vss 0.00224f
C1452 Iin.n302 vss 0
C1453 Iin.n303 vss 0.00128f
C1454 Iin.n304 vss 0.00128f
C1455 Iin.n305 vss 0
C1456 Iin.n306 vss 0
C1457 Iin.n307 vss 0.00101f
C1458 Iin.n308 vss 0.00101f
C1459 Iin.n309 vss 0
C1460 Iin.n310 vss 0
C1461 Iin.n311 vss 0.00706f
C1462 Iin.n312 vss 0.0102f
C1463 Iin.n313 vss 0.00706f
C1464 Iin.n314 vss 0
C1465 Iin.n315 vss 0
C1466 Iin.n316 vss 0.0166f
C1467 Iin.n317 vss 0.01463f
C1468 Iin.n318 vss 0.0121f
C1469 Iin.n319 vss 0
C1470 Iin.n320 vss 0.00128f
C1471 Iin.n321 vss 0.00128f
C1472 Iin.n322 vss 0
C1473 Iin.n323 vss 0
C1474 Iin.n324 vss 0.00101f
C1475 Iin.n325 vss 0.00101f
C1476 Iin.n326 vss 0
C1477 Iin.n327 vss 0
C1478 Iin.n328 vss 0.00706f
C1479 Iin.n329 vss 0.0102f
C1480 Iin.n330 vss 0.00706f
C1481 Iin.n331 vss 0
C1482 Iin.n332 vss 0
C1483 Iin.n333 vss 0.00709f
C1484 Iin.n334 vss 0.0055f
C1485 Iin.n335 vss 0.00952f
C1486 Iin.n336 vss 0
C1487 Iin.n337 vss 0
C1488 Iin.n338 vss 0.01167f
C1489 Iin.n339 vss 0
C1490 Iin.n340 vss 0.00952f
C1491 Iin.n341 vss 0
C1492 Iin.n342 vss 0
C1493 Iin.n343 vss 0
C1494 Iin.n344 vss 0
C1495 Iin.n345 vss 0
C1496 Iin.n346 vss 0
C1497 Iin.n347 vss 0
C1498 Iin.n348 vss 0
C1499 Iin.n349 vss 0.00741f
C1500 Iin.n350 vss 0
C1501 Iin.n351 vss 0.01184f
C1502 Iin.n352 vss 0
C1503 Iin.n353 vss 0
C1504 Iin.n354 vss 0.00101f
C1505 Iin.n355 vss 0.00383f
C1506 Iin.n356 vss 0.00128f
C1507 Iin.n357 vss 0.00681f
C1508 Iin.n358 vss 0.00681f
C1509 Iin.n359 vss 0
C1510 Iin.n360 vss 0.00105f
C1511 Iin.n361 vss 0
C1512 Iin.n362 vss 0
C1513 Iin.n363 vss 0
C1514 Iin.n364 vss 0.0646f
C1515 Iin.n365 vss 0
C1516 Iin.n366 vss 0.00136f
C1517 Iin.n367 vss 0
C1518 Iin.n368 vss 0
C1519 Iin.n369 vss 0
C1520 Iin.n370 vss 0
C1521 Iin.n371 vss 0
C1522 Iin.n372 vss 0
C1523 Iin.n373 vss 0
C1524 Iin.n374 vss 0
C1525 Iin.n375 vss 0
C1526 Iin.n376 vss 0.00681f
C1527 Iin.n377 vss 0
C1528 Iin.n378 vss 0
C1529 Iin.n379 vss 0
C1530 Iin.n380 vss 0.07658f
C1531 Iin.n381 vss 0
C1532 Iin.n382 vss 0
C1533 Iin.n383 vss 0
C1534 Iin.n384 vss 0.00681f
C1535 Iin.n385 vss 0
C1536 Iin.n386 vss 0
C1537 Iin.n387 vss 0
C1538 Iin.n388 vss 0
C1539 Iin.n389 vss 0
C1540 Iin.n390 vss 0.00792f
C1541 Iin.n391 vss 0.03927f
C1542 Iin.n392 vss 0.02297f
C1543 Iin.n393 vss 0.00818f
C1544 Iin.n394 vss 0.00952f
C1545 Iin.n395 vss 0
C1546 Iin.n396 vss 0
C1547 Iin.n397 vss 0
C1548 Iin.n398 vss 0
C1549 Iin.n399 vss 0
C1550 Iin.n400 vss 0.00681f
C1551 Iin.n401 vss 0
C1552 Iin.n402 vss 0
C1553 Iin.n403 vss 0
C1554 Iin.n404 vss 0
C1555 Iin.n405 vss 0
C1556 Iin.n406 vss 0
C1557 Iin.n407 vss 0
C1558 Iin.n408 vss 0
C1559 Iin.n409 vss 0
C1560 Iin.n410 vss 0
C1561 Iin.n411 vss 0
C1562 Iin.n412 vss 0
C1563 Iin.n413 vss 0
C1564 Iin.n414 vss 0
C1565 Iin.n415 vss 0
C1566 Iin.n416 vss 0
C1567 Iin.n417 vss 0
C1568 Iin.n418 vss 0
C1569 Iin.n419 vss 0
C1570 Iin.n420 vss 0
C1571 Iin.n421 vss 0
C1572 Iin.n422 vss 0
C1573 Iin.n423 vss 0
C1574 Iin.n424 vss 0
C1575 Iin.n425 vss 0
C1576 Iin.n426 vss 0
C1577 Iin.n427 vss 0
C1578 Iin.n428 vss 0
C1579 Iin.n429 vss 0
C1580 Iin.n430 vss 0
C1581 Iin.n431 vss 0
C1582 Iin.n432 vss 0
C1583 Iin.n433 vss 0
C1584 Iin.n434 vss 0
C1585 Iin.n435 vss 0
C1586 Iin.n436 vss 0.00681f
C1587 Iin.n437 vss 0.00681f
C1588 Iin.n438 vss 0
C1589 Iin.n439 vss 0
C1590 Iin.n440 vss 0
C1591 Iin.n441 vss 0
C1592 Iin.n442 vss 0.0075f
C1593 Iin.n443 vss 0
C1594 Iin.n444 vss 0
C1595 Iin.n445 vss 0
C1596 Iin.n446 vss 0
C1597 Iin.n447 vss 0
C1598 Iin.n448 vss 0
C1599 Iin.n449 vss 0
C1600 Iin.n450 vss 0
C1601 Iin.n451 vss 0.00105f
C1602 Iin.n452 vss 0
C1603 Iin.n453 vss 0
C1604 Iin.n454 vss 0
C1605 Iin.n455 vss 0.00128f
C1606 Iin.n456 vss 0.00681f
C1607 Iin.n457 vss 0.01184f
C1608 Iin.n458 vss 0
C1609 Iin.n459 vss 0
C1610 Iin.n460 vss 0
C1611 Iin.n461 vss 0
C1612 Iin.n462 vss 0
C1613 Iin.n463 vss 0
C1614 Iin.n464 vss 0
C1615 Iin.n465 vss 0.00707f
C1616 Iin.n466 vss 0
C1617 Iin.n467 vss 0
C1618 Iin.n468 vss 0
C1619 Iin.n469 vss 0
C1620 Iin.n470 vss 0
C1621 Iin.n471 vss 0
C1622 Iin.n472 vss 0
C1623 Iin.n473 vss 0
C1624 Iin.n474 vss 0
C1625 Iin.n475 vss 0
C1626 Iin.n476 vss 0
C1627 Iin.n477 vss 0
C1628 Iin.n478 vss 0.00681f
C1629 Iin.n479 vss 0.00128f
C1630 Iin.n480 vss 0
C1631 Iin.n481 vss 0.00681f
C1632 Iin.n482 vss 0.01184f
C1633 Iin.n483 vss 0
C1634 Iin.n484 vss 0
C1635 Iin.n485 vss 0
C1636 Iin.n486 vss 0.06458f
C1637 Iin.n488 vss 0
C1638 Iin.n489 vss 0
C1639 Iin.n490 vss 0.00698f
C1640 Iin.n491 vss 0
C1641 Iin.n492 vss 0
C1642 Iin.n493 vss 0
C1643 Iin.n494 vss 0
C1644 Iin.n495 vss 0
C1645 Iin.n496 vss 0
C1646 Iin.n497 vss 0
C1647 Iin.n498 vss 0
C1648 Iin.n499 vss 0
C1649 Iin.n500 vss 0
C1650 Iin.n501 vss 0
C1651 Iin.n502 vss 0
C1652 Iin.n503 vss 0
C1653 Iin.n504 vss 0
C1654 Iin.n505 vss 0
C1655 Iin.n506 vss 0.01953f
C1656 Iin.n507 vss 0.00148f
C1657 Iin.n508 vss 0.00341f
C1658 Iin.n509 vss 0
C1659 Iin.n510 vss 0
C1660 Iin.n511 vss 0
C1661 Iin.n512 vss 0.01184f
C1662 Iin.n513 vss 0.00681f
C1663 Iin.n514 vss 0
C1664 Iin.n515 vss 0
C1665 Iin.n516 vss 0.00718f
C1666 Iin.n517 vss 0.00224f
C1667 Iin.n518 vss 0.00128f
C1668 Iin.n519 vss 0.00681f
C1669 Iin.n520 vss 0.00758f
C1670 Iin.n521 vss 0
C1671 Iin.n522 vss 0
C1672 Iin.n523 vss 0
C1673 Iin.n524 vss 0
C1674 Iin.n525 vss 0
C1675 Iin.n526 vss 0.00818f
C1676 Iin.n527 vss 0.00681f
C1677 Iin.n528 vss 0.00128f
C1678 Iin.n529 vss 0.00381f
C1679 Iin.n530 vss 0.00718f
C1680 Iin.n531 vss 0.00944f
C1681 Iin.n532 vss 0.00545f
C1682 Iin.n533 vss 0.06534f
C1683 Iin.n534 vss 0.0094f
C1684 Iin.n535 vss 0.02866f
C1685 Iin.n536 vss 0.06246f
C1686 Iin.n537 vss 0.01553f
C1687 Iin.n538 vss 0.00718f
C1688 Iin.n539 vss 0.00224f
C1689 Iin.n540 vss 0.00128f
C1690 Iin.n541 vss 0.00681f
C1691 Iin.n542 vss 0.00392f
C1692 Iin.n543 vss 0
C1693 Iin.n544 vss 0
C1694 Iin.n545 vss 0
C1695 Iin.n546 vss 0
C1696 Iin.n547 vss 0
C1697 Iin.n548 vss 0.02104f
C1698 Iin.n549 vss 0.02104f
C1699 Iin.n550 vss 0.02104f
C1700 Iin.n551 vss 0
C1701 Iin.n552 vss 0
C1702 Iin.n553 vss 0
C1703 Iin.n554 vss 0
C1704 Iin.n555 vss 0
C1705 Iin.n556 vss 0.02104f
C1706 Iin.n557 vss 0.02104f
C1707 Iin.n558 vss 0.02104f
C1708 Iin.n559 vss 0
C1709 Iin.n560 vss 0
C1710 Iin.n561 vss 0
C1711 Iin.n562 vss 0
C1712 Iin.n563 vss 0
C1713 Iin.n564 vss 0.02104f
C1714 Iin.n565 vss 0.02104f
C1715 Iin.n566 vss 0.02104f
C1716 Iin.n567 vss 0
C1717 Iin.n568 vss 0
C1718 Iin.n569 vss 0
C1719 Iin.n570 vss 0
C1720 Iin.n571 vss 0
C1721 Iin.n572 vss 0.02104f
C1722 Iin.n573 vss 0
C1723 Iin.n574 vss 0
C1724 Iin.n575 vss 0
C1725 Iin.n576 vss 0
C1726 vss.n0 vss 0.00851f
C1727 vss.n1 vss 0.00111f
C1728 vss.n2 vss 0
C1729 vss.n3 vss 0
C1730 vss.n4 vss 0
C1731 vss.n5 vss 0
C1732 vss.n6 vss 0
C1733 vss.n7 vss 0
C1734 vss.n8 vss 0.0023f
C1735 vss.n9 vss 0.0023f
C1736 vss.n10 vss 0
C1737 vss.n11 vss 0
C1738 vss.n12 vss 0
C1739 vss.n13 vss 0
C1740 vss.n14 vss 0
C1741 vss.n15 vss 0
C1742 vss.n16 vss 0.0023f
C1743 vss.n17 vss 0
C1744 vss.n18 vss 0
C1745 vss.n19 vss 0
C1746 vss.n20 vss 0
C1747 vss.n21 vss 0
C1748 vss.n22 vss 0.0023f
C1749 vss.n23 vss 0
C1750 vss.n24 vss 0
C1751 vss.n25 vss 0
C1752 vss.n26 vss 0
C1753 vss.n27 vss 0
C1754 vss.n28 vss 0.0023f
C1755 vss.n29 vss 0
C1756 vss.n30 vss 0
C1757 vss.n31 vss 0
C1758 vss.n32 vss 0
C1759 vss.n33 vss 0
C1760 vss.n34 vss 0.0023f
C1761 vss.n35 vss 0
C1762 vss.n36 vss 0
C1763 vss.n37 vss 0
C1764 vss.n38 vss 0
C1765 vss.n39 vss 0
C1766 vss.n40 vss 0.0023f
C1767 vss.n41 vss 0
C1768 vss.n42 vss 0
C1769 vss.n43 vss 0
C1770 vss.n44 vss 0
C1771 vss.n45 vss 0
C1772 vss.n46 vss 0.0023f
C1773 vss.n47 vss 0
C1774 vss.n48 vss 0
C1775 vss.n49 vss 0
C1776 vss.n50 vss 0
C1777 vss.n51 vss 0
C1778 vss.n52 vss 0.0023f
C1779 vss.n53 vss 0
C1780 vss.n54 vss 0
C1781 vss.n55 vss 0
C1782 vss.n56 vss 0
C1783 vss.n57 vss 0
C1784 vss.n58 vss 0.0023f
C1785 vss.n59 vss 0
C1786 vss.n60 vss 0
C1787 vss.n61 vss 0
C1788 vss.n62 vss 0
C1789 vss.n63 vss 0
C1790 vss.n64 vss 0.0023f
C1791 vss.n65 vss 0
C1792 vss.n66 vss 0
C1793 vss.n67 vss 0
C1794 vss.n68 vss 0
C1795 vss.n69 vss 0
C1796 vss.n70 vss 0.0023f
C1797 vss.n71 vss 0
C1798 vss.n72 vss 0
C1799 vss.n73 vss 0
C1800 vss.n74 vss 0
C1801 vss.n75 vss 0
C1802 vss.n76 vss 0.0023f
C1803 vss.n77 vss 0
C1804 vss.n78 vss 0
C1805 vss.n79 vss 0
C1806 vss.n80 vss 0
C1807 vss.n81 vss 0
C1808 vss.n82 vss 0.0023f
C1809 vss.n83 vss 0
C1810 vss.n84 vss 0
C1811 vss.n85 vss 0
C1812 vss.n86 vss 0
C1813 vss.n87 vss 0
C1814 vss.n88 vss 0.0023f
C1815 vss.n89 vss 0
C1816 vss.n90 vss 0
C1817 vss.n91 vss 0
C1818 vss.n92 vss 0
C1819 vss.n93 vss 0
C1820 vss.n94 vss 0.0023f
C1821 vss.n95 vss 0
C1822 vss.n96 vss 0
C1823 vss.n97 vss 0
C1824 vss.n98 vss 0.00901f
C1825 vss.n99 vss 0
C1826 vss.n100 vss 0
C1827 vss.n101 vss 0
C1828 vss.n102 vss 0.00301f
C1829 vss.n104 vss 0
C1830 vss.n105 vss 0
C1831 vss.n106 vss 0
C1832 vss.n107 vss 0
C1833 vss.n108 vss 0
C1834 vss.n109 vss 0
C1835 vss.n110 vss 0
C1836 vss.n111 vss 0.0023f
C1837 vss.n112 vss 0
C1838 vss.n113 vss 0
C1839 vss.n114 vss 0
C1840 vss.n115 vss 0
C1841 vss.n116 vss 0
C1842 vss.n117 vss 0
C1843 vss.n118 vss 0
C1844 vss.n119 vss 0.0023f
C1845 vss.n120 vss 0
C1846 vss.n121 vss 0
C1847 vss.n122 vss 0
C1848 vss.n123 vss 0
C1849 vss.n124 vss 0
C1850 vss.n125 vss 0
C1851 vss.n126 vss 0
C1852 vss.n127 vss 0.0023f
C1853 vss.n128 vss 0
C1854 vss.n129 vss 0
C1855 vss.n130 vss 0
C1856 vss.n131 vss 0
C1857 vss.n132 vss 0
C1858 vss.n133 vss 0
C1859 vss.n134 vss 0
C1860 vss.n135 vss 0.0023f
C1861 vss.n136 vss 0
C1862 vss.n137 vss 0
C1863 vss.n138 vss 0
C1864 vss.n139 vss 0
C1865 vss.n140 vss 0
C1866 vss.n141 vss 0
C1867 vss.n142 vss 0
C1868 vss.n143 vss 0.0023f
C1869 vss.n144 vss 0
C1870 vss.n145 vss 0
C1871 vss.n146 vss 0
C1872 vss.n147 vss 0
C1873 vss.n148 vss 0
C1874 vss.n149 vss 0
C1875 vss.n150 vss 0
C1876 vss.n151 vss 0.0023f
C1877 vss.n152 vss 0
C1878 vss.n153 vss 0
C1879 vss.n154 vss 0
C1880 vss.n155 vss 0
C1881 vss.n156 vss 0
C1882 vss.n157 vss 0
C1883 vss.n158 vss 0
C1884 vss.n159 vss 0.0023f
C1885 vss.n160 vss 0
C1886 vss.n161 vss 0
C1887 vss.n162 vss 0
C1888 vss.n163 vss 0
C1889 vss.n164 vss 0
C1890 vss.n165 vss 0
C1891 vss.n166 vss 0
C1892 vss.n167 vss 0.0023f
C1893 vss.n168 vss 0
C1894 vss.n169 vss 0
C1895 vss.n170 vss 0
C1896 vss.n171 vss 0
C1897 vss.n172 vss 0
C1898 vss.n173 vss 0
C1899 vss.n174 vss 0
C1900 vss.n175 vss 0.0023f
C1901 vss.n176 vss 0
C1902 vss.n177 vss 0
C1903 vss.n178 vss 0
C1904 vss.n179 vss 0
C1905 vss.n180 vss 0
C1906 vss.n181 vss 0
C1907 vss.n182 vss 0
C1908 vss.n183 vss 0.0023f
C1909 vss.n184 vss 0
C1910 vss.n185 vss 0
C1911 vss.n186 vss 0
C1912 vss.n187 vss 0
C1913 vss.n188 vss 0
C1914 vss.n189 vss 0
C1915 vss.n190 vss 0
C1916 vss.n191 vss 0.0023f
C1917 vss.n192 vss 0
C1918 vss.n193 vss 0
C1919 vss.n194 vss 0
C1920 vss.n195 vss 0
C1921 vss.n196 vss 0
C1922 vss.n197 vss 0
C1923 vss.n198 vss 0
C1924 vss.n199 vss 0.0023f
C1925 vss.n200 vss 0
C1926 vss.n201 vss 0
C1927 vss.n202 vss 0
C1928 vss.n203 vss 0
C1929 vss.n204 vss 0
C1930 vss.n205 vss 0
C1931 vss.n206 vss 0
C1932 vss.n207 vss 0.0023f
C1933 vss.n208 vss 0
C1934 vss.n209 vss 0
C1935 vss.n210 vss 0
C1936 vss.n211 vss 0
C1937 vss.n212 vss 0
C1938 vss.n213 vss 0
C1939 vss.n214 vss 0
C1940 vss.n215 vss 0.0023f
C1941 vss.n216 vss 0
C1942 vss.n217 vss 0
C1943 vss.n218 vss 0
C1944 vss.n219 vss 0
C1945 vss.n220 vss 0
C1946 vss.n221 vss 0
C1947 vss.n222 vss 0
C1948 vss.n223 vss 0
C1949 vss.n224 vss 0
C1950 vss.n225 vss 0
C1951 vss.n226 vss 0
C1952 vss.n227 vss 0
C1953 vss.n228 vss 0.0023f
C1954 vss.n229 vss 0
C1955 vss.n230 vss 0
C1956 vss.n231 vss 0
C1957 vss.n232 vss 0
C1958 vss.n233 vss 0
C1959 vss.n234 vss 0
C1960 vss.n235 vss 0
C1961 vss.n236 vss 0
C1962 vss.n237 vss 0
C1963 vss.n238 vss 0
C1964 vss.n239 vss 0.0023f
C1965 vss.n240 vss 0
C1966 vss.n241 vss 0
C1967 vss.n242 vss 0
C1968 vss.n243 vss 0
C1969 vss.n244 vss 0
C1970 vss.n245 vss 0
C1971 vss.n246 vss 0
C1972 vss.n247 vss 0
C1973 vss.n248 vss 0
C1974 vss.n249 vss 0
C1975 vss.n250 vss 0.0023f
C1976 vss.n251 vss 0
C1977 vss.n252 vss 0
C1978 vss.n253 vss 0
C1979 vss.n254 vss 0
C1980 vss.n255 vss 0
C1981 vss.n256 vss 0
C1982 vss.n257 vss 0
C1983 vss.n258 vss 0
C1984 vss.n259 vss 0
C1985 vss.n260 vss 0
C1986 vss.n261 vss 0.00104f
C1987 vss.n262 vss 0.00104f
C1988 vss.n263 vss 0.00129f
C1989 vss.n264 vss 0
C1990 vss.n265 vss 0
C1991 vss.n266 vss 0
C1992 vss.n267 vss 0.00214f
C1993 vss.n268 vss 0
C1994 vss.n269 vss 0
C1995 vss.n270 vss 0
C1996 vss.n271 vss 0.00714f
C1997 vss.n272 vss 0.00103f
C1998 vss.n273 vss 0.00316f
C1999 vss.n274 vss 0.00679f
C2000 vss.n275 vss 0.00171f
C2001 vss.n276 vss 0
C2002 vss.n277 vss 0
C2003 vss.n278 vss 0
C2004 vss.n279 vss 0
C2005 vss.n280 vss 0
C2006 vss.n281 vss 0
C2007 vss.n282 vss 0
C2008 vss.n283 vss 0
C2009 vss.n284 vss 0
C2010 vss.n285 vss 0
C2011 vss.n286 vss 0
C2012 vss.n287 vss 0
C2013 vss.n288 vss 0
C2014 vss.n289 vss 0
C2015 vss.n290 vss 0
C2016 vss.n291 vss 0
C2017 vss.n292 vss 0.00112f
C2018 vss.n293 vss 0
C2019 vss.n294 vss 0
C2020 vss.n295 vss 0
C2021 vss.n296 vss 0.00126f
C2022 vss.n297 vss 0
C2023 vss.n298 vss 0
C2024 vss.n299 vss 0
C2025 vss.n300 vss 0
C2026 vss.n301 vss 0
C2027 vss.n302 vss 0
C2028 vss.n303 vss 0
C2029 vss.n304 vss 0
C2030 vss.n305 vss 0
C2031 vss.n306 vss 0
C2032 vss.n307 vss 0
C2033 vss.n308 vss 0
C2034 vss.n309 vss 0.00112f
C2035 vss.n310 vss 0
C2036 vss.n311 vss 0
C2037 vss.n312 vss 0
C2038 vss.n313 vss 0.00181f
C2039 vss.n314 vss 0.0016f
C2040 vss.n315 vss 0.00132f
C2041 vss.n316 vss 0
C2042 vss.n317 vss 0
C2043 vss.n318 vss 0
C2044 vss.n319 vss 0
C2045 vss.n320 vss 0
C2046 vss.n321 vss 0
C2047 vss.n322 vss 0
C2048 vss.n323 vss 0
C2049 vss.n324 vss 0
C2050 vss.n325 vss 0
C2051 vss.n326 vss 0.00112f
C2052 vss.n327 vss 0
C2053 vss.n328 vss 0
C2054 vss.n329 vss 0
C2055 vss.n330 vss 0
C2056 vss.n331 vss 0
C2057 vss.n332 vss 0.00104f
C2058 vss.n333 vss 0
C2059 vss.n334 vss 0
C2060 vss.n335 vss 0.00128f
C2061 vss.n336 vss 0
C2062 vss.n337 vss 0
C2063 vss.n338 vss 0
C2064 vss.n339 vss 0
C2065 vss.n340 vss 0
C2066 vss.n341 vss 0
C2067 vss.n342 vss 0
C2068 vss.n343 vss 0
C2069 vss.n344 vss 0
C2070 vss.n345 vss 0
C2071 vss.n346 vss 0
C2072 vss.n347 vss 0.00129f
C2073 vss.n348 vss 0
C2074 vss.n349 vss 0
C2075 vss.n350 vss 0
C2076 vss.n351 vss 0
C2077 vss.n352 vss 0
C2078 vss.n353 vss 0
C2079 vss.n354 vss 0
C2080 vss.n355 vss 0
C2081 vss.n356 vss 0
C2082 vss.n357 vss 0
C2083 vss.n358 vss 0
C2084 vss.n359 vss 0
C2085 vss.n360 vss 0
C2086 vss.n361 vss 0
C2087 vss.n362 vss 0
C2088 vss.n363 vss 0.00837f
C2089 vss.n364 vss 0
C2090 vss.n365 vss 0.00706f
C2091 vss.n366 vss 0
C2092 vss.n367 vss 0
C2093 vss.n368 vss 0
C2094 vss.n369 vss 0
C2095 vss.n370 vss 0
C2096 vss.n371 vss 0
C2097 vss.n372 vss 0
C2098 vss.n373 vss 0
C2099 vss.n374 vss 0
C2100 vss.n375 vss 0
C2101 vss.n376 vss 0
C2102 vss.n377 vss 0
C2103 vss.n378 vss 0
C2104 vss.n379 vss 0
C2105 vss.n380 vss 0
C2106 vss.n381 vss 0
C2107 vss.n382 vss 0
C2108 vss.n383 vss 0
C2109 vss.n384 vss 0
C2110 vss.n385 vss 0
C2111 vss.n386 vss 0
C2112 vss.n387 vss 0
C2113 vss.n388 vss 0
C2114 vss.n389 vss 0
C2115 vss.n390 vss 0
C2116 vss.n391 vss 0
C2117 vss.n392 vss 0
C2118 vss.n393 vss 0
C2119 vss.n394 vss 0
C2120 vss.n395 vss 0
C2121 vss.n396 vss 0
C2122 vss.n397 vss 0
C2123 vss.n398 vss 0
C2124 vss.n399 vss 0
C2125 vss.n400 vss 0
C2126 vss.n401 vss 0
C2127 vss.n402 vss 0
C2128 vss.n403 vss 0
C2129 vss.n404 vss 0
C2130 vss.n405 vss 0
C2131 vss.n406 vss 0
C2132 vss.n407 vss 0
C2133 vss.n408 vss 0
C2134 vss.n409 vss 0
C2135 vss.n410 vss 0
C2136 vss.n411 vss 0
C2137 vss.n412 vss 0
C2138 vss.n413 vss 0
C2139 vss.n414 vss 0
C2140 vss.n415 vss 0
C2141 vss.n416 vss 0
C2142 vss.n417 vss 0
C2143 vss.n418 vss 0
C2144 vss.n419 vss 0
C2145 vss.n420 vss 0
C2146 vss.n421 vss 0
C2147 vss.n422 vss 0
C2148 vss.n423 vss 0
C2149 vss.n424 vss 0
C2150 vss.n425 vss 0
C2151 vss.n426 vss 0
C2152 vss.n427 vss 0
C2153 vss.n428 vss 0
C2154 vss.n429 vss 0
C2155 vss.n430 vss 0
C2156 vss.n431 vss 0
C2157 vss.n432 vss 0
C2158 vss.n433 vss 0
C2159 vss.n434 vss 0
C2160 vss.n435 vss 0
C2161 vss.n436 vss 0
C2162 vss.n437 vss 0
C2163 vss.n438 vss 0
C2164 vss.n439 vss 0
C2165 vss.n440 vss 0.00122f
C2166 vss.n441 vss 0
C2167 vss.n442 vss 0
C2168 vss.n443 vss 0
C2169 vss.n444 vss 0
C2170 vss.n445 vss 0
C2171 vss.n446 vss 0
C2172 vss.n447 vss 0
C2173 vss.n448 vss 0
C2174 vss.n449 vss 0
C2175 vss.n450 vss 0
C2176 vss.n451 vss 0
C2177 vss.n452 vss 0
C2178 vss.n453 vss 0
C2179 vss.n454 vss 0
C2180 vss.n455 vss 0
C2181 vss.n456 vss 0
C2182 vss.n457 vss 0
C2183 vss.n458 vss 0.00129f
C2184 vss.n459 vss 0
C2185 vss.n460 vss 0
C2186 vss.n461 vss 0
C2187 vss.n462 vss 0
C2188 vss.n463 vss 0
C2189 vss.n464 vss 0
C2190 vss.n465 vss 0
C2191 vss.n466 vss 0
C2192 vss.n467 vss 0
C2193 vss.n468 vss 0
C2194 vss.n469 vss 0
C2195 vss.n470 vss 0
C2196 vss.n471 vss 0
C2197 vss.n472 vss 0
C2198 vss.n473 vss 0
C2199 vss.n474 vss 0
C2200 vss.n475 vss 0
C2201 vss.n476 vss 0
C2202 vss.n477 vss 0
C2203 vss.n478 vss 0
C2204 vss.n479 vss 0
C2205 vss.n480 vss 0
C2206 vss.n481 vss 0.00129f
C2207 vss.n482 vss 0
C2208 vss.n483 vss 0
C2209 vss.n484 vss 0
C2210 vss.n486 vss 0
C2211 vss.n487 vss 0
C2212 vss.n488 vss 0
C2213 vss.n489 vss 0
C2214 vss.n490 vss 0
C2215 vss.n491 vss 0
C2216 vss.n492 vss 0
C2217 vss.n493 vss 0
C2218 vss.n494 vss 0
C2219 vss.n495 vss 0
C2220 vss.n496 vss 0
C2221 vss.n497 vss 0
C2222 vss.n498 vss 0
C2223 vss.n499 vss 0
C2224 vss.n500 vss 0
C2225 vss.n501 vss 0
C2226 vss.n502 vss 0
C2227 vss.n503 vss 0
C2228 vss.n504 vss 0
C2229 vss.n505 vss 0
C2230 vss.n506 vss 0
C2231 vss.n507 vss 0
C2232 vss.n508 vss 0
C2233 vss.n509 vss 0
C2234 vss.n510 vss 0
C2235 vss.n511 vss 0
C2236 vss.n512 vss 0
C2237 vss.n513 vss 0
C2238 vss.n514 vss 0
C2239 vss.n515 vss 0
C2240 vss.n516 vss 0
C2241 vss.n517 vss 0
C2242 vss.n518 vss 0
C2243 vss.n519 vss 0
C2244 vss.n520 vss 0
C2245 vss.n521 vss 0
C2246 vss.n522 vss 0
C2247 vss.n523 vss 0
C2248 vss.n524 vss 0
C2249 vss.n525 vss 0
C2250 vss.n526 vss 0
C2251 vss.n527 vss 0
C2252 vss.n528 vss 0
C2253 vss.n529 vss 0
C2254 vss.n530 vss 0
C2255 vss.n531 vss 0
C2256 vss.n532 vss 0.00103f
C2257 vss.n533 vss 0.00148f
C2258 vss.n534 vss 0
C2259 vss.n535 vss 0
C2260 vss.n536 vss 0
C2261 vss.n537 vss 0.00706f
C2262 vss.n538 vss 0.00429f
C2263 vss.n539 vss 0.00251f
C2264 vss.n540 vss 0.00212f
C2265 vss.n541 vss 0.00206f
C2266 vss.n542 vss 0.0023f
C2267 vss.n543 vss 0
C2268 vss.n544 vss 0
C2269 vss.n545 vss 0
C2270 vss.n546 vss 0
C2271 vss.n547 vss 0
C2272 vss.n548 vss 0.0023f
C2273 vss.n549 vss 0.0023f
C2274 vss.n550 vss 0.0023f
C2275 vss.n551 vss 0
C2276 vss.n552 vss 0
C2277 vss.n553 vss 0
C2278 vss.n554 vss 0
C2279 vss.n555 vss 0
C2280 vss.n556 vss 0.0023f
C2281 vss.n557 vss 0.0023f
C2282 vss.n558 vss 0.0023f
C2283 vss.n559 vss 0
C2284 vss.n560 vss 0
C2285 vss.n561 vss 0
C2286 vss.n562 vss 0
C2287 vss.n563 vss 0
C2288 vss.n564 vss 0.0023f
C2289 vss.n565 vss 0.0023f
C2290 vss.n566 vss 0.0023f
C2291 vss.n567 vss 0
C2292 vss.n568 vss 0
C2293 vss.n569 vss 0
C2294 vss.n570 vss 0
C2295 vss.n571 vss 0
C2296 vss.n572 vss 0.0023f
C2297 vss.n573 vss 0
C2298 vss.n574 vss 0
C2299 vss.n575 vss 0
C2300 vss.n576 vss 0
C2301 Unnamed_89a8896a_2/a_64_n131# vss 0.7065f
C2302 Unnamed_89a8896a_2/a_n64_n339# vss -0.16387f
.ends
