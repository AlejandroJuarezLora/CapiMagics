* NGSPICE file created from neurona_lvs.ext - technology: gf180mcuD

.subckt Unnamed_f25afa91 a_64_n131# w_n450_n560# a_n64_n339# a_n184_n131# VSUBS
X0 a_64_n131# a_n64_n339# a_n184_n131# w_n450_n560# pfet_03v3 ad=0.3p pd=2.2u as=0.3p ps=2.2u w=0.5u l=0.64u
C0 a_n184_n131# a_n64_n339# 0.04083f
C1 a_n184_n131# a_64_n131# 0.33132f
C2 a_64_n131# a_n64_n339# 0.01761f
C3 a_n184_n131# w_n450_n560# 0.22492f
C4 w_n450_n560# a_n64_n339# 0.46029f
C5 a_64_n131# w_n450_n560# 0.48547f
C6 a_64_n131# VSUBS 0.04567f
C7 a_n184_n131# VSUBS 0.04433f
C8 a_n64_n339# VSUBS 0.0526f
C9 w_n450_n560# VSUBS 3.77582f
.ends

.subckt Unnamed_2ef3bd2b a_n5000_n519# a_n5120_n311# a_n5330_n683# a_5000_n311#
X0 a_5000_n311# a_n5000_n519# a_n5120_n311# a_n5330_n683# nfet_03v3 ad=1.38p pd=5.8u as=1.38p ps=5.8u w=2.3u l=50u
C0 a_5000_n311# a_n5120_n311# 4.41467f
C1 a_5000_n311# a_n5000_n519# 0.22856f
C2 a_n5000_n519# a_n5120_n311# 1.8049f
C3 a_5000_n311# a_n5330_n683# 5.37377f
C4 a_n5120_n311# a_n5330_n683# 1.24677f
C5 a_n5000_n519# a_n5330_n683# 21.8141f
.ends

.subckt Unnamed_cc55e001 a_64_n131# a_n394_n504# a_n64_n339# a_n184_n131#
X0 a_64_n131# a_n64_n339# a_n184_n131# a_n394_n504# nfet_03v3 ad=0.3p pd=2.2u as=0.3p ps=2.2u w=0.5u l=0.64u
C0 a_64_n131# a_n184_n131# 0.33132f
C1 a_64_n131# a_n64_n339# 0.01761f
C2 a_n64_n339# a_n184_n131# 0.04083f
C3 a_64_n131# a_n394_n504# 0.53111f
C4 a_n184_n131# a_n394_n504# 0.26925f
C5 a_n64_n339# a_n394_n504# 0.51289f
.ends

.subckt neurona_lvs Vss
XUnnamed_f25afa91_0 Vss Vss Unnamed_f25afa91_2/a_64_n131# Vss Vss Unnamed_f25afa91
XUnnamed_f25afa91_1 Vss Vss Unnamed_f25afa91_2/a_64_n131# Vss Vss Unnamed_f25afa91
XUnnamed_f25afa91_2 Unnamed_f25afa91_2/a_64_n131# Vss Unnamed_f25afa91_2/a_n64_n339#
+ Vss Vss Unnamed_f25afa91
XUnnamed_2ef3bd2b_0 Vss Vss Vss Vss Unnamed_2ef3bd2b
XUnnamed_cc55e001_0 Vss Vss Unnamed_f25afa91_2/a_64_n131# Vss Unnamed_cc55e001
XUnnamed_cc55e001_1 Vss Vss Unnamed_f25afa91_2/a_64_n131# Vss Unnamed_cc55e001
XUnnamed_cc55e001_2 Unnamed_f25afa91_2/a_64_n131# Vss Unnamed_f25afa91_2/a_n64_n339#
+ Vss Unnamed_cc55e001
R0 Vss.n477 Vss.n475 18200
R1 Vss.n476 Vss.n395 18200
R2 Vss.n478 Vss.n477 14238.8
R3 Vss.n477 Vss.n476 4468.75
R4 Vss.n476 Vss.n179 4062.5
R5 Vss.n49 Vss.n48 521.494
R6 Vss.n48 Vss.n47 521.494
R7 Vss.n32 Vss.n31 521.494
R8 Vss.n31 Vss.n30 521.494
R9 Vss.n15 Vss.n14 521.494
R10 Vss.n14 Vss.n6 521.494
R11 Vss.n478 Vss.n457 229.434
R12 Vss.n430 Vss.n412 144.525
R13 Vss.n423 Vss.n421 144.525
R14 Vss.n507 Vss.n506 144.525
R15 Vss.n474 Vss.n453 144.525
R16 Vss.n631 Vss.n58 140.912
R17 Vss.n630 Vss.n61 140.912
R18 Vss.n516 Vss.n395 139.106
R19 Vss.n475 Vss.n403 131.88
R20 Vss.n431 Vss.n410 130.072
R21 Vss.n441 Vss.n411 130.072
R22 Vss.n496 Vss.n495 128.267
R23 Vss.n495 Vss.n494 122.847
R24 Vss.n493 Vss.n492 122.847
R25 Vss.n420 Vss.n411 121.04
R26 Vss.n515 Vss.n58 110.201
R27 Vss.n506 Vss.n505 102.975
R28 Vss.n253 Vss.n242 94.2375
R29 Vss.n261 Vss.n242 94.2375
R30 Vss.n261 Vss.n236 94.2375
R31 Vss.n269 Vss.n236 94.2375
R32 Vss.n269 Vss.n230 94.2375
R33 Vss.n277 Vss.n230 94.2375
R34 Vss.n277 Vss.n224 94.2375
R35 Vss.n285 Vss.n224 94.2375
R36 Vss.n285 Vss.n218 94.2375
R37 Vss.n293 Vss.n218 94.2375
R38 Vss.n293 Vss.n212 94.2375
R39 Vss.n301 Vss.n212 94.2375
R40 Vss.n301 Vss.n203 94.2375
R41 Vss.n312 Vss.n203 94.2375
R42 Vss.n312 Vss.n204 94.2375
R43 Vss.n204 Vss.n197 94.2375
R44 Vss.n322 Vss.n197 94.2375
R45 Vss.n322 Vss.n194 94.2375
R46 Vss.n327 Vss.n194 94.2375
R47 Vss.n328 Vss.n327 94.2375
R48 Vss.n331 Vss.n328 94.2375
R49 Vss.n331 Vss.n192 94.2375
R50 Vss.n336 Vss.n192 94.2375
R51 Vss.n337 Vss.n336 94.2375
R52 Vss.n340 Vss.n337 94.2375
R53 Vss.n340 Vss.n190 94.2375
R54 Vss.n345 Vss.n190 94.2375
R55 Vss.n346 Vss.n345 94.2375
R56 Vss.n349 Vss.n346 94.2375
R57 Vss.n349 Vss.n188 94.2375
R58 Vss.n354 Vss.n188 94.2375
R59 Vss.n355 Vss.n354 94.2375
R60 Vss.n358 Vss.n355 94.2375
R61 Vss.n358 Vss.n186 94.2375
R62 Vss.n363 Vss.n186 94.2375
R63 Vss.n364 Vss.n363 94.2375
R64 Vss.n367 Vss.n364 94.2375
R65 Vss.n367 Vss.n184 94.2375
R66 Vss.n372 Vss.n184 94.2375
R67 Vss.n373 Vss.n372 94.2375
R68 Vss.n375 Vss.n373 94.2375
R69 Vss.n375 Vss.n182 94.2375
R70 Vss.n380 Vss.n182 94.2375
R71 Vss.n381 Vss.n380 94.2375
R72 Vss.n382 Vss.n381 94.2375
R73 Vss.n412 Vss.n180 92.135
R74 Vss.n479 Vss.n75 84.0977
R75 Vss.n480 Vss.n479 84.0977
R76 Vss.n254 Vss.n245 84.0977
R77 Vss.n382 Vss.n179 74.2122
R78 Vss.n458 Vss.n456 69.0283
R79 Vss.n491 Vss.n458 69.0283
R80 Vss.n497 Vss.n451 69.0283
R81 Vss.n497 Vss.n450 69.0283
R82 Vss.n435 Vss.n432 69.0283
R83 Vss.n440 Vss.n409 69.0283
R84 Vss.n435 Vss.n408 69.0283
R85 Vss.n442 Vss.n409 69.0283
R86 Vss.n504 Vss.n56 69.0283
R87 Vss.n504 Vss.n503 69.0283
R88 Vss.n59 Vss.n57 69.0283
R89 Vss.n632 Vss.n57 69.0283
R90 Vss.n50 Vss.n39 62.1255
R91 Vss.n46 Vss.n39 62.1255
R92 Vss.n41 Vss.n40 62.1255
R93 Vss.n40 Vss.n38 62.1255
R94 Vss.n33 Vss.n22 62.1255
R95 Vss.n29 Vss.n22 62.1255
R96 Vss.n24 Vss.n23 62.1255
R97 Vss.n23 Vss.n21 62.1255
R98 Vss.n13 Vss.n4 62.1255
R99 Vss.n13 Vss.n12 62.1255
R100 Vss.n7 Vss.n5 62.1255
R101 Vss.n16 Vss.n5 62.1255
R102 Vss.n252 Vss.n245 52.7258
R103 Vss.n531 Vss.n180 52.3907
R104 Vss.n505 Vss.n403 41.5514
R105 Vss.n516 Vss.n515 34.3251
R106 Vss.n531 Vss.n179 30.712
R107 Vss.n423 Vss.n420 23.4858
R108 Vss.n494 Vss.n493 21.6792
R109 Vss.n492 Vss.n457 21.6792
R110 Vss.n496 Vss.n453 16.2595
R111 Vss.n491 Vss.n451 15.5561
R112 Vss.n456 Vss.n450 15.5561
R113 Vss.n440 Vss.n432 15.5561
R114 Vss.n442 Vss.n408 15.5561
R115 Vss.n503 Vss.n59 15.5561
R116 Vss.n251 Vss.n241 15.5561
R117 Vss.n262 Vss.n241 15.5561
R118 Vss.n262 Vss.n237 15.5561
R119 Vss.n268 Vss.n237 15.5561
R120 Vss.n268 Vss.n229 15.5561
R121 Vss.n278 Vss.n229 15.5561
R122 Vss.n278 Vss.n225 15.5561
R123 Vss.n284 Vss.n225 15.5561
R124 Vss.n284 Vss.n217 15.5561
R125 Vss.n294 Vss.n217 15.5561
R126 Vss.n294 Vss.n213 15.5561
R127 Vss.n300 Vss.n213 15.5561
R128 Vss.n300 Vss.n202 15.5561
R129 Vss.n313 Vss.n202 15.5561
R130 Vss.n313 Vss.n198 15.5561
R131 Vss.n320 Vss.n198 15.5561
R132 Vss.n321 Vss.n320 15.5561
R133 Vss.n321 Vss.n84 15.5561
R134 Vss.n85 Vss.n84 15.5561
R135 Vss.n86 Vss.n85 15.5561
R136 Vss.n330 Vss.n86 15.5561
R137 Vss.n330 Vss.n329 15.5561
R138 Vss.n329 Vss.n101 15.5561
R139 Vss.n102 Vss.n101 15.5561
R140 Vss.n339 Vss.n102 15.5561
R141 Vss.n339 Vss.n338 15.5561
R142 Vss.n338 Vss.n115 15.5561
R143 Vss.n116 Vss.n115 15.5561
R144 Vss.n348 Vss.n116 15.5561
R145 Vss.n348 Vss.n347 15.5561
R146 Vss.n347 Vss.n128 15.5561
R147 Vss.n129 Vss.n128 15.5561
R148 Vss.n357 Vss.n129 15.5561
R149 Vss.n357 Vss.n356 15.5561
R150 Vss.n356 Vss.n145 15.5561
R151 Vss.n146 Vss.n145 15.5561
R152 Vss.n366 Vss.n146 15.5561
R153 Vss.n366 Vss.n365 15.5561
R154 Vss.n365 Vss.n159 15.5561
R155 Vss.n160 Vss.n159 15.5561
R156 Vss.n374 Vss.n160 15.5561
R157 Vss.n374 Vss.n168 15.5561
R158 Vss.n169 Vss.n168 15.5561
R159 Vss.n170 Vss.n169 15.5561
R160 Vss.n177 Vss.n170 15.5561
R161 Vss.n532 Vss.n177 15.5561
R162 Vss.n532 Vss.n178 15.5561
R163 Vss.n429 Vss.n178 15.5561
R164 Vss.n429 Vss.n413 15.5561
R165 Vss.n425 Vss.n413 15.5561
R166 Vss.n425 Vss.n424 15.5561
R167 Vss.n424 Vss.n396 15.5561
R168 Vss.n514 Vss.n396 15.5561
R169 Vss.n514 Vss.n397 15.5561
R170 Vss.n397 Vss.n60 15.5561
R171 Vss.n508 Vss.n60 15.5561
R172 Vss.n508 Vss.n402 15.5561
R173 Vss.n462 Vss.n402 15.5561
R174 Vss.n473 Vss.n462 15.5561
R175 Vss.n473 Vss.n463 15.5561
R176 Vss.n463 Vss.n454 15.5561
R177 Vss.n455 Vss.n454 15.5561
R178 Vss.n480 Vss.n455 15.5561
R179 Vss.n254 Vss.n243 15.5561
R180 Vss.n260 Vss.n243 15.5561
R181 Vss.n260 Vss.n235 15.5561
R182 Vss.n270 Vss.n235 15.5561
R183 Vss.n270 Vss.n231 15.5561
R184 Vss.n276 Vss.n231 15.5561
R185 Vss.n276 Vss.n223 15.5561
R186 Vss.n286 Vss.n223 15.5561
R187 Vss.n286 Vss.n219 15.5561
R188 Vss.n292 Vss.n219 15.5561
R189 Vss.n292 Vss.n211 15.5561
R190 Vss.n302 Vss.n211 15.5561
R191 Vss.n302 Vss.n205 15.5561
R192 Vss.n311 Vss.n205 15.5561
R193 Vss.n311 Vss.n206 15.5561
R194 Vss.n206 Vss.n195 15.5561
R195 Vss.n323 Vss.n195 15.5561
R196 Vss.n324 Vss.n323 15.5561
R197 Vss.n326 Vss.n324 15.5561
R198 Vss.n326 Vss.n193 15.5561
R199 Vss.n332 Vss.n193 15.5561
R200 Vss.n334 Vss.n332 15.5561
R201 Vss.n335 Vss.n334 15.5561
R202 Vss.n335 Vss.n191 15.5561
R203 Vss.n341 Vss.n191 15.5561
R204 Vss.n343 Vss.n341 15.5561
R205 Vss.n344 Vss.n343 15.5561
R206 Vss.n344 Vss.n189 15.5561
R207 Vss.n350 Vss.n189 15.5561
R208 Vss.n352 Vss.n350 15.5561
R209 Vss.n353 Vss.n352 15.5561
R210 Vss.n353 Vss.n187 15.5561
R211 Vss.n359 Vss.n187 15.5561
R212 Vss.n361 Vss.n359 15.5561
R213 Vss.n362 Vss.n361 15.5561
R214 Vss.n362 Vss.n185 15.5561
R215 Vss.n368 Vss.n185 15.5561
R216 Vss.n370 Vss.n368 15.5561
R217 Vss.n371 Vss.n370 15.5561
R218 Vss.n371 Vss.n183 15.5561
R219 Vss.n376 Vss.n183 15.5561
R220 Vss.n377 Vss.n376 15.5561
R221 Vss.n379 Vss.n377 15.5561
R222 Vss.n379 Vss.n181 15.5561
R223 Vss.n383 Vss.n181 15.5561
R224 Vss.n530 Vss.n383 15.5561
R225 Vss.n530 Vss.n384 15.5561
R226 Vss.n389 Vss.n384 15.5561
R227 Vss.n390 Vss.n389 15.5561
R228 Vss.n391 Vss.n390 15.5561
R229 Vss.n422 Vss.n391 15.5561
R230 Vss.n422 Vss.n394 15.5561
R231 Vss.n517 Vss.n394 15.5561
R232 Vss.n517 Vss.n62 15.5561
R233 Vss.n629 Vss.n62 15.5561
R234 Vss.n629 Vss.n63 15.5561
R235 Vss.n68 Vss.n63 15.5561
R236 Vss.n69 Vss.n68 15.5561
R237 Vss.n70 Vss.n69 15.5561
R238 Vss.n452 Vss.n70 15.5561
R239 Vss.n452 Vss.n73 15.5561
R240 Vss.n74 Vss.n73 15.5561
R241 Vss.n75 Vss.n74 15.5561
R242 Vss.n431 Vss.n430 14.453
R243 Vss.n441 Vss.n410 14.453
R244 Vss.n475 Vss.n474 12.6464
R245 Vss.n539 Vss.n538 12.5005
R246 Vss.n174 Vss.n167 12.5005
R247 Vss.n543 Vss.n164 12.5005
R248 Vss.n547 Vss.n546 12.5005
R249 Vss.n549 Vss.n548 12.5005
R250 Vss.n552 Vss.n157 12.5005
R251 Vss.n152 Vss.n150 12.5005
R252 Vss.n558 Vss.n557 12.5005
R253 Vss.n560 Vss.n559 12.5005
R254 Vss.n563 Vss.n143 12.5005
R255 Vss.n138 Vss.n136 12.5005
R256 Vss.n569 Vss.n568 12.5005
R257 Vss.n571 Vss.n570 12.5005
R258 Vss.n574 Vss.n126 12.5005
R259 Vss.n122 Vss.n120 12.5005
R260 Vss.n580 Vss.n579 12.5005
R261 Vss.n582 Vss.n581 12.5005
R262 Vss.n585 Vss.n113 12.5005
R263 Vss.n108 Vss.n106 12.5005
R264 Vss.n591 Vss.n590 12.5005
R265 Vss.n593 Vss.n592 12.5005
R266 Vss.n596 Vss.n99 12.5005
R267 Vss.n94 Vss.n92 12.5005
R268 Vss.n602 Vss.n601 12.5005
R269 Vss.n604 Vss.n603 12.5005
R270 Vss.n91 Vss.n81 12.5005
R271 Vss.n608 Vss.n82 12.5005
R272 Vss.n635 Vss.n634 12.0394
R273 Vss.n82 Vss.n79 11.7031
R274 Vss.n538 Vss.n537 11.545
R275 Vss.n488 Vss.n483 10.9121
R276 Vss.n612 Vss.n611 7.89186
R277 Vss.n613 Vss.n612 7.73533
R278 Vss.n247 Vss.n246 7.57378
R279 Vss.n51 Vss.n50 6.37187
R280 Vss.n51 Vss.n38 6.37187
R281 Vss.n34 Vss.n33 6.37187
R282 Vss.n34 Vss.n21 6.37187
R283 Vss.n17 Vss.n16 6.37187
R284 Vss.n17 Vss.n4 6.37187
R285 Vss.n46 Vss.n45 6.3005
R286 Vss.n42 Vss.n41 6.3005
R287 Vss.n29 Vss.n28 6.3005
R288 Vss.n25 Vss.n24 6.3005
R289 Vss.n12 Vss.n11 6.3005
R290 Vss.n8 Vss.n7 6.3005
R291 Vss.n91 Vss.n82 5.61588
R292 Vss.n603 Vss.n91 5.61588
R293 Vss.n603 Vss.n602 5.61588
R294 Vss.n602 Vss.n92 5.61588
R295 Vss.n99 Vss.n92 5.61588
R296 Vss.n592 Vss.n99 5.61588
R297 Vss.n592 Vss.n591 5.61588
R298 Vss.n591 Vss.n106 5.61588
R299 Vss.n113 Vss.n106 5.61588
R300 Vss.n581 Vss.n113 5.61588
R301 Vss.n581 Vss.n580 5.61588
R302 Vss.n580 Vss.n120 5.61588
R303 Vss.n126 Vss.n120 5.61588
R304 Vss.n570 Vss.n569 5.61588
R305 Vss.n569 Vss.n136 5.61588
R306 Vss.n143 Vss.n136 5.61588
R307 Vss.n559 Vss.n143 5.61588
R308 Vss.n559 Vss.n558 5.61588
R309 Vss.n558 Vss.n150 5.61588
R310 Vss.n157 Vss.n150 5.61588
R311 Vss.n548 Vss.n157 5.61588
R312 Vss.n548 Vss.n547 5.61588
R313 Vss.n547 Vss.n164 5.61588
R314 Vss.n174 Vss.n164 5.61588
R315 Vss.n538 Vss.n174 5.61588
R316 Vss.n421 Vss.n395 5.42018
R317 Vss.n249 Vss.n248 5.35452
R318 Vss.n498 Vss.n449 5.20101
R319 Vss.n437 Vss.n436 5.20101
R320 Vss.n43 Vss.n1 5.20101
R321 Vss.n44 Vss.n0 5.20101
R322 Vss.n26 Vss.n20 5.20101
R323 Vss.n27 Vss.n19 5.20101
R324 Vss.n9 Vss.n3 5.20101
R325 Vss.n10 Vss.n2 5.20101
R326 Vss.n485 Vss.n456 5.2005
R327 Vss.n492 Vss.n456 5.2005
R328 Vss.n484 Vss.n450 5.2005
R329 Vss.n494 Vss.n450 5.2005
R330 Vss.n491 Vss.n490 5.2005
R331 Vss.n492 Vss.n491 5.2005
R332 Vss.n459 Vss.n451 5.2005
R333 Vss.n494 Vss.n451 5.2005
R334 Vss.n440 Vss.n439 5.2005
R335 Vss.n441 Vss.n440 5.2005
R336 Vss.n433 Vss.n432 5.2005
R337 Vss.n432 Vss.n431 5.2005
R338 Vss.n443 Vss.n442 5.2005
R339 Vss.n442 Vss.n441 5.2005
R340 Vss.n408 Vss.n407 5.2005
R341 Vss.n431 Vss.n408 5.2005
R342 Vss.n503 Vss.n502 5.2005
R343 Vss.n503 Vss.n61 5.2005
R344 Vss.n404 Vss.n59 5.2005
R345 Vss.n631 Vss.n59 5.2005
R346 Vss.n61 Vss.n56 5.2005
R347 Vss.n632 Vss.n631 5.2005
R348 Vss.n481 Vss.n480 5.2005
R349 Vss.n480 Vss.n457 5.2005
R350 Vss.n461 Vss.n455 5.2005
R351 Vss.n493 Vss.n455 5.2005
R352 Vss.n470 Vss.n454 5.2005
R353 Vss.n495 Vss.n454 5.2005
R354 Vss.n471 Vss.n463 5.2005
R355 Vss.n463 Vss.n453 5.2005
R356 Vss.n473 Vss.n472 5.2005
R357 Vss.n474 Vss.n473 5.2005
R358 Vss.n464 Vss.n462 5.2005
R359 Vss.n462 Vss.n403 5.2005
R360 Vss.n402 Vss.n401 5.2005
R361 Vss.n506 Vss.n402 5.2005
R362 Vss.n509 Vss.n508 5.2005
R363 Vss.n508 Vss.n507 5.2005
R364 Vss.n511 Vss.n60 5.2005
R365 Vss.n630 Vss.n60 5.2005
R366 Vss.n512 Vss.n397 5.2005
R367 Vss.n397 Vss.n58 5.2005
R368 Vss.n514 Vss.n513 5.2005
R369 Vss.n516 Vss.n514 5.2005
R370 Vss.n398 Vss.n396 5.2005
R371 Vss.n421 Vss.n396 5.2005
R372 Vss.n424 Vss.n419 5.2005
R373 Vss.n424 Vss.n423 5.2005
R374 Vss.n426 Vss.n425 5.2005
R375 Vss.n425 Vss.n411 5.2005
R376 Vss.n427 Vss.n413 5.2005
R377 Vss.n413 Vss.n410 5.2005
R378 Vss.n429 Vss.n428 5.2005
R379 Vss.n430 Vss.n429 5.2005
R380 Vss.n178 Vss.n176 5.2005
R381 Vss.n412 Vss.n178 5.2005
R382 Vss.n533 Vss.n532 5.2005
R383 Vss.n532 Vss.n531 5.2005
R384 Vss.n177 Vss.n171 5.2005
R385 Vss.n382 Vss.n177 5.2005
R386 Vss.n540 Vss.n170 5.2005
R387 Vss.n381 Vss.n170 5.2005
R388 Vss.n541 Vss.n169 5.2005
R389 Vss.n380 Vss.n169 5.2005
R390 Vss.n542 Vss.n168 5.2005
R391 Vss.n182 Vss.n168 5.2005
R392 Vss.n374 Vss.n161 5.2005
R393 Vss.n375 Vss.n374 5.2005
R394 Vss.n550 Vss.n160 5.2005
R395 Vss.n373 Vss.n160 5.2005
R396 Vss.n551 Vss.n159 5.2005
R397 Vss.n372 Vss.n159 5.2005
R398 Vss.n365 Vss.n158 5.2005
R399 Vss.n365 Vss.n184 5.2005
R400 Vss.n366 Vss.n147 5.2005
R401 Vss.n367 Vss.n366 5.2005
R402 Vss.n561 Vss.n146 5.2005
R403 Vss.n364 Vss.n146 5.2005
R404 Vss.n562 Vss.n145 5.2005
R405 Vss.n363 Vss.n145 5.2005
R406 Vss.n356 Vss.n144 5.2005
R407 Vss.n356 Vss.n186 5.2005
R408 Vss.n357 Vss.n130 5.2005
R409 Vss.n358 Vss.n357 5.2005
R410 Vss.n572 Vss.n129 5.2005
R411 Vss.n355 Vss.n129 5.2005
R412 Vss.n573 Vss.n128 5.2005
R413 Vss.n354 Vss.n128 5.2005
R414 Vss.n347 Vss.n127 5.2005
R415 Vss.n347 Vss.n188 5.2005
R416 Vss.n348 Vss.n117 5.2005
R417 Vss.n349 Vss.n348 5.2005
R418 Vss.n583 Vss.n116 5.2005
R419 Vss.n346 Vss.n116 5.2005
R420 Vss.n584 Vss.n115 5.2005
R421 Vss.n345 Vss.n115 5.2005
R422 Vss.n338 Vss.n114 5.2005
R423 Vss.n338 Vss.n190 5.2005
R424 Vss.n339 Vss.n103 5.2005
R425 Vss.n340 Vss.n339 5.2005
R426 Vss.n594 Vss.n102 5.2005
R427 Vss.n337 Vss.n102 5.2005
R428 Vss.n595 Vss.n101 5.2005
R429 Vss.n336 Vss.n101 5.2005
R430 Vss.n329 Vss.n100 5.2005
R431 Vss.n329 Vss.n192 5.2005
R432 Vss.n330 Vss.n87 5.2005
R433 Vss.n331 Vss.n330 5.2005
R434 Vss.n605 Vss.n86 5.2005
R435 Vss.n328 Vss.n86 5.2005
R436 Vss.n606 Vss.n85 5.2005
R437 Vss.n327 Vss.n85 5.2005
R438 Vss.n607 Vss.n84 5.2005
R439 Vss.n194 Vss.n84 5.2005
R440 Vss.n321 Vss.n83 5.2005
R441 Vss.n322 Vss.n321 5.2005
R442 Vss.n320 Vss.n319 5.2005
R443 Vss.n320 Vss.n197 5.2005
R444 Vss.n199 Vss.n198 5.2005
R445 Vss.n204 Vss.n198 5.2005
R446 Vss.n314 Vss.n313 5.2005
R447 Vss.n313 Vss.n312 5.2005
R448 Vss.n202 Vss.n201 5.2005
R449 Vss.n203 Vss.n202 5.2005
R450 Vss.n300 Vss.n299 5.2005
R451 Vss.n301 Vss.n300 5.2005
R452 Vss.n214 Vss.n213 5.2005
R453 Vss.n213 Vss.n212 5.2005
R454 Vss.n295 Vss.n294 5.2005
R455 Vss.n294 Vss.n293 5.2005
R456 Vss.n217 Vss.n216 5.2005
R457 Vss.n218 Vss.n217 5.2005
R458 Vss.n284 Vss.n283 5.2005
R459 Vss.n285 Vss.n284 5.2005
R460 Vss.n226 Vss.n225 5.2005
R461 Vss.n225 Vss.n224 5.2005
R462 Vss.n279 Vss.n278 5.2005
R463 Vss.n278 Vss.n277 5.2005
R464 Vss.n229 Vss.n228 5.2005
R465 Vss.n230 Vss.n229 5.2005
R466 Vss.n268 Vss.n267 5.2005
R467 Vss.n269 Vss.n268 5.2005
R468 Vss.n238 Vss.n237 5.2005
R469 Vss.n237 Vss.n236 5.2005
R470 Vss.n263 Vss.n262 5.2005
R471 Vss.n262 Vss.n261 5.2005
R472 Vss.n241 Vss.n240 5.2005
R473 Vss.n242 Vss.n241 5.2005
R474 Vss.n251 Vss.n250 5.2005
R475 Vss.n616 Vss.n75 5.2005
R476 Vss.n457 Vss.n75 5.2005
R477 Vss.n617 Vss.n74 5.2005
R478 Vss.n493 Vss.n74 5.2005
R479 Vss.n618 Vss.n73 5.2005
R480 Vss.n495 Vss.n73 5.2005
R481 Vss.n452 Vss.n71 5.2005
R482 Vss.n453 Vss.n452 5.2005
R483 Vss.n622 Vss.n70 5.2005
R484 Vss.n474 Vss.n70 5.2005
R485 Vss.n623 Vss.n69 5.2005
R486 Vss.n403 Vss.n69 5.2005
R487 Vss.n624 Vss.n68 5.2005
R488 Vss.n506 Vss.n68 5.2005
R489 Vss.n65 Vss.n63 5.2005
R490 Vss.n507 Vss.n63 5.2005
R491 Vss.n629 Vss.n628 5.2005
R492 Vss.n630 Vss.n629 5.2005
R493 Vss.n64 Vss.n62 5.2005
R494 Vss.n62 Vss.n58 5.2005
R495 Vss.n518 Vss.n517 5.2005
R496 Vss.n517 Vss.n516 5.2005
R497 Vss.n519 Vss.n394 5.2005
R498 Vss.n421 Vss.n394 5.2005
R499 Vss.n422 Vss.n392 5.2005
R500 Vss.n423 Vss.n422 5.2005
R501 Vss.n523 Vss.n391 5.2005
R502 Vss.n411 Vss.n391 5.2005
R503 Vss.n524 Vss.n390 5.2005
R504 Vss.n410 Vss.n390 5.2005
R505 Vss.n525 Vss.n389 5.2005
R506 Vss.n430 Vss.n389 5.2005
R507 Vss.n386 Vss.n384 5.2005
R508 Vss.n412 Vss.n384 5.2005
R509 Vss.n530 Vss.n529 5.2005
R510 Vss.n531 Vss.n530 5.2005
R511 Vss.n385 Vss.n383 5.2005
R512 Vss.n383 Vss.n382 5.2005
R513 Vss.n181 Vss.n172 5.2005
R514 Vss.n381 Vss.n181 5.2005
R515 Vss.n379 Vss.n378 5.2005
R516 Vss.n380 Vss.n379 5.2005
R517 Vss.n377 Vss.n166 5.2005
R518 Vss.n377 Vss.n182 5.2005
R519 Vss.n376 Vss.n165 5.2005
R520 Vss.n376 Vss.n375 5.2005
R521 Vss.n183 Vss.n162 5.2005
R522 Vss.n373 Vss.n183 5.2005
R523 Vss.n371 Vss.n155 5.2005
R524 Vss.n372 Vss.n371 5.2005
R525 Vss.n370 Vss.n369 5.2005
R526 Vss.n370 Vss.n184 5.2005
R527 Vss.n368 Vss.n151 5.2005
R528 Vss.n368 Vss.n367 5.2005
R529 Vss.n185 Vss.n148 5.2005
R530 Vss.n364 Vss.n185 5.2005
R531 Vss.n362 Vss.n141 5.2005
R532 Vss.n363 Vss.n362 5.2005
R533 Vss.n361 Vss.n360 5.2005
R534 Vss.n361 Vss.n186 5.2005
R535 Vss.n359 Vss.n137 5.2005
R536 Vss.n359 Vss.n358 5.2005
R537 Vss.n187 Vss.n132 5.2005
R538 Vss.n355 Vss.n187 5.2005
R539 Vss.n353 Vss.n125 5.2005
R540 Vss.n354 Vss.n353 5.2005
R541 Vss.n352 Vss.n351 5.2005
R542 Vss.n352 Vss.n188 5.2005
R543 Vss.n350 Vss.n121 5.2005
R544 Vss.n350 Vss.n349 5.2005
R545 Vss.n189 Vss.n118 5.2005
R546 Vss.n346 Vss.n189 5.2005
R547 Vss.n344 Vss.n111 5.2005
R548 Vss.n345 Vss.n344 5.2005
R549 Vss.n343 Vss.n342 5.2005
R550 Vss.n343 Vss.n190 5.2005
R551 Vss.n341 Vss.n107 5.2005
R552 Vss.n341 Vss.n340 5.2005
R553 Vss.n191 Vss.n104 5.2005
R554 Vss.n337 Vss.n191 5.2005
R555 Vss.n335 Vss.n97 5.2005
R556 Vss.n336 Vss.n335 5.2005
R557 Vss.n334 Vss.n333 5.2005
R558 Vss.n334 Vss.n192 5.2005
R559 Vss.n332 Vss.n93 5.2005
R560 Vss.n332 Vss.n331 5.2005
R561 Vss.n193 Vss.n89 5.2005
R562 Vss.n328 Vss.n193 5.2005
R563 Vss.n326 Vss.n325 5.2005
R564 Vss.n327 Vss.n326 5.2005
R565 Vss.n324 Vss.n80 5.2005
R566 Vss.n324 Vss.n194 5.2005
R567 Vss.n323 Vss.n196 5.2005
R568 Vss.n323 Vss.n322 5.2005
R569 Vss.n306 Vss.n195 5.2005
R570 Vss.n197 Vss.n195 5.2005
R571 Vss.n208 Vss.n206 5.2005
R572 Vss.n206 Vss.n204 5.2005
R573 Vss.n311 Vss.n310 5.2005
R574 Vss.n312 Vss.n311 5.2005
R575 Vss.n207 Vss.n205 5.2005
R576 Vss.n205 Vss.n203 5.2005
R577 Vss.n303 Vss.n302 5.2005
R578 Vss.n302 Vss.n301 5.2005
R579 Vss.n211 Vss.n210 5.2005
R580 Vss.n212 Vss.n211 5.2005
R581 Vss.n292 Vss.n291 5.2005
R582 Vss.n293 Vss.n292 5.2005
R583 Vss.n220 Vss.n219 5.2005
R584 Vss.n219 Vss.n218 5.2005
R585 Vss.n287 Vss.n286 5.2005
R586 Vss.n286 Vss.n285 5.2005
R587 Vss.n223 Vss.n222 5.2005
R588 Vss.n224 Vss.n223 5.2005
R589 Vss.n276 Vss.n275 5.2005
R590 Vss.n277 Vss.n276 5.2005
R591 Vss.n232 Vss.n231 5.2005
R592 Vss.n231 Vss.n230 5.2005
R593 Vss.n271 Vss.n270 5.2005
R594 Vss.n270 Vss.n269 5.2005
R595 Vss.n235 Vss.n234 5.2005
R596 Vss.n236 Vss.n235 5.2005
R597 Vss.n260 Vss.n259 5.2005
R598 Vss.n261 Vss.n260 5.2005
R599 Vss.n244 Vss.n243 5.2005
R600 Vss.n243 Vss.n242 5.2005
R601 Vss.n255 Vss.n254 5.2005
R602 Vss.n254 Vss.n253 5.2005
R603 Vss.n487 Vss.n486 5.19319
R604 Vss.n438 Vss.n405 5.19319
R605 Vss.n248 Vss.n247 5.14053
R606 Vss.n483 Vss.n76 5.12952
R607 Vss.n634 Vss.n54 5.12001
R608 Vss.n634 Vss.n53 5.11219
R609 Vss.n615 Vss.n614 5.04833
R610 Vss.n488 Vss.n487 4.98321
R611 Vss.n499 Vss.n498 4.98321
R612 Vss.n445 Vss.n405 4.98321
R613 Vss.n436 Vss.n434 4.98321
R614 Vss.n446 Vss.n54 4.98321
R615 Vss.n500 Vss.n53 4.98321
R616 Vss.n52 Vss.n1 4.98321
R617 Vss.n35 Vss.n20 4.98321
R618 Vss.n18 Vss.n3 4.98321
R619 Vss.n52 Vss.n0 4.97539
R620 Vss.n35 Vss.n19 4.97539
R621 Vss.n18 Vss.n2 4.97539
R622 Vss.n614 Vss.n613 4.7183
R623 Vss.n535 Vss.n171 4.5005
R624 Vss.n534 Vss.n533 4.5005
R625 Vss.n176 Vss.n175 4.5005
R626 Vss.n428 Vss.n414 4.5005
R627 Vss.n427 Vss.n415 4.5005
R628 Vss.n426 Vss.n416 4.5005
R629 Vss.n419 Vss.n418 4.5005
R630 Vss.n417 Vss.n398 4.5005
R631 Vss.n513 Vss.n399 4.5005
R632 Vss.n512 Vss.n400 4.5005
R633 Vss.n490 Vss.n489 4.5005
R634 Vss.n459 Vss.n448 4.5005
R635 Vss.n486 Vss.n485 4.5005
R636 Vss.n484 Vss.n449 4.5005
R637 Vss.n439 Vss.n438 4.5005
R638 Vss.n437 Vss.n433 4.5005
R639 Vss.n444 Vss.n443 4.5005
R640 Vss.n407 Vss.n406 4.5005
R641 Vss.n502 Vss.n501 4.5005
R642 Vss.n447 Vss.n404 4.5005
R643 Vss.n45 Vss.n44 4.5005
R644 Vss.n43 Vss.n42 4.5005
R645 Vss.n28 Vss.n27 4.5005
R646 Vss.n26 Vss.n25 4.5005
R647 Vss.n11 Vss.n10 4.5005
R648 Vss.n9 Vss.n8 4.5005
R649 Vss.n465 Vss.n401 4.5005
R650 Vss.n466 Vss.n464 4.5005
R651 Vss.n472 Vss.n467 4.5005
R652 Vss.n471 Vss.n468 4.5005
R653 Vss.n470 Vss.n469 4.5005
R654 Vss.n461 Vss.n460 4.5005
R655 Vss.n482 Vss.n481 4.5005
R656 Vss.n387 Vss.n385 4.5005
R657 Vss.n529 Vss.n528 4.5005
R658 Vss.n527 Vss.n386 4.5005
R659 Vss.n526 Vss.n525 4.5005
R660 Vss.n524 Vss.n388 4.5005
R661 Vss.n523 Vss.n522 4.5005
R662 Vss.n521 Vss.n392 4.5005
R663 Vss.n520 Vss.n519 4.5005
R664 Vss.n518 Vss.n393 4.5005
R665 Vss.n66 Vss.n64 4.5005
R666 Vss.n628 Vss.n627 4.5005
R667 Vss.n626 Vss.n65 4.5005
R668 Vss.n625 Vss.n624 4.5005
R669 Vss.n623 Vss.n67 4.5005
R670 Vss.n622 Vss.n621 4.5005
R671 Vss.n620 Vss.n71 4.5005
R672 Vss.n619 Vss.n618 4.5005
R673 Vss.n617 Vss.n72 4.5005
R674 Vss.n616 Vss.n615 4.5005
R675 Vss.n257 Vss.n244 4.5005
R676 Vss.n259 Vss.n258 4.5005
R677 Vss.n234 Vss.n233 4.5005
R678 Vss.n272 Vss.n271 4.5005
R679 Vss.n273 Vss.n232 4.5005
R680 Vss.n275 Vss.n274 4.5005
R681 Vss.n222 Vss.n221 4.5005
R682 Vss.n288 Vss.n287 4.5005
R683 Vss.n289 Vss.n220 4.5005
R684 Vss.n291 Vss.n290 4.5005
R685 Vss.n210 Vss.n209 4.5005
R686 Vss.n304 Vss.n303 4.5005
R687 Vss.n305 Vss.n207 4.5005
R688 Vss.n310 Vss.n309 4.5005
R689 Vss.n308 Vss.n208 4.5005
R690 Vss.n307 Vss.n306 4.5005
R691 Vss.n196 Vss.n78 4.5005
R692 Vss.n256 Vss.n255 4.5005
R693 Vss.n240 Vss.n239 4.5005
R694 Vss.n264 Vss.n263 4.5005
R695 Vss.n265 Vss.n238 4.5005
R696 Vss.n267 Vss.n266 4.5005
R697 Vss.n228 Vss.n227 4.5005
R698 Vss.n280 Vss.n279 4.5005
R699 Vss.n281 Vss.n226 4.5005
R700 Vss.n283 Vss.n282 4.5005
R701 Vss.n216 Vss.n215 4.5005
R702 Vss.n296 Vss.n295 4.5005
R703 Vss.n297 Vss.n214 4.5005
R704 Vss.n299 Vss.n298 4.5005
R705 Vss.n201 Vss.n200 4.5005
R706 Vss.n315 Vss.n314 4.5005
R707 Vss.n316 Vss.n199 4.5005
R708 Vss.n319 Vss.n318 4.5005
R709 Vss.n317 Vss.n83 4.5005
R710 Vss.n250 Vss.n249 4.5005
R711 Vss.n608 Vss.n80 4.5005
R712 Vss.n325 Vss.n81 4.5005
R713 Vss.n604 Vss.n89 4.5005
R714 Vss.n601 Vss.n93 4.5005
R715 Vss.n333 Vss.n94 4.5005
R716 Vss.n596 Vss.n97 4.5005
R717 Vss.n593 Vss.n104 4.5005
R718 Vss.n590 Vss.n107 4.5005
R719 Vss.n342 Vss.n108 4.5005
R720 Vss.n585 Vss.n111 4.5005
R721 Vss.n582 Vss.n118 4.5005
R722 Vss.n579 Vss.n121 4.5005
R723 Vss.n351 Vss.n122 4.5005
R724 Vss.n574 Vss.n125 4.5005
R725 Vss.n571 Vss.n132 4.5005
R726 Vss.n568 Vss.n137 4.5005
R727 Vss.n360 Vss.n138 4.5005
R728 Vss.n563 Vss.n141 4.5005
R729 Vss.n560 Vss.n148 4.5005
R730 Vss.n557 Vss.n151 4.5005
R731 Vss.n369 Vss.n152 4.5005
R732 Vss.n552 Vss.n155 4.5005
R733 Vss.n549 Vss.n162 4.5005
R734 Vss.n546 Vss.n165 4.5005
R735 Vss.n543 Vss.n166 4.5005
R736 Vss.n378 Vss.n167 4.5005
R737 Vss.n539 Vss.n172 4.5005
R738 Vss.n608 Vss.n607 4.5005
R739 Vss.n606 Vss.n81 4.5005
R740 Vss.n605 Vss.n604 4.5005
R741 Vss.n601 Vss.n87 4.5005
R742 Vss.n100 Vss.n94 4.5005
R743 Vss.n596 Vss.n595 4.5005
R744 Vss.n594 Vss.n593 4.5005
R745 Vss.n590 Vss.n103 4.5005
R746 Vss.n114 Vss.n108 4.5005
R747 Vss.n585 Vss.n584 4.5005
R748 Vss.n583 Vss.n582 4.5005
R749 Vss.n579 Vss.n117 4.5005
R750 Vss.n127 Vss.n122 4.5005
R751 Vss.n574 Vss.n573 4.5005
R752 Vss.n572 Vss.n571 4.5005
R753 Vss.n568 Vss.n130 4.5005
R754 Vss.n144 Vss.n138 4.5005
R755 Vss.n563 Vss.n562 4.5005
R756 Vss.n561 Vss.n560 4.5005
R757 Vss.n557 Vss.n147 4.5005
R758 Vss.n158 Vss.n152 4.5005
R759 Vss.n552 Vss.n551 4.5005
R760 Vss.n550 Vss.n549 4.5005
R761 Vss.n546 Vss.n161 4.5005
R762 Vss.n543 Vss.n542 4.5005
R763 Vss.n541 Vss.n167 4.5005
R764 Vss.n540 Vss.n539 4.5005
R765 Vss.n631 Vss.n630 3.61362
R766 Vss.n507 Vss.n61 3.61362
R767 Vss.n47 Vss.n46 3.31679
R768 Vss.n47 Vss.n41 3.31679
R769 Vss.n49 Vss.n38 3.31679
R770 Vss.n50 Vss.n49 3.31679
R771 Vss.n30 Vss.n29 3.31679
R772 Vss.n30 Vss.n24 3.31679
R773 Vss.n32 Vss.n21 3.31679
R774 Vss.n33 Vss.n32 3.31679
R775 Vss.n12 Vss.n6 3.31679
R776 Vss.n7 Vss.n6 3.31679
R777 Vss.n15 Vss.n4 3.31679
R778 Vss.n16 Vss.n15 3.31679
R779 Vss.n634 Vss.n633 3.28078
R780 Vss.n253 Vss.n252 3.26114
R781 Vss.n633 Vss.n632 3.14293
R782 Vss.n633 Vss.n56 3.14293
R783 Vss.n135 Vss.n126 2.80819
R784 Vss.n570 Vss.n135 2.80819
R785 Vss.n613 Vss.n77 2.6735
R786 Vss.n611 Vss.n610 2.4683
R787 Vss.n35 Vss.n34 2.21557
R788 Vss.n18 Vss.n17 2.21557
R789 Vss.n52 Vss.n51 2.21557
R790 Vss.n510 Vss.n55 2.21557
R791 Vss.n252 Vss.n251 1.82789
R792 Vss.n537 Vss.n55 1.23277
R793 Vss.n36 Vss 1.0868
R794 Vss.n39 Vss.n0 0.9005
R795 Vss.n48 Vss.n39 0.9005
R796 Vss.n40 Vss.n1 0.9005
R797 Vss.n48 Vss.n40 0.9005
R798 Vss.n22 Vss.n19 0.9005
R799 Vss.n31 Vss.n22 0.9005
R800 Vss.n23 Vss.n20 0.9005
R801 Vss.n31 Vss.n23 0.9005
R802 Vss.n13 Vss.n2 0.9005
R803 Vss.n14 Vss.n13 0.9005
R804 Vss.n5 Vss.n3 0.9005
R805 Vss.n14 Vss.n5 0.9005
R806 Vss.n498 Vss.n497 0.743357
R807 Vss.n497 Vss.n496 0.743357
R808 Vss.n487 Vss.n458 0.743357
R809 Vss.n478 Vss.n458 0.743357
R810 Vss.n409 Vss.n405 0.743357
R811 Vss.n420 Vss.n409 0.743357
R812 Vss.n436 Vss.n435 0.743357
R813 Vss.n435 Vss.n180 0.743357
R814 Vss.n504 Vss.n53 0.743357
R815 Vss.n505 Vss.n504 0.743357
R816 Vss.n57 Vss.n54 0.743357
R817 Vss.n515 Vss.n57 0.743357
R818 Vss.n610 Vss.n609 0.573125
R819 Vss.n536 Vss.n173 0.483125
R820 Vss.n609 Vss.n79 0.483125
R821 Vss.n479 Vss.n76 0.473227
R822 Vss.n479 Vss.n478 0.473227
R823 Vss.n248 Vss.n245 0.473227
R824 Vss.n387 Vss.n77 0.44735
R825 Vss.n173 Vss.n77 0.393125
R826 Vss.n37 Vss.n18 0.316383
R827 Vss.n614 Vss.n76 0.29887
R828 Vss.n545 Vss.n544 0.28625
R829 Vss.n544 Vss.n163 0.28175
R830 Vss.n156 Vss.n154 0.28175
R831 Vss.n554 Vss.n553 0.28175
R832 Vss.n556 Vss.n555 0.28175
R833 Vss.n153 Vss.n149 0.28175
R834 Vss.n142 Vss.n140 0.28175
R835 Vss.n565 Vss.n564 0.28175
R836 Vss.n567 Vss.n566 0.28175
R837 Vss.n139 Vss.n133 0.28175
R838 Vss.n131 Vss.n124 0.28175
R839 Vss.n576 Vss.n575 0.28175
R840 Vss.n578 Vss.n577 0.28175
R841 Vss.n123 Vss.n119 0.28175
R842 Vss.n112 Vss.n110 0.28175
R843 Vss.n587 Vss.n586 0.28175
R844 Vss.n589 Vss.n588 0.28175
R845 Vss.n109 Vss.n105 0.28175
R846 Vss.n98 Vss.n96 0.28175
R847 Vss.n598 Vss.n597 0.28175
R848 Vss.n600 Vss.n599 0.28175
R849 Vss.n95 Vss.n90 0.28175
R850 Vss.n246 Vss.n88 0.28175
R851 Vss.n536 Vss.n535 0.26735
R852 Vss.n483 Vss.n482 0.2255
R853 Vss.n537 Vss.n536 0.219838
R854 Vss.n610 Vss.n78 0.20615
R855 Vss.n317 Vss.n79 0.20615
R856 Vss.n500 Vss.n499 0.2057
R857 Vss.n446 Vss.n445 0.2057
R858 Vss.n37 Vss.n36 0.2057
R859 Vss.n434 Vss.n173 0.1841
R860 Vss.n135 Vss.n134 0.1684
R861 Vss.n250 Vss.n240 0.1445
R862 Vss.n263 Vss.n240 0.1445
R863 Vss.n263 Vss.n238 0.1445
R864 Vss.n267 Vss.n238 0.1445
R865 Vss.n267 Vss.n228 0.1445
R866 Vss.n279 Vss.n228 0.1445
R867 Vss.n279 Vss.n226 0.1445
R868 Vss.n283 Vss.n226 0.1445
R869 Vss.n283 Vss.n216 0.1445
R870 Vss.n295 Vss.n216 0.1445
R871 Vss.n295 Vss.n214 0.1445
R872 Vss.n299 Vss.n214 0.1445
R873 Vss.n299 Vss.n201 0.1445
R874 Vss.n314 Vss.n201 0.1445
R875 Vss.n314 Vss.n199 0.1445
R876 Vss.n319 Vss.n199 0.1445
R877 Vss.n319 Vss.n83 0.1445
R878 Vss.n607 Vss.n83 0.1445
R879 Vss.n607 Vss.n606 0.1445
R880 Vss.n606 Vss.n605 0.1445
R881 Vss.n605 Vss.n87 0.1445
R882 Vss.n100 Vss.n87 0.1445
R883 Vss.n595 Vss.n100 0.1445
R884 Vss.n595 Vss.n594 0.1445
R885 Vss.n594 Vss.n103 0.1445
R886 Vss.n114 Vss.n103 0.1445
R887 Vss.n584 Vss.n114 0.1445
R888 Vss.n584 Vss.n583 0.1445
R889 Vss.n583 Vss.n117 0.1445
R890 Vss.n127 Vss.n117 0.1445
R891 Vss.n573 Vss.n127 0.1445
R892 Vss.n573 Vss.n572 0.1445
R893 Vss.n572 Vss.n130 0.1445
R894 Vss.n144 Vss.n130 0.1445
R895 Vss.n562 Vss.n144 0.1445
R896 Vss.n562 Vss.n561 0.1445
R897 Vss.n561 Vss.n147 0.1445
R898 Vss.n158 Vss.n147 0.1445
R899 Vss.n551 Vss.n158 0.1445
R900 Vss.n551 Vss.n550 0.1445
R901 Vss.n550 Vss.n161 0.1445
R902 Vss.n542 Vss.n161 0.1445
R903 Vss.n542 Vss.n541 0.1445
R904 Vss.n541 Vss.n540 0.1445
R905 Vss.n540 Vss.n171 0.1445
R906 Vss.n533 Vss.n171 0.1445
R907 Vss.n533 Vss.n176 0.1445
R908 Vss.n428 Vss.n176 0.1445
R909 Vss.n428 Vss.n427 0.1445
R910 Vss.n427 Vss.n426 0.1445
R911 Vss.n426 Vss.n419 0.1445
R912 Vss.n419 Vss.n398 0.1445
R913 Vss.n513 Vss.n398 0.1445
R914 Vss.n513 Vss.n512 0.1445
R915 Vss.n512 Vss.n511 0.1445
R916 Vss.n509 Vss.n401 0.1445
R917 Vss.n464 Vss.n401 0.1445
R918 Vss.n472 Vss.n464 0.1445
R919 Vss.n472 Vss.n471 0.1445
R920 Vss.n471 Vss.n470 0.1445
R921 Vss.n470 Vss.n461 0.1445
R922 Vss.n481 Vss.n461 0.1445
R923 Vss.n535 Vss.n534 0.1445
R924 Vss.n534 Vss.n175 0.1445
R925 Vss.n414 Vss.n175 0.1445
R926 Vss.n415 Vss.n414 0.1445
R927 Vss.n416 Vss.n415 0.1445
R928 Vss.n418 Vss.n416 0.1445
R929 Vss.n418 Vss.n417 0.1445
R930 Vss.n417 Vss.n399 0.1445
R931 Vss.n400 Vss.n399 0.1445
R932 Vss.n528 Vss.n387 0.1445
R933 Vss.n528 Vss.n527 0.1445
R934 Vss.n527 Vss.n526 0.1445
R935 Vss.n526 Vss.n388 0.1445
R936 Vss.n522 Vss.n388 0.1445
R937 Vss.n522 Vss.n521 0.1445
R938 Vss.n521 Vss.n520 0.1445
R939 Vss.n520 Vss.n393 0.1445
R940 Vss.n393 Vss.n66 0.1445
R941 Vss.n627 Vss.n66 0.1445
R942 Vss.n627 Vss.n626 0.1445
R943 Vss.n626 Vss.n625 0.1445
R944 Vss.n625 Vss.n67 0.1445
R945 Vss.n621 Vss.n67 0.1445
R946 Vss.n621 Vss.n620 0.1445
R947 Vss.n620 Vss.n619 0.1445
R948 Vss.n619 Vss.n72 0.1445
R949 Vss.n615 Vss.n72 0.1445
R950 Vss.n502 Vss.n404 0.1445
R951 Vss.n443 Vss.n407 0.1445
R952 Vss.n490 Vss.n459 0.1445
R953 Vss.n486 Vss.n449 0.1445
R954 Vss.n485 Vss.n484 0.1445
R955 Vss.n439 Vss.n433 0.1445
R956 Vss.n438 Vss.n437 0.1445
R957 Vss.n45 Vss.n42 0.1445
R958 Vss.n44 Vss.n43 0.1445
R959 Vss.n28 Vss.n25 0.1445
R960 Vss.n27 Vss.n26 0.1445
R961 Vss.n11 Vss.n8 0.1445
R962 Vss.n10 Vss.n9 0.1445
R963 Vss.n466 Vss.n465 0.1445
R964 Vss.n467 Vss.n466 0.1445
R965 Vss.n468 Vss.n467 0.1445
R966 Vss.n469 Vss.n468 0.1445
R967 Vss.n469 Vss.n460 0.1445
R968 Vss.n482 Vss.n460 0.1445
R969 Vss.n255 Vss.n244 0.1445
R970 Vss.n259 Vss.n244 0.1445
R971 Vss.n259 Vss.n234 0.1445
R972 Vss.n271 Vss.n234 0.1445
R973 Vss.n271 Vss.n232 0.1445
R974 Vss.n275 Vss.n232 0.1445
R975 Vss.n275 Vss.n222 0.1445
R976 Vss.n287 Vss.n222 0.1445
R977 Vss.n287 Vss.n220 0.1445
R978 Vss.n291 Vss.n220 0.1445
R979 Vss.n291 Vss.n210 0.1445
R980 Vss.n303 Vss.n210 0.1445
R981 Vss.n303 Vss.n207 0.1445
R982 Vss.n310 Vss.n207 0.1445
R983 Vss.n310 Vss.n208 0.1445
R984 Vss.n306 Vss.n208 0.1445
R985 Vss.n306 Vss.n196 0.1445
R986 Vss.n196 Vss.n80 0.1445
R987 Vss.n325 Vss.n80 0.1445
R988 Vss.n325 Vss.n89 0.1445
R989 Vss.n93 Vss.n89 0.1445
R990 Vss.n333 Vss.n93 0.1445
R991 Vss.n333 Vss.n97 0.1445
R992 Vss.n104 Vss.n97 0.1445
R993 Vss.n107 Vss.n104 0.1445
R994 Vss.n342 Vss.n107 0.1445
R995 Vss.n342 Vss.n111 0.1445
R996 Vss.n118 Vss.n111 0.1445
R997 Vss.n121 Vss.n118 0.1445
R998 Vss.n351 Vss.n121 0.1445
R999 Vss.n351 Vss.n125 0.1445
R1000 Vss.n132 Vss.n125 0.1445
R1001 Vss.n137 Vss.n132 0.1445
R1002 Vss.n360 Vss.n137 0.1445
R1003 Vss.n360 Vss.n141 0.1445
R1004 Vss.n148 Vss.n141 0.1445
R1005 Vss.n151 Vss.n148 0.1445
R1006 Vss.n369 Vss.n151 0.1445
R1007 Vss.n369 Vss.n155 0.1445
R1008 Vss.n162 Vss.n155 0.1445
R1009 Vss.n165 Vss.n162 0.1445
R1010 Vss.n166 Vss.n165 0.1445
R1011 Vss.n378 Vss.n166 0.1445
R1012 Vss.n378 Vss.n172 0.1445
R1013 Vss.n385 Vss.n172 0.1445
R1014 Vss.n529 Vss.n385 0.1445
R1015 Vss.n529 Vss.n386 0.1445
R1016 Vss.n525 Vss.n386 0.1445
R1017 Vss.n525 Vss.n524 0.1445
R1018 Vss.n524 Vss.n523 0.1445
R1019 Vss.n523 Vss.n392 0.1445
R1020 Vss.n519 Vss.n392 0.1445
R1021 Vss.n519 Vss.n518 0.1445
R1022 Vss.n518 Vss.n64 0.1445
R1023 Vss.n628 Vss.n64 0.1445
R1024 Vss.n628 Vss.n65 0.1445
R1025 Vss.n624 Vss.n65 0.1445
R1026 Vss.n624 Vss.n623 0.1445
R1027 Vss.n623 Vss.n622 0.1445
R1028 Vss.n622 Vss.n71 0.1445
R1029 Vss.n618 Vss.n71 0.1445
R1030 Vss.n618 Vss.n617 0.1445
R1031 Vss.n617 Vss.n616 0.1445
R1032 Vss.n257 Vss.n256 0.1445
R1033 Vss.n258 Vss.n257 0.1445
R1034 Vss.n258 Vss.n233 0.1445
R1035 Vss.n272 Vss.n233 0.1445
R1036 Vss.n273 Vss.n272 0.1445
R1037 Vss.n274 Vss.n273 0.1445
R1038 Vss.n274 Vss.n221 0.1445
R1039 Vss.n288 Vss.n221 0.1445
R1040 Vss.n289 Vss.n288 0.1445
R1041 Vss.n290 Vss.n289 0.1445
R1042 Vss.n290 Vss.n209 0.1445
R1043 Vss.n304 Vss.n209 0.1445
R1044 Vss.n305 Vss.n304 0.1445
R1045 Vss.n309 Vss.n305 0.1445
R1046 Vss.n309 Vss.n308 0.1445
R1047 Vss.n308 Vss.n307 0.1445
R1048 Vss.n307 Vss.n78 0.1445
R1049 Vss.n249 Vss.n239 0.1445
R1050 Vss.n264 Vss.n239 0.1445
R1051 Vss.n265 Vss.n264 0.1445
R1052 Vss.n266 Vss.n265 0.1445
R1053 Vss.n266 Vss.n227 0.1445
R1054 Vss.n280 Vss.n227 0.1445
R1055 Vss.n281 Vss.n280 0.1445
R1056 Vss.n282 Vss.n281 0.1445
R1057 Vss.n282 Vss.n215 0.1445
R1058 Vss.n296 Vss.n215 0.1445
R1059 Vss.n297 Vss.n296 0.1445
R1060 Vss.n298 Vss.n297 0.1445
R1061 Vss.n298 Vss.n200 0.1445
R1062 Vss.n315 Vss.n200 0.1445
R1063 Vss.n316 Vss.n315 0.1445
R1064 Vss.n318 Vss.n316 0.1445
R1065 Vss.n318 Vss.n317 0.1445
R1066 Vss.n36 Vss.n35 0.111183
R1067 Vss.n52 Vss.n37 0.111183
R1068 Vss.n634 Vss.n55 0.107176
R1069 Vss.n510 Vss.n509 0.0718661
R1070 Vss.n511 Vss.n510 0.0718661
R1071 Vss.n465 Vss.n55 0.0671
R1072 Vss.n400 Vss.n55 0.0599
R1073 Vss.n256 Vss 0.0599
R1074 Vss.n35 Vss 0.0577669
R1075 Vss Vss.n635 0.0507793
R1076 Vss.n247 Vss 0.0490611
R1077 Vss.n611 Vss 0.0455
R1078 Vss.n499 Vss.n448 0.0298531
R1079 Vss.n489 Vss.n488 0.0298531
R1080 Vss.n434 Vss.n406 0.0298531
R1081 Vss.n445 Vss.n444 0.0298531
R1082 Vss.n447 Vss.n446 0.0298531
R1083 Vss.n501 Vss.n500 0.0298531
R1084 Vss.n489 Vss.n448 0.019907
R1085 Vss.n444 Vss.n406 0.019907
R1086 Vss.n501 Vss.n447 0.019907
R1087 Vss.n635 Vss.n52 0.00748758
R1088 Vss.n246 Vss.n95 0.005
R1089 Vss.n599 Vss.n95 0.005
R1090 Vss.n599 Vss.n598 0.005
R1091 Vss.n598 Vss.n96 0.005
R1092 Vss.n109 Vss.n96 0.005
R1093 Vss.n588 Vss.n109 0.005
R1094 Vss.n588 Vss.n587 0.005
R1095 Vss.n587 Vss.n110 0.005
R1096 Vss.n123 Vss.n110 0.005
R1097 Vss.n577 Vss.n123 0.005
R1098 Vss.n577 Vss.n576 0.005
R1099 Vss.n576 Vss.n124 0.005
R1100 Vss.n139 Vss.n124 0.005
R1101 Vss.n566 Vss.n139 0.005
R1102 Vss.n566 Vss.n565 0.005
R1103 Vss.n565 Vss.n140 0.005
R1104 Vss.n153 Vss.n140 0.005
R1105 Vss.n555 Vss.n153 0.005
R1106 Vss.n555 Vss.n554 0.005
R1107 Vss.n554 Vss.n154 0.005
R1108 Vss.n544 Vss.n154 0.005
R1109 Vss.n608 Vss.n81 0.00389783
R1110 Vss.n543 Vss.n167 0.00389783
R1111 Vss.n539 Vss.n167 0.00389783
R1112 Vss.n88 Vss.n81 0.00317579
R1113 Vss.n604 Vss.n90 0.00317579
R1114 Vss.n601 Vss.n600 0.00317579
R1115 Vss.n597 Vss.n94 0.00317579
R1116 Vss.n596 Vss.n98 0.00317579
R1117 Vss.n593 Vss.n105 0.00317579
R1118 Vss.n590 Vss.n589 0.00317579
R1119 Vss.n586 Vss.n108 0.00317579
R1120 Vss.n585 Vss.n112 0.00317579
R1121 Vss.n582 Vss.n119 0.00317579
R1122 Vss.n579 Vss.n578 0.00317579
R1123 Vss.n575 Vss.n122 0.00317579
R1124 Vss.n571 Vss.n133 0.00317579
R1125 Vss.n568 Vss.n567 0.00317579
R1126 Vss.n564 Vss.n138 0.00317579
R1127 Vss.n563 Vss.n142 0.00317579
R1128 Vss.n560 Vss.n149 0.00317579
R1129 Vss.n557 Vss.n556 0.00317579
R1130 Vss.n553 Vss.n152 0.00317579
R1131 Vss.n552 Vss.n156 0.00317579
R1132 Vss.n549 Vss.n163 0.00317579
R1133 Vss.n546 Vss.n545 0.00317579
R1134 Vss.n574 Vss 0.00219891
R1135 Vss.n609 Vss.n608 0.0020715
R1136 Vss.n131 Vss 0.00147688
R1137 Vss.n604 Vss.n88 0.00122204
R1138 Vss.n601 Vss.n90 0.00122204
R1139 Vss.n600 Vss.n94 0.00122204
R1140 Vss.n597 Vss.n596 0.00122204
R1141 Vss.n593 Vss.n98 0.00122204
R1142 Vss.n590 Vss.n105 0.00122204
R1143 Vss.n589 Vss.n108 0.00122204
R1144 Vss.n586 Vss.n585 0.00122204
R1145 Vss.n582 Vss.n112 0.00122204
R1146 Vss.n579 Vss.n119 0.00122204
R1147 Vss.n578 Vss.n122 0.00122204
R1148 Vss.n575 Vss.n574 0.00122204
R1149 Vss.n571 Vss.n131 0.00122204
R1150 Vss.n568 Vss.n133 0.00122204
R1151 Vss.n567 Vss.n138 0.00122204
R1152 Vss.n564 Vss.n563 0.00122204
R1153 Vss.n560 Vss.n142 0.00122204
R1154 Vss.n557 Vss.n149 0.00122204
R1155 Vss.n556 Vss.n152 0.00122204
R1156 Vss.n553 Vss.n552 0.00122204
R1157 Vss.n549 Vss.n156 0.00122204
R1158 Vss.n546 Vss.n163 0.00122204
R1159 Vss.n545 Vss.n543 0.00122204
R1160 Vss.n539 Vss.n173 0.000627419
R1161 Vdd.n584 Vdd.n79 18200
R1162 Vdd.n583 Vdd.n80 18200
R1163 Vdd.n585 Vdd.n584 14238.8
R1164 Vdd.n584 Vdd.n583 4468.75
R1165 Vdd.n583 Vdd.n582 4062.5
R1166 Vdd.n15 Vdd.n14 521.494
R1167 Vdd.n14 Vdd.n6 521.494
R1168 Vdd.n32 Vdd.n31 521.494
R1169 Vdd.n31 Vdd.n30 521.494
R1170 Vdd.n632 Vdd.n631 521.494
R1171 Vdd.n631 Vdd.n630 521.494
R1172 Vdd.n585 Vdd.n71 229.434
R1173 Vdd.n575 Vdd.n92 144.525
R1174 Vdd.n564 Vdd.n109 144.525
R1175 Vdd.n605 Vdd.n50 144.525
R1176 Vdd.n546 Vdd.n537 144.525
R1177 Vdd.n613 Vdd.n40 140.912
R1178 Vdd.n612 Vdd.n43 140.912
R1179 Vdd.n558 Vdd.n80 139.106
R1180 Vdd.n79 Vdd.n52 131.88
R1181 Vdd.n574 Vdd.n95 130.072
R1182 Vdd.n107 Vdd.n106 130.072
R1183 Vdd.n536 Vdd.n60 128.267
R1184 Vdd.n594 Vdd.n60 122.847
R1185 Vdd.n593 Vdd.n63 122.847
R1186 Vdd.n565 Vdd.n107 121.04
R1187 Vdd.n557 Vdd.n40 110.201
R1188 Vdd.n605 Vdd.n604 102.975
R1189 Vdd.n359 Vdd.n252 94.2375
R1190 Vdd.n261 Vdd.n252 94.2375
R1191 Vdd.n349 Vdd.n261 94.2375
R1192 Vdd.n349 Vdd.n348 94.2375
R1193 Vdd.n348 Vdd.n347 94.2375
R1194 Vdd.n347 Vdd.n265 94.2375
R1195 Vdd.n341 Vdd.n265 94.2375
R1196 Vdd.n341 Vdd.n340 94.2375
R1197 Vdd.n340 Vdd.n339 94.2375
R1198 Vdd.n339 Vdd.n275 94.2375
R1199 Vdd.n333 Vdd.n275 94.2375
R1200 Vdd.n333 Vdd.n332 94.2375
R1201 Vdd.n332 Vdd.n331 94.2375
R1202 Vdd.n331 Vdd.n286 94.2375
R1203 Vdd.n325 Vdd.n286 94.2375
R1204 Vdd.n325 Vdd.n240 94.2375
R1205 Vdd.n371 Vdd.n240 94.2375
R1206 Vdd.n371 Vdd.n232 94.2375
R1207 Vdd.n381 Vdd.n232 94.2375
R1208 Vdd.n382 Vdd.n381 94.2375
R1209 Vdd.n382 Vdd.n224 94.2375
R1210 Vdd.n392 Vdd.n224 94.2375
R1211 Vdd.n392 Vdd.n211 94.2375
R1212 Vdd.n405 Vdd.n211 94.2375
R1213 Vdd.n406 Vdd.n405 94.2375
R1214 Vdd.n406 Vdd.n203 94.2375
R1215 Vdd.n416 Vdd.n203 94.2375
R1216 Vdd.n416 Vdd.n191 94.2375
R1217 Vdd.n431 Vdd.n191 94.2375
R1218 Vdd.n431 Vdd.n183 94.2375
R1219 Vdd.n441 Vdd.n183 94.2375
R1220 Vdd.n442 Vdd.n441 94.2375
R1221 Vdd.n442 Vdd.n174 94.2375
R1222 Vdd.n452 Vdd.n174 94.2375
R1223 Vdd.n452 Vdd.n161 94.2375
R1224 Vdd.n465 Vdd.n161 94.2375
R1225 Vdd.n466 Vdd.n465 94.2375
R1226 Vdd.n466 Vdd.n152 94.2375
R1227 Vdd.n476 Vdd.n152 94.2375
R1228 Vdd.n476 Vdd.n153 94.2375
R1229 Vdd.n153 Vdd.n139 94.2375
R1230 Vdd.n488 Vdd.n139 94.2375
R1231 Vdd.n488 Vdd.n128 94.2375
R1232 Vdd.n501 Vdd.n128 94.2375
R1233 Vdd.n501 Vdd.n81 94.2375
R1234 Vdd.n92 Vdd.n83 92.135
R1235 Vdd.n586 Vdd.n70 84.0977
R1236 Vdd.n586 Vdd.n65 84.0977
R1237 Vdd.n360 Vdd.n250 84.0977
R1238 Vdd.n582 Vdd.n81 74.2122
R1239 Vdd.n78 Vdd.n72 69.0283
R1240 Vdd.n78 Vdd.n59 69.0283
R1241 Vdd.n595 Vdd.n58 69.0283
R1242 Vdd.n61 Vdd.n58 69.0283
R1243 Vdd.n96 Vdd.n94 69.0283
R1244 Vdd.n566 Vdd.n105 69.0283
R1245 Vdd.n573 Vdd.n96 69.0283
R1246 Vdd.n566 Vdd.n97 69.0283
R1247 Vdd.n603 Vdd.n38 69.0283
R1248 Vdd.n603 Vdd.n602 69.0283
R1249 Vdd.n41 Vdd.n39 69.0283
R1250 Vdd.n614 Vdd.n39 69.0283
R1251 Vdd.n13 Vdd.n4 62.1255
R1252 Vdd.n13 Vdd.n12 62.1255
R1253 Vdd.n7 Vdd.n5 62.1255
R1254 Vdd.n16 Vdd.n5 62.1255
R1255 Vdd.n33 Vdd.n22 62.1255
R1256 Vdd.n29 Vdd.n22 62.1255
R1257 Vdd.n24 Vdd.n23 62.1255
R1258 Vdd.n23 Vdd.n21 62.1255
R1259 Vdd.n633 Vdd.n622 62.1255
R1260 Vdd.n629 Vdd.n622 62.1255
R1261 Vdd.n624 Vdd.n623 62.1255
R1262 Vdd.n623 Vdd.n621 62.1255
R1263 Vdd.n358 Vdd.n250 52.7258
R1264 Vdd.n581 Vdd.n83 52.3907
R1265 Vdd.n604 Vdd.n52 41.5514
R1266 Vdd.n558 Vdd.n557 34.3251
R1267 Vdd.n582 Vdd.n581 30.712
R1268 Vdd.n565 Vdd.n564 23.4858
R1269 Vdd.n594 Vdd.n593 21.6792
R1270 Vdd.n71 Vdd.n63 21.6792
R1271 Vdd.n537 Vdd.n536 16.2595
R1272 Vdd.n595 Vdd.n59 15.5561
R1273 Vdd.n72 Vdd.n61 15.5561
R1274 Vdd.n357 Vdd.n253 15.5561
R1275 Vdd.n259 Vdd.n253 15.5561
R1276 Vdd.n350 Vdd.n259 15.5561
R1277 Vdd.n350 Vdd.n260 15.5561
R1278 Vdd.n346 Vdd.n260 15.5561
R1279 Vdd.n346 Vdd.n266 15.5561
R1280 Vdd.n342 Vdd.n266 15.5561
R1281 Vdd.n342 Vdd.n271 15.5561
R1282 Vdd.n338 Vdd.n271 15.5561
R1283 Vdd.n338 Vdd.n276 15.5561
R1284 Vdd.n334 Vdd.n276 15.5561
R1285 Vdd.n334 Vdd.n282 15.5561
R1286 Vdd.n330 Vdd.n282 15.5561
R1287 Vdd.n330 Vdd.n287 15.5561
R1288 Vdd.n326 Vdd.n287 15.5561
R1289 Vdd.n326 Vdd.n239 15.5561
R1290 Vdd.n372 Vdd.n239 15.5561
R1291 Vdd.n372 Vdd.n233 15.5561
R1292 Vdd.n380 Vdd.n233 15.5561
R1293 Vdd.n380 Vdd.n225 15.5561
R1294 Vdd.n390 Vdd.n225 15.5561
R1295 Vdd.n391 Vdd.n390 15.5561
R1296 Vdd.n391 Vdd.n212 15.5561
R1297 Vdd.n404 Vdd.n212 15.5561
R1298 Vdd.n404 Vdd.n204 15.5561
R1299 Vdd.n414 Vdd.n204 15.5561
R1300 Vdd.n415 Vdd.n414 15.5561
R1301 Vdd.n415 Vdd.n192 15.5561
R1302 Vdd.n430 Vdd.n192 15.5561
R1303 Vdd.n430 Vdd.n184 15.5561
R1304 Vdd.n440 Vdd.n184 15.5561
R1305 Vdd.n440 Vdd.n175 15.5561
R1306 Vdd.n450 Vdd.n175 15.5561
R1307 Vdd.n451 Vdd.n450 15.5561
R1308 Vdd.n451 Vdd.n162 15.5561
R1309 Vdd.n464 Vdd.n162 15.5561
R1310 Vdd.n464 Vdd.n154 15.5561
R1311 Vdd.n474 Vdd.n154 15.5561
R1312 Vdd.n475 Vdd.n474 15.5561
R1313 Vdd.n475 Vdd.n140 15.5561
R1314 Vdd.n486 Vdd.n140 15.5561
R1315 Vdd.n487 Vdd.n486 15.5561
R1316 Vdd.n487 Vdd.n129 15.5561
R1317 Vdd.n500 Vdd.n129 15.5561
R1318 Vdd.n500 Vdd.n84 15.5561
R1319 Vdd.n580 Vdd.n84 15.5561
R1320 Vdd.n580 Vdd.n85 15.5561
R1321 Vdd.n576 Vdd.n85 15.5561
R1322 Vdd.n576 Vdd.n91 15.5561
R1323 Vdd.n110 Vdd.n91 15.5561
R1324 Vdd.n563 Vdd.n110 15.5561
R1325 Vdd.n563 Vdd.n111 15.5561
R1326 Vdd.n559 Vdd.n111 15.5561
R1327 Vdd.n559 Vdd.n44 15.5561
R1328 Vdd.n611 Vdd.n44 15.5561
R1329 Vdd.n611 Vdd.n45 15.5561
R1330 Vdd.n606 Vdd.n45 15.5561
R1331 Vdd.n606 Vdd.n49 15.5561
R1332 Vdd.n545 Vdd.n49 15.5561
R1333 Vdd.n545 Vdd.n538 15.5561
R1334 Vdd.n538 Vdd.n64 15.5561
R1335 Vdd.n592 Vdd.n64 15.5561
R1336 Vdd.n592 Vdd.n65 15.5561
R1337 Vdd.n360 Vdd.n251 15.5561
R1338 Vdd.n301 Vdd.n251 15.5561
R1339 Vdd.n301 Vdd.n262 15.5561
R1340 Vdd.n263 Vdd.n262 15.5561
R1341 Vdd.n264 Vdd.n263 15.5561
R1342 Vdd.n298 Vdd.n264 15.5561
R1343 Vdd.n298 Vdd.n272 15.5561
R1344 Vdd.n273 Vdd.n272 15.5561
R1345 Vdd.n274 Vdd.n273 15.5561
R1346 Vdd.n295 Vdd.n274 15.5561
R1347 Vdd.n295 Vdd.n283 15.5561
R1348 Vdd.n284 Vdd.n283 15.5561
R1349 Vdd.n285 Vdd.n284 15.5561
R1350 Vdd.n292 Vdd.n285 15.5561
R1351 Vdd.n324 Vdd.n292 15.5561
R1352 Vdd.n324 Vdd.n241 15.5561
R1353 Vdd.n370 Vdd.n241 15.5561
R1354 Vdd.n370 Vdd.n242 15.5561
R1355 Vdd.n242 Vdd.n231 15.5561
R1356 Vdd.n383 Vdd.n231 15.5561
R1357 Vdd.n383 Vdd.n222 15.5561
R1358 Vdd.n393 Vdd.n222 15.5561
R1359 Vdd.n393 Vdd.n223 15.5561
R1360 Vdd.n223 Vdd.n210 15.5561
R1361 Vdd.n407 Vdd.n210 15.5561
R1362 Vdd.n407 Vdd.n202 15.5561
R1363 Vdd.n417 Vdd.n202 15.5561
R1364 Vdd.n417 Vdd.n190 15.5561
R1365 Vdd.n432 Vdd.n190 15.5561
R1366 Vdd.n433 Vdd.n432 15.5561
R1367 Vdd.n433 Vdd.n182 15.5561
R1368 Vdd.n443 Vdd.n182 15.5561
R1369 Vdd.n443 Vdd.n172 15.5561
R1370 Vdd.n453 Vdd.n172 15.5561
R1371 Vdd.n453 Vdd.n173 15.5561
R1372 Vdd.n173 Vdd.n160 15.5561
R1373 Vdd.n467 Vdd.n160 15.5561
R1374 Vdd.n467 Vdd.n150 15.5561
R1375 Vdd.n477 Vdd.n150 15.5561
R1376 Vdd.n477 Vdd.n151 15.5561
R1377 Vdd.n151 Vdd.n138 15.5561
R1378 Vdd.n489 Vdd.n138 15.5561
R1379 Vdd.n489 Vdd.n127 15.5561
R1380 Vdd.n502 Vdd.n127 15.5561
R1381 Vdd.n503 Vdd.n502 15.5561
R1382 Vdd.n503 Vdd.n82 15.5561
R1383 Vdd.n506 Vdd.n82 15.5561
R1384 Vdd.n506 Vdd.n93 15.5561
R1385 Vdd.n512 Vdd.n93 15.5561
R1386 Vdd.n513 Vdd.n512 15.5561
R1387 Vdd.n513 Vdd.n108 15.5561
R1388 Vdd.n119 Vdd.n108 15.5561
R1389 Vdd.n556 Vdd.n119 15.5561
R1390 Vdd.n556 Vdd.n120 15.5561
R1391 Vdd.n120 Vdd.n42 15.5561
R1392 Vdd.n551 Vdd.n42 15.5561
R1393 Vdd.n551 Vdd.n51 15.5561
R1394 Vdd.n548 Vdd.n51 15.5561
R1395 Vdd.n548 Vdd.n547 15.5561
R1396 Vdd.n547 Vdd.n535 15.5561
R1397 Vdd.n535 Vdd.n525 15.5561
R1398 Vdd.n525 Vdd.n62 15.5561
R1399 Vdd.n70 Vdd.n62 15.5561
R1400 Vdd.n105 Vdd.n94 15.5561
R1401 Vdd.n573 Vdd.n97 15.5561
R1402 Vdd.n602 Vdd.n41 15.5561
R1403 Vdd.n575 Vdd.n574 14.453
R1404 Vdd.n106 Vdd.n95 14.453
R1405 Vdd.n546 Vdd.n79 12.6464
R1406 Vdd.n498 Vdd.n497 12.5005
R1407 Vdd.n493 Vdd.n131 12.5005
R1408 Vdd.n492 Vdd.n491 12.5005
R1409 Vdd.n484 Vdd.n133 12.5005
R1410 Vdd.n146 Vdd.n142 12.5005
R1411 Vdd.n479 Vdd.n147 12.5005
R1412 Vdd.n472 Vdd.n471 12.5005
R1413 Vdd.n470 Vdd.n469 12.5005
R1414 Vdd.n462 Vdd.n157 12.5005
R1415 Vdd.n168 Vdd.n164 12.5005
R1416 Vdd.n455 Vdd.n169 12.5005
R1417 Vdd.n448 Vdd.n447 12.5005
R1418 Vdd.n446 Vdd.n445 12.5005
R1419 Vdd.n438 Vdd.n437 12.5005
R1420 Vdd.n436 Vdd.n435 12.5005
R1421 Vdd.n428 Vdd.n187 12.5005
R1422 Vdd.n198 Vdd.n194 12.5005
R1423 Vdd.n419 Vdd.n199 12.5005
R1424 Vdd.n412 Vdd.n411 12.5005
R1425 Vdd.n410 Vdd.n409 12.5005
R1426 Vdd.n402 Vdd.n207 12.5005
R1427 Vdd.n218 Vdd.n214 12.5005
R1428 Vdd.n395 Vdd.n219 12.5005
R1429 Vdd.n388 Vdd.n387 12.5005
R1430 Vdd.n386 Vdd.n385 12.5005
R1431 Vdd.n378 Vdd.n228 12.5005
R1432 Vdd.n377 Vdd.n376 12.5005
R1433 Vdd.n617 Vdd.n616 12.0394
R1434 Vdd.n376 Vdd.n375 11.7031
R1435 Vdd.n497 Vdd.n496 11.545
R1436 Vdd.n588 Vdd.n68 10.9121
R1437 Vdd.n366 Vdd.n365 7.89186
R1438 Vdd.n365 Vdd.n364 7.73533
R1439 Vdd.n247 Vdd.n246 7.57378
R1440 Vdd.n17 Vdd.n16 6.37187
R1441 Vdd.n17 Vdd.n4 6.37187
R1442 Vdd.n34 Vdd.n33 6.37187
R1443 Vdd.n34 Vdd.n21 6.37187
R1444 Vdd.n634 Vdd.n633 6.37187
R1445 Vdd.n634 Vdd.n621 6.37187
R1446 Vdd.n12 Vdd.n11 6.3005
R1447 Vdd.n8 Vdd.n7 6.3005
R1448 Vdd.n29 Vdd.n28 6.3005
R1449 Vdd.n25 Vdd.n24 6.3005
R1450 Vdd.n629 Vdd.n628 6.3005
R1451 Vdd.n625 Vdd.n624 6.3005
R1452 Vdd.n376 Vdd.n228 5.61588
R1453 Vdd.n386 Vdd.n228 5.61588
R1454 Vdd.n387 Vdd.n386 5.61588
R1455 Vdd.n387 Vdd.n219 5.61588
R1456 Vdd.n219 Vdd.n218 5.61588
R1457 Vdd.n218 Vdd.n207 5.61588
R1458 Vdd.n410 Vdd.n207 5.61588
R1459 Vdd.n411 Vdd.n410 5.61588
R1460 Vdd.n411 Vdd.n199 5.61588
R1461 Vdd.n199 Vdd.n198 5.61588
R1462 Vdd.n198 Vdd.n187 5.61588
R1463 Vdd.n436 Vdd.n187 5.61588
R1464 Vdd.n437 Vdd.n436 5.61588
R1465 Vdd.n447 Vdd.n446 5.61588
R1466 Vdd.n447 Vdd.n169 5.61588
R1467 Vdd.n169 Vdd.n168 5.61588
R1468 Vdd.n168 Vdd.n157 5.61588
R1469 Vdd.n470 Vdd.n157 5.61588
R1470 Vdd.n471 Vdd.n470 5.61588
R1471 Vdd.n471 Vdd.n147 5.61588
R1472 Vdd.n147 Vdd.n146 5.61588
R1473 Vdd.n146 Vdd.n133 5.61588
R1474 Vdd.n492 Vdd.n133 5.61588
R1475 Vdd.n493 Vdd.n492 5.61588
R1476 Vdd.n497 Vdd.n493 5.61588
R1477 Vdd.n109 Vdd.n80 5.42018
R1478 Vdd.n255 Vdd.n254 5.35452
R1479 Vdd.n9 Vdd.n3 5.20101
R1480 Vdd.n10 Vdd.n2 5.20101
R1481 Vdd.n26 Vdd.n20 5.20101
R1482 Vdd.n27 Vdd.n19 5.20101
R1483 Vdd.n73 Vdd.n55 5.20101
R1484 Vdd.n102 Vdd.n101 5.20101
R1485 Vdd.n626 Vdd.n1 5.20101
R1486 Vdd.n627 Vdd.n0 5.20101
R1487 Vdd.n504 Vdd.n503 5.2005
R1488 Vdd.n503 Vdd.n81 5.2005
R1489 Vdd.n502 Vdd.n125 5.2005
R1490 Vdd.n502 Vdd.n501 5.2005
R1491 Vdd.n137 Vdd.n127 5.2005
R1492 Vdd.n128 Vdd.n127 5.2005
R1493 Vdd.n490 Vdd.n489 5.2005
R1494 Vdd.n489 Vdd.n488 5.2005
R1495 Vdd.n138 Vdd.n136 5.2005
R1496 Vdd.n139 Vdd.n138 5.2005
R1497 Vdd.n151 Vdd.n149 5.2005
R1498 Vdd.n153 Vdd.n151 5.2005
R1499 Vdd.n478 Vdd.n477 5.2005
R1500 Vdd.n477 Vdd.n476 5.2005
R1501 Vdd.n150 Vdd.n148 5.2005
R1502 Vdd.n152 Vdd.n150 5.2005
R1503 Vdd.n468 Vdd.n467 5.2005
R1504 Vdd.n467 Vdd.n466 5.2005
R1505 Vdd.n160 Vdd.n159 5.2005
R1506 Vdd.n465 Vdd.n160 5.2005
R1507 Vdd.n173 Vdd.n171 5.2005
R1508 Vdd.n173 Vdd.n161 5.2005
R1509 Vdd.n454 Vdd.n453 5.2005
R1510 Vdd.n453 Vdd.n452 5.2005
R1511 Vdd.n172 Vdd.n170 5.2005
R1512 Vdd.n174 Vdd.n172 5.2005
R1513 Vdd.n444 Vdd.n443 5.2005
R1514 Vdd.n443 Vdd.n442 5.2005
R1515 Vdd.n182 Vdd.n181 5.2005
R1516 Vdd.n441 Vdd.n182 5.2005
R1517 Vdd.n434 Vdd.n433 5.2005
R1518 Vdd.n433 Vdd.n183 5.2005
R1519 Vdd.n432 Vdd.n189 5.2005
R1520 Vdd.n432 Vdd.n431 5.2005
R1521 Vdd.n201 Vdd.n190 5.2005
R1522 Vdd.n191 Vdd.n190 5.2005
R1523 Vdd.n418 Vdd.n417 5.2005
R1524 Vdd.n417 Vdd.n416 5.2005
R1525 Vdd.n202 Vdd.n200 5.2005
R1526 Vdd.n203 Vdd.n202 5.2005
R1527 Vdd.n408 Vdd.n407 5.2005
R1528 Vdd.n407 Vdd.n406 5.2005
R1529 Vdd.n210 Vdd.n209 5.2005
R1530 Vdd.n405 Vdd.n210 5.2005
R1531 Vdd.n223 Vdd.n221 5.2005
R1532 Vdd.n223 Vdd.n211 5.2005
R1533 Vdd.n394 Vdd.n393 5.2005
R1534 Vdd.n393 Vdd.n392 5.2005
R1535 Vdd.n222 Vdd.n220 5.2005
R1536 Vdd.n224 Vdd.n222 5.2005
R1537 Vdd.n384 Vdd.n383 5.2005
R1538 Vdd.n383 Vdd.n382 5.2005
R1539 Vdd.n231 Vdd.n230 5.2005
R1540 Vdd.n381 Vdd.n231 5.2005
R1541 Vdd.n242 Vdd.n236 5.2005
R1542 Vdd.n242 Vdd.n232 5.2005
R1543 Vdd.n370 Vdd.n369 5.2005
R1544 Vdd.n371 Vdd.n370 5.2005
R1545 Vdd.n243 Vdd.n241 5.2005
R1546 Vdd.n241 Vdd.n240 5.2005
R1547 Vdd.n324 Vdd.n323 5.2005
R1548 Vdd.n325 Vdd.n324 5.2005
R1549 Vdd.n293 Vdd.n292 5.2005
R1550 Vdd.n292 Vdd.n286 5.2005
R1551 Vdd.n319 Vdd.n285 5.2005
R1552 Vdd.n331 Vdd.n285 5.2005
R1553 Vdd.n318 Vdd.n284 5.2005
R1554 Vdd.n332 Vdd.n284 5.2005
R1555 Vdd.n317 Vdd.n283 5.2005
R1556 Vdd.n333 Vdd.n283 5.2005
R1557 Vdd.n296 Vdd.n295 5.2005
R1558 Vdd.n295 Vdd.n275 5.2005
R1559 Vdd.n313 Vdd.n274 5.2005
R1560 Vdd.n339 Vdd.n274 5.2005
R1561 Vdd.n312 Vdd.n273 5.2005
R1562 Vdd.n340 Vdd.n273 5.2005
R1563 Vdd.n311 Vdd.n272 5.2005
R1564 Vdd.n341 Vdd.n272 5.2005
R1565 Vdd.n299 Vdd.n298 5.2005
R1566 Vdd.n298 Vdd.n265 5.2005
R1567 Vdd.n307 Vdd.n264 5.2005
R1568 Vdd.n347 Vdd.n264 5.2005
R1569 Vdd.n306 Vdd.n263 5.2005
R1570 Vdd.n348 Vdd.n263 5.2005
R1571 Vdd.n305 Vdd.n262 5.2005
R1572 Vdd.n349 Vdd.n262 5.2005
R1573 Vdd.n302 Vdd.n301 5.2005
R1574 Vdd.n301 Vdd.n261 5.2005
R1575 Vdd.n251 Vdd.n249 5.2005
R1576 Vdd.n252 Vdd.n251 5.2005
R1577 Vdd.n361 Vdd.n360 5.2005
R1578 Vdd.n360 Vdd.n359 5.2005
R1579 Vdd.n86 Vdd.n84 5.2005
R1580 Vdd.n84 Vdd.n81 5.2005
R1581 Vdd.n500 Vdd.n499 5.2005
R1582 Vdd.n501 Vdd.n500 5.2005
R1583 Vdd.n130 Vdd.n129 5.2005
R1584 Vdd.n129 Vdd.n128 5.2005
R1585 Vdd.n487 Vdd.n135 5.2005
R1586 Vdd.n488 Vdd.n487 5.2005
R1587 Vdd.n486 Vdd.n485 5.2005
R1588 Vdd.n486 Vdd.n139 5.2005
R1589 Vdd.n141 Vdd.n140 5.2005
R1590 Vdd.n153 Vdd.n140 5.2005
R1591 Vdd.n475 Vdd.n145 5.2005
R1592 Vdd.n476 Vdd.n475 5.2005
R1593 Vdd.n474 Vdd.n473 5.2005
R1594 Vdd.n474 Vdd.n152 5.2005
R1595 Vdd.n155 Vdd.n154 5.2005
R1596 Vdd.n466 Vdd.n154 5.2005
R1597 Vdd.n464 Vdd.n463 5.2005
R1598 Vdd.n465 Vdd.n464 5.2005
R1599 Vdd.n163 Vdd.n162 5.2005
R1600 Vdd.n162 Vdd.n161 5.2005
R1601 Vdd.n451 Vdd.n167 5.2005
R1602 Vdd.n452 Vdd.n451 5.2005
R1603 Vdd.n450 Vdd.n449 5.2005
R1604 Vdd.n450 Vdd.n174 5.2005
R1605 Vdd.n176 Vdd.n175 5.2005
R1606 Vdd.n442 Vdd.n175 5.2005
R1607 Vdd.n440 Vdd.n439 5.2005
R1608 Vdd.n441 Vdd.n440 5.2005
R1609 Vdd.n185 Vdd.n184 5.2005
R1610 Vdd.n184 Vdd.n183 5.2005
R1611 Vdd.n430 Vdd.n429 5.2005
R1612 Vdd.n431 Vdd.n430 5.2005
R1613 Vdd.n193 Vdd.n192 5.2005
R1614 Vdd.n192 Vdd.n191 5.2005
R1615 Vdd.n415 Vdd.n197 5.2005
R1616 Vdd.n416 Vdd.n415 5.2005
R1617 Vdd.n414 Vdd.n413 5.2005
R1618 Vdd.n414 Vdd.n203 5.2005
R1619 Vdd.n205 Vdd.n204 5.2005
R1620 Vdd.n406 Vdd.n204 5.2005
R1621 Vdd.n404 Vdd.n403 5.2005
R1622 Vdd.n405 Vdd.n404 5.2005
R1623 Vdd.n213 Vdd.n212 5.2005
R1624 Vdd.n212 Vdd.n211 5.2005
R1625 Vdd.n391 Vdd.n217 5.2005
R1626 Vdd.n392 Vdd.n391 5.2005
R1627 Vdd.n390 Vdd.n389 5.2005
R1628 Vdd.n390 Vdd.n224 5.2005
R1629 Vdd.n226 Vdd.n225 5.2005
R1630 Vdd.n382 Vdd.n225 5.2005
R1631 Vdd.n380 Vdd.n379 5.2005
R1632 Vdd.n381 Vdd.n380 5.2005
R1633 Vdd.n234 Vdd.n233 5.2005
R1634 Vdd.n233 Vdd.n232 5.2005
R1635 Vdd.n373 Vdd.n372 5.2005
R1636 Vdd.n372 Vdd.n371 5.2005
R1637 Vdd.n239 Vdd.n238 5.2005
R1638 Vdd.n240 Vdd.n239 5.2005
R1639 Vdd.n327 Vdd.n326 5.2005
R1640 Vdd.n326 Vdd.n325 5.2005
R1641 Vdd.n328 Vdd.n287 5.2005
R1642 Vdd.n287 Vdd.n286 5.2005
R1643 Vdd.n330 Vdd.n329 5.2005
R1644 Vdd.n331 Vdd.n330 5.2005
R1645 Vdd.n282 Vdd.n281 5.2005
R1646 Vdd.n332 Vdd.n282 5.2005
R1647 Vdd.n335 Vdd.n334 5.2005
R1648 Vdd.n334 Vdd.n333 5.2005
R1649 Vdd.n336 Vdd.n276 5.2005
R1650 Vdd.n276 Vdd.n275 5.2005
R1651 Vdd.n338 Vdd.n337 5.2005
R1652 Vdd.n339 Vdd.n338 5.2005
R1653 Vdd.n271 Vdd.n270 5.2005
R1654 Vdd.n340 Vdd.n271 5.2005
R1655 Vdd.n343 Vdd.n342 5.2005
R1656 Vdd.n342 Vdd.n341 5.2005
R1657 Vdd.n344 Vdd.n266 5.2005
R1658 Vdd.n266 Vdd.n265 5.2005
R1659 Vdd.n346 Vdd.n345 5.2005
R1660 Vdd.n347 Vdd.n346 5.2005
R1661 Vdd.n260 Vdd.n258 5.2005
R1662 Vdd.n348 Vdd.n260 5.2005
R1663 Vdd.n351 Vdd.n350 5.2005
R1664 Vdd.n350 Vdd.n349 5.2005
R1665 Vdd.n259 Vdd.n256 5.2005
R1666 Vdd.n261 Vdd.n259 5.2005
R1667 Vdd.n355 Vdd.n253 5.2005
R1668 Vdd.n253 Vdd.n252 5.2005
R1669 Vdd.n357 Vdd.n356 5.2005
R1670 Vdd.n75 Vdd.n72 5.2005
R1671 Vdd.n72 Vdd.n63 5.2005
R1672 Vdd.n74 Vdd.n61 5.2005
R1673 Vdd.n594 Vdd.n61 5.2005
R1674 Vdd.n59 Vdd.n57 5.2005
R1675 Vdd.n63 Vdd.n59 5.2005
R1676 Vdd.n596 Vdd.n595 5.2005
R1677 Vdd.n595 Vdd.n594 5.2005
R1678 Vdd.n531 Vdd.n70 5.2005
R1679 Vdd.n71 Vdd.n70 5.2005
R1680 Vdd.n532 Vdd.n62 5.2005
R1681 Vdd.n593 Vdd.n62 5.2005
R1682 Vdd.n533 Vdd.n525 5.2005
R1683 Vdd.n525 Vdd.n60 5.2005
R1684 Vdd.n535 Vdd.n534 5.2005
R1685 Vdd.n537 Vdd.n535 5.2005
R1686 Vdd.n547 Vdd.n524 5.2005
R1687 Vdd.n547 Vdd.n546 5.2005
R1688 Vdd.n549 Vdd.n548 5.2005
R1689 Vdd.n548 Vdd.n52 5.2005
R1690 Vdd.n550 Vdd.n51 5.2005
R1691 Vdd.n605 Vdd.n51 5.2005
R1692 Vdd.n552 Vdd.n551 5.2005
R1693 Vdd.n551 Vdd.n50 5.2005
R1694 Vdd.n553 Vdd.n42 5.2005
R1695 Vdd.n612 Vdd.n42 5.2005
R1696 Vdd.n554 Vdd.n120 5.2005
R1697 Vdd.n120 Vdd.n40 5.2005
R1698 Vdd.n556 Vdd.n555 5.2005
R1699 Vdd.n558 Vdd.n556 5.2005
R1700 Vdd.n121 Vdd.n119 5.2005
R1701 Vdd.n119 Vdd.n109 5.2005
R1702 Vdd.n515 Vdd.n108 5.2005
R1703 Vdd.n564 Vdd.n108 5.2005
R1704 Vdd.n514 Vdd.n513 5.2005
R1705 Vdd.n513 Vdd.n107 5.2005
R1706 Vdd.n512 Vdd.n511 5.2005
R1707 Vdd.n512 Vdd.n95 5.2005
R1708 Vdd.n123 Vdd.n93 5.2005
R1709 Vdd.n575 Vdd.n93 5.2005
R1710 Vdd.n507 Vdd.n506 5.2005
R1711 Vdd.n506 Vdd.n92 5.2005
R1712 Vdd.n505 Vdd.n82 5.2005
R1713 Vdd.n581 Vdd.n82 5.2005
R1714 Vdd.n590 Vdd.n65 5.2005
R1715 Vdd.n71 Vdd.n65 5.2005
R1716 Vdd.n592 Vdd.n591 5.2005
R1717 Vdd.n593 Vdd.n592 5.2005
R1718 Vdd.n66 Vdd.n64 5.2005
R1719 Vdd.n64 Vdd.n60 5.2005
R1720 Vdd.n543 Vdd.n538 5.2005
R1721 Vdd.n538 Vdd.n537 5.2005
R1722 Vdd.n545 Vdd.n544 5.2005
R1723 Vdd.n546 Vdd.n545 5.2005
R1724 Vdd.n49 Vdd.n48 5.2005
R1725 Vdd.n52 Vdd.n49 5.2005
R1726 Vdd.n607 Vdd.n606 5.2005
R1727 Vdd.n606 Vdd.n605 5.2005
R1728 Vdd.n608 Vdd.n45 5.2005
R1729 Vdd.n50 Vdd.n45 5.2005
R1730 Vdd.n611 Vdd.n610 5.2005
R1731 Vdd.n612 Vdd.n611 5.2005
R1732 Vdd.n46 Vdd.n44 5.2005
R1733 Vdd.n44 Vdd.n40 5.2005
R1734 Vdd.n560 Vdd.n559 5.2005
R1735 Vdd.n559 Vdd.n558 5.2005
R1736 Vdd.n561 Vdd.n111 5.2005
R1737 Vdd.n111 Vdd.n109 5.2005
R1738 Vdd.n563 Vdd.n562 5.2005
R1739 Vdd.n564 Vdd.n563 5.2005
R1740 Vdd.n112 Vdd.n110 5.2005
R1741 Vdd.n110 Vdd.n107 5.2005
R1742 Vdd.n91 Vdd.n90 5.2005
R1743 Vdd.n95 Vdd.n91 5.2005
R1744 Vdd.n577 Vdd.n576 5.2005
R1745 Vdd.n576 Vdd.n575 5.2005
R1746 Vdd.n578 Vdd.n85 5.2005
R1747 Vdd.n92 Vdd.n85 5.2005
R1748 Vdd.n580 Vdd.n579 5.2005
R1749 Vdd.n581 Vdd.n580 5.2005
R1750 Vdd.n105 Vdd.n104 5.2005
R1751 Vdd.n106 Vdd.n105 5.2005
R1752 Vdd.n103 Vdd.n94 5.2005
R1753 Vdd.n574 Vdd.n94 5.2005
R1754 Vdd.n98 Vdd.n97 5.2005
R1755 Vdd.n106 Vdd.n97 5.2005
R1756 Vdd.n573 Vdd.n572 5.2005
R1757 Vdd.n574 Vdd.n573 5.2005
R1758 Vdd.n602 Vdd.n601 5.2005
R1759 Vdd.n602 Vdd.n43 5.2005
R1760 Vdd.n53 Vdd.n41 5.2005
R1761 Vdd.n613 Vdd.n41 5.2005
R1762 Vdd.n43 Vdd.n38 5.2005
R1763 Vdd.n614 Vdd.n613 5.2005
R1764 Vdd.n77 Vdd.n76 5.19319
R1765 Vdd.n567 Vdd.n100 5.19319
R1766 Vdd.n254 Vdd.n247 5.14053
R1767 Vdd.n588 Vdd.n587 5.12952
R1768 Vdd.n616 Vdd.n36 5.12001
R1769 Vdd.n616 Vdd.n35 5.11219
R1770 Vdd.n530 Vdd.n69 5.04833
R1771 Vdd.n18 Vdd.n3 4.98321
R1772 Vdd.n618 Vdd.n20 4.98321
R1773 Vdd.n77 Vdd.n68 4.98321
R1774 Vdd.n598 Vdd.n55 4.98321
R1775 Vdd.n569 Vdd.n567 4.98321
R1776 Vdd.n101 Vdd.n99 4.98321
R1777 Vdd.n568 Vdd.n36 4.98321
R1778 Vdd.n599 Vdd.n35 4.98321
R1779 Vdd.n635 Vdd.n1 4.98321
R1780 Vdd.n18 Vdd.n2 4.97539
R1781 Vdd.n618 Vdd.n19 4.97539
R1782 Vdd.n635 Vdd.n0 4.97539
R1783 Vdd.n364 Vdd.n69 4.7183
R1784 Vdd.n11 Vdd.n10 4.5005
R1785 Vdd.n9 Vdd.n8 4.5005
R1786 Vdd.n28 Vdd.n27 4.5005
R1787 Vdd.n26 Vdd.n25 4.5005
R1788 Vdd.n76 Vdd.n75 4.5005
R1789 Vdd.n74 Vdd.n73 4.5005
R1790 Vdd.n57 Vdd.n56 4.5005
R1791 Vdd.n597 Vdd.n596 4.5005
R1792 Vdd.n377 Vdd.n234 4.5005
R1793 Vdd.n379 Vdd.n378 4.5005
R1794 Vdd.n385 Vdd.n226 4.5005
R1795 Vdd.n389 Vdd.n388 4.5005
R1796 Vdd.n395 Vdd.n217 4.5005
R1797 Vdd.n214 Vdd.n213 4.5005
R1798 Vdd.n403 Vdd.n402 4.5005
R1799 Vdd.n409 Vdd.n205 4.5005
R1800 Vdd.n413 Vdd.n412 4.5005
R1801 Vdd.n419 Vdd.n197 4.5005
R1802 Vdd.n194 Vdd.n193 4.5005
R1803 Vdd.n429 Vdd.n428 4.5005
R1804 Vdd.n435 Vdd.n185 4.5005
R1805 Vdd.n439 Vdd.n438 4.5005
R1806 Vdd.n445 Vdd.n176 4.5005
R1807 Vdd.n449 Vdd.n448 4.5005
R1808 Vdd.n455 Vdd.n167 4.5005
R1809 Vdd.n164 Vdd.n163 4.5005
R1810 Vdd.n463 Vdd.n462 4.5005
R1811 Vdd.n469 Vdd.n155 4.5005
R1812 Vdd.n473 Vdd.n472 4.5005
R1813 Vdd.n479 Vdd.n145 4.5005
R1814 Vdd.n142 Vdd.n141 4.5005
R1815 Vdd.n485 Vdd.n484 4.5005
R1816 Vdd.n491 Vdd.n135 4.5005
R1817 Vdd.n131 Vdd.n130 4.5005
R1818 Vdd.n499 Vdd.n498 4.5005
R1819 Vdd.n494 Vdd.n86 4.5005
R1820 Vdd.n579 Vdd.n87 4.5005
R1821 Vdd.n578 Vdd.n88 4.5005
R1822 Vdd.n577 Vdd.n89 4.5005
R1823 Vdd.n113 Vdd.n90 4.5005
R1824 Vdd.n114 Vdd.n112 4.5005
R1825 Vdd.n562 Vdd.n115 4.5005
R1826 Vdd.n561 Vdd.n116 4.5005
R1827 Vdd.n560 Vdd.n118 4.5005
R1828 Vdd.n117 Vdd.n46 4.5005
R1829 Vdd.n607 Vdd.n47 4.5005
R1830 Vdd.n539 Vdd.n48 4.5005
R1831 Vdd.n544 Vdd.n540 4.5005
R1832 Vdd.n543 Vdd.n542 4.5005
R1833 Vdd.n541 Vdd.n66 4.5005
R1834 Vdd.n591 Vdd.n67 4.5005
R1835 Vdd.n590 Vdd.n589 4.5005
R1836 Vdd.n355 Vdd.n354 4.5005
R1837 Vdd.n353 Vdd.n256 4.5005
R1838 Vdd.n352 Vdd.n351 4.5005
R1839 Vdd.n258 Vdd.n257 4.5005
R1840 Vdd.n345 Vdd.n267 4.5005
R1841 Vdd.n344 Vdd.n268 4.5005
R1842 Vdd.n343 Vdd.n269 4.5005
R1843 Vdd.n277 Vdd.n270 4.5005
R1844 Vdd.n337 Vdd.n278 4.5005
R1845 Vdd.n336 Vdd.n279 4.5005
R1846 Vdd.n335 Vdd.n280 4.5005
R1847 Vdd.n288 Vdd.n281 4.5005
R1848 Vdd.n329 Vdd.n289 4.5005
R1849 Vdd.n328 Vdd.n290 4.5005
R1850 Vdd.n327 Vdd.n291 4.5005
R1851 Vdd.n238 Vdd.n237 4.5005
R1852 Vdd.n374 Vdd.n373 4.5005
R1853 Vdd.n356 Vdd.n255 4.5005
R1854 Vdd.n249 Vdd.n248 4.5005
R1855 Vdd.n303 Vdd.n302 4.5005
R1856 Vdd.n305 Vdd.n304 4.5005
R1857 Vdd.n306 Vdd.n300 4.5005
R1858 Vdd.n308 Vdd.n307 4.5005
R1859 Vdd.n309 Vdd.n299 4.5005
R1860 Vdd.n311 Vdd.n310 4.5005
R1861 Vdd.n312 Vdd.n297 4.5005
R1862 Vdd.n314 Vdd.n313 4.5005
R1863 Vdd.n315 Vdd.n296 4.5005
R1864 Vdd.n317 Vdd.n316 4.5005
R1865 Vdd.n318 Vdd.n294 4.5005
R1866 Vdd.n320 Vdd.n319 4.5005
R1867 Vdd.n321 Vdd.n293 4.5005
R1868 Vdd.n323 Vdd.n322 4.5005
R1869 Vdd.n244 Vdd.n243 4.5005
R1870 Vdd.n369 Vdd.n368 4.5005
R1871 Vdd.n377 Vdd.n236 4.5005
R1872 Vdd.n378 Vdd.n230 4.5005
R1873 Vdd.n385 Vdd.n384 4.5005
R1874 Vdd.n388 Vdd.n220 4.5005
R1875 Vdd.n395 Vdd.n394 4.5005
R1876 Vdd.n221 Vdd.n214 4.5005
R1877 Vdd.n402 Vdd.n209 4.5005
R1878 Vdd.n409 Vdd.n408 4.5005
R1879 Vdd.n412 Vdd.n200 4.5005
R1880 Vdd.n419 Vdd.n418 4.5005
R1881 Vdd.n201 Vdd.n194 4.5005
R1882 Vdd.n428 Vdd.n189 4.5005
R1883 Vdd.n435 Vdd.n434 4.5005
R1884 Vdd.n438 Vdd.n181 4.5005
R1885 Vdd.n445 Vdd.n444 4.5005
R1886 Vdd.n448 Vdd.n170 4.5005
R1887 Vdd.n455 Vdd.n454 4.5005
R1888 Vdd.n171 Vdd.n164 4.5005
R1889 Vdd.n462 Vdd.n159 4.5005
R1890 Vdd.n469 Vdd.n468 4.5005
R1891 Vdd.n472 Vdd.n148 4.5005
R1892 Vdd.n479 Vdd.n478 4.5005
R1893 Vdd.n149 Vdd.n142 4.5005
R1894 Vdd.n484 Vdd.n136 4.5005
R1895 Vdd.n491 Vdd.n490 4.5005
R1896 Vdd.n137 Vdd.n131 4.5005
R1897 Vdd.n498 Vdd.n125 4.5005
R1898 Vdd.n504 Vdd.n126 4.5005
R1899 Vdd.n505 Vdd.n124 4.5005
R1900 Vdd.n508 Vdd.n507 4.5005
R1901 Vdd.n509 Vdd.n123 4.5005
R1902 Vdd.n511 Vdd.n510 4.5005
R1903 Vdd.n514 Vdd.n122 4.5005
R1904 Vdd.n516 Vdd.n515 4.5005
R1905 Vdd.n517 Vdd.n121 4.5005
R1906 Vdd.n555 Vdd.n518 4.5005
R1907 Vdd.n554 Vdd.n519 4.5005
R1908 Vdd.n553 Vdd.n520 4.5005
R1909 Vdd.n552 Vdd.n521 4.5005
R1910 Vdd.n550 Vdd.n522 4.5005
R1911 Vdd.n549 Vdd.n523 4.5005
R1912 Vdd.n526 Vdd.n524 4.5005
R1913 Vdd.n534 Vdd.n527 4.5005
R1914 Vdd.n533 Vdd.n528 4.5005
R1915 Vdd.n532 Vdd.n529 4.5005
R1916 Vdd.n531 Vdd.n530 4.5005
R1917 Vdd.n362 Vdd.n361 4.5005
R1918 Vdd.n104 Vdd.n100 4.5005
R1919 Vdd.n103 Vdd.n102 4.5005
R1920 Vdd.n570 Vdd.n98 4.5005
R1921 Vdd.n572 Vdd.n571 4.5005
R1922 Vdd.n601 Vdd.n600 4.5005
R1923 Vdd.n54 Vdd.n53 4.5005
R1924 Vdd.n628 Vdd.n627 4.5005
R1925 Vdd.n626 Vdd.n625 4.5005
R1926 Vdd.n613 Vdd.n612 3.61362
R1927 Vdd.n50 Vdd.n43 3.61362
R1928 Vdd.n12 Vdd.n6 3.31679
R1929 Vdd.n7 Vdd.n6 3.31679
R1930 Vdd.n15 Vdd.n4 3.31679
R1931 Vdd.n16 Vdd.n15 3.31679
R1932 Vdd.n30 Vdd.n29 3.31679
R1933 Vdd.n30 Vdd.n24 3.31679
R1934 Vdd.n32 Vdd.n21 3.31679
R1935 Vdd.n33 Vdd.n32 3.31679
R1936 Vdd.n630 Vdd.n629 3.31679
R1937 Vdd.n630 Vdd.n624 3.31679
R1938 Vdd.n632 Vdd.n621 3.31679
R1939 Vdd.n633 Vdd.n632 3.31679
R1940 Vdd.n616 Vdd.n615 3.28078
R1941 Vdd.n359 Vdd.n358 3.26114
R1942 Vdd.n615 Vdd.n614 3.14293
R1943 Vdd.n615 Vdd.n38 3.14293
R1944 Vdd.n437 Vdd.n179 2.80819
R1945 Vdd.n446 Vdd.n179 2.80819
R1946 Vdd.n364 Vdd.n363 2.6735
R1947 Vdd.n367 Vdd.n366 2.4683
R1948 Vdd.n18 Vdd.n17 2.21557
R1949 Vdd.n609 Vdd.n37 2.21557
R1950 Vdd.n618 Vdd.n34 2.21557
R1951 Vdd.n635 Vdd.n634 2.21557
R1952 Vdd.n358 Vdd.n357 1.82789
R1953 Vdd.n496 Vdd.n37 1.23277
R1954 Vdd.n620 Vss 1.0868
R1955 Vdd.n13 Vdd.n2 0.9005
R1956 Vdd.n14 Vdd.n13 0.9005
R1957 Vdd.n5 Vdd.n3 0.9005
R1958 Vdd.n14 Vdd.n5 0.9005
R1959 Vdd.n22 Vdd.n19 0.9005
R1960 Vdd.n31 Vdd.n22 0.9005
R1961 Vdd.n23 Vdd.n20 0.9005
R1962 Vdd.n31 Vdd.n23 0.9005
R1963 Vdd.n622 Vdd.n0 0.9005
R1964 Vdd.n631 Vdd.n622 0.9005
R1965 Vdd.n623 Vdd.n1 0.9005
R1966 Vdd.n631 Vdd.n623 0.9005
R1967 Vdd.n58 Vdd.n55 0.743357
R1968 Vdd.n536 Vdd.n58 0.743357
R1969 Vdd.n78 Vdd.n77 0.743357
R1970 Vdd.n585 Vdd.n78 0.743357
R1971 Vdd.n567 Vdd.n566 0.743357
R1972 Vdd.n566 Vdd.n565 0.743357
R1973 Vdd.n101 Vdd.n96 0.743357
R1974 Vdd.n96 Vdd.n83 0.743357
R1975 Vdd.n603 Vdd.n35 0.743357
R1976 Vdd.n604 Vdd.n603 0.743357
R1977 Vdd.n39 Vdd.n36 0.743357
R1978 Vdd.n557 Vdd.n39 0.743357
R1979 Vdd.n367 Vdd.n235 0.573125
R1980 Vdd.n495 Vdd.n132 0.483125
R1981 Vdd.n375 Vdd.n235 0.483125
R1982 Vdd.n254 Vdd.n250 0.473227
R1983 Vdd.n587 Vdd.n586 0.473227
R1984 Vdd.n586 Vdd.n585 0.473227
R1985 Vdd.n363 Vdd.n126 0.44735
R1986 Vdd.n363 Vdd.n132 0.393125
R1987 Vdd.n619 Vdd.n18 0.316383
R1988 Vdd.n587 Vdd.n69 0.29887
R1989 Vdd.n482 Vdd.n134 0.28625
R1990 Vdd.n483 Vdd.n482 0.28175
R1991 Vdd.n481 Vdd.n480 0.28175
R1992 Vdd.n144 Vdd.n143 0.28175
R1993 Vdd.n458 Vdd.n156 0.28175
R1994 Vdd.n459 Vdd.n158 0.28175
R1995 Vdd.n461 Vdd.n460 0.28175
R1996 Vdd.n457 Vdd.n456 0.28175
R1997 Vdd.n166 Vdd.n165 0.28175
R1998 Vdd.n422 Vdd.n177 0.28175
R1999 Vdd.n423 Vdd.n180 0.28175
R2000 Vdd.n424 Vdd.n186 0.28175
R2001 Vdd.n425 Vdd.n188 0.28175
R2002 Vdd.n427 Vdd.n426 0.28175
R2003 Vdd.n421 Vdd.n420 0.28175
R2004 Vdd.n196 Vdd.n195 0.28175
R2005 Vdd.n398 Vdd.n206 0.28175
R2006 Vdd.n399 Vdd.n208 0.28175
R2007 Vdd.n401 Vdd.n400 0.28175
R2008 Vdd.n397 Vdd.n396 0.28175
R2009 Vdd.n216 Vdd.n215 0.28175
R2010 Vdd.n245 Vdd.n227 0.28175
R2011 Vdd.n246 Vdd.n229 0.28175
R2012 Vdd.n495 Vdd.n494 0.26735
R2013 Vdd.n589 Vdd.n588 0.2255
R2014 Vdd.n496 Vdd.n495 0.219838
R2015 Vdd.n375 Vdd.n374 0.20615
R2016 Vdd.n368 Vdd.n367 0.20615
R2017 Vdd.n599 Vdd.n598 0.2057
R2018 Vdd.n569 Vdd.n568 0.2057
R2019 Vdd.n620 Vdd.n619 0.2057
R2020 Vdd.n132 Vdd.n99 0.1841
R2021 Vdd.n179 Vdd.n178 0.1684
R2022 Vdd.n11 Vdd.n8 0.1445
R2023 Vdd.n10 Vdd.n9 0.1445
R2024 Vdd.n28 Vdd.n25 0.1445
R2025 Vdd.n27 Vdd.n26 0.1445
R2026 Vdd.n601 Vdd.n53 0.1445
R2027 Vdd.n572 Vdd.n98 0.1445
R2028 Vdd.n494 Vdd.n87 0.1445
R2029 Vdd.n88 Vdd.n87 0.1445
R2030 Vdd.n89 Vdd.n88 0.1445
R2031 Vdd.n113 Vdd.n89 0.1445
R2032 Vdd.n114 Vdd.n113 0.1445
R2033 Vdd.n115 Vdd.n114 0.1445
R2034 Vdd.n116 Vdd.n115 0.1445
R2035 Vdd.n118 Vdd.n116 0.1445
R2036 Vdd.n118 Vdd.n117 0.1445
R2037 Vdd.n596 Vdd.n57 0.1445
R2038 Vdd.n75 Vdd.n74 0.1445
R2039 Vdd.n76 Vdd.n73 0.1445
R2040 Vdd.n539 Vdd.n47 0.1445
R2041 Vdd.n540 Vdd.n539 0.1445
R2042 Vdd.n542 Vdd.n540 0.1445
R2043 Vdd.n542 Vdd.n541 0.1445
R2044 Vdd.n541 Vdd.n67 0.1445
R2045 Vdd.n589 Vdd.n67 0.1445
R2046 Vdd.n126 Vdd.n124 0.1445
R2047 Vdd.n508 Vdd.n124 0.1445
R2048 Vdd.n509 Vdd.n508 0.1445
R2049 Vdd.n510 Vdd.n509 0.1445
R2050 Vdd.n510 Vdd.n122 0.1445
R2051 Vdd.n516 Vdd.n122 0.1445
R2052 Vdd.n517 Vdd.n516 0.1445
R2053 Vdd.n518 Vdd.n517 0.1445
R2054 Vdd.n519 Vdd.n518 0.1445
R2055 Vdd.n520 Vdd.n519 0.1445
R2056 Vdd.n521 Vdd.n520 0.1445
R2057 Vdd.n522 Vdd.n521 0.1445
R2058 Vdd.n523 Vdd.n522 0.1445
R2059 Vdd.n526 Vdd.n523 0.1445
R2060 Vdd.n527 Vdd.n526 0.1445
R2061 Vdd.n528 Vdd.n527 0.1445
R2062 Vdd.n529 Vdd.n528 0.1445
R2063 Vdd.n530 Vdd.n529 0.1445
R2064 Vdd.n356 Vdd.n355 0.1445
R2065 Vdd.n355 Vdd.n256 0.1445
R2066 Vdd.n351 Vdd.n256 0.1445
R2067 Vdd.n351 Vdd.n258 0.1445
R2068 Vdd.n345 Vdd.n258 0.1445
R2069 Vdd.n345 Vdd.n344 0.1445
R2070 Vdd.n344 Vdd.n343 0.1445
R2071 Vdd.n343 Vdd.n270 0.1445
R2072 Vdd.n337 Vdd.n270 0.1445
R2073 Vdd.n337 Vdd.n336 0.1445
R2074 Vdd.n336 Vdd.n335 0.1445
R2075 Vdd.n335 Vdd.n281 0.1445
R2076 Vdd.n329 Vdd.n281 0.1445
R2077 Vdd.n329 Vdd.n328 0.1445
R2078 Vdd.n328 Vdd.n327 0.1445
R2079 Vdd.n327 Vdd.n238 0.1445
R2080 Vdd.n373 Vdd.n238 0.1445
R2081 Vdd.n373 Vdd.n234 0.1445
R2082 Vdd.n379 Vdd.n234 0.1445
R2083 Vdd.n379 Vdd.n226 0.1445
R2084 Vdd.n389 Vdd.n226 0.1445
R2085 Vdd.n389 Vdd.n217 0.1445
R2086 Vdd.n217 Vdd.n213 0.1445
R2087 Vdd.n403 Vdd.n213 0.1445
R2088 Vdd.n403 Vdd.n205 0.1445
R2089 Vdd.n413 Vdd.n205 0.1445
R2090 Vdd.n413 Vdd.n197 0.1445
R2091 Vdd.n197 Vdd.n193 0.1445
R2092 Vdd.n429 Vdd.n193 0.1445
R2093 Vdd.n429 Vdd.n185 0.1445
R2094 Vdd.n439 Vdd.n185 0.1445
R2095 Vdd.n439 Vdd.n176 0.1445
R2096 Vdd.n449 Vdd.n176 0.1445
R2097 Vdd.n449 Vdd.n167 0.1445
R2098 Vdd.n167 Vdd.n163 0.1445
R2099 Vdd.n463 Vdd.n163 0.1445
R2100 Vdd.n463 Vdd.n155 0.1445
R2101 Vdd.n473 Vdd.n155 0.1445
R2102 Vdd.n473 Vdd.n145 0.1445
R2103 Vdd.n145 Vdd.n141 0.1445
R2104 Vdd.n485 Vdd.n141 0.1445
R2105 Vdd.n485 Vdd.n135 0.1445
R2106 Vdd.n135 Vdd.n130 0.1445
R2107 Vdd.n499 Vdd.n130 0.1445
R2108 Vdd.n499 Vdd.n86 0.1445
R2109 Vdd.n579 Vdd.n86 0.1445
R2110 Vdd.n579 Vdd.n578 0.1445
R2111 Vdd.n578 Vdd.n577 0.1445
R2112 Vdd.n577 Vdd.n90 0.1445
R2113 Vdd.n112 Vdd.n90 0.1445
R2114 Vdd.n562 Vdd.n112 0.1445
R2115 Vdd.n562 Vdd.n561 0.1445
R2116 Vdd.n561 Vdd.n560 0.1445
R2117 Vdd.n560 Vdd.n46 0.1445
R2118 Vdd.n610 Vdd.n46 0.1445
R2119 Vdd.n608 Vdd.n607 0.1445
R2120 Vdd.n607 Vdd.n48 0.1445
R2121 Vdd.n544 Vdd.n48 0.1445
R2122 Vdd.n544 Vdd.n543 0.1445
R2123 Vdd.n543 Vdd.n66 0.1445
R2124 Vdd.n591 Vdd.n66 0.1445
R2125 Vdd.n591 Vdd.n590 0.1445
R2126 Vdd.n354 Vdd.n255 0.1445
R2127 Vdd.n354 Vdd.n353 0.1445
R2128 Vdd.n353 Vdd.n352 0.1445
R2129 Vdd.n352 Vdd.n257 0.1445
R2130 Vdd.n267 Vdd.n257 0.1445
R2131 Vdd.n268 Vdd.n267 0.1445
R2132 Vdd.n269 Vdd.n268 0.1445
R2133 Vdd.n277 Vdd.n269 0.1445
R2134 Vdd.n278 Vdd.n277 0.1445
R2135 Vdd.n279 Vdd.n278 0.1445
R2136 Vdd.n280 Vdd.n279 0.1445
R2137 Vdd.n288 Vdd.n280 0.1445
R2138 Vdd.n289 Vdd.n288 0.1445
R2139 Vdd.n290 Vdd.n289 0.1445
R2140 Vdd.n291 Vdd.n290 0.1445
R2141 Vdd.n291 Vdd.n237 0.1445
R2142 Vdd.n374 Vdd.n237 0.1445
R2143 Vdd.n362 Vdd.n248 0.1445
R2144 Vdd.n303 Vdd.n248 0.1445
R2145 Vdd.n304 Vdd.n303 0.1445
R2146 Vdd.n304 Vdd.n300 0.1445
R2147 Vdd.n308 Vdd.n300 0.1445
R2148 Vdd.n309 Vdd.n308 0.1445
R2149 Vdd.n310 Vdd.n309 0.1445
R2150 Vdd.n310 Vdd.n297 0.1445
R2151 Vdd.n314 Vdd.n297 0.1445
R2152 Vdd.n315 Vdd.n314 0.1445
R2153 Vdd.n316 Vdd.n315 0.1445
R2154 Vdd.n316 Vdd.n294 0.1445
R2155 Vdd.n320 Vdd.n294 0.1445
R2156 Vdd.n321 Vdd.n320 0.1445
R2157 Vdd.n322 Vdd.n321 0.1445
R2158 Vdd.n322 Vdd.n244 0.1445
R2159 Vdd.n368 Vdd.n244 0.1445
R2160 Vdd.n361 Vdd.n249 0.1445
R2161 Vdd.n302 Vdd.n249 0.1445
R2162 Vdd.n305 Vdd.n302 0.1445
R2163 Vdd.n306 Vdd.n305 0.1445
R2164 Vdd.n307 Vdd.n306 0.1445
R2165 Vdd.n307 Vdd.n299 0.1445
R2166 Vdd.n311 Vdd.n299 0.1445
R2167 Vdd.n312 Vdd.n311 0.1445
R2168 Vdd.n313 Vdd.n312 0.1445
R2169 Vdd.n313 Vdd.n296 0.1445
R2170 Vdd.n317 Vdd.n296 0.1445
R2171 Vdd.n318 Vdd.n317 0.1445
R2172 Vdd.n319 Vdd.n318 0.1445
R2173 Vdd.n319 Vdd.n293 0.1445
R2174 Vdd.n323 Vdd.n293 0.1445
R2175 Vdd.n323 Vdd.n243 0.1445
R2176 Vdd.n369 Vdd.n243 0.1445
R2177 Vdd.n369 Vdd.n236 0.1445
R2178 Vdd.n236 Vdd.n230 0.1445
R2179 Vdd.n384 Vdd.n230 0.1445
R2180 Vdd.n384 Vdd.n220 0.1445
R2181 Vdd.n394 Vdd.n220 0.1445
R2182 Vdd.n394 Vdd.n221 0.1445
R2183 Vdd.n221 Vdd.n209 0.1445
R2184 Vdd.n408 Vdd.n209 0.1445
R2185 Vdd.n408 Vdd.n200 0.1445
R2186 Vdd.n418 Vdd.n200 0.1445
R2187 Vdd.n418 Vdd.n201 0.1445
R2188 Vdd.n201 Vdd.n189 0.1445
R2189 Vdd.n434 Vdd.n189 0.1445
R2190 Vdd.n434 Vdd.n181 0.1445
R2191 Vdd.n444 Vdd.n181 0.1445
R2192 Vdd.n444 Vdd.n170 0.1445
R2193 Vdd.n454 Vdd.n170 0.1445
R2194 Vdd.n454 Vdd.n171 0.1445
R2195 Vdd.n171 Vdd.n159 0.1445
R2196 Vdd.n468 Vdd.n159 0.1445
R2197 Vdd.n468 Vdd.n148 0.1445
R2198 Vdd.n478 Vdd.n148 0.1445
R2199 Vdd.n478 Vdd.n149 0.1445
R2200 Vdd.n149 Vdd.n136 0.1445
R2201 Vdd.n490 Vdd.n136 0.1445
R2202 Vdd.n490 Vdd.n137 0.1445
R2203 Vdd.n137 Vdd.n125 0.1445
R2204 Vdd.n504 Vdd.n125 0.1445
R2205 Vdd.n505 Vdd.n504 0.1445
R2206 Vdd.n507 Vdd.n505 0.1445
R2207 Vdd.n507 Vdd.n123 0.1445
R2208 Vdd.n511 Vdd.n123 0.1445
R2209 Vdd.n514 Vdd.n511 0.1445
R2210 Vdd.n515 Vdd.n514 0.1445
R2211 Vdd.n515 Vdd.n121 0.1445
R2212 Vdd.n555 Vdd.n121 0.1445
R2213 Vdd.n555 Vdd.n554 0.1445
R2214 Vdd.n554 Vdd.n553 0.1445
R2215 Vdd.n553 Vdd.n552 0.1445
R2216 Vdd.n552 Vdd.n550 0.1445
R2217 Vdd.n550 Vdd.n549 0.1445
R2218 Vdd.n549 Vdd.n524 0.1445
R2219 Vdd.n534 Vdd.n524 0.1445
R2220 Vdd.n534 Vdd.n533 0.1445
R2221 Vdd.n533 Vdd.n532 0.1445
R2222 Vdd.n532 Vdd.n531 0.1445
R2223 Vdd.n104 Vdd.n103 0.1445
R2224 Vdd.n102 Vdd.n100 0.1445
R2225 Vdd.n628 Vdd.n625 0.1445
R2226 Vdd.n627 Vdd.n626 0.1445
R2227 Vdd.n619 Vdd.n618 0.111183
R2228 Vdd.n635 Vdd.n620 0.111183
R2229 Vdd.n616 Vdd.n37 0.107176
R2230 Vdd.n610 Vdd.n609 0.0718661
R2231 Vdd.n609 Vdd.n608 0.0718661
R2232 Vdd.n47 Vdd.n37 0.0671
R2233 Vdd.n117 Vdd.n37 0.0599
R2234 Vss Vdd.n362 0.0599
R2235 Vss Vdd.n635 0.0577669
R2236 Vdd.n617 Vss 0.0507793
R2237 Vss Vdd.n247 0.0490611
R2238 Vdd.n366 Vss 0.0455
R2239 Vdd.n598 Vdd.n597 0.0298531
R2240 Vdd.n68 Vdd.n56 0.0298531
R2241 Vdd.n571 Vdd.n99 0.0298531
R2242 Vdd.n570 Vdd.n569 0.0298531
R2243 Vdd.n568 Vdd.n54 0.0298531
R2244 Vdd.n600 Vdd.n599 0.0298531
R2245 Vdd.n597 Vdd.n56 0.019907
R2246 Vdd.n571 Vdd.n570 0.019907
R2247 Vdd.n600 Vdd.n54 0.019907
R2248 Vdd.n618 Vdd.n617 0.00748758
R2249 Vdd.n246 Vdd.n245 0.005
R2250 Vdd.n245 Vdd.n215 0.005
R2251 Vdd.n397 Vdd.n215 0.005
R2252 Vdd.n400 Vdd.n397 0.005
R2253 Vdd.n400 Vdd.n399 0.005
R2254 Vdd.n399 Vdd.n398 0.005
R2255 Vdd.n398 Vdd.n195 0.005
R2256 Vdd.n421 Vdd.n195 0.005
R2257 Vdd.n426 Vdd.n421 0.005
R2258 Vdd.n426 Vdd.n425 0.005
R2259 Vdd.n425 Vdd.n424 0.005
R2260 Vdd.n424 Vdd.n423 0.005
R2261 Vdd.n423 Vdd.n422 0.005
R2262 Vdd.n422 Vdd.n165 0.005
R2263 Vdd.n457 Vdd.n165 0.005
R2264 Vdd.n460 Vdd.n457 0.005
R2265 Vdd.n460 Vdd.n459 0.005
R2266 Vdd.n459 Vdd.n458 0.005
R2267 Vdd.n458 Vdd.n143 0.005
R2268 Vdd.n481 Vdd.n143 0.005
R2269 Vdd.n482 Vdd.n481 0.005
R2270 Vdd.n378 Vdd.n377 0.00389783
R2271 Vdd.n491 Vdd.n131 0.00389783
R2272 Vdd.n498 Vdd.n131 0.00389783
R2273 Vdd.n378 Vdd.n229 0.00317579
R2274 Vdd.n385 Vdd.n227 0.00317579
R2275 Vdd.n388 Vdd.n216 0.00317579
R2276 Vdd.n396 Vdd.n395 0.00317579
R2277 Vdd.n401 Vdd.n214 0.00317579
R2278 Vdd.n402 Vdd.n208 0.00317579
R2279 Vdd.n409 Vdd.n206 0.00317579
R2280 Vdd.n412 Vdd.n196 0.00317579
R2281 Vdd.n420 Vdd.n419 0.00317579
R2282 Vdd.n427 Vdd.n194 0.00317579
R2283 Vdd.n428 Vdd.n188 0.00317579
R2284 Vdd.n435 Vdd.n186 0.00317579
R2285 Vdd.n445 Vdd.n177 0.00317579
R2286 Vdd.n448 Vdd.n166 0.00317579
R2287 Vdd.n456 Vdd.n455 0.00317579
R2288 Vdd.n461 Vdd.n164 0.00317579
R2289 Vdd.n462 Vdd.n158 0.00317579
R2290 Vdd.n469 Vdd.n156 0.00317579
R2291 Vdd.n472 Vdd.n144 0.00317579
R2292 Vdd.n480 Vdd.n479 0.00317579
R2293 Vdd.n483 Vdd.n142 0.00317579
R2294 Vdd.n484 Vdd.n134 0.00317579
R2295 Vdd.n438 Vss 0.00219891
R2296 Vdd.n377 Vdd.n235 0.0020715
R2297 Vss Vdd.n180 0.00147688
R2298 Vdd.n385 Vdd.n229 0.00122204
R2299 Vdd.n388 Vdd.n227 0.00122204
R2300 Vdd.n395 Vdd.n216 0.00122204
R2301 Vdd.n396 Vdd.n214 0.00122204
R2302 Vdd.n402 Vdd.n401 0.00122204
R2303 Vdd.n409 Vdd.n208 0.00122204
R2304 Vdd.n412 Vdd.n206 0.00122204
R2305 Vdd.n419 Vdd.n196 0.00122204
R2306 Vdd.n420 Vdd.n194 0.00122204
R2307 Vdd.n428 Vdd.n427 0.00122204
R2308 Vdd.n435 Vdd.n188 0.00122204
R2309 Vdd.n438 Vdd.n186 0.00122204
R2310 Vdd.n445 Vdd.n180 0.00122204
R2311 Vdd.n448 Vdd.n177 0.00122204
R2312 Vdd.n455 Vdd.n166 0.00122204
R2313 Vdd.n456 Vdd.n164 0.00122204
R2314 Vdd.n462 Vdd.n461 0.00122204
R2315 Vdd.n469 Vdd.n158 0.00122204
R2316 Vdd.n472 Vdd.n156 0.00122204
R2317 Vdd.n479 Vdd.n144 0.00122204
R2318 Vdd.n480 Vdd.n142 0.00122204
R2319 Vdd.n484 Vdd.n483 0.00122204
R2320 Vdd.n491 Vdd.n134 0.00122204
R2321 Vdd.n498 Vdd.n132 0.000627419
R2322 Iin.n595 Iin.n52 18200
R2323 Iin.n596 Iin.n51 18200
R2324 Iin.n595 Iin.n594 14238.8
R2325 Iin.n596 Iin.n595 4468.75
R2326 Iin.n597 Iin.n596 4062.5
R2327 Iin.n137 Iin.n136 521.494
R2328 Iin.n136 Iin.n135 521.494
R2329 Iin.n120 Iin.n119 521.494
R2330 Iin.n119 Iin.n118 521.494
R2331 Iin.n103 Iin.n102 521.494
R2332 Iin.n102 Iin.n94 521.494
R2333 Iin.n594 Iin.n53 229.434
R2334 Iin.n488 Iin.n171 144.525
R2335 Iin.n525 Iin.n157 144.525
R2336 Iin.n550 Iin.n82 144.525
R2337 Iin.n567 Iin.n67 144.525
R2338 Iin.n535 Iin.n145 140.912
R2339 Iin.n542 Iin.n541 140.912
R2340 Iin.n151 Iin.n51 139.106
R2341 Iin.n83 Iin.n52 131.88
R2342 Iin.n499 Iin.n498 130.072
R2343 Iin.n515 Iin.n164 130.072
R2344 Iin.n579 Iin.n578 128.267
R2345 Iin.n578 Iin.n69 122.847
R2346 Iin.n586 Iin.n63 122.847
R2347 Iin.n515 Iin.n514 121.04
R2348 Iin.n536 Iin.n535 110.201
R2349 Iin.n550 Iin.n84 102.975
R2350 Iin.n294 Iin.n284 94.2375
R2351 Iin.n303 Iin.n284 94.2375
R2352 Iin.n303 Iin.n278 94.2375
R2353 Iin.n311 Iin.n278 94.2375
R2354 Iin.n311 Iin.n272 94.2375
R2355 Iin.n319 Iin.n272 94.2375
R2356 Iin.n319 Iin.n266 94.2375
R2357 Iin.n327 Iin.n266 94.2375
R2358 Iin.n327 Iin.n260 94.2375
R2359 Iin.n337 Iin.n260 94.2375
R2360 Iin.n337 Iin.n254 94.2375
R2361 Iin.n345 Iin.n254 94.2375
R2362 Iin.n345 Iin.n248 94.2375
R2363 Iin.n357 Iin.n248 94.2375
R2364 Iin.n357 Iin.n356 94.2375
R2365 Iin.n356 Iin.n242 94.2375
R2366 Iin.n367 Iin.n242 94.2375
R2367 Iin.n367 Iin.n239 94.2375
R2368 Iin.n372 Iin.n239 94.2375
R2369 Iin.n373 Iin.n372 94.2375
R2370 Iin.n376 Iin.n373 94.2375
R2371 Iin.n376 Iin.n237 94.2375
R2372 Iin.n381 Iin.n237 94.2375
R2373 Iin.n382 Iin.n381 94.2375
R2374 Iin.n385 Iin.n382 94.2375
R2375 Iin.n385 Iin.n235 94.2375
R2376 Iin.n390 Iin.n235 94.2375
R2377 Iin.n391 Iin.n390 94.2375
R2378 Iin.n393 Iin.n391 94.2375
R2379 Iin.n393 Iin.n233 94.2375
R2380 Iin.n432 Iin.n233 94.2375
R2381 Iin.n432 Iin.n431 94.2375
R2382 Iin.n431 Iin.n430 94.2375
R2383 Iin.n430 Iin.n429 94.2375
R2384 Iin.n429 Iin.n428 94.2375
R2385 Iin.n428 Iin.n425 94.2375
R2386 Iin.n425 Iin.n424 94.2375
R2387 Iin.n424 Iin.n423 94.2375
R2388 Iin.n423 Iin.n422 94.2375
R2389 Iin.n422 Iin.n419 94.2375
R2390 Iin.n419 Iin.n418 94.2375
R2391 Iin.n418 Iin.n417 94.2375
R2392 Iin.n417 Iin.n416 94.2375
R2393 Iin.n416 Iin.n48 94.2375
R2394 Iin.n598 Iin.n48 94.2375
R2395 Iin.n488 Iin.n480 92.135
R2396 Iin.n593 Iin.n55 84.0977
R2397 Iin.n593 Iin.n56 84.0977
R2398 Iin.n293 Iin.n287 84.0977
R2399 Iin.n598 Iin.n597 74.2122
R2400 Iin.n585 Iin.n54 69.0283
R2401 Iin.n587 Iin.n54 69.0283
R2402 Iin.n580 Iin.n62 69.0283
R2403 Iin.n580 Iin.n64 69.0283
R2404 Iin.n177 Iin.n170 69.0283
R2405 Iin.n513 Iin.n166 69.0283
R2406 Iin.n500 Iin.n170 69.0283
R2407 Iin.n513 Iin.n167 69.0283
R2408 Iin.n540 Iin.n148 69.0283
R2409 Iin.n148 Iin.n147 69.0283
R2410 Iin.n537 Iin.n149 69.0283
R2411 Iin.n538 Iin.n537 69.0283
R2412 Iin.n138 Iin.n127 62.1255
R2413 Iin.n134 Iin.n127 62.1255
R2414 Iin.n129 Iin.n128 62.1255
R2415 Iin.n128 Iin.n126 62.1255
R2416 Iin.n121 Iin.n110 62.1255
R2417 Iin.n117 Iin.n110 62.1255
R2418 Iin.n112 Iin.n111 62.1255
R2419 Iin.n111 Iin.n109 62.1255
R2420 Iin.n101 Iin.n92 62.1255
R2421 Iin.n101 Iin.n100 62.1255
R2422 Iin.n95 Iin.n93 62.1255
R2423 Iin.n104 Iin.n93 62.1255
R2424 Iin.n295 Iin.n287 52.7258
R2425 Iin.n480 Iin.n50 52.3907
R2426 Iin.n84 Iin.n83 41.5514
R2427 Iin.n536 Iin.n151 34.3251
R2428 Iin.n597 Iin.n50 30.712
R2429 Iin.n514 Iin.n157 23.4858
R2430 Iin.n69 Iin.n63 21.6792
R2431 Iin.n586 Iin.n53 21.6792
R2432 Iin.n579 Iin.n67 16.2595
R2433 Iin.n587 Iin.n62 15.5561
R2434 Iin.n585 Iin.n64 15.5561
R2435 Iin.n177 Iin.n166 15.5561
R2436 Iin.n500 Iin.n167 15.5561
R2437 Iin.n149 Iin.n147 15.5561
R2438 Iin.n296 Iin.n285 15.5561
R2439 Iin.n302 Iin.n285 15.5561
R2440 Iin.n302 Iin.n277 15.5561
R2441 Iin.n312 Iin.n277 15.5561
R2442 Iin.n312 Iin.n273 15.5561
R2443 Iin.n318 Iin.n273 15.5561
R2444 Iin.n318 Iin.n265 15.5561
R2445 Iin.n328 Iin.n265 15.5561
R2446 Iin.n328 Iin.n261 15.5561
R2447 Iin.n336 Iin.n261 15.5561
R2448 Iin.n336 Iin.n253 15.5561
R2449 Iin.n346 Iin.n253 15.5561
R2450 Iin.n347 Iin.n346 15.5561
R2451 Iin.n347 Iin.n249 15.5561
R2452 Iin.n355 Iin.n249 15.5561
R2453 Iin.n355 Iin.n240 15.5561
R2454 Iin.n368 Iin.n240 15.5561
R2455 Iin.n369 Iin.n368 15.5561
R2456 Iin.n371 Iin.n369 15.5561
R2457 Iin.n371 Iin.n238 15.5561
R2458 Iin.n377 Iin.n238 15.5561
R2459 Iin.n379 Iin.n377 15.5561
R2460 Iin.n380 Iin.n379 15.5561
R2461 Iin.n380 Iin.n236 15.5561
R2462 Iin.n386 Iin.n236 15.5561
R2463 Iin.n388 Iin.n386 15.5561
R2464 Iin.n389 Iin.n388 15.5561
R2465 Iin.n389 Iin.n234 15.5561
R2466 Iin.n394 Iin.n234 15.5561
R2467 Iin.n395 Iin.n394 15.5561
R2468 Iin.n396 Iin.n395 15.5561
R2469 Iin.n399 Iin.n396 15.5561
R2470 Iin.n400 Iin.n399 15.5561
R2471 Iin.n401 Iin.n400 15.5561
R2472 Iin.n402 Iin.n401 15.5561
R2473 Iin.n404 Iin.n402 15.5561
R2474 Iin.n405 Iin.n404 15.5561
R2475 Iin.n406 Iin.n405 15.5561
R2476 Iin.n407 Iin.n406 15.5561
R2477 Iin.n409 Iin.n407 15.5561
R2478 Iin.n410 Iin.n409 15.5561
R2479 Iin.n411 Iin.n410 15.5561
R2480 Iin.n414 Iin.n411 15.5561
R2481 Iin.n414 Iin.n412 15.5561
R2482 Iin.n412 Iin.n49 15.5561
R2483 Iin.n479 Iin.n49 15.5561
R2484 Iin.n489 Iin.n479 15.5561
R2485 Iin.n489 Iin.n178 15.5561
R2486 Iin.n497 Iin.n178 15.5561
R2487 Iin.n497 Iin.n165 15.5561
R2488 Iin.n165 Iin.n156 15.5561
R2489 Iin.n526 Iin.n156 15.5561
R2490 Iin.n526 Iin.n152 15.5561
R2491 Iin.n534 Iin.n152 15.5561
R2492 Iin.n534 Iin.n146 15.5561
R2493 Iin.n146 Iin.n81 15.5561
R2494 Iin.n551 Iin.n81 15.5561
R2495 Iin.n551 Iin.n76 15.5561
R2496 Iin.n566 Iin.n76 15.5561
R2497 Iin.n566 Iin.n77 15.5561
R2498 Iin.n77 Iin.n68 15.5561
R2499 Iin.n561 Iin.n68 15.5561
R2500 Iin.n561 Iin.n55 15.5561
R2501 Iin.n293 Iin.n283 15.5561
R2502 Iin.n304 Iin.n283 15.5561
R2503 Iin.n304 Iin.n279 15.5561
R2504 Iin.n310 Iin.n279 15.5561
R2505 Iin.n310 Iin.n271 15.5561
R2506 Iin.n320 Iin.n271 15.5561
R2507 Iin.n320 Iin.n267 15.5561
R2508 Iin.n326 Iin.n267 15.5561
R2509 Iin.n326 Iin.n259 15.5561
R2510 Iin.n338 Iin.n259 15.5561
R2511 Iin.n338 Iin.n255 15.5561
R2512 Iin.n344 Iin.n255 15.5561
R2513 Iin.n344 Iin.n247 15.5561
R2514 Iin.n358 Iin.n247 15.5561
R2515 Iin.n358 Iin.n243 15.5561
R2516 Iin.n365 Iin.n243 15.5561
R2517 Iin.n366 Iin.n365 15.5561
R2518 Iin.n366 Iin.n187 15.5561
R2519 Iin.n188 Iin.n187 15.5561
R2520 Iin.n189 Iin.n188 15.5561
R2521 Iin.n375 Iin.n189 15.5561
R2522 Iin.n375 Iin.n374 15.5561
R2523 Iin.n374 Iin.n204 15.5561
R2524 Iin.n205 Iin.n204 15.5561
R2525 Iin.n384 Iin.n205 15.5561
R2526 Iin.n384 Iin.n383 15.5561
R2527 Iin.n383 Iin.n218 15.5561
R2528 Iin.n219 Iin.n218 15.5561
R2529 Iin.n392 Iin.n219 15.5561
R2530 Iin.n392 Iin.n231 15.5561
R2531 Iin.n433 Iin.n231 15.5561
R2532 Iin.n433 Iin.n232 15.5561
R2533 Iin.n232 Iin.n8 15.5561
R2534 Iin.n9 Iin.n8 15.5561
R2535 Iin.n427 Iin.n9 15.5561
R2536 Iin.n427 Iin.n426 15.5561
R2537 Iin.n426 Iin.n22 15.5561
R2538 Iin.n23 Iin.n22 15.5561
R2539 Iin.n421 Iin.n23 15.5561
R2540 Iin.n421 Iin.n420 15.5561
R2541 Iin.n420 Iin.n35 15.5561
R2542 Iin.n36 Iin.n35 15.5561
R2543 Iin.n415 Iin.n36 15.5561
R2544 Iin.n415 Iin.n43 15.5561
R2545 Iin.n599 Iin.n43 15.5561
R2546 Iin.n599 Iin.n47 15.5561
R2547 Iin.n487 Iin.n47 15.5561
R2548 Iin.n487 Iin.n481 15.5561
R2549 Iin.n481 Iin.n163 15.5561
R2550 Iin.n516 Iin.n163 15.5561
R2551 Iin.n516 Iin.n158 15.5561
R2552 Iin.n524 Iin.n158 15.5561
R2553 Iin.n524 Iin.n159 15.5561
R2554 Iin.n159 Iin.n144 15.5561
R2555 Iin.n543 Iin.n144 15.5561
R2556 Iin.n543 Iin.n85 15.5561
R2557 Iin.n549 Iin.n85 15.5561
R2558 Iin.n549 Iin.n75 15.5561
R2559 Iin.n568 Iin.n75 15.5561
R2560 Iin.n568 Iin.n70 15.5561
R2561 Iin.n577 Iin.n70 15.5561
R2562 Iin.n577 Iin.n71 15.5561
R2563 Iin.n71 Iin.n56 15.5561
R2564 Iin.n499 Iin.n171 14.453
R2565 Iin.n498 Iin.n164 14.453
R2566 Iin.n567 Iin.n52 12.6464
R2567 Iin.n603 Iin.n602 12.5005
R2568 Iin.n604 Iin.n39 12.5005
R2569 Iin.n606 Iin.n605 12.5005
R2570 Iin.n609 Iin.n33 12.5005
R2571 Iin.n29 Iin.n27 12.5005
R2572 Iin.n615 Iin.n614 12.5005
R2573 Iin.n617 Iin.n616 12.5005
R2574 Iin.n620 Iin.n20 12.5005
R2575 Iin.n15 Iin.n13 12.5005
R2576 Iin.n626 Iin.n625 12.5005
R2577 Iin.n628 Iin.n627 12.5005
R2578 Iin.n631 Iin.n6 12.5005
R2579 Iin.n224 Iin.n1 12.5005
R2580 Iin.n226 Iin.n0 12.5005
R2581 Iin.n436 Iin.n227 12.5005
R2582 Iin.n441 Iin.n440 12.5005
R2583 Iin.n443 Iin.n442 12.5005
R2584 Iin.n446 Iin.n216 12.5005
R2585 Iin.n211 Iin.n209 12.5005
R2586 Iin.n452 Iin.n451 12.5005
R2587 Iin.n454 Iin.n453 12.5005
R2588 Iin.n457 Iin.n202 12.5005
R2589 Iin.n197 Iin.n195 12.5005
R2590 Iin.n463 Iin.n462 12.5005
R2591 Iin.n465 Iin.n464 12.5005
R2592 Iin.n194 Iin.n184 12.5005
R2593 Iin.n469 Iin.n185 12.5005
R2594 Iin.n142 Iin.n141 12.0394
R2595 Iin.n185 Iin.n182 11.7031
R2596 Iin.n603 Iin.n40 11.545
R2597 Iin.n591 Iin.n590 10.9121
R2598 Iin.n473 Iin.n472 7.89186
R2599 Iin.n474 Iin.n473 7.73533
R2600 Iin.n289 Iin.n288 7.57378
R2601 Iin.n139 Iin.n138 6.37187
R2602 Iin.n139 Iin.n126 6.37187
R2603 Iin.n122 Iin.n121 6.37187
R2604 Iin.n122 Iin.n109 6.37187
R2605 Iin.n105 Iin.n104 6.37187
R2606 Iin.n105 Iin.n92 6.37187
R2607 Iin.n134 Iin.n133 6.3005
R2608 Iin.n130 Iin.n129 6.3005
R2609 Iin.n117 Iin.n116 6.3005
R2610 Iin.n113 Iin.n112 6.3005
R2611 Iin.n100 Iin.n99 6.3005
R2612 Iin.n96 Iin.n95 6.3005
R2613 Iin.n194 Iin.n185 5.61588
R2614 Iin.n464 Iin.n194 5.61588
R2615 Iin.n464 Iin.n463 5.61588
R2616 Iin.n463 Iin.n195 5.61588
R2617 Iin.n202 Iin.n195 5.61588
R2618 Iin.n453 Iin.n202 5.61588
R2619 Iin.n453 Iin.n452 5.61588
R2620 Iin.n452 Iin.n209 5.61588
R2621 Iin.n216 Iin.n209 5.61588
R2622 Iin.n442 Iin.n216 5.61588
R2623 Iin.n442 Iin.n441 5.61588
R2624 Iin.n441 Iin.n227 5.61588
R2625 Iin.n227 Iin.n226 5.61588
R2626 Iin.n224 Iin.n6 5.61588
R2627 Iin.n627 Iin.n6 5.61588
R2628 Iin.n627 Iin.n626 5.61588
R2629 Iin.n626 Iin.n13 5.61588
R2630 Iin.n20 Iin.n13 5.61588
R2631 Iin.n616 Iin.n20 5.61588
R2632 Iin.n616 Iin.n615 5.61588
R2633 Iin.n615 Iin.n27 5.61588
R2634 Iin.n33 Iin.n27 5.61588
R2635 Iin.n605 Iin.n33 5.61588
R2636 Iin.n605 Iin.n604 5.61588
R2637 Iin.n604 Iin.n603 5.61588
R2638 Iin.n525 Iin.n51 5.42018
R2639 Iin.n291 Iin.n290 5.35452
R2640 Iin.n582 Iin.n581 5.20101
R2641 Iin.n175 Iin.n174 5.20101
R2642 Iin.n131 Iin.n89 5.20101
R2643 Iin.n132 Iin.n88 5.20101
R2644 Iin.n114 Iin.n108 5.20101
R2645 Iin.n115 Iin.n107 5.20101
R2646 Iin.n97 Iin.n91 5.20101
R2647 Iin.n98 Iin.n90 5.20101
R2648 Iin.n585 Iin.n584 5.2005
R2649 Iin.n586 Iin.n585 5.2005
R2650 Iin.n65 Iin.n64 5.2005
R2651 Iin.n69 Iin.n64 5.2005
R2652 Iin.n588 Iin.n587 5.2005
R2653 Iin.n587 Iin.n586 5.2005
R2654 Iin.n62 Iin.n61 5.2005
R2655 Iin.n69 Iin.n62 5.2005
R2656 Iin.n172 Iin.n166 5.2005
R2657 Iin.n166 Iin.n164 5.2005
R2658 Iin.n177 Iin.n176 5.2005
R2659 Iin.n499 Iin.n177 5.2005
R2660 Iin.n502 Iin.n167 5.2005
R2661 Iin.n167 Iin.n164 5.2005
R2662 Iin.n501 Iin.n500 5.2005
R2663 Iin.n500 Iin.n499 5.2005
R2664 Iin.n507 Iin.n147 5.2005
R2665 Iin.n541 Iin.n147 5.2005
R2666 Iin.n508 Iin.n149 5.2005
R2667 Iin.n149 Iin.n145 5.2005
R2668 Iin.n541 Iin.n540 5.2005
R2669 Iin.n538 Iin.n145 5.2005
R2670 Iin.n560 Iin.n55 5.2005
R2671 Iin.n55 Iin.n53 5.2005
R2672 Iin.n562 Iin.n561 5.2005
R2673 Iin.n561 Iin.n63 5.2005
R2674 Iin.n563 Iin.n68 5.2005
R2675 Iin.n578 Iin.n68 5.2005
R2676 Iin.n564 Iin.n77 5.2005
R2677 Iin.n77 Iin.n67 5.2005
R2678 Iin.n566 Iin.n565 5.2005
R2679 Iin.n567 Iin.n566 5.2005
R2680 Iin.n78 Iin.n76 5.2005
R2681 Iin.n83 Iin.n76 5.2005
R2682 Iin.n552 Iin.n551 5.2005
R2683 Iin.n551 Iin.n550 5.2005
R2684 Iin.n81 Iin.n80 5.2005
R2685 Iin.n82 Iin.n81 5.2005
R2686 Iin.n532 Iin.n146 5.2005
R2687 Iin.n542 Iin.n146 5.2005
R2688 Iin.n534 Iin.n533 5.2005
R2689 Iin.n535 Iin.n534 5.2005
R2690 Iin.n153 Iin.n152 5.2005
R2691 Iin.n152 Iin.n151 5.2005
R2692 Iin.n527 Iin.n526 5.2005
R2693 Iin.n526 Iin.n525 5.2005
R2694 Iin.n156 Iin.n155 5.2005
R2695 Iin.n157 Iin.n156 5.2005
R2696 Iin.n495 Iin.n165 5.2005
R2697 Iin.n515 Iin.n165 5.2005
R2698 Iin.n497 Iin.n496 5.2005
R2699 Iin.n498 Iin.n497 5.2005
R2700 Iin.n179 Iin.n178 5.2005
R2701 Iin.n178 Iin.n171 5.2005
R2702 Iin.n490 Iin.n489 5.2005
R2703 Iin.n489 Iin.n488 5.2005
R2704 Iin.n479 Iin.n478 5.2005
R2705 Iin.n479 Iin.n50 5.2005
R2706 Iin.n477 Iin.n49 5.2005
R2707 Iin.n598 Iin.n49 5.2005
R2708 Iin.n412 Iin.n41 5.2005
R2709 Iin.n412 Iin.n48 5.2005
R2710 Iin.n414 Iin.n413 5.2005
R2711 Iin.n416 Iin.n414 5.2005
R2712 Iin.n411 Iin.n38 5.2005
R2713 Iin.n417 Iin.n411 5.2005
R2714 Iin.n410 Iin.n32 5.2005
R2715 Iin.n418 Iin.n410 5.2005
R2716 Iin.n409 Iin.n408 5.2005
R2717 Iin.n419 Iin.n409 5.2005
R2718 Iin.n407 Iin.n28 5.2005
R2719 Iin.n422 Iin.n407 5.2005
R2720 Iin.n406 Iin.n25 5.2005
R2721 Iin.n423 Iin.n406 5.2005
R2722 Iin.n405 Iin.n18 5.2005
R2723 Iin.n424 Iin.n405 5.2005
R2724 Iin.n404 Iin.n403 5.2005
R2725 Iin.n425 Iin.n404 5.2005
R2726 Iin.n402 Iin.n14 5.2005
R2727 Iin.n428 Iin.n402 5.2005
R2728 Iin.n401 Iin.n11 5.2005
R2729 Iin.n429 Iin.n401 5.2005
R2730 Iin.n400 Iin.n4 5.2005
R2731 Iin.n430 Iin.n400 5.2005
R2732 Iin.n399 Iin.n398 5.2005
R2733 Iin.n431 Iin.n399 5.2005
R2734 Iin.n397 Iin.n396 5.2005
R2735 Iin.n432 Iin.n396 5.2005
R2736 Iin.n395 Iin.n229 5.2005
R2737 Iin.n395 Iin.n233 5.2005
R2738 Iin.n394 Iin.n228 5.2005
R2739 Iin.n394 Iin.n393 5.2005
R2740 Iin.n234 Iin.n221 5.2005
R2741 Iin.n391 Iin.n234 5.2005
R2742 Iin.n389 Iin.n214 5.2005
R2743 Iin.n390 Iin.n389 5.2005
R2744 Iin.n388 Iin.n387 5.2005
R2745 Iin.n388 Iin.n235 5.2005
R2746 Iin.n386 Iin.n210 5.2005
R2747 Iin.n386 Iin.n385 5.2005
R2748 Iin.n236 Iin.n207 5.2005
R2749 Iin.n382 Iin.n236 5.2005
R2750 Iin.n380 Iin.n200 5.2005
R2751 Iin.n381 Iin.n380 5.2005
R2752 Iin.n379 Iin.n378 5.2005
R2753 Iin.n379 Iin.n237 5.2005
R2754 Iin.n377 Iin.n196 5.2005
R2755 Iin.n377 Iin.n376 5.2005
R2756 Iin.n238 Iin.n192 5.2005
R2757 Iin.n373 Iin.n238 5.2005
R2758 Iin.n371 Iin.n370 5.2005
R2759 Iin.n372 Iin.n371 5.2005
R2760 Iin.n369 Iin.n183 5.2005
R2761 Iin.n369 Iin.n239 5.2005
R2762 Iin.n368 Iin.n241 5.2005
R2763 Iin.n368 Iin.n367 5.2005
R2764 Iin.n353 Iin.n240 5.2005
R2765 Iin.n242 Iin.n240 5.2005
R2766 Iin.n355 Iin.n354 5.2005
R2767 Iin.n356 Iin.n355 5.2005
R2768 Iin.n250 Iin.n249 5.2005
R2769 Iin.n357 Iin.n249 5.2005
R2770 Iin.n348 Iin.n347 5.2005
R2771 Iin.n347 Iin.n248 5.2005
R2772 Iin.n346 Iin.n252 5.2005
R2773 Iin.n346 Iin.n345 5.2005
R2774 Iin.n334 Iin.n253 5.2005
R2775 Iin.n254 Iin.n253 5.2005
R2776 Iin.n336 Iin.n335 5.2005
R2777 Iin.n337 Iin.n336 5.2005
R2778 Iin.n262 Iin.n261 5.2005
R2779 Iin.n261 Iin.n260 5.2005
R2780 Iin.n329 Iin.n328 5.2005
R2781 Iin.n328 Iin.n327 5.2005
R2782 Iin.n265 Iin.n264 5.2005
R2783 Iin.n266 Iin.n265 5.2005
R2784 Iin.n318 Iin.n317 5.2005
R2785 Iin.n319 Iin.n318 5.2005
R2786 Iin.n274 Iin.n273 5.2005
R2787 Iin.n273 Iin.n272 5.2005
R2788 Iin.n313 Iin.n312 5.2005
R2789 Iin.n312 Iin.n311 5.2005
R2790 Iin.n277 Iin.n276 5.2005
R2791 Iin.n278 Iin.n277 5.2005
R2792 Iin.n302 Iin.n301 5.2005
R2793 Iin.n303 Iin.n302 5.2005
R2794 Iin.n286 Iin.n285 5.2005
R2795 Iin.n285 Iin.n284 5.2005
R2796 Iin.n297 Iin.n296 5.2005
R2797 Iin.n574 Iin.n56 5.2005
R2798 Iin.n56 Iin.n53 5.2005
R2799 Iin.n575 Iin.n71 5.2005
R2800 Iin.n71 Iin.n63 5.2005
R2801 Iin.n577 Iin.n576 5.2005
R2802 Iin.n578 Iin.n577 5.2005
R2803 Iin.n72 Iin.n70 5.2005
R2804 Iin.n70 Iin.n67 5.2005
R2805 Iin.n569 Iin.n568 5.2005
R2806 Iin.n568 Iin.n567 5.2005
R2807 Iin.n75 Iin.n74 5.2005
R2808 Iin.n83 Iin.n75 5.2005
R2809 Iin.n549 Iin.n548 5.2005
R2810 Iin.n550 Iin.n549 5.2005
R2811 Iin.n86 Iin.n85 5.2005
R2812 Iin.n85 Iin.n82 5.2005
R2813 Iin.n544 Iin.n543 5.2005
R2814 Iin.n543 Iin.n542 5.2005
R2815 Iin.n144 Iin.n143 5.2005
R2816 Iin.n535 Iin.n144 5.2005
R2817 Iin.n522 Iin.n159 5.2005
R2818 Iin.n159 Iin.n151 5.2005
R2819 Iin.n524 Iin.n523 5.2005
R2820 Iin.n525 Iin.n524 5.2005
R2821 Iin.n160 Iin.n158 5.2005
R2822 Iin.n158 Iin.n157 5.2005
R2823 Iin.n517 Iin.n516 5.2005
R2824 Iin.n516 Iin.n515 5.2005
R2825 Iin.n163 Iin.n162 5.2005
R2826 Iin.n498 Iin.n163 5.2005
R2827 Iin.n485 Iin.n481 5.2005
R2828 Iin.n481 Iin.n171 5.2005
R2829 Iin.n487 Iin.n486 5.2005
R2830 Iin.n488 Iin.n487 5.2005
R2831 Iin.n47 Iin.n46 5.2005
R2832 Iin.n50 Iin.n47 5.2005
R2833 Iin.n600 Iin.n599 5.2005
R2834 Iin.n599 Iin.n598 5.2005
R2835 Iin.n601 Iin.n43 5.2005
R2836 Iin.n48 Iin.n43 5.2005
R2837 Iin.n415 Iin.n37 5.2005
R2838 Iin.n416 Iin.n415 5.2005
R2839 Iin.n607 Iin.n36 5.2005
R2840 Iin.n417 Iin.n36 5.2005
R2841 Iin.n608 Iin.n35 5.2005
R2842 Iin.n418 Iin.n35 5.2005
R2843 Iin.n420 Iin.n34 5.2005
R2844 Iin.n420 Iin.n419 5.2005
R2845 Iin.n421 Iin.n24 5.2005
R2846 Iin.n422 Iin.n421 5.2005
R2847 Iin.n618 Iin.n23 5.2005
R2848 Iin.n423 Iin.n23 5.2005
R2849 Iin.n619 Iin.n22 5.2005
R2850 Iin.n424 Iin.n22 5.2005
R2851 Iin.n426 Iin.n21 5.2005
R2852 Iin.n426 Iin.n425 5.2005
R2853 Iin.n427 Iin.n10 5.2005
R2854 Iin.n428 Iin.n427 5.2005
R2855 Iin.n629 Iin.n9 5.2005
R2856 Iin.n429 Iin.n9 5.2005
R2857 Iin.n630 Iin.n8 5.2005
R2858 Iin.n430 Iin.n8 5.2005
R2859 Iin.n232 Iin.n7 5.2005
R2860 Iin.n431 Iin.n232 5.2005
R2861 Iin.n434 Iin.n433 5.2005
R2862 Iin.n433 Iin.n432 5.2005
R2863 Iin.n435 Iin.n231 5.2005
R2864 Iin.n233 Iin.n231 5.2005
R2865 Iin.n392 Iin.n220 5.2005
R2866 Iin.n393 Iin.n392 5.2005
R2867 Iin.n444 Iin.n219 5.2005
R2868 Iin.n391 Iin.n219 5.2005
R2869 Iin.n445 Iin.n218 5.2005
R2870 Iin.n390 Iin.n218 5.2005
R2871 Iin.n383 Iin.n217 5.2005
R2872 Iin.n383 Iin.n235 5.2005
R2873 Iin.n384 Iin.n206 5.2005
R2874 Iin.n385 Iin.n384 5.2005
R2875 Iin.n455 Iin.n205 5.2005
R2876 Iin.n382 Iin.n205 5.2005
R2877 Iin.n456 Iin.n204 5.2005
R2878 Iin.n381 Iin.n204 5.2005
R2879 Iin.n374 Iin.n203 5.2005
R2880 Iin.n374 Iin.n237 5.2005
R2881 Iin.n375 Iin.n190 5.2005
R2882 Iin.n376 Iin.n375 5.2005
R2883 Iin.n466 Iin.n189 5.2005
R2884 Iin.n373 Iin.n189 5.2005
R2885 Iin.n467 Iin.n188 5.2005
R2886 Iin.n372 Iin.n188 5.2005
R2887 Iin.n468 Iin.n187 5.2005
R2888 Iin.n239 Iin.n187 5.2005
R2889 Iin.n366 Iin.n186 5.2005
R2890 Iin.n367 Iin.n366 5.2005
R2891 Iin.n365 Iin.n364 5.2005
R2892 Iin.n365 Iin.n242 5.2005
R2893 Iin.n244 Iin.n243 5.2005
R2894 Iin.n356 Iin.n243 5.2005
R2895 Iin.n359 Iin.n358 5.2005
R2896 Iin.n358 Iin.n357 5.2005
R2897 Iin.n247 Iin.n246 5.2005
R2898 Iin.n248 Iin.n247 5.2005
R2899 Iin.n344 Iin.n343 5.2005
R2900 Iin.n345 Iin.n344 5.2005
R2901 Iin.n256 Iin.n255 5.2005
R2902 Iin.n255 Iin.n254 5.2005
R2903 Iin.n339 Iin.n338 5.2005
R2904 Iin.n338 Iin.n337 5.2005
R2905 Iin.n259 Iin.n258 5.2005
R2906 Iin.n260 Iin.n259 5.2005
R2907 Iin.n326 Iin.n325 5.2005
R2908 Iin.n327 Iin.n326 5.2005
R2909 Iin.n268 Iin.n267 5.2005
R2910 Iin.n267 Iin.n266 5.2005
R2911 Iin.n321 Iin.n320 5.2005
R2912 Iin.n320 Iin.n319 5.2005
R2913 Iin.n271 Iin.n270 5.2005
R2914 Iin.n272 Iin.n271 5.2005
R2915 Iin.n310 Iin.n309 5.2005
R2916 Iin.n311 Iin.n310 5.2005
R2917 Iin.n280 Iin.n279 5.2005
R2918 Iin.n279 Iin.n278 5.2005
R2919 Iin.n305 Iin.n304 5.2005
R2920 Iin.n304 Iin.n303 5.2005
R2921 Iin.n283 Iin.n282 5.2005
R2922 Iin.n284 Iin.n283 5.2005
R2923 Iin.n293 Iin.n292 5.2005
R2924 Iin.n294 Iin.n293 5.2005
R2925 Iin.n583 Iin.n59 5.19319
R2926 Iin.n512 Iin.n168 5.19319
R2927 Iin.n290 Iin.n289 5.14053
R2928 Iin.n592 Iin.n591 5.12952
R2929 Iin.n150 Iin.n142 5.12001
R2930 Iin.n504 Iin.n142 5.11219
R2931 Iin.n559 Iin.n57 5.04833
R2932 Iin.n590 Iin.n59 4.98321
R2933 Iin.n581 Iin.n66 4.98321
R2934 Iin.n512 Iin.n511 4.98321
R2935 Iin.n174 Iin.n173 4.98321
R2936 Iin.n510 Iin.n150 4.98321
R2937 Iin.n505 Iin.n504 4.98321
R2938 Iin.n140 Iin.n89 4.98321
R2939 Iin.n123 Iin.n108 4.98321
R2940 Iin.n106 Iin.n91 4.98321
R2941 Iin.n140 Iin.n88 4.97539
R2942 Iin.n123 Iin.n107 4.97539
R2943 Iin.n106 Iin.n90 4.97539
R2944 Iin.n474 Iin.n57 4.7183
R2945 Iin.n600 Iin.n45 4.5005
R2946 Iin.n482 Iin.n46 4.5005
R2947 Iin.n486 Iin.n483 4.5005
R2948 Iin.n485 Iin.n484 4.5005
R2949 Iin.n162 Iin.n161 4.5005
R2950 Iin.n518 Iin.n517 4.5005
R2951 Iin.n519 Iin.n160 4.5005
R2952 Iin.n523 Iin.n520 4.5005
R2953 Iin.n522 Iin.n521 4.5005
R2954 Iin.n143 Iin.n87 4.5005
R2955 Iin.n589 Iin.n588 4.5005
R2956 Iin.n61 Iin.n60 4.5005
R2957 Iin.n584 Iin.n583 4.5005
R2958 Iin.n582 Iin.n65 4.5005
R2959 Iin.n172 Iin.n168 4.5005
R2960 Iin.n176 Iin.n175 4.5005
R2961 Iin.n503 Iin.n502 4.5005
R2962 Iin.n501 Iin.n169 4.5005
R2963 Iin.n507 Iin.n506 4.5005
R2964 Iin.n509 Iin.n508 4.5005
R2965 Iin.n133 Iin.n132 4.5005
R2966 Iin.n131 Iin.n130 4.5005
R2967 Iin.n116 Iin.n115 4.5005
R2968 Iin.n114 Iin.n113 4.5005
R2969 Iin.n99 Iin.n98 4.5005
R2970 Iin.n97 Iin.n96 4.5005
R2971 Iin.n548 Iin.n547 4.5005
R2972 Iin.n74 Iin.n73 4.5005
R2973 Iin.n570 Iin.n569 4.5005
R2974 Iin.n571 Iin.n72 4.5005
R2975 Iin.n576 Iin.n572 4.5005
R2976 Iin.n575 Iin.n573 4.5005
R2977 Iin.n574 Iin.n58 4.5005
R2978 Iin.n299 Iin.n286 4.5005
R2979 Iin.n301 Iin.n300 4.5005
R2980 Iin.n276 Iin.n275 4.5005
R2981 Iin.n314 Iin.n313 4.5005
R2982 Iin.n315 Iin.n274 4.5005
R2983 Iin.n317 Iin.n316 4.5005
R2984 Iin.n264 Iin.n263 4.5005
R2985 Iin.n330 Iin.n329 4.5005
R2986 Iin.n331 Iin.n262 4.5005
R2987 Iin.n335 Iin.n332 4.5005
R2988 Iin.n334 Iin.n333 4.5005
R2989 Iin.n252 Iin.n251 4.5005
R2990 Iin.n349 Iin.n348 4.5005
R2991 Iin.n350 Iin.n250 4.5005
R2992 Iin.n354 Iin.n351 4.5005
R2993 Iin.n353 Iin.n352 4.5005
R2994 Iin.n241 Iin.n181 4.5005
R2995 Iin.n477 Iin.n476 4.5005
R2996 Iin.n478 Iin.n180 4.5005
R2997 Iin.n491 Iin.n490 4.5005
R2998 Iin.n492 Iin.n179 4.5005
R2999 Iin.n496 Iin.n493 4.5005
R3000 Iin.n495 Iin.n494 4.5005
R3001 Iin.n155 Iin.n154 4.5005
R3002 Iin.n528 Iin.n527 4.5005
R3003 Iin.n529 Iin.n153 4.5005
R3004 Iin.n533 Iin.n530 4.5005
R3005 Iin.n532 Iin.n531 4.5005
R3006 Iin.n80 Iin.n79 4.5005
R3007 Iin.n553 Iin.n552 4.5005
R3008 Iin.n554 Iin.n78 4.5005
R3009 Iin.n565 Iin.n555 4.5005
R3010 Iin.n564 Iin.n556 4.5005
R3011 Iin.n563 Iin.n557 4.5005
R3012 Iin.n562 Iin.n558 4.5005
R3013 Iin.n560 Iin.n559 4.5005
R3014 Iin.n298 Iin.n297 4.5005
R3015 Iin.n282 Iin.n281 4.5005
R3016 Iin.n306 Iin.n305 4.5005
R3017 Iin.n307 Iin.n280 4.5005
R3018 Iin.n309 Iin.n308 4.5005
R3019 Iin.n270 Iin.n269 4.5005
R3020 Iin.n322 Iin.n321 4.5005
R3021 Iin.n323 Iin.n268 4.5005
R3022 Iin.n325 Iin.n324 4.5005
R3023 Iin.n258 Iin.n257 4.5005
R3024 Iin.n340 Iin.n339 4.5005
R3025 Iin.n341 Iin.n256 4.5005
R3026 Iin.n343 Iin.n342 4.5005
R3027 Iin.n246 Iin.n245 4.5005
R3028 Iin.n360 Iin.n359 4.5005
R3029 Iin.n361 Iin.n244 4.5005
R3030 Iin.n364 Iin.n363 4.5005
R3031 Iin.n362 Iin.n186 4.5005
R3032 Iin.n292 Iin.n291 4.5005
R3033 Iin.n469 Iin.n183 4.5005
R3034 Iin.n370 Iin.n184 4.5005
R3035 Iin.n465 Iin.n192 4.5005
R3036 Iin.n462 Iin.n196 4.5005
R3037 Iin.n378 Iin.n197 4.5005
R3038 Iin.n457 Iin.n200 4.5005
R3039 Iin.n454 Iin.n207 4.5005
R3040 Iin.n451 Iin.n210 4.5005
R3041 Iin.n387 Iin.n211 4.5005
R3042 Iin.n446 Iin.n214 4.5005
R3043 Iin.n443 Iin.n221 4.5005
R3044 Iin.n440 Iin.n228 4.5005
R3045 Iin.n436 Iin.n229 4.5005
R3046 Iin.n397 Iin.n0 4.5005
R3047 Iin.n398 Iin.n1 4.5005
R3048 Iin.n631 Iin.n4 4.5005
R3049 Iin.n628 Iin.n11 4.5005
R3050 Iin.n625 Iin.n14 4.5005
R3051 Iin.n403 Iin.n15 4.5005
R3052 Iin.n620 Iin.n18 4.5005
R3053 Iin.n617 Iin.n25 4.5005
R3054 Iin.n614 Iin.n28 4.5005
R3055 Iin.n408 Iin.n29 4.5005
R3056 Iin.n609 Iin.n32 4.5005
R3057 Iin.n606 Iin.n38 4.5005
R3058 Iin.n413 Iin.n39 4.5005
R3059 Iin.n602 Iin.n41 4.5005
R3060 Iin.n469 Iin.n468 4.5005
R3061 Iin.n467 Iin.n184 4.5005
R3062 Iin.n466 Iin.n465 4.5005
R3063 Iin.n462 Iin.n190 4.5005
R3064 Iin.n203 Iin.n197 4.5005
R3065 Iin.n457 Iin.n456 4.5005
R3066 Iin.n455 Iin.n454 4.5005
R3067 Iin.n451 Iin.n206 4.5005
R3068 Iin.n217 Iin.n211 4.5005
R3069 Iin.n446 Iin.n445 4.5005
R3070 Iin.n444 Iin.n443 4.5005
R3071 Iin.n440 Iin.n220 4.5005
R3072 Iin.n436 Iin.n435 4.5005
R3073 Iin.n434 Iin.n0 4.5005
R3074 Iin.n7 Iin.n1 4.5005
R3075 Iin.n631 Iin.n630 4.5005
R3076 Iin.n629 Iin.n628 4.5005
R3077 Iin.n625 Iin.n10 4.5005
R3078 Iin.n21 Iin.n15 4.5005
R3079 Iin.n620 Iin.n619 4.5005
R3080 Iin.n618 Iin.n617 4.5005
R3081 Iin.n614 Iin.n24 4.5005
R3082 Iin.n34 Iin.n29 4.5005
R3083 Iin.n609 Iin.n608 4.5005
R3084 Iin.n607 Iin.n606 4.5005
R3085 Iin.n39 Iin.n37 4.5005
R3086 Iin.n602 Iin.n601 4.5005
R3087 Iin.n542 Iin.n145 3.61362
R3088 Iin.n541 Iin.n82 3.61362
R3089 Iin.n135 Iin.n134 3.31679
R3090 Iin.n135 Iin.n129 3.31679
R3091 Iin.n137 Iin.n126 3.31679
R3092 Iin.n138 Iin.n137 3.31679
R3093 Iin.n118 Iin.n117 3.31679
R3094 Iin.n118 Iin.n112 3.31679
R3095 Iin.n120 Iin.n109 3.31679
R3096 Iin.n121 Iin.n120 3.31679
R3097 Iin.n100 Iin.n94 3.31679
R3098 Iin.n95 Iin.n94 3.31679
R3099 Iin.n103 Iin.n92 3.31679
R3100 Iin.n104 Iin.n103 3.31679
R3101 Iin.n539 Iin.n142 3.28078
R3102 Iin.n295 Iin.n294 3.26114
R3103 Iin.n539 Iin.n538 3.14293
R3104 Iin.n540 Iin.n539 3.14293
R3105 Iin.n226 Iin.n225 2.80819
R3106 Iin.n225 Iin.n224 2.80819
R3107 Iin.n475 Iin.n474 2.6735
R3108 Iin.n472 Iin.n471 2.4683
R3109 Iin.n123 Iin.n122 2.21557
R3110 Iin.n106 Iin.n105 2.21557
R3111 Iin.n140 Iin.n139 2.21557
R3112 Iin.n546 Iin.n545 2.21557
R3113 Iin.n296 Iin.n295 1.82789
R3114 Iin.n546 Iin.n40 1.23277
R3115 Iin.n124 Vss 1.0868
R3116 Iin.n127 Iin.n88 0.9005
R3117 Iin.n136 Iin.n127 0.9005
R3118 Iin.n128 Iin.n89 0.9005
R3119 Iin.n136 Iin.n128 0.9005
R3120 Iin.n110 Iin.n107 0.9005
R3121 Iin.n119 Iin.n110 0.9005
R3122 Iin.n111 Iin.n108 0.9005
R3123 Iin.n119 Iin.n111 0.9005
R3124 Iin.n101 Iin.n90 0.9005
R3125 Iin.n102 Iin.n101 0.9005
R3126 Iin.n93 Iin.n91 0.9005
R3127 Iin.n102 Iin.n93 0.9005
R3128 Iin.n581 Iin.n580 0.743357
R3129 Iin.n580 Iin.n579 0.743357
R3130 Iin.n59 Iin.n54 0.743357
R3131 Iin.n594 Iin.n54 0.743357
R3132 Iin.n513 Iin.n512 0.743357
R3133 Iin.n514 Iin.n513 0.743357
R3134 Iin.n174 Iin.n170 0.743357
R3135 Iin.n480 Iin.n170 0.743357
R3136 Iin.n504 Iin.n148 0.743357
R3137 Iin.n148 Iin.n84 0.743357
R3138 Iin.n537 Iin.n150 0.743357
R3139 Iin.n537 Iin.n536 0.743357
R3140 Iin.n471 Iin.n470 0.573125
R3141 Iin.n44 Iin.n42 0.483125
R3142 Iin.n470 Iin.n182 0.483125
R3143 Iin.n593 Iin.n592 0.473227
R3144 Iin.n594 Iin.n593 0.473227
R3145 Iin.n290 Iin.n287 0.473227
R3146 Iin.n476 Iin.n475 0.44735
R3147 Iin.n475 Iin.n42 0.393125
R3148 Iin.n125 Iin.n106 0.316383
R3149 Iin.n592 Iin.n57 0.29887
R3150 Iin.n611 Iin.n31 0.28625
R3151 Iin.n611 Iin.n610 0.28175
R3152 Iin.n613 Iin.n612 0.28175
R3153 Iin.n30 Iin.n26 0.28175
R3154 Iin.n19 Iin.n17 0.28175
R3155 Iin.n622 Iin.n621 0.28175
R3156 Iin.n624 Iin.n623 0.28175
R3157 Iin.n16 Iin.n12 0.28175
R3158 Iin.n5 Iin.n3 0.28175
R3159 Iin.n633 Iin.n632 0.28175
R3160 Iin.n635 Iin.n634 0.28175
R3161 Iin.n230 Iin.n2 0.28175
R3162 Iin.n439 Iin.n438 0.28175
R3163 Iin.n437 Iin.n222 0.28175
R3164 Iin.n215 Iin.n213 0.28175
R3165 Iin.n448 Iin.n447 0.28175
R3166 Iin.n450 Iin.n449 0.28175
R3167 Iin.n212 Iin.n208 0.28175
R3168 Iin.n201 Iin.n199 0.28175
R3169 Iin.n459 Iin.n458 0.28175
R3170 Iin.n461 Iin.n460 0.28175
R3171 Iin.n198 Iin.n193 0.28175
R3172 Iin.n288 Iin.n191 0.28175
R3173 Iin.n45 Iin.n44 0.26735
R3174 Iin.n591 Iin.n58 0.2255
R3175 Iin.n44 Iin.n40 0.219838
R3176 Iin.n471 Iin.n181 0.20615
R3177 Iin.n362 Iin.n182 0.20615
R3178 Iin.n505 Iin.n66 0.2057
R3179 Iin.n511 Iin.n510 0.2057
R3180 Iin.n125 Iin.n124 0.2057
R3181 Iin.n173 Iin.n42 0.1841
R3182 Iin.n225 Iin.n223 0.1684
R3183 Iin.n482 Iin.n45 0.1445
R3184 Iin.n483 Iin.n482 0.1445
R3185 Iin.n484 Iin.n483 0.1445
R3186 Iin.n484 Iin.n161 0.1445
R3187 Iin.n518 Iin.n161 0.1445
R3188 Iin.n519 Iin.n518 0.1445
R3189 Iin.n520 Iin.n519 0.1445
R3190 Iin.n521 Iin.n520 0.1445
R3191 Iin.n521 Iin.n87 0.1445
R3192 Iin.n292 Iin.n282 0.1445
R3193 Iin.n305 Iin.n282 0.1445
R3194 Iin.n305 Iin.n280 0.1445
R3195 Iin.n309 Iin.n280 0.1445
R3196 Iin.n309 Iin.n270 0.1445
R3197 Iin.n321 Iin.n270 0.1445
R3198 Iin.n321 Iin.n268 0.1445
R3199 Iin.n325 Iin.n268 0.1445
R3200 Iin.n325 Iin.n258 0.1445
R3201 Iin.n339 Iin.n258 0.1445
R3202 Iin.n339 Iin.n256 0.1445
R3203 Iin.n343 Iin.n256 0.1445
R3204 Iin.n343 Iin.n246 0.1445
R3205 Iin.n359 Iin.n246 0.1445
R3206 Iin.n359 Iin.n244 0.1445
R3207 Iin.n364 Iin.n244 0.1445
R3208 Iin.n364 Iin.n186 0.1445
R3209 Iin.n468 Iin.n186 0.1445
R3210 Iin.n468 Iin.n467 0.1445
R3211 Iin.n467 Iin.n466 0.1445
R3212 Iin.n466 Iin.n190 0.1445
R3213 Iin.n203 Iin.n190 0.1445
R3214 Iin.n456 Iin.n203 0.1445
R3215 Iin.n456 Iin.n455 0.1445
R3216 Iin.n455 Iin.n206 0.1445
R3217 Iin.n217 Iin.n206 0.1445
R3218 Iin.n445 Iin.n217 0.1445
R3219 Iin.n445 Iin.n444 0.1445
R3220 Iin.n444 Iin.n220 0.1445
R3221 Iin.n435 Iin.n220 0.1445
R3222 Iin.n435 Iin.n434 0.1445
R3223 Iin.n434 Iin.n7 0.1445
R3224 Iin.n630 Iin.n7 0.1445
R3225 Iin.n630 Iin.n629 0.1445
R3226 Iin.n629 Iin.n10 0.1445
R3227 Iin.n21 Iin.n10 0.1445
R3228 Iin.n619 Iin.n21 0.1445
R3229 Iin.n619 Iin.n618 0.1445
R3230 Iin.n618 Iin.n24 0.1445
R3231 Iin.n34 Iin.n24 0.1445
R3232 Iin.n608 Iin.n34 0.1445
R3233 Iin.n608 Iin.n607 0.1445
R3234 Iin.n607 Iin.n37 0.1445
R3235 Iin.n601 Iin.n37 0.1445
R3236 Iin.n601 Iin.n600 0.1445
R3237 Iin.n600 Iin.n46 0.1445
R3238 Iin.n486 Iin.n46 0.1445
R3239 Iin.n486 Iin.n485 0.1445
R3240 Iin.n485 Iin.n162 0.1445
R3241 Iin.n517 Iin.n162 0.1445
R3242 Iin.n517 Iin.n160 0.1445
R3243 Iin.n523 Iin.n160 0.1445
R3244 Iin.n523 Iin.n522 0.1445
R3245 Iin.n522 Iin.n143 0.1445
R3246 Iin.n544 Iin.n143 0.1445
R3247 Iin.n548 Iin.n86 0.1445
R3248 Iin.n548 Iin.n74 0.1445
R3249 Iin.n569 Iin.n74 0.1445
R3250 Iin.n569 Iin.n72 0.1445
R3251 Iin.n576 Iin.n72 0.1445
R3252 Iin.n576 Iin.n575 0.1445
R3253 Iin.n575 Iin.n574 0.1445
R3254 Iin.n508 Iin.n507 0.1445
R3255 Iin.n502 Iin.n501 0.1445
R3256 Iin.n588 Iin.n61 0.1445
R3257 Iin.n583 Iin.n582 0.1445
R3258 Iin.n584 Iin.n65 0.1445
R3259 Iin.n176 Iin.n172 0.1445
R3260 Iin.n175 Iin.n168 0.1445
R3261 Iin.n133 Iin.n130 0.1445
R3262 Iin.n132 Iin.n131 0.1445
R3263 Iin.n116 Iin.n113 0.1445
R3264 Iin.n115 Iin.n114 0.1445
R3265 Iin.n99 Iin.n96 0.1445
R3266 Iin.n98 Iin.n97 0.1445
R3267 Iin.n547 Iin.n73 0.1445
R3268 Iin.n570 Iin.n73 0.1445
R3269 Iin.n571 Iin.n570 0.1445
R3270 Iin.n572 Iin.n571 0.1445
R3271 Iin.n573 Iin.n572 0.1445
R3272 Iin.n573 Iin.n58 0.1445
R3273 Iin.n476 Iin.n180 0.1445
R3274 Iin.n491 Iin.n180 0.1445
R3275 Iin.n492 Iin.n491 0.1445
R3276 Iin.n493 Iin.n492 0.1445
R3277 Iin.n494 Iin.n493 0.1445
R3278 Iin.n494 Iin.n154 0.1445
R3279 Iin.n528 Iin.n154 0.1445
R3280 Iin.n529 Iin.n528 0.1445
R3281 Iin.n530 Iin.n529 0.1445
R3282 Iin.n531 Iin.n530 0.1445
R3283 Iin.n531 Iin.n79 0.1445
R3284 Iin.n553 Iin.n79 0.1445
R3285 Iin.n554 Iin.n553 0.1445
R3286 Iin.n555 Iin.n554 0.1445
R3287 Iin.n556 Iin.n555 0.1445
R3288 Iin.n557 Iin.n556 0.1445
R3289 Iin.n558 Iin.n557 0.1445
R3290 Iin.n559 Iin.n558 0.1445
R3291 Iin.n299 Iin.n298 0.1445
R3292 Iin.n300 Iin.n299 0.1445
R3293 Iin.n300 Iin.n275 0.1445
R3294 Iin.n314 Iin.n275 0.1445
R3295 Iin.n315 Iin.n314 0.1445
R3296 Iin.n316 Iin.n315 0.1445
R3297 Iin.n316 Iin.n263 0.1445
R3298 Iin.n330 Iin.n263 0.1445
R3299 Iin.n331 Iin.n330 0.1445
R3300 Iin.n332 Iin.n331 0.1445
R3301 Iin.n333 Iin.n332 0.1445
R3302 Iin.n333 Iin.n251 0.1445
R3303 Iin.n349 Iin.n251 0.1445
R3304 Iin.n350 Iin.n349 0.1445
R3305 Iin.n351 Iin.n350 0.1445
R3306 Iin.n352 Iin.n351 0.1445
R3307 Iin.n352 Iin.n181 0.1445
R3308 Iin.n297 Iin.n286 0.1445
R3309 Iin.n301 Iin.n286 0.1445
R3310 Iin.n301 Iin.n276 0.1445
R3311 Iin.n313 Iin.n276 0.1445
R3312 Iin.n313 Iin.n274 0.1445
R3313 Iin.n317 Iin.n274 0.1445
R3314 Iin.n317 Iin.n264 0.1445
R3315 Iin.n329 Iin.n264 0.1445
R3316 Iin.n329 Iin.n262 0.1445
R3317 Iin.n335 Iin.n262 0.1445
R3318 Iin.n335 Iin.n334 0.1445
R3319 Iin.n334 Iin.n252 0.1445
R3320 Iin.n348 Iin.n252 0.1445
R3321 Iin.n348 Iin.n250 0.1445
R3322 Iin.n354 Iin.n250 0.1445
R3323 Iin.n354 Iin.n353 0.1445
R3324 Iin.n353 Iin.n241 0.1445
R3325 Iin.n241 Iin.n183 0.1445
R3326 Iin.n370 Iin.n183 0.1445
R3327 Iin.n370 Iin.n192 0.1445
R3328 Iin.n196 Iin.n192 0.1445
R3329 Iin.n378 Iin.n196 0.1445
R3330 Iin.n378 Iin.n200 0.1445
R3331 Iin.n207 Iin.n200 0.1445
R3332 Iin.n210 Iin.n207 0.1445
R3333 Iin.n387 Iin.n210 0.1445
R3334 Iin.n387 Iin.n214 0.1445
R3335 Iin.n221 Iin.n214 0.1445
R3336 Iin.n228 Iin.n221 0.1445
R3337 Iin.n229 Iin.n228 0.1445
R3338 Iin.n397 Iin.n229 0.1445
R3339 Iin.n398 Iin.n397 0.1445
R3340 Iin.n398 Iin.n4 0.1445
R3341 Iin.n11 Iin.n4 0.1445
R3342 Iin.n14 Iin.n11 0.1445
R3343 Iin.n403 Iin.n14 0.1445
R3344 Iin.n403 Iin.n18 0.1445
R3345 Iin.n25 Iin.n18 0.1445
R3346 Iin.n28 Iin.n25 0.1445
R3347 Iin.n408 Iin.n28 0.1445
R3348 Iin.n408 Iin.n32 0.1445
R3349 Iin.n38 Iin.n32 0.1445
R3350 Iin.n413 Iin.n38 0.1445
R3351 Iin.n413 Iin.n41 0.1445
R3352 Iin.n477 Iin.n41 0.1445
R3353 Iin.n478 Iin.n477 0.1445
R3354 Iin.n490 Iin.n478 0.1445
R3355 Iin.n490 Iin.n179 0.1445
R3356 Iin.n496 Iin.n179 0.1445
R3357 Iin.n496 Iin.n495 0.1445
R3358 Iin.n495 Iin.n155 0.1445
R3359 Iin.n527 Iin.n155 0.1445
R3360 Iin.n527 Iin.n153 0.1445
R3361 Iin.n533 Iin.n153 0.1445
R3362 Iin.n533 Iin.n532 0.1445
R3363 Iin.n532 Iin.n80 0.1445
R3364 Iin.n552 Iin.n80 0.1445
R3365 Iin.n552 Iin.n78 0.1445
R3366 Iin.n565 Iin.n78 0.1445
R3367 Iin.n565 Iin.n564 0.1445
R3368 Iin.n564 Iin.n563 0.1445
R3369 Iin.n563 Iin.n562 0.1445
R3370 Iin.n562 Iin.n560 0.1445
R3371 Iin.n291 Iin.n281 0.1445
R3372 Iin.n306 Iin.n281 0.1445
R3373 Iin.n307 Iin.n306 0.1445
R3374 Iin.n308 Iin.n307 0.1445
R3375 Iin.n308 Iin.n269 0.1445
R3376 Iin.n322 Iin.n269 0.1445
R3377 Iin.n323 Iin.n322 0.1445
R3378 Iin.n324 Iin.n323 0.1445
R3379 Iin.n324 Iin.n257 0.1445
R3380 Iin.n340 Iin.n257 0.1445
R3381 Iin.n341 Iin.n340 0.1445
R3382 Iin.n342 Iin.n341 0.1445
R3383 Iin.n342 Iin.n245 0.1445
R3384 Iin.n360 Iin.n245 0.1445
R3385 Iin.n361 Iin.n360 0.1445
R3386 Iin.n363 Iin.n361 0.1445
R3387 Iin.n363 Iin.n362 0.1445
R3388 Iin.n124 Iin.n123 0.111183
R3389 Iin.n140 Iin.n125 0.111183
R3390 Iin.n546 Iin.n142 0.107176
R3391 Iin.n545 Iin.n544 0.0718661
R3392 Iin.n545 Iin.n86 0.0718661
R3393 Iin.n547 Iin.n546 0.0671
R3394 Iin.n546 Iin.n87 0.0599
R3395 Iin.n298 Vss 0.0599
R3396 Iin.n123 Vss 0.0577669
R3397 Iin.n141 Vss 0.0507793
R3398 Iin.n289 Vss 0.0490611
R3399 Iin.n472 Vss 0.0455
R3400 Iin.n66 Iin.n60 0.0298531
R3401 Iin.n590 Iin.n589 0.0298531
R3402 Iin.n173 Iin.n169 0.0298531
R3403 Iin.n511 Iin.n503 0.0298531
R3404 Iin.n510 Iin.n509 0.0298531
R3405 Iin.n506 Iin.n505 0.0298531
R3406 Iin.n589 Iin.n60 0.019907
R3407 Iin.n503 Iin.n169 0.019907
R3408 Iin.n509 Iin.n506 0.019907
R3409 Iin.n141 Iin.n140 0.00748758
R3410 Iin.n288 Iin.n198 0.005
R3411 Iin.n460 Iin.n198 0.005
R3412 Iin.n460 Iin.n459 0.005
R3413 Iin.n459 Iin.n199 0.005
R3414 Iin.n212 Iin.n199 0.005
R3415 Iin.n449 Iin.n212 0.005
R3416 Iin.n449 Iin.n448 0.005
R3417 Iin.n448 Iin.n213 0.005
R3418 Iin.n437 Iin.n213 0.005
R3419 Iin.n438 Iin.n437 0.005
R3420 Iin.n438 Iin.n2 0.005
R3421 Iin.n634 Iin.n2 0.005
R3422 Iin.n634 Iin.n633 0.005
R3423 Iin.n633 Iin.n3 0.005
R3424 Iin.n16 Iin.n3 0.005
R3425 Iin.n623 Iin.n16 0.005
R3426 Iin.n623 Iin.n622 0.005
R3427 Iin.n622 Iin.n17 0.005
R3428 Iin.n30 Iin.n17 0.005
R3429 Iin.n612 Iin.n30 0.005
R3430 Iin.n612 Iin.n611 0.005
R3431 Iin.n469 Iin.n184 0.00389783
R3432 Iin.n606 Iin.n39 0.00389783
R3433 Iin.n602 Iin.n39 0.00389783
R3434 Iin.n191 Iin.n184 0.00317579
R3435 Iin.n465 Iin.n193 0.00317579
R3436 Iin.n462 Iin.n461 0.00317579
R3437 Iin.n458 Iin.n197 0.00317579
R3438 Iin.n457 Iin.n201 0.00317579
R3439 Iin.n454 Iin.n208 0.00317579
R3440 Iin.n451 Iin.n450 0.00317579
R3441 Iin.n447 Iin.n211 0.00317579
R3442 Iin.n446 Iin.n215 0.00317579
R3443 Iin.n443 Iin.n222 0.00317579
R3444 Iin.n440 Iin.n439 0.00317579
R3445 Iin.n436 Iin.n230 0.00317579
R3446 Iin.n632 Iin.n1 0.00317579
R3447 Iin.n631 Iin.n5 0.00317579
R3448 Iin.n628 Iin.n12 0.00317579
R3449 Iin.n625 Iin.n624 0.00317579
R3450 Iin.n621 Iin.n15 0.00317579
R3451 Iin.n620 Iin.n19 0.00317579
R3452 Iin.n617 Iin.n26 0.00317579
R3453 Iin.n614 Iin.n613 0.00317579
R3454 Iin.n610 Iin.n29 0.00317579
R3455 Iin.n609 Iin.n31 0.00317579
R3456 Vss Iin.n0 0.00219891
R3457 Iin.n470 Iin.n469 0.0020715
R3458 Vss Iin.n635 0.00147688
R3459 Iin.n465 Iin.n191 0.00122204
R3460 Iin.n462 Iin.n193 0.00122204
R3461 Iin.n461 Iin.n197 0.00122204
R3462 Iin.n458 Iin.n457 0.00122204
R3463 Iin.n454 Iin.n201 0.00122204
R3464 Iin.n451 Iin.n208 0.00122204
R3465 Iin.n450 Iin.n211 0.00122204
R3466 Iin.n447 Iin.n446 0.00122204
R3467 Iin.n443 Iin.n215 0.00122204
R3468 Iin.n440 Iin.n222 0.00122204
R3469 Iin.n439 Iin.n436 0.00122204
R3470 Iin.n230 Iin.n0 0.00122204
R3471 Iin.n635 Iin.n1 0.00122204
R3472 Iin.n632 Iin.n631 0.00122204
R3473 Iin.n628 Iin.n5 0.00122204
R3474 Iin.n625 Iin.n12 0.00122204
R3475 Iin.n624 Iin.n15 0.00122204
R3476 Iin.n621 Iin.n620 0.00122204
R3477 Iin.n617 Iin.n19 0.00122204
R3478 Iin.n614 Iin.n26 0.00122204
R3479 Iin.n613 Iin.n29 0.00122204
R3480 Iin.n610 Iin.n609 0.00122204
R3481 Iin.n606 Iin.n31 0.00122204
R3482 Iin.n602 Iin.n42 0.000627419
R3483 spike_neg.n584 spike_neg.n79 18200
R3484 spike_neg.n583 spike_neg.n80 18200
R3485 spike_neg.n585 spike_neg.n584 14238.8
R3486 spike_neg.n584 spike_neg.n583 4468.75
R3487 spike_neg.n583 spike_neg.n582 4062.5
R3488 spike_neg.n32 spike_neg.n31 521.494
R3489 spike_neg.n31 spike_neg.n30 521.494
R3490 spike_neg.n632 spike_neg.n631 521.494
R3491 spike_neg.n631 spike_neg.n630 521.494
R3492 spike_neg.n15 spike_neg.n14 521.494
R3493 spike_neg.n14 spike_neg.n6 521.494
R3494 spike_neg.n585 spike_neg.n71 229.434
R3495 spike_neg.n575 spike_neg.n92 144.525
R3496 spike_neg.n564 spike_neg.n109 144.525
R3497 spike_neg.n605 spike_neg.n50 144.525
R3498 spike_neg.n546 spike_neg.n537 144.525
R3499 spike_neg.n613 spike_neg.n40 140.912
R3500 spike_neg.n612 spike_neg.n43 140.912
R3501 spike_neg.n558 spike_neg.n80 139.106
R3502 spike_neg.n79 spike_neg.n52 131.88
R3503 spike_neg.n574 spike_neg.n95 130.072
R3504 spike_neg.n107 spike_neg.n106 130.072
R3505 spike_neg.n536 spike_neg.n60 128.267
R3506 spike_neg.n594 spike_neg.n60 122.847
R3507 spike_neg.n593 spike_neg.n63 122.847
R3508 spike_neg.n565 spike_neg.n107 121.04
R3509 spike_neg.n557 spike_neg.n40 110.201
R3510 spike_neg.n605 spike_neg.n604 102.975
R3511 spike_neg.n359 spike_neg.n252 94.2375
R3512 spike_neg.n261 spike_neg.n252 94.2375
R3513 spike_neg.n349 spike_neg.n261 94.2375
R3514 spike_neg.n349 spike_neg.n348 94.2375
R3515 spike_neg.n348 spike_neg.n347 94.2375
R3516 spike_neg.n347 spike_neg.n265 94.2375
R3517 spike_neg.n341 spike_neg.n265 94.2375
R3518 spike_neg.n341 spike_neg.n340 94.2375
R3519 spike_neg.n340 spike_neg.n339 94.2375
R3520 spike_neg.n339 spike_neg.n275 94.2375
R3521 spike_neg.n333 spike_neg.n275 94.2375
R3522 spike_neg.n333 spike_neg.n332 94.2375
R3523 spike_neg.n332 spike_neg.n331 94.2375
R3524 spike_neg.n331 spike_neg.n286 94.2375
R3525 spike_neg.n325 spike_neg.n286 94.2375
R3526 spike_neg.n325 spike_neg.n240 94.2375
R3527 spike_neg.n371 spike_neg.n240 94.2375
R3528 spike_neg.n371 spike_neg.n232 94.2375
R3529 spike_neg.n381 spike_neg.n232 94.2375
R3530 spike_neg.n382 spike_neg.n381 94.2375
R3531 spike_neg.n382 spike_neg.n224 94.2375
R3532 spike_neg.n392 spike_neg.n224 94.2375
R3533 spike_neg.n392 spike_neg.n211 94.2375
R3534 spike_neg.n405 spike_neg.n211 94.2375
R3535 spike_neg.n406 spike_neg.n405 94.2375
R3536 spike_neg.n406 spike_neg.n203 94.2375
R3537 spike_neg.n416 spike_neg.n203 94.2375
R3538 spike_neg.n416 spike_neg.n191 94.2375
R3539 spike_neg.n431 spike_neg.n191 94.2375
R3540 spike_neg.n431 spike_neg.n183 94.2375
R3541 spike_neg.n441 spike_neg.n183 94.2375
R3542 spike_neg.n442 spike_neg.n441 94.2375
R3543 spike_neg.n442 spike_neg.n174 94.2375
R3544 spike_neg.n452 spike_neg.n174 94.2375
R3545 spike_neg.n452 spike_neg.n161 94.2375
R3546 spike_neg.n465 spike_neg.n161 94.2375
R3547 spike_neg.n466 spike_neg.n465 94.2375
R3548 spike_neg.n466 spike_neg.n152 94.2375
R3549 spike_neg.n476 spike_neg.n152 94.2375
R3550 spike_neg.n476 spike_neg.n153 94.2375
R3551 spike_neg.n153 spike_neg.n139 94.2375
R3552 spike_neg.n488 spike_neg.n139 94.2375
R3553 spike_neg.n488 spike_neg.n128 94.2375
R3554 spike_neg.n501 spike_neg.n128 94.2375
R3555 spike_neg.n501 spike_neg.n81 94.2375
R3556 spike_neg.n92 spike_neg.n83 92.135
R3557 spike_neg.n586 spike_neg.n70 84.0977
R3558 spike_neg.n586 spike_neg.n65 84.0977
R3559 spike_neg.n360 spike_neg.n250 84.0977
R3560 spike_neg.n582 spike_neg.n81 74.2122
R3561 spike_neg.n78 spike_neg.n72 69.0283
R3562 spike_neg.n78 spike_neg.n59 69.0283
R3563 spike_neg.n595 spike_neg.n58 69.0283
R3564 spike_neg.n61 spike_neg.n58 69.0283
R3565 spike_neg.n96 spike_neg.n94 69.0283
R3566 spike_neg.n566 spike_neg.n105 69.0283
R3567 spike_neg.n573 spike_neg.n96 69.0283
R3568 spike_neg.n566 spike_neg.n97 69.0283
R3569 spike_neg.n603 spike_neg.n38 69.0283
R3570 spike_neg.n603 spike_neg.n602 69.0283
R3571 spike_neg.n41 spike_neg.n39 69.0283
R3572 spike_neg.n614 spike_neg.n39 69.0283
R3573 spike_neg.n33 spike_neg.n22 62.1255
R3574 spike_neg.n29 spike_neg.n22 62.1255
R3575 spike_neg.n24 spike_neg.n23 62.1255
R3576 spike_neg.n23 spike_neg.n21 62.1255
R3577 spike_neg.n633 spike_neg.n622 62.1255
R3578 spike_neg.n629 spike_neg.n622 62.1255
R3579 spike_neg.n624 spike_neg.n623 62.1255
R3580 spike_neg.n623 spike_neg.n621 62.1255
R3581 spike_neg.n13 spike_neg.n4 62.1255
R3582 spike_neg.n13 spike_neg.n12 62.1255
R3583 spike_neg.n7 spike_neg.n5 62.1255
R3584 spike_neg.n16 spike_neg.n5 62.1255
R3585 spike_neg.n358 spike_neg.n250 52.7258
R3586 spike_neg.n581 spike_neg.n83 52.3907
R3587 spike_neg.n604 spike_neg.n52 41.5514
R3588 spike_neg.n558 spike_neg.n557 34.3251
R3589 spike_neg.n582 spike_neg.n581 30.712
R3590 spike_neg.n565 spike_neg.n564 23.4858
R3591 spike_neg.n594 spike_neg.n593 21.6792
R3592 spike_neg.n71 spike_neg.n63 21.6792
R3593 spike_neg.n537 spike_neg.n536 16.2595
R3594 spike_neg.n595 spike_neg.n59 15.5561
R3595 spike_neg.n72 spike_neg.n61 15.5561
R3596 spike_neg.n357 spike_neg.n253 15.5561
R3597 spike_neg.n259 spike_neg.n253 15.5561
R3598 spike_neg.n350 spike_neg.n259 15.5561
R3599 spike_neg.n350 spike_neg.n260 15.5561
R3600 spike_neg.n346 spike_neg.n260 15.5561
R3601 spike_neg.n346 spike_neg.n266 15.5561
R3602 spike_neg.n342 spike_neg.n266 15.5561
R3603 spike_neg.n342 spike_neg.n271 15.5561
R3604 spike_neg.n338 spike_neg.n271 15.5561
R3605 spike_neg.n338 spike_neg.n276 15.5561
R3606 spike_neg.n334 spike_neg.n276 15.5561
R3607 spike_neg.n334 spike_neg.n282 15.5561
R3608 spike_neg.n330 spike_neg.n282 15.5561
R3609 spike_neg.n330 spike_neg.n287 15.5561
R3610 spike_neg.n326 spike_neg.n287 15.5561
R3611 spike_neg.n326 spike_neg.n239 15.5561
R3612 spike_neg.n372 spike_neg.n239 15.5561
R3613 spike_neg.n372 spike_neg.n233 15.5561
R3614 spike_neg.n380 spike_neg.n233 15.5561
R3615 spike_neg.n380 spike_neg.n225 15.5561
R3616 spike_neg.n390 spike_neg.n225 15.5561
R3617 spike_neg.n391 spike_neg.n390 15.5561
R3618 spike_neg.n391 spike_neg.n212 15.5561
R3619 spike_neg.n404 spike_neg.n212 15.5561
R3620 spike_neg.n404 spike_neg.n204 15.5561
R3621 spike_neg.n414 spike_neg.n204 15.5561
R3622 spike_neg.n415 spike_neg.n414 15.5561
R3623 spike_neg.n415 spike_neg.n192 15.5561
R3624 spike_neg.n430 spike_neg.n192 15.5561
R3625 spike_neg.n430 spike_neg.n184 15.5561
R3626 spike_neg.n440 spike_neg.n184 15.5561
R3627 spike_neg.n440 spike_neg.n175 15.5561
R3628 spike_neg.n450 spike_neg.n175 15.5561
R3629 spike_neg.n451 spike_neg.n450 15.5561
R3630 spike_neg.n451 spike_neg.n162 15.5561
R3631 spike_neg.n464 spike_neg.n162 15.5561
R3632 spike_neg.n464 spike_neg.n154 15.5561
R3633 spike_neg.n474 spike_neg.n154 15.5561
R3634 spike_neg.n475 spike_neg.n474 15.5561
R3635 spike_neg.n475 spike_neg.n140 15.5561
R3636 spike_neg.n486 spike_neg.n140 15.5561
R3637 spike_neg.n487 spike_neg.n486 15.5561
R3638 spike_neg.n487 spike_neg.n129 15.5561
R3639 spike_neg.n500 spike_neg.n129 15.5561
R3640 spike_neg.n500 spike_neg.n84 15.5561
R3641 spike_neg.n580 spike_neg.n84 15.5561
R3642 spike_neg.n580 spike_neg.n85 15.5561
R3643 spike_neg.n576 spike_neg.n85 15.5561
R3644 spike_neg.n576 spike_neg.n91 15.5561
R3645 spike_neg.n110 spike_neg.n91 15.5561
R3646 spike_neg.n563 spike_neg.n110 15.5561
R3647 spike_neg.n563 spike_neg.n111 15.5561
R3648 spike_neg.n559 spike_neg.n111 15.5561
R3649 spike_neg.n559 spike_neg.n44 15.5561
R3650 spike_neg.n611 spike_neg.n44 15.5561
R3651 spike_neg.n611 spike_neg.n45 15.5561
R3652 spike_neg.n606 spike_neg.n45 15.5561
R3653 spike_neg.n606 spike_neg.n49 15.5561
R3654 spike_neg.n545 spike_neg.n49 15.5561
R3655 spike_neg.n545 spike_neg.n538 15.5561
R3656 spike_neg.n538 spike_neg.n64 15.5561
R3657 spike_neg.n592 spike_neg.n64 15.5561
R3658 spike_neg.n592 spike_neg.n65 15.5561
R3659 spike_neg.n360 spike_neg.n251 15.5561
R3660 spike_neg.n301 spike_neg.n251 15.5561
R3661 spike_neg.n301 spike_neg.n262 15.5561
R3662 spike_neg.n263 spike_neg.n262 15.5561
R3663 spike_neg.n264 spike_neg.n263 15.5561
R3664 spike_neg.n298 spike_neg.n264 15.5561
R3665 spike_neg.n298 spike_neg.n272 15.5561
R3666 spike_neg.n273 spike_neg.n272 15.5561
R3667 spike_neg.n274 spike_neg.n273 15.5561
R3668 spike_neg.n295 spike_neg.n274 15.5561
R3669 spike_neg.n295 spike_neg.n283 15.5561
R3670 spike_neg.n284 spike_neg.n283 15.5561
R3671 spike_neg.n285 spike_neg.n284 15.5561
R3672 spike_neg.n292 spike_neg.n285 15.5561
R3673 spike_neg.n324 spike_neg.n292 15.5561
R3674 spike_neg.n324 spike_neg.n241 15.5561
R3675 spike_neg.n370 spike_neg.n241 15.5561
R3676 spike_neg.n370 spike_neg.n242 15.5561
R3677 spike_neg.n242 spike_neg.n231 15.5561
R3678 spike_neg.n383 spike_neg.n231 15.5561
R3679 spike_neg.n383 spike_neg.n222 15.5561
R3680 spike_neg.n393 spike_neg.n222 15.5561
R3681 spike_neg.n393 spike_neg.n223 15.5561
R3682 spike_neg.n223 spike_neg.n210 15.5561
R3683 spike_neg.n407 spike_neg.n210 15.5561
R3684 spike_neg.n407 spike_neg.n202 15.5561
R3685 spike_neg.n417 spike_neg.n202 15.5561
R3686 spike_neg.n417 spike_neg.n190 15.5561
R3687 spike_neg.n432 spike_neg.n190 15.5561
R3688 spike_neg.n433 spike_neg.n432 15.5561
R3689 spike_neg.n433 spike_neg.n182 15.5561
R3690 spike_neg.n443 spike_neg.n182 15.5561
R3691 spike_neg.n443 spike_neg.n172 15.5561
R3692 spike_neg.n453 spike_neg.n172 15.5561
R3693 spike_neg.n453 spike_neg.n173 15.5561
R3694 spike_neg.n173 spike_neg.n160 15.5561
R3695 spike_neg.n467 spike_neg.n160 15.5561
R3696 spike_neg.n467 spike_neg.n150 15.5561
R3697 spike_neg.n477 spike_neg.n150 15.5561
R3698 spike_neg.n477 spike_neg.n151 15.5561
R3699 spike_neg.n151 spike_neg.n138 15.5561
R3700 spike_neg.n489 spike_neg.n138 15.5561
R3701 spike_neg.n489 spike_neg.n127 15.5561
R3702 spike_neg.n502 spike_neg.n127 15.5561
R3703 spike_neg.n503 spike_neg.n502 15.5561
R3704 spike_neg.n503 spike_neg.n82 15.5561
R3705 spike_neg.n506 spike_neg.n82 15.5561
R3706 spike_neg.n506 spike_neg.n93 15.5561
R3707 spike_neg.n512 spike_neg.n93 15.5561
R3708 spike_neg.n513 spike_neg.n512 15.5561
R3709 spike_neg.n513 spike_neg.n108 15.5561
R3710 spike_neg.n119 spike_neg.n108 15.5561
R3711 spike_neg.n556 spike_neg.n119 15.5561
R3712 spike_neg.n556 spike_neg.n120 15.5561
R3713 spike_neg.n120 spike_neg.n42 15.5561
R3714 spike_neg.n551 spike_neg.n42 15.5561
R3715 spike_neg.n551 spike_neg.n51 15.5561
R3716 spike_neg.n548 spike_neg.n51 15.5561
R3717 spike_neg.n548 spike_neg.n547 15.5561
R3718 spike_neg.n547 spike_neg.n535 15.5561
R3719 spike_neg.n535 spike_neg.n525 15.5561
R3720 spike_neg.n525 spike_neg.n62 15.5561
R3721 spike_neg.n70 spike_neg.n62 15.5561
R3722 spike_neg.n105 spike_neg.n94 15.5561
R3723 spike_neg.n573 spike_neg.n97 15.5561
R3724 spike_neg.n602 spike_neg.n41 15.5561
R3725 spike_neg.n575 spike_neg.n574 14.453
R3726 spike_neg.n106 spike_neg.n95 14.453
R3727 spike_neg.n546 spike_neg.n79 12.6464
R3728 spike_neg.n498 spike_neg.n497 12.5005
R3729 spike_neg.n493 spike_neg.n131 12.5005
R3730 spike_neg.n492 spike_neg.n491 12.5005
R3731 spike_neg.n484 spike_neg.n133 12.5005
R3732 spike_neg.n146 spike_neg.n142 12.5005
R3733 spike_neg.n479 spike_neg.n147 12.5005
R3734 spike_neg.n472 spike_neg.n471 12.5005
R3735 spike_neg.n470 spike_neg.n469 12.5005
R3736 spike_neg.n462 spike_neg.n157 12.5005
R3737 spike_neg.n168 spike_neg.n164 12.5005
R3738 spike_neg.n455 spike_neg.n169 12.5005
R3739 spike_neg.n448 spike_neg.n447 12.5005
R3740 spike_neg.n446 spike_neg.n445 12.5005
R3741 spike_neg.n438 spike_neg.n437 12.5005
R3742 spike_neg.n436 spike_neg.n435 12.5005
R3743 spike_neg.n428 spike_neg.n187 12.5005
R3744 spike_neg.n198 spike_neg.n194 12.5005
R3745 spike_neg.n419 spike_neg.n199 12.5005
R3746 spike_neg.n412 spike_neg.n411 12.5005
R3747 spike_neg.n410 spike_neg.n409 12.5005
R3748 spike_neg.n402 spike_neg.n207 12.5005
R3749 spike_neg.n218 spike_neg.n214 12.5005
R3750 spike_neg.n395 spike_neg.n219 12.5005
R3751 spike_neg.n388 spike_neg.n387 12.5005
R3752 spike_neg.n386 spike_neg.n385 12.5005
R3753 spike_neg.n378 spike_neg.n228 12.5005
R3754 spike_neg.n377 spike_neg.n376 12.5005
R3755 spike_neg.n617 spike_neg.n616 12.0394
R3756 spike_neg.n376 spike_neg.n375 11.7031
R3757 spike_neg.n497 spike_neg.n496 11.545
R3758 spike_neg.n588 spike_neg.n68 10.9121
R3759 spike_neg.n366 spike_neg.n365 7.89186
R3760 spike_neg.n365 spike_neg.n364 7.73533
R3761 spike_neg.n247 spike_neg.n246 7.57378
R3762 spike_neg.n34 spike_neg.n33 6.37187
R3763 spike_neg.n34 spike_neg.n21 6.37187
R3764 spike_neg.n634 spike_neg.n633 6.37187
R3765 spike_neg.n634 spike_neg.n621 6.37187
R3766 spike_neg.n17 spike_neg.n16 6.37187
R3767 spike_neg.n17 spike_neg.n4 6.37187
R3768 spike_neg.n29 spike_neg.n28 6.3005
R3769 spike_neg.n25 spike_neg.n24 6.3005
R3770 spike_neg.n629 spike_neg.n628 6.3005
R3771 spike_neg.n625 spike_neg.n624 6.3005
R3772 spike_neg.n12 spike_neg.n11 6.3005
R3773 spike_neg.n8 spike_neg.n7 6.3005
R3774 spike_neg.n376 spike_neg.n228 5.61588
R3775 spike_neg.n386 spike_neg.n228 5.61588
R3776 spike_neg.n387 spike_neg.n386 5.61588
R3777 spike_neg.n387 spike_neg.n219 5.61588
R3778 spike_neg.n219 spike_neg.n218 5.61588
R3779 spike_neg.n218 spike_neg.n207 5.61588
R3780 spike_neg.n410 spike_neg.n207 5.61588
R3781 spike_neg.n411 spike_neg.n410 5.61588
R3782 spike_neg.n411 spike_neg.n199 5.61588
R3783 spike_neg.n199 spike_neg.n198 5.61588
R3784 spike_neg.n198 spike_neg.n187 5.61588
R3785 spike_neg.n436 spike_neg.n187 5.61588
R3786 spike_neg.n437 spike_neg.n436 5.61588
R3787 spike_neg.n447 spike_neg.n446 5.61588
R3788 spike_neg.n447 spike_neg.n169 5.61588
R3789 spike_neg.n169 spike_neg.n168 5.61588
R3790 spike_neg.n168 spike_neg.n157 5.61588
R3791 spike_neg.n470 spike_neg.n157 5.61588
R3792 spike_neg.n471 spike_neg.n470 5.61588
R3793 spike_neg.n471 spike_neg.n147 5.61588
R3794 spike_neg.n147 spike_neg.n146 5.61588
R3795 spike_neg.n146 spike_neg.n133 5.61588
R3796 spike_neg.n492 spike_neg.n133 5.61588
R3797 spike_neg.n493 spike_neg.n492 5.61588
R3798 spike_neg.n497 spike_neg.n493 5.61588
R3799 spike_neg.n109 spike_neg.n80 5.42018
R3800 spike_neg.n255 spike_neg.n254 5.35452
R3801 spike_neg.n73 spike_neg.n55 5.20101
R3802 spike_neg.n102 spike_neg.n101 5.20101
R3803 spike_neg.n26 spike_neg.n20 5.20101
R3804 spike_neg.n27 spike_neg.n19 5.20101
R3805 spike_neg.n626 spike_neg.n1 5.20101
R3806 spike_neg.n627 spike_neg.n0 5.20101
R3807 spike_neg.n9 spike_neg.n3 5.20101
R3808 spike_neg.n10 spike_neg.n2 5.20101
R3809 spike_neg.n504 spike_neg.n503 5.2005
R3810 spike_neg.n503 spike_neg.n81 5.2005
R3811 spike_neg.n502 spike_neg.n125 5.2005
R3812 spike_neg.n502 spike_neg.n501 5.2005
R3813 spike_neg.n137 spike_neg.n127 5.2005
R3814 spike_neg.n128 spike_neg.n127 5.2005
R3815 spike_neg.n490 spike_neg.n489 5.2005
R3816 spike_neg.n489 spike_neg.n488 5.2005
R3817 spike_neg.n138 spike_neg.n136 5.2005
R3818 spike_neg.n139 spike_neg.n138 5.2005
R3819 spike_neg.n151 spike_neg.n149 5.2005
R3820 spike_neg.n153 spike_neg.n151 5.2005
R3821 spike_neg.n478 spike_neg.n477 5.2005
R3822 spike_neg.n477 spike_neg.n476 5.2005
R3823 spike_neg.n150 spike_neg.n148 5.2005
R3824 spike_neg.n152 spike_neg.n150 5.2005
R3825 spike_neg.n468 spike_neg.n467 5.2005
R3826 spike_neg.n467 spike_neg.n466 5.2005
R3827 spike_neg.n160 spike_neg.n159 5.2005
R3828 spike_neg.n465 spike_neg.n160 5.2005
R3829 spike_neg.n173 spike_neg.n171 5.2005
R3830 spike_neg.n173 spike_neg.n161 5.2005
R3831 spike_neg.n454 spike_neg.n453 5.2005
R3832 spike_neg.n453 spike_neg.n452 5.2005
R3833 spike_neg.n172 spike_neg.n170 5.2005
R3834 spike_neg.n174 spike_neg.n172 5.2005
R3835 spike_neg.n444 spike_neg.n443 5.2005
R3836 spike_neg.n443 spike_neg.n442 5.2005
R3837 spike_neg.n182 spike_neg.n181 5.2005
R3838 spike_neg.n441 spike_neg.n182 5.2005
R3839 spike_neg.n434 spike_neg.n433 5.2005
R3840 spike_neg.n433 spike_neg.n183 5.2005
R3841 spike_neg.n432 spike_neg.n189 5.2005
R3842 spike_neg.n432 spike_neg.n431 5.2005
R3843 spike_neg.n201 spike_neg.n190 5.2005
R3844 spike_neg.n191 spike_neg.n190 5.2005
R3845 spike_neg.n418 spike_neg.n417 5.2005
R3846 spike_neg.n417 spike_neg.n416 5.2005
R3847 spike_neg.n202 spike_neg.n200 5.2005
R3848 spike_neg.n203 spike_neg.n202 5.2005
R3849 spike_neg.n408 spike_neg.n407 5.2005
R3850 spike_neg.n407 spike_neg.n406 5.2005
R3851 spike_neg.n210 spike_neg.n209 5.2005
R3852 spike_neg.n405 spike_neg.n210 5.2005
R3853 spike_neg.n223 spike_neg.n221 5.2005
R3854 spike_neg.n223 spike_neg.n211 5.2005
R3855 spike_neg.n394 spike_neg.n393 5.2005
R3856 spike_neg.n393 spike_neg.n392 5.2005
R3857 spike_neg.n222 spike_neg.n220 5.2005
R3858 spike_neg.n224 spike_neg.n222 5.2005
R3859 spike_neg.n384 spike_neg.n383 5.2005
R3860 spike_neg.n383 spike_neg.n382 5.2005
R3861 spike_neg.n231 spike_neg.n230 5.2005
R3862 spike_neg.n381 spike_neg.n231 5.2005
R3863 spike_neg.n242 spike_neg.n236 5.2005
R3864 spike_neg.n242 spike_neg.n232 5.2005
R3865 spike_neg.n370 spike_neg.n369 5.2005
R3866 spike_neg.n371 spike_neg.n370 5.2005
R3867 spike_neg.n243 spike_neg.n241 5.2005
R3868 spike_neg.n241 spike_neg.n240 5.2005
R3869 spike_neg.n324 spike_neg.n323 5.2005
R3870 spike_neg.n325 spike_neg.n324 5.2005
R3871 spike_neg.n293 spike_neg.n292 5.2005
R3872 spike_neg.n292 spike_neg.n286 5.2005
R3873 spike_neg.n319 spike_neg.n285 5.2005
R3874 spike_neg.n331 spike_neg.n285 5.2005
R3875 spike_neg.n318 spike_neg.n284 5.2005
R3876 spike_neg.n332 spike_neg.n284 5.2005
R3877 spike_neg.n317 spike_neg.n283 5.2005
R3878 spike_neg.n333 spike_neg.n283 5.2005
R3879 spike_neg.n296 spike_neg.n295 5.2005
R3880 spike_neg.n295 spike_neg.n275 5.2005
R3881 spike_neg.n313 spike_neg.n274 5.2005
R3882 spike_neg.n339 spike_neg.n274 5.2005
R3883 spike_neg.n312 spike_neg.n273 5.2005
R3884 spike_neg.n340 spike_neg.n273 5.2005
R3885 spike_neg.n311 spike_neg.n272 5.2005
R3886 spike_neg.n341 spike_neg.n272 5.2005
R3887 spike_neg.n299 spike_neg.n298 5.2005
R3888 spike_neg.n298 spike_neg.n265 5.2005
R3889 spike_neg.n307 spike_neg.n264 5.2005
R3890 spike_neg.n347 spike_neg.n264 5.2005
R3891 spike_neg.n306 spike_neg.n263 5.2005
R3892 spike_neg.n348 spike_neg.n263 5.2005
R3893 spike_neg.n305 spike_neg.n262 5.2005
R3894 spike_neg.n349 spike_neg.n262 5.2005
R3895 spike_neg.n302 spike_neg.n301 5.2005
R3896 spike_neg.n301 spike_neg.n261 5.2005
R3897 spike_neg.n251 spike_neg.n249 5.2005
R3898 spike_neg.n252 spike_neg.n251 5.2005
R3899 spike_neg.n361 spike_neg.n360 5.2005
R3900 spike_neg.n360 spike_neg.n359 5.2005
R3901 spike_neg.n86 spike_neg.n84 5.2005
R3902 spike_neg.n84 spike_neg.n81 5.2005
R3903 spike_neg.n500 spike_neg.n499 5.2005
R3904 spike_neg.n501 spike_neg.n500 5.2005
R3905 spike_neg.n130 spike_neg.n129 5.2005
R3906 spike_neg.n129 spike_neg.n128 5.2005
R3907 spike_neg.n487 spike_neg.n135 5.2005
R3908 spike_neg.n488 spike_neg.n487 5.2005
R3909 spike_neg.n486 spike_neg.n485 5.2005
R3910 spike_neg.n486 spike_neg.n139 5.2005
R3911 spike_neg.n141 spike_neg.n140 5.2005
R3912 spike_neg.n153 spike_neg.n140 5.2005
R3913 spike_neg.n475 spike_neg.n145 5.2005
R3914 spike_neg.n476 spike_neg.n475 5.2005
R3915 spike_neg.n474 spike_neg.n473 5.2005
R3916 spike_neg.n474 spike_neg.n152 5.2005
R3917 spike_neg.n155 spike_neg.n154 5.2005
R3918 spike_neg.n466 spike_neg.n154 5.2005
R3919 spike_neg.n464 spike_neg.n463 5.2005
R3920 spike_neg.n465 spike_neg.n464 5.2005
R3921 spike_neg.n163 spike_neg.n162 5.2005
R3922 spike_neg.n162 spike_neg.n161 5.2005
R3923 spike_neg.n451 spike_neg.n167 5.2005
R3924 spike_neg.n452 spike_neg.n451 5.2005
R3925 spike_neg.n450 spike_neg.n449 5.2005
R3926 spike_neg.n450 spike_neg.n174 5.2005
R3927 spike_neg.n176 spike_neg.n175 5.2005
R3928 spike_neg.n442 spike_neg.n175 5.2005
R3929 spike_neg.n440 spike_neg.n439 5.2005
R3930 spike_neg.n441 spike_neg.n440 5.2005
R3931 spike_neg.n185 spike_neg.n184 5.2005
R3932 spike_neg.n184 spike_neg.n183 5.2005
R3933 spike_neg.n430 spike_neg.n429 5.2005
R3934 spike_neg.n431 spike_neg.n430 5.2005
R3935 spike_neg.n193 spike_neg.n192 5.2005
R3936 spike_neg.n192 spike_neg.n191 5.2005
R3937 spike_neg.n415 spike_neg.n197 5.2005
R3938 spike_neg.n416 spike_neg.n415 5.2005
R3939 spike_neg.n414 spike_neg.n413 5.2005
R3940 spike_neg.n414 spike_neg.n203 5.2005
R3941 spike_neg.n205 spike_neg.n204 5.2005
R3942 spike_neg.n406 spike_neg.n204 5.2005
R3943 spike_neg.n404 spike_neg.n403 5.2005
R3944 spike_neg.n405 spike_neg.n404 5.2005
R3945 spike_neg.n213 spike_neg.n212 5.2005
R3946 spike_neg.n212 spike_neg.n211 5.2005
R3947 spike_neg.n391 spike_neg.n217 5.2005
R3948 spike_neg.n392 spike_neg.n391 5.2005
R3949 spike_neg.n390 spike_neg.n389 5.2005
R3950 spike_neg.n390 spike_neg.n224 5.2005
R3951 spike_neg.n226 spike_neg.n225 5.2005
R3952 spike_neg.n382 spike_neg.n225 5.2005
R3953 spike_neg.n380 spike_neg.n379 5.2005
R3954 spike_neg.n381 spike_neg.n380 5.2005
R3955 spike_neg.n234 spike_neg.n233 5.2005
R3956 spike_neg.n233 spike_neg.n232 5.2005
R3957 spike_neg.n373 spike_neg.n372 5.2005
R3958 spike_neg.n372 spike_neg.n371 5.2005
R3959 spike_neg.n239 spike_neg.n238 5.2005
R3960 spike_neg.n240 spike_neg.n239 5.2005
R3961 spike_neg.n327 spike_neg.n326 5.2005
R3962 spike_neg.n326 spike_neg.n325 5.2005
R3963 spike_neg.n328 spike_neg.n287 5.2005
R3964 spike_neg.n287 spike_neg.n286 5.2005
R3965 spike_neg.n330 spike_neg.n329 5.2005
R3966 spike_neg.n331 spike_neg.n330 5.2005
R3967 spike_neg.n282 spike_neg.n281 5.2005
R3968 spike_neg.n332 spike_neg.n282 5.2005
R3969 spike_neg.n335 spike_neg.n334 5.2005
R3970 spike_neg.n334 spike_neg.n333 5.2005
R3971 spike_neg.n336 spike_neg.n276 5.2005
R3972 spike_neg.n276 spike_neg.n275 5.2005
R3973 spike_neg.n338 spike_neg.n337 5.2005
R3974 spike_neg.n339 spike_neg.n338 5.2005
R3975 spike_neg.n271 spike_neg.n270 5.2005
R3976 spike_neg.n340 spike_neg.n271 5.2005
R3977 spike_neg.n343 spike_neg.n342 5.2005
R3978 spike_neg.n342 spike_neg.n341 5.2005
R3979 spike_neg.n344 spike_neg.n266 5.2005
R3980 spike_neg.n266 spike_neg.n265 5.2005
R3981 spike_neg.n346 spike_neg.n345 5.2005
R3982 spike_neg.n347 spike_neg.n346 5.2005
R3983 spike_neg.n260 spike_neg.n258 5.2005
R3984 spike_neg.n348 spike_neg.n260 5.2005
R3985 spike_neg.n351 spike_neg.n350 5.2005
R3986 spike_neg.n350 spike_neg.n349 5.2005
R3987 spike_neg.n259 spike_neg.n256 5.2005
R3988 spike_neg.n261 spike_neg.n259 5.2005
R3989 spike_neg.n355 spike_neg.n253 5.2005
R3990 spike_neg.n253 spike_neg.n252 5.2005
R3991 spike_neg.n357 spike_neg.n356 5.2005
R3992 spike_neg.n75 spike_neg.n72 5.2005
R3993 spike_neg.n72 spike_neg.n63 5.2005
R3994 spike_neg.n74 spike_neg.n61 5.2005
R3995 spike_neg.n594 spike_neg.n61 5.2005
R3996 spike_neg.n59 spike_neg.n57 5.2005
R3997 spike_neg.n63 spike_neg.n59 5.2005
R3998 spike_neg.n596 spike_neg.n595 5.2005
R3999 spike_neg.n595 spike_neg.n594 5.2005
R4000 spike_neg.n531 spike_neg.n70 5.2005
R4001 spike_neg.n71 spike_neg.n70 5.2005
R4002 spike_neg.n532 spike_neg.n62 5.2005
R4003 spike_neg.n593 spike_neg.n62 5.2005
R4004 spike_neg.n533 spike_neg.n525 5.2005
R4005 spike_neg.n525 spike_neg.n60 5.2005
R4006 spike_neg.n535 spike_neg.n534 5.2005
R4007 spike_neg.n537 spike_neg.n535 5.2005
R4008 spike_neg.n547 spike_neg.n524 5.2005
R4009 spike_neg.n547 spike_neg.n546 5.2005
R4010 spike_neg.n549 spike_neg.n548 5.2005
R4011 spike_neg.n548 spike_neg.n52 5.2005
R4012 spike_neg.n550 spike_neg.n51 5.2005
R4013 spike_neg.n605 spike_neg.n51 5.2005
R4014 spike_neg.n552 spike_neg.n551 5.2005
R4015 spike_neg.n551 spike_neg.n50 5.2005
R4016 spike_neg.n553 spike_neg.n42 5.2005
R4017 spike_neg.n612 spike_neg.n42 5.2005
R4018 spike_neg.n554 spike_neg.n120 5.2005
R4019 spike_neg.n120 spike_neg.n40 5.2005
R4020 spike_neg.n556 spike_neg.n555 5.2005
R4021 spike_neg.n558 spike_neg.n556 5.2005
R4022 spike_neg.n121 spike_neg.n119 5.2005
R4023 spike_neg.n119 spike_neg.n109 5.2005
R4024 spike_neg.n515 spike_neg.n108 5.2005
R4025 spike_neg.n564 spike_neg.n108 5.2005
R4026 spike_neg.n514 spike_neg.n513 5.2005
R4027 spike_neg.n513 spike_neg.n107 5.2005
R4028 spike_neg.n512 spike_neg.n511 5.2005
R4029 spike_neg.n512 spike_neg.n95 5.2005
R4030 spike_neg.n123 spike_neg.n93 5.2005
R4031 spike_neg.n575 spike_neg.n93 5.2005
R4032 spike_neg.n507 spike_neg.n506 5.2005
R4033 spike_neg.n506 spike_neg.n92 5.2005
R4034 spike_neg.n505 spike_neg.n82 5.2005
R4035 spike_neg.n581 spike_neg.n82 5.2005
R4036 spike_neg.n590 spike_neg.n65 5.2005
R4037 spike_neg.n71 spike_neg.n65 5.2005
R4038 spike_neg.n592 spike_neg.n591 5.2005
R4039 spike_neg.n593 spike_neg.n592 5.2005
R4040 spike_neg.n66 spike_neg.n64 5.2005
R4041 spike_neg.n64 spike_neg.n60 5.2005
R4042 spike_neg.n543 spike_neg.n538 5.2005
R4043 spike_neg.n538 spike_neg.n537 5.2005
R4044 spike_neg.n545 spike_neg.n544 5.2005
R4045 spike_neg.n546 spike_neg.n545 5.2005
R4046 spike_neg.n49 spike_neg.n48 5.2005
R4047 spike_neg.n52 spike_neg.n49 5.2005
R4048 spike_neg.n607 spike_neg.n606 5.2005
R4049 spike_neg.n606 spike_neg.n605 5.2005
R4050 spike_neg.n608 spike_neg.n45 5.2005
R4051 spike_neg.n50 spike_neg.n45 5.2005
R4052 spike_neg.n611 spike_neg.n610 5.2005
R4053 spike_neg.n612 spike_neg.n611 5.2005
R4054 spike_neg.n46 spike_neg.n44 5.2005
R4055 spike_neg.n44 spike_neg.n40 5.2005
R4056 spike_neg.n560 spike_neg.n559 5.2005
R4057 spike_neg.n559 spike_neg.n558 5.2005
R4058 spike_neg.n561 spike_neg.n111 5.2005
R4059 spike_neg.n111 spike_neg.n109 5.2005
R4060 spike_neg.n563 spike_neg.n562 5.2005
R4061 spike_neg.n564 spike_neg.n563 5.2005
R4062 spike_neg.n112 spike_neg.n110 5.2005
R4063 spike_neg.n110 spike_neg.n107 5.2005
R4064 spike_neg.n91 spike_neg.n90 5.2005
R4065 spike_neg.n95 spike_neg.n91 5.2005
R4066 spike_neg.n577 spike_neg.n576 5.2005
R4067 spike_neg.n576 spike_neg.n575 5.2005
R4068 spike_neg.n578 spike_neg.n85 5.2005
R4069 spike_neg.n92 spike_neg.n85 5.2005
R4070 spike_neg.n580 spike_neg.n579 5.2005
R4071 spike_neg.n581 spike_neg.n580 5.2005
R4072 spike_neg.n105 spike_neg.n104 5.2005
R4073 spike_neg.n106 spike_neg.n105 5.2005
R4074 spike_neg.n103 spike_neg.n94 5.2005
R4075 spike_neg.n574 spike_neg.n94 5.2005
R4076 spike_neg.n98 spike_neg.n97 5.2005
R4077 spike_neg.n106 spike_neg.n97 5.2005
R4078 spike_neg.n573 spike_neg.n572 5.2005
R4079 spike_neg.n574 spike_neg.n573 5.2005
R4080 spike_neg.n602 spike_neg.n601 5.2005
R4081 spike_neg.n602 spike_neg.n43 5.2005
R4082 spike_neg.n53 spike_neg.n41 5.2005
R4083 spike_neg.n613 spike_neg.n41 5.2005
R4084 spike_neg.n43 spike_neg.n38 5.2005
R4085 spike_neg.n614 spike_neg.n613 5.2005
R4086 spike_neg.n77 spike_neg.n76 5.19319
R4087 spike_neg.n567 spike_neg.n100 5.19319
R4088 spike_neg.n254 spike_neg.n247 5.14053
R4089 spike_neg.n588 spike_neg.n587 5.12952
R4090 spike_neg.n616 spike_neg.n36 5.12001
R4091 spike_neg.n616 spike_neg.n35 5.11219
R4092 spike_neg.n530 spike_neg.n69 5.04833
R4093 spike_neg.n77 spike_neg.n68 4.98321
R4094 spike_neg.n598 spike_neg.n55 4.98321
R4095 spike_neg.n569 spike_neg.n567 4.98321
R4096 spike_neg.n101 spike_neg.n99 4.98321
R4097 spike_neg.n568 spike_neg.n36 4.98321
R4098 spike_neg.n599 spike_neg.n35 4.98321
R4099 spike_neg.n618 spike_neg.n20 4.98321
R4100 spike_neg.n635 spike_neg.n1 4.98321
R4101 spike_neg.n18 spike_neg.n3 4.98321
R4102 spike_neg.n618 spike_neg.n19 4.97539
R4103 spike_neg.n635 spike_neg.n0 4.97539
R4104 spike_neg.n18 spike_neg.n2 4.97539
R4105 spike_neg.n364 spike_neg.n69 4.7183
R4106 spike_neg.n76 spike_neg.n75 4.5005
R4107 spike_neg.n74 spike_neg.n73 4.5005
R4108 spike_neg.n57 spike_neg.n56 4.5005
R4109 spike_neg.n597 spike_neg.n596 4.5005
R4110 spike_neg.n377 spike_neg.n234 4.5005
R4111 spike_neg.n379 spike_neg.n378 4.5005
R4112 spike_neg.n385 spike_neg.n226 4.5005
R4113 spike_neg.n389 spike_neg.n388 4.5005
R4114 spike_neg.n395 spike_neg.n217 4.5005
R4115 spike_neg.n214 spike_neg.n213 4.5005
R4116 spike_neg.n403 spike_neg.n402 4.5005
R4117 spike_neg.n409 spike_neg.n205 4.5005
R4118 spike_neg.n413 spike_neg.n412 4.5005
R4119 spike_neg.n419 spike_neg.n197 4.5005
R4120 spike_neg.n194 spike_neg.n193 4.5005
R4121 spike_neg.n429 spike_neg.n428 4.5005
R4122 spike_neg.n435 spike_neg.n185 4.5005
R4123 spike_neg.n439 spike_neg.n438 4.5005
R4124 spike_neg.n445 spike_neg.n176 4.5005
R4125 spike_neg.n449 spike_neg.n448 4.5005
R4126 spike_neg.n455 spike_neg.n167 4.5005
R4127 spike_neg.n164 spike_neg.n163 4.5005
R4128 spike_neg.n463 spike_neg.n462 4.5005
R4129 spike_neg.n469 spike_neg.n155 4.5005
R4130 spike_neg.n473 spike_neg.n472 4.5005
R4131 spike_neg.n479 spike_neg.n145 4.5005
R4132 spike_neg.n142 spike_neg.n141 4.5005
R4133 spike_neg.n485 spike_neg.n484 4.5005
R4134 spike_neg.n491 spike_neg.n135 4.5005
R4135 spike_neg.n131 spike_neg.n130 4.5005
R4136 spike_neg.n499 spike_neg.n498 4.5005
R4137 spike_neg.n494 spike_neg.n86 4.5005
R4138 spike_neg.n579 spike_neg.n87 4.5005
R4139 spike_neg.n578 spike_neg.n88 4.5005
R4140 spike_neg.n577 spike_neg.n89 4.5005
R4141 spike_neg.n113 spike_neg.n90 4.5005
R4142 spike_neg.n114 spike_neg.n112 4.5005
R4143 spike_neg.n562 spike_neg.n115 4.5005
R4144 spike_neg.n561 spike_neg.n116 4.5005
R4145 spike_neg.n560 spike_neg.n118 4.5005
R4146 spike_neg.n117 spike_neg.n46 4.5005
R4147 spike_neg.n607 spike_neg.n47 4.5005
R4148 spike_neg.n539 spike_neg.n48 4.5005
R4149 spike_neg.n544 spike_neg.n540 4.5005
R4150 spike_neg.n543 spike_neg.n542 4.5005
R4151 spike_neg.n541 spike_neg.n66 4.5005
R4152 spike_neg.n591 spike_neg.n67 4.5005
R4153 spike_neg.n590 spike_neg.n589 4.5005
R4154 spike_neg.n355 spike_neg.n354 4.5005
R4155 spike_neg.n353 spike_neg.n256 4.5005
R4156 spike_neg.n352 spike_neg.n351 4.5005
R4157 spike_neg.n258 spike_neg.n257 4.5005
R4158 spike_neg.n345 spike_neg.n267 4.5005
R4159 spike_neg.n344 spike_neg.n268 4.5005
R4160 spike_neg.n343 spike_neg.n269 4.5005
R4161 spike_neg.n277 spike_neg.n270 4.5005
R4162 spike_neg.n337 spike_neg.n278 4.5005
R4163 spike_neg.n336 spike_neg.n279 4.5005
R4164 spike_neg.n335 spike_neg.n280 4.5005
R4165 spike_neg.n288 spike_neg.n281 4.5005
R4166 spike_neg.n329 spike_neg.n289 4.5005
R4167 spike_neg.n328 spike_neg.n290 4.5005
R4168 spike_neg.n327 spike_neg.n291 4.5005
R4169 spike_neg.n238 spike_neg.n237 4.5005
R4170 spike_neg.n374 spike_neg.n373 4.5005
R4171 spike_neg.n356 spike_neg.n255 4.5005
R4172 spike_neg.n249 spike_neg.n248 4.5005
R4173 spike_neg.n303 spike_neg.n302 4.5005
R4174 spike_neg.n305 spike_neg.n304 4.5005
R4175 spike_neg.n306 spike_neg.n300 4.5005
R4176 spike_neg.n308 spike_neg.n307 4.5005
R4177 spike_neg.n309 spike_neg.n299 4.5005
R4178 spike_neg.n311 spike_neg.n310 4.5005
R4179 spike_neg.n312 spike_neg.n297 4.5005
R4180 spike_neg.n314 spike_neg.n313 4.5005
R4181 spike_neg.n315 spike_neg.n296 4.5005
R4182 spike_neg.n317 spike_neg.n316 4.5005
R4183 spike_neg.n318 spike_neg.n294 4.5005
R4184 spike_neg.n320 spike_neg.n319 4.5005
R4185 spike_neg.n321 spike_neg.n293 4.5005
R4186 spike_neg.n323 spike_neg.n322 4.5005
R4187 spike_neg.n244 spike_neg.n243 4.5005
R4188 spike_neg.n369 spike_neg.n368 4.5005
R4189 spike_neg.n377 spike_neg.n236 4.5005
R4190 spike_neg.n378 spike_neg.n230 4.5005
R4191 spike_neg.n385 spike_neg.n384 4.5005
R4192 spike_neg.n388 spike_neg.n220 4.5005
R4193 spike_neg.n395 spike_neg.n394 4.5005
R4194 spike_neg.n221 spike_neg.n214 4.5005
R4195 spike_neg.n402 spike_neg.n209 4.5005
R4196 spike_neg.n409 spike_neg.n408 4.5005
R4197 spike_neg.n412 spike_neg.n200 4.5005
R4198 spike_neg.n419 spike_neg.n418 4.5005
R4199 spike_neg.n201 spike_neg.n194 4.5005
R4200 spike_neg.n428 spike_neg.n189 4.5005
R4201 spike_neg.n435 spike_neg.n434 4.5005
R4202 spike_neg.n438 spike_neg.n181 4.5005
R4203 spike_neg.n445 spike_neg.n444 4.5005
R4204 spike_neg.n448 spike_neg.n170 4.5005
R4205 spike_neg.n455 spike_neg.n454 4.5005
R4206 spike_neg.n171 spike_neg.n164 4.5005
R4207 spike_neg.n462 spike_neg.n159 4.5005
R4208 spike_neg.n469 spike_neg.n468 4.5005
R4209 spike_neg.n472 spike_neg.n148 4.5005
R4210 spike_neg.n479 spike_neg.n478 4.5005
R4211 spike_neg.n149 spike_neg.n142 4.5005
R4212 spike_neg.n484 spike_neg.n136 4.5005
R4213 spike_neg.n491 spike_neg.n490 4.5005
R4214 spike_neg.n137 spike_neg.n131 4.5005
R4215 spike_neg.n498 spike_neg.n125 4.5005
R4216 spike_neg.n504 spike_neg.n126 4.5005
R4217 spike_neg.n505 spike_neg.n124 4.5005
R4218 spike_neg.n508 spike_neg.n507 4.5005
R4219 spike_neg.n509 spike_neg.n123 4.5005
R4220 spike_neg.n511 spike_neg.n510 4.5005
R4221 spike_neg.n514 spike_neg.n122 4.5005
R4222 spike_neg.n516 spike_neg.n515 4.5005
R4223 spike_neg.n517 spike_neg.n121 4.5005
R4224 spike_neg.n555 spike_neg.n518 4.5005
R4225 spike_neg.n554 spike_neg.n519 4.5005
R4226 spike_neg.n553 spike_neg.n520 4.5005
R4227 spike_neg.n552 spike_neg.n521 4.5005
R4228 spike_neg.n550 spike_neg.n522 4.5005
R4229 spike_neg.n549 spike_neg.n523 4.5005
R4230 spike_neg.n526 spike_neg.n524 4.5005
R4231 spike_neg.n534 spike_neg.n527 4.5005
R4232 spike_neg.n533 spike_neg.n528 4.5005
R4233 spike_neg.n532 spike_neg.n529 4.5005
R4234 spike_neg.n531 spike_neg.n530 4.5005
R4235 spike_neg.n362 spike_neg.n361 4.5005
R4236 spike_neg.n104 spike_neg.n100 4.5005
R4237 spike_neg.n103 spike_neg.n102 4.5005
R4238 spike_neg.n570 spike_neg.n98 4.5005
R4239 spike_neg.n572 spike_neg.n571 4.5005
R4240 spike_neg.n601 spike_neg.n600 4.5005
R4241 spike_neg.n54 spike_neg.n53 4.5005
R4242 spike_neg.n28 spike_neg.n27 4.5005
R4243 spike_neg.n26 spike_neg.n25 4.5005
R4244 spike_neg.n628 spike_neg.n627 4.5005
R4245 spike_neg.n626 spike_neg.n625 4.5005
R4246 spike_neg.n11 spike_neg.n10 4.5005
R4247 spike_neg.n9 spike_neg.n8 4.5005
R4248 spike_neg.n613 spike_neg.n612 3.61362
R4249 spike_neg.n50 spike_neg.n43 3.61362
R4250 spike_neg.n30 spike_neg.n29 3.31679
R4251 spike_neg.n30 spike_neg.n24 3.31679
R4252 spike_neg.n32 spike_neg.n21 3.31679
R4253 spike_neg.n33 spike_neg.n32 3.31679
R4254 spike_neg.n630 spike_neg.n629 3.31679
R4255 spike_neg.n630 spike_neg.n624 3.31679
R4256 spike_neg.n632 spike_neg.n621 3.31679
R4257 spike_neg.n633 spike_neg.n632 3.31679
R4258 spike_neg.n12 spike_neg.n6 3.31679
R4259 spike_neg.n7 spike_neg.n6 3.31679
R4260 spike_neg.n15 spike_neg.n4 3.31679
R4261 spike_neg.n16 spike_neg.n15 3.31679
R4262 spike_neg.n616 spike_neg.n615 3.28078
R4263 spike_neg.n359 spike_neg.n358 3.26114
R4264 spike_neg.n615 spike_neg.n614 3.14293
R4265 spike_neg.n615 spike_neg.n38 3.14293
R4266 spike_neg.n437 spike_neg.n179 2.80819
R4267 spike_neg.n446 spike_neg.n179 2.80819
R4268 spike_neg.n364 spike_neg.n363 2.6735
R4269 spike_neg.n367 spike_neg.n366 2.4683
R4270 spike_neg.n609 spike_neg.n37 2.21557
R4271 spike_neg.n635 spike_neg.n634 2.21557
R4272 spike_neg.n18 spike_neg.n17 2.21557
R4273 spike_neg.n618 spike_neg.n34 2.21557
R4274 spike_neg.n358 spike_neg.n357 1.82789
R4275 spike_neg.n496 spike_neg.n37 1.23277
R4276 spike_neg.n620 Vss 1.0868
R4277 spike_neg.n22 spike_neg.n19 0.9005
R4278 spike_neg.n31 spike_neg.n22 0.9005
R4279 spike_neg.n23 spike_neg.n20 0.9005
R4280 spike_neg.n31 spike_neg.n23 0.9005
R4281 spike_neg.n622 spike_neg.n0 0.9005
R4282 spike_neg.n631 spike_neg.n622 0.9005
R4283 spike_neg.n623 spike_neg.n1 0.9005
R4284 spike_neg.n631 spike_neg.n623 0.9005
R4285 spike_neg.n13 spike_neg.n2 0.9005
R4286 spike_neg.n14 spike_neg.n13 0.9005
R4287 spike_neg.n5 spike_neg.n3 0.9005
R4288 spike_neg.n14 spike_neg.n5 0.9005
R4289 spike_neg.n58 spike_neg.n55 0.743357
R4290 spike_neg.n536 spike_neg.n58 0.743357
R4291 spike_neg.n78 spike_neg.n77 0.743357
R4292 spike_neg.n585 spike_neg.n78 0.743357
R4293 spike_neg.n567 spike_neg.n566 0.743357
R4294 spike_neg.n566 spike_neg.n565 0.743357
R4295 spike_neg.n101 spike_neg.n96 0.743357
R4296 spike_neg.n96 spike_neg.n83 0.743357
R4297 spike_neg.n603 spike_neg.n35 0.743357
R4298 spike_neg.n604 spike_neg.n603 0.743357
R4299 spike_neg.n39 spike_neg.n36 0.743357
R4300 spike_neg.n557 spike_neg.n39 0.743357
R4301 spike_neg.n367 spike_neg.n235 0.573125
R4302 spike_neg.n495 spike_neg.n132 0.483125
R4303 spike_neg.n375 spike_neg.n235 0.483125
R4304 spike_neg.n254 spike_neg.n250 0.473227
R4305 spike_neg.n587 spike_neg.n586 0.473227
R4306 spike_neg.n586 spike_neg.n585 0.473227
R4307 spike_neg.n363 spike_neg.n126 0.44735
R4308 spike_neg.n363 spike_neg.n132 0.393125
R4309 spike_neg.n619 spike_neg.n18 0.316383
R4310 spike_neg.n587 spike_neg.n69 0.29887
R4311 spike_neg.n482 spike_neg.n134 0.28625
R4312 spike_neg.n483 spike_neg.n482 0.28175
R4313 spike_neg.n481 spike_neg.n480 0.28175
R4314 spike_neg.n144 spike_neg.n143 0.28175
R4315 spike_neg.n458 spike_neg.n156 0.28175
R4316 spike_neg.n459 spike_neg.n158 0.28175
R4317 spike_neg.n461 spike_neg.n460 0.28175
R4318 spike_neg.n457 spike_neg.n456 0.28175
R4319 spike_neg.n166 spike_neg.n165 0.28175
R4320 spike_neg.n422 spike_neg.n177 0.28175
R4321 spike_neg.n423 spike_neg.n180 0.28175
R4322 spike_neg.n424 spike_neg.n186 0.28175
R4323 spike_neg.n425 spike_neg.n188 0.28175
R4324 spike_neg.n427 spike_neg.n426 0.28175
R4325 spike_neg.n421 spike_neg.n420 0.28175
R4326 spike_neg.n196 spike_neg.n195 0.28175
R4327 spike_neg.n398 spike_neg.n206 0.28175
R4328 spike_neg.n399 spike_neg.n208 0.28175
R4329 spike_neg.n401 spike_neg.n400 0.28175
R4330 spike_neg.n397 spike_neg.n396 0.28175
R4331 spike_neg.n216 spike_neg.n215 0.28175
R4332 spike_neg.n245 spike_neg.n227 0.28175
R4333 spike_neg.n246 spike_neg.n229 0.28175
R4334 spike_neg.n495 spike_neg.n494 0.26735
R4335 spike_neg.n589 spike_neg.n588 0.2255
R4336 spike_neg.n496 spike_neg.n495 0.219838
R4337 spike_neg.n375 spike_neg.n374 0.20615
R4338 spike_neg.n368 spike_neg.n367 0.20615
R4339 spike_neg.n599 spike_neg.n598 0.2057
R4340 spike_neg.n569 spike_neg.n568 0.2057
R4341 spike_neg.n620 spike_neg.n619 0.2057
R4342 spike_neg.n132 spike_neg.n99 0.1841
R4343 spike_neg.n179 spike_neg.n178 0.1684
R4344 spike_neg.n601 spike_neg.n53 0.1445
R4345 spike_neg.n572 spike_neg.n98 0.1445
R4346 spike_neg.n494 spike_neg.n87 0.1445
R4347 spike_neg.n88 spike_neg.n87 0.1445
R4348 spike_neg.n89 spike_neg.n88 0.1445
R4349 spike_neg.n113 spike_neg.n89 0.1445
R4350 spike_neg.n114 spike_neg.n113 0.1445
R4351 spike_neg.n115 spike_neg.n114 0.1445
R4352 spike_neg.n116 spike_neg.n115 0.1445
R4353 spike_neg.n118 spike_neg.n116 0.1445
R4354 spike_neg.n118 spike_neg.n117 0.1445
R4355 spike_neg.n596 spike_neg.n57 0.1445
R4356 spike_neg.n75 spike_neg.n74 0.1445
R4357 spike_neg.n76 spike_neg.n73 0.1445
R4358 spike_neg.n539 spike_neg.n47 0.1445
R4359 spike_neg.n540 spike_neg.n539 0.1445
R4360 spike_neg.n542 spike_neg.n540 0.1445
R4361 spike_neg.n542 spike_neg.n541 0.1445
R4362 spike_neg.n541 spike_neg.n67 0.1445
R4363 spike_neg.n589 spike_neg.n67 0.1445
R4364 spike_neg.n126 spike_neg.n124 0.1445
R4365 spike_neg.n508 spike_neg.n124 0.1445
R4366 spike_neg.n509 spike_neg.n508 0.1445
R4367 spike_neg.n510 spike_neg.n509 0.1445
R4368 spike_neg.n510 spike_neg.n122 0.1445
R4369 spike_neg.n516 spike_neg.n122 0.1445
R4370 spike_neg.n517 spike_neg.n516 0.1445
R4371 spike_neg.n518 spike_neg.n517 0.1445
R4372 spike_neg.n519 spike_neg.n518 0.1445
R4373 spike_neg.n520 spike_neg.n519 0.1445
R4374 spike_neg.n521 spike_neg.n520 0.1445
R4375 spike_neg.n522 spike_neg.n521 0.1445
R4376 spike_neg.n523 spike_neg.n522 0.1445
R4377 spike_neg.n526 spike_neg.n523 0.1445
R4378 spike_neg.n527 spike_neg.n526 0.1445
R4379 spike_neg.n528 spike_neg.n527 0.1445
R4380 spike_neg.n529 spike_neg.n528 0.1445
R4381 spike_neg.n530 spike_neg.n529 0.1445
R4382 spike_neg.n356 spike_neg.n355 0.1445
R4383 spike_neg.n355 spike_neg.n256 0.1445
R4384 spike_neg.n351 spike_neg.n256 0.1445
R4385 spike_neg.n351 spike_neg.n258 0.1445
R4386 spike_neg.n345 spike_neg.n258 0.1445
R4387 spike_neg.n345 spike_neg.n344 0.1445
R4388 spike_neg.n344 spike_neg.n343 0.1445
R4389 spike_neg.n343 spike_neg.n270 0.1445
R4390 spike_neg.n337 spike_neg.n270 0.1445
R4391 spike_neg.n337 spike_neg.n336 0.1445
R4392 spike_neg.n336 spike_neg.n335 0.1445
R4393 spike_neg.n335 spike_neg.n281 0.1445
R4394 spike_neg.n329 spike_neg.n281 0.1445
R4395 spike_neg.n329 spike_neg.n328 0.1445
R4396 spike_neg.n328 spike_neg.n327 0.1445
R4397 spike_neg.n327 spike_neg.n238 0.1445
R4398 spike_neg.n373 spike_neg.n238 0.1445
R4399 spike_neg.n373 spike_neg.n234 0.1445
R4400 spike_neg.n379 spike_neg.n234 0.1445
R4401 spike_neg.n379 spike_neg.n226 0.1445
R4402 spike_neg.n389 spike_neg.n226 0.1445
R4403 spike_neg.n389 spike_neg.n217 0.1445
R4404 spike_neg.n217 spike_neg.n213 0.1445
R4405 spike_neg.n403 spike_neg.n213 0.1445
R4406 spike_neg.n403 spike_neg.n205 0.1445
R4407 spike_neg.n413 spike_neg.n205 0.1445
R4408 spike_neg.n413 spike_neg.n197 0.1445
R4409 spike_neg.n197 spike_neg.n193 0.1445
R4410 spike_neg.n429 spike_neg.n193 0.1445
R4411 spike_neg.n429 spike_neg.n185 0.1445
R4412 spike_neg.n439 spike_neg.n185 0.1445
R4413 spike_neg.n439 spike_neg.n176 0.1445
R4414 spike_neg.n449 spike_neg.n176 0.1445
R4415 spike_neg.n449 spike_neg.n167 0.1445
R4416 spike_neg.n167 spike_neg.n163 0.1445
R4417 spike_neg.n463 spike_neg.n163 0.1445
R4418 spike_neg.n463 spike_neg.n155 0.1445
R4419 spike_neg.n473 spike_neg.n155 0.1445
R4420 spike_neg.n473 spike_neg.n145 0.1445
R4421 spike_neg.n145 spike_neg.n141 0.1445
R4422 spike_neg.n485 spike_neg.n141 0.1445
R4423 spike_neg.n485 spike_neg.n135 0.1445
R4424 spike_neg.n135 spike_neg.n130 0.1445
R4425 spike_neg.n499 spike_neg.n130 0.1445
R4426 spike_neg.n499 spike_neg.n86 0.1445
R4427 spike_neg.n579 spike_neg.n86 0.1445
R4428 spike_neg.n579 spike_neg.n578 0.1445
R4429 spike_neg.n578 spike_neg.n577 0.1445
R4430 spike_neg.n577 spike_neg.n90 0.1445
R4431 spike_neg.n112 spike_neg.n90 0.1445
R4432 spike_neg.n562 spike_neg.n112 0.1445
R4433 spike_neg.n562 spike_neg.n561 0.1445
R4434 spike_neg.n561 spike_neg.n560 0.1445
R4435 spike_neg.n560 spike_neg.n46 0.1445
R4436 spike_neg.n610 spike_neg.n46 0.1445
R4437 spike_neg.n608 spike_neg.n607 0.1445
R4438 spike_neg.n607 spike_neg.n48 0.1445
R4439 spike_neg.n544 spike_neg.n48 0.1445
R4440 spike_neg.n544 spike_neg.n543 0.1445
R4441 spike_neg.n543 spike_neg.n66 0.1445
R4442 spike_neg.n591 spike_neg.n66 0.1445
R4443 spike_neg.n591 spike_neg.n590 0.1445
R4444 spike_neg.n354 spike_neg.n255 0.1445
R4445 spike_neg.n354 spike_neg.n353 0.1445
R4446 spike_neg.n353 spike_neg.n352 0.1445
R4447 spike_neg.n352 spike_neg.n257 0.1445
R4448 spike_neg.n267 spike_neg.n257 0.1445
R4449 spike_neg.n268 spike_neg.n267 0.1445
R4450 spike_neg.n269 spike_neg.n268 0.1445
R4451 spike_neg.n277 spike_neg.n269 0.1445
R4452 spike_neg.n278 spike_neg.n277 0.1445
R4453 spike_neg.n279 spike_neg.n278 0.1445
R4454 spike_neg.n280 spike_neg.n279 0.1445
R4455 spike_neg.n288 spike_neg.n280 0.1445
R4456 spike_neg.n289 spike_neg.n288 0.1445
R4457 spike_neg.n290 spike_neg.n289 0.1445
R4458 spike_neg.n291 spike_neg.n290 0.1445
R4459 spike_neg.n291 spike_neg.n237 0.1445
R4460 spike_neg.n374 spike_neg.n237 0.1445
R4461 spike_neg.n362 spike_neg.n248 0.1445
R4462 spike_neg.n303 spike_neg.n248 0.1445
R4463 spike_neg.n304 spike_neg.n303 0.1445
R4464 spike_neg.n304 spike_neg.n300 0.1445
R4465 spike_neg.n308 spike_neg.n300 0.1445
R4466 spike_neg.n309 spike_neg.n308 0.1445
R4467 spike_neg.n310 spike_neg.n309 0.1445
R4468 spike_neg.n310 spike_neg.n297 0.1445
R4469 spike_neg.n314 spike_neg.n297 0.1445
R4470 spike_neg.n315 spike_neg.n314 0.1445
R4471 spike_neg.n316 spike_neg.n315 0.1445
R4472 spike_neg.n316 spike_neg.n294 0.1445
R4473 spike_neg.n320 spike_neg.n294 0.1445
R4474 spike_neg.n321 spike_neg.n320 0.1445
R4475 spike_neg.n322 spike_neg.n321 0.1445
R4476 spike_neg.n322 spike_neg.n244 0.1445
R4477 spike_neg.n368 spike_neg.n244 0.1445
R4478 spike_neg.n361 spike_neg.n249 0.1445
R4479 spike_neg.n302 spike_neg.n249 0.1445
R4480 spike_neg.n305 spike_neg.n302 0.1445
R4481 spike_neg.n306 spike_neg.n305 0.1445
R4482 spike_neg.n307 spike_neg.n306 0.1445
R4483 spike_neg.n307 spike_neg.n299 0.1445
R4484 spike_neg.n311 spike_neg.n299 0.1445
R4485 spike_neg.n312 spike_neg.n311 0.1445
R4486 spike_neg.n313 spike_neg.n312 0.1445
R4487 spike_neg.n313 spike_neg.n296 0.1445
R4488 spike_neg.n317 spike_neg.n296 0.1445
R4489 spike_neg.n318 spike_neg.n317 0.1445
R4490 spike_neg.n319 spike_neg.n318 0.1445
R4491 spike_neg.n319 spike_neg.n293 0.1445
R4492 spike_neg.n323 spike_neg.n293 0.1445
R4493 spike_neg.n323 spike_neg.n243 0.1445
R4494 spike_neg.n369 spike_neg.n243 0.1445
R4495 spike_neg.n369 spike_neg.n236 0.1445
R4496 spike_neg.n236 spike_neg.n230 0.1445
R4497 spike_neg.n384 spike_neg.n230 0.1445
R4498 spike_neg.n384 spike_neg.n220 0.1445
R4499 spike_neg.n394 spike_neg.n220 0.1445
R4500 spike_neg.n394 spike_neg.n221 0.1445
R4501 spike_neg.n221 spike_neg.n209 0.1445
R4502 spike_neg.n408 spike_neg.n209 0.1445
R4503 spike_neg.n408 spike_neg.n200 0.1445
R4504 spike_neg.n418 spike_neg.n200 0.1445
R4505 spike_neg.n418 spike_neg.n201 0.1445
R4506 spike_neg.n201 spike_neg.n189 0.1445
R4507 spike_neg.n434 spike_neg.n189 0.1445
R4508 spike_neg.n434 spike_neg.n181 0.1445
R4509 spike_neg.n444 spike_neg.n181 0.1445
R4510 spike_neg.n444 spike_neg.n170 0.1445
R4511 spike_neg.n454 spike_neg.n170 0.1445
R4512 spike_neg.n454 spike_neg.n171 0.1445
R4513 spike_neg.n171 spike_neg.n159 0.1445
R4514 spike_neg.n468 spike_neg.n159 0.1445
R4515 spike_neg.n468 spike_neg.n148 0.1445
R4516 spike_neg.n478 spike_neg.n148 0.1445
R4517 spike_neg.n478 spike_neg.n149 0.1445
R4518 spike_neg.n149 spike_neg.n136 0.1445
R4519 spike_neg.n490 spike_neg.n136 0.1445
R4520 spike_neg.n490 spike_neg.n137 0.1445
R4521 spike_neg.n137 spike_neg.n125 0.1445
R4522 spike_neg.n504 spike_neg.n125 0.1445
R4523 spike_neg.n505 spike_neg.n504 0.1445
R4524 spike_neg.n507 spike_neg.n505 0.1445
R4525 spike_neg.n507 spike_neg.n123 0.1445
R4526 spike_neg.n511 spike_neg.n123 0.1445
R4527 spike_neg.n514 spike_neg.n511 0.1445
R4528 spike_neg.n515 spike_neg.n514 0.1445
R4529 spike_neg.n515 spike_neg.n121 0.1445
R4530 spike_neg.n555 spike_neg.n121 0.1445
R4531 spike_neg.n555 spike_neg.n554 0.1445
R4532 spike_neg.n554 spike_neg.n553 0.1445
R4533 spike_neg.n553 spike_neg.n552 0.1445
R4534 spike_neg.n552 spike_neg.n550 0.1445
R4535 spike_neg.n550 spike_neg.n549 0.1445
R4536 spike_neg.n549 spike_neg.n524 0.1445
R4537 spike_neg.n534 spike_neg.n524 0.1445
R4538 spike_neg.n534 spike_neg.n533 0.1445
R4539 spike_neg.n533 spike_neg.n532 0.1445
R4540 spike_neg.n532 spike_neg.n531 0.1445
R4541 spike_neg.n104 spike_neg.n103 0.1445
R4542 spike_neg.n102 spike_neg.n100 0.1445
R4543 spike_neg.n28 spike_neg.n25 0.1445
R4544 spike_neg.n27 spike_neg.n26 0.1445
R4545 spike_neg.n628 spike_neg.n625 0.1445
R4546 spike_neg.n627 spike_neg.n626 0.1445
R4547 spike_neg.n11 spike_neg.n8 0.1445
R4548 spike_neg.n10 spike_neg.n9 0.1445
R4549 spike_neg.n635 spike_neg.n620 0.111183
R4550 spike_neg.n619 spike_neg.n618 0.111183
R4551 spike_neg.n616 spike_neg.n37 0.107176
R4552 spike_neg.n610 spike_neg.n609 0.0718661
R4553 spike_neg.n609 spike_neg.n608 0.0718661
R4554 spike_neg.n47 spike_neg.n37 0.0671
R4555 spike_neg.n117 spike_neg.n37 0.0599
R4556 Vss spike_neg.n362 0.0599
R4557 Vss spike_neg.n635 0.0577669
R4558 spike_neg.n617 Vss 0.0507793
R4559 Vss spike_neg.n247 0.0490611
R4560 spike_neg.n366 Vss 0.0455
R4561 spike_neg.n598 spike_neg.n597 0.0298531
R4562 spike_neg.n68 spike_neg.n56 0.0298531
R4563 spike_neg.n571 spike_neg.n99 0.0298531
R4564 spike_neg.n570 spike_neg.n569 0.0298531
R4565 spike_neg.n568 spike_neg.n54 0.0298531
R4566 spike_neg.n600 spike_neg.n599 0.0298531
R4567 spike_neg.n597 spike_neg.n56 0.019907
R4568 spike_neg.n571 spike_neg.n570 0.019907
R4569 spike_neg.n600 spike_neg.n54 0.019907
R4570 spike_neg.n618 spike_neg.n617 0.00748758
R4571 spike_neg.n246 spike_neg.n245 0.005
R4572 spike_neg.n245 spike_neg.n215 0.005
R4573 spike_neg.n397 spike_neg.n215 0.005
R4574 spike_neg.n400 spike_neg.n397 0.005
R4575 spike_neg.n400 spike_neg.n399 0.005
R4576 spike_neg.n399 spike_neg.n398 0.005
R4577 spike_neg.n398 spike_neg.n195 0.005
R4578 spike_neg.n421 spike_neg.n195 0.005
R4579 spike_neg.n426 spike_neg.n421 0.005
R4580 spike_neg.n426 spike_neg.n425 0.005
R4581 spike_neg.n425 spike_neg.n424 0.005
R4582 spike_neg.n424 spike_neg.n423 0.005
R4583 spike_neg.n423 spike_neg.n422 0.005
R4584 spike_neg.n422 spike_neg.n165 0.005
R4585 spike_neg.n457 spike_neg.n165 0.005
R4586 spike_neg.n460 spike_neg.n457 0.005
R4587 spike_neg.n460 spike_neg.n459 0.005
R4588 spike_neg.n459 spike_neg.n458 0.005
R4589 spike_neg.n458 spike_neg.n143 0.005
R4590 spike_neg.n481 spike_neg.n143 0.005
R4591 spike_neg.n482 spike_neg.n481 0.005
R4592 spike_neg.n378 spike_neg.n377 0.00389783
R4593 spike_neg.n491 spike_neg.n131 0.00389783
R4594 spike_neg.n498 spike_neg.n131 0.00389783
R4595 spike_neg.n378 spike_neg.n229 0.00317579
R4596 spike_neg.n385 spike_neg.n227 0.00317579
R4597 spike_neg.n388 spike_neg.n216 0.00317579
R4598 spike_neg.n396 spike_neg.n395 0.00317579
R4599 spike_neg.n401 spike_neg.n214 0.00317579
R4600 spike_neg.n402 spike_neg.n208 0.00317579
R4601 spike_neg.n409 spike_neg.n206 0.00317579
R4602 spike_neg.n412 spike_neg.n196 0.00317579
R4603 spike_neg.n420 spike_neg.n419 0.00317579
R4604 spike_neg.n427 spike_neg.n194 0.00317579
R4605 spike_neg.n428 spike_neg.n188 0.00317579
R4606 spike_neg.n435 spike_neg.n186 0.00317579
R4607 spike_neg.n445 spike_neg.n177 0.00317579
R4608 spike_neg.n448 spike_neg.n166 0.00317579
R4609 spike_neg.n456 spike_neg.n455 0.00317579
R4610 spike_neg.n461 spike_neg.n164 0.00317579
R4611 spike_neg.n462 spike_neg.n158 0.00317579
R4612 spike_neg.n469 spike_neg.n156 0.00317579
R4613 spike_neg.n472 spike_neg.n144 0.00317579
R4614 spike_neg.n480 spike_neg.n479 0.00317579
R4615 spike_neg.n483 spike_neg.n142 0.00317579
R4616 spike_neg.n484 spike_neg.n134 0.00317579
R4617 spike_neg.n438 Vss 0.00219891
R4618 spike_neg.n377 spike_neg.n235 0.0020715
R4619 Vss spike_neg.n180 0.00147688
R4620 spike_neg.n385 spike_neg.n229 0.00122204
R4621 spike_neg.n388 spike_neg.n227 0.00122204
R4622 spike_neg.n395 spike_neg.n216 0.00122204
R4623 spike_neg.n396 spike_neg.n214 0.00122204
R4624 spike_neg.n402 spike_neg.n401 0.00122204
R4625 spike_neg.n409 spike_neg.n208 0.00122204
R4626 spike_neg.n412 spike_neg.n206 0.00122204
R4627 spike_neg.n419 spike_neg.n196 0.00122204
R4628 spike_neg.n420 spike_neg.n194 0.00122204
R4629 spike_neg.n428 spike_neg.n427 0.00122204
R4630 spike_neg.n435 spike_neg.n188 0.00122204
R4631 spike_neg.n438 spike_neg.n186 0.00122204
R4632 spike_neg.n445 spike_neg.n180 0.00122204
R4633 spike_neg.n448 spike_neg.n177 0.00122204
R4634 spike_neg.n455 spike_neg.n166 0.00122204
R4635 spike_neg.n456 spike_neg.n164 0.00122204
R4636 spike_neg.n462 spike_neg.n461 0.00122204
R4637 spike_neg.n469 spike_neg.n158 0.00122204
R4638 spike_neg.n472 spike_neg.n156 0.00122204
R4639 spike_neg.n479 spike_neg.n144 0.00122204
R4640 spike_neg.n480 spike_neg.n142 0.00122204
R4641 spike_neg.n484 spike_neg.n483 0.00122204
R4642 spike_neg.n491 spike_neg.n134 0.00122204
R4643 spike_neg.n498 spike_neg.n132 0.000627419
R4644 spike.n549 spike.n44 18200
R4645 spike.n548 spike.n45 18200
R4646 spike.n550 spike.n549 14238.8
R4647 spike.n549 spike.n548 4468.75
R4648 spike.n548 spike.n547 4062.5
R4649 spike.n614 spike.n613 521.494
R4650 spike.n613 spike.n612 521.494
R4651 spike.n597 spike.n596 521.494
R4652 spike.n596 spike.n588 521.494
R4653 spike.n631 spike.n630 521.494
R4654 spike.n630 spike.n629 521.494
R4655 spike.n550 spike.n36 229.434
R4656 spike.n540 spike.n57 144.525
R4657 spike.n529 spike.n74 144.525
R4658 spike.n570 spike.n15 144.525
R4659 spike.n511 spike.n502 144.525
R4660 spike.n578 spike.n5 140.912
R4661 spike.n577 spike.n8 140.912
R4662 spike.n523 spike.n45 139.106
R4663 spike.n44 spike.n17 131.88
R4664 spike.n539 spike.n60 130.072
R4665 spike.n72 spike.n71 130.072
R4666 spike.n501 spike.n25 128.267
R4667 spike.n559 spike.n25 122.847
R4668 spike.n558 spike.n28 122.847
R4669 spike.n530 spike.n72 121.04
R4670 spike.n522 spike.n5 110.201
R4671 spike.n570 spike.n569 102.975
R4672 spike.n324 spike.n217 94.2375
R4673 spike.n226 spike.n217 94.2375
R4674 spike.n314 spike.n226 94.2375
R4675 spike.n314 spike.n313 94.2375
R4676 spike.n313 spike.n312 94.2375
R4677 spike.n312 spike.n230 94.2375
R4678 spike.n306 spike.n230 94.2375
R4679 spike.n306 spike.n305 94.2375
R4680 spike.n305 spike.n304 94.2375
R4681 spike.n304 spike.n240 94.2375
R4682 spike.n298 spike.n240 94.2375
R4683 spike.n298 spike.n297 94.2375
R4684 spike.n297 spike.n296 94.2375
R4685 spike.n296 spike.n251 94.2375
R4686 spike.n290 spike.n251 94.2375
R4687 spike.n290 spike.n205 94.2375
R4688 spike.n336 spike.n205 94.2375
R4689 spike.n336 spike.n197 94.2375
R4690 spike.n346 spike.n197 94.2375
R4691 spike.n347 spike.n346 94.2375
R4692 spike.n347 spike.n189 94.2375
R4693 spike.n357 spike.n189 94.2375
R4694 spike.n357 spike.n176 94.2375
R4695 spike.n370 spike.n176 94.2375
R4696 spike.n371 spike.n370 94.2375
R4697 spike.n371 spike.n168 94.2375
R4698 spike.n381 spike.n168 94.2375
R4699 spike.n381 spike.n156 94.2375
R4700 spike.n396 spike.n156 94.2375
R4701 spike.n396 spike.n148 94.2375
R4702 spike.n406 spike.n148 94.2375
R4703 spike.n407 spike.n406 94.2375
R4704 spike.n407 spike.n139 94.2375
R4705 spike.n417 spike.n139 94.2375
R4706 spike.n417 spike.n126 94.2375
R4707 spike.n430 spike.n126 94.2375
R4708 spike.n431 spike.n430 94.2375
R4709 spike.n431 spike.n117 94.2375
R4710 spike.n441 spike.n117 94.2375
R4711 spike.n441 spike.n118 94.2375
R4712 spike.n118 spike.n104 94.2375
R4713 spike.n453 spike.n104 94.2375
R4714 spike.n453 spike.n93 94.2375
R4715 spike.n466 spike.n93 94.2375
R4716 spike.n466 spike.n46 94.2375
R4717 spike.n57 spike.n48 92.135
R4718 spike.n551 spike.n35 84.0977
R4719 spike.n551 spike.n30 84.0977
R4720 spike.n325 spike.n215 84.0977
R4721 spike.n547 spike.n46 74.2122
R4722 spike.n43 spike.n37 69.0283
R4723 spike.n43 spike.n24 69.0283
R4724 spike.n560 spike.n23 69.0283
R4725 spike.n26 spike.n23 69.0283
R4726 spike.n61 spike.n59 69.0283
R4727 spike.n531 spike.n70 69.0283
R4728 spike.n538 spike.n61 69.0283
R4729 spike.n531 spike.n62 69.0283
R4730 spike.n568 spike.n3 69.0283
R4731 spike.n568 spike.n567 69.0283
R4732 spike.n6 spike.n4 69.0283
R4733 spike.n579 spike.n4 69.0283
R4734 spike.n615 spike.n604 62.1255
R4735 spike.n611 spike.n604 62.1255
R4736 spike.n606 spike.n605 62.1255
R4737 spike.n605 spike.n603 62.1255
R4738 spike.n595 spike.n586 62.1255
R4739 spike.n595 spike.n594 62.1255
R4740 spike.n589 spike.n587 62.1255
R4741 spike.n598 spike.n587 62.1255
R4742 spike.n632 spike.n621 62.1255
R4743 spike.n628 spike.n621 62.1255
R4744 spike.n623 spike.n622 62.1255
R4745 spike.n622 spike.n620 62.1255
R4746 spike.n323 spike.n215 52.7258
R4747 spike.n546 spike.n48 52.3907
R4748 spike.n569 spike.n17 41.5514
R4749 spike.n523 spike.n522 34.3251
R4750 spike.n547 spike.n546 30.712
R4751 spike.n530 spike.n529 23.4858
R4752 spike.n559 spike.n558 21.6792
R4753 spike.n36 spike.n28 21.6792
R4754 spike.n502 spike.n501 16.2595
R4755 spike.n560 spike.n24 15.5561
R4756 spike.n37 spike.n26 15.5561
R4757 spike.n322 spike.n218 15.5561
R4758 spike.n224 spike.n218 15.5561
R4759 spike.n315 spike.n224 15.5561
R4760 spike.n315 spike.n225 15.5561
R4761 spike.n311 spike.n225 15.5561
R4762 spike.n311 spike.n231 15.5561
R4763 spike.n307 spike.n231 15.5561
R4764 spike.n307 spike.n236 15.5561
R4765 spike.n303 spike.n236 15.5561
R4766 spike.n303 spike.n241 15.5561
R4767 spike.n299 spike.n241 15.5561
R4768 spike.n299 spike.n247 15.5561
R4769 spike.n295 spike.n247 15.5561
R4770 spike.n295 spike.n252 15.5561
R4771 spike.n291 spike.n252 15.5561
R4772 spike.n291 spike.n204 15.5561
R4773 spike.n337 spike.n204 15.5561
R4774 spike.n337 spike.n198 15.5561
R4775 spike.n345 spike.n198 15.5561
R4776 spike.n345 spike.n190 15.5561
R4777 spike.n355 spike.n190 15.5561
R4778 spike.n356 spike.n355 15.5561
R4779 spike.n356 spike.n177 15.5561
R4780 spike.n369 spike.n177 15.5561
R4781 spike.n369 spike.n169 15.5561
R4782 spike.n379 spike.n169 15.5561
R4783 spike.n380 spike.n379 15.5561
R4784 spike.n380 spike.n157 15.5561
R4785 spike.n395 spike.n157 15.5561
R4786 spike.n395 spike.n149 15.5561
R4787 spike.n405 spike.n149 15.5561
R4788 spike.n405 spike.n140 15.5561
R4789 spike.n415 spike.n140 15.5561
R4790 spike.n416 spike.n415 15.5561
R4791 spike.n416 spike.n127 15.5561
R4792 spike.n429 spike.n127 15.5561
R4793 spike.n429 spike.n119 15.5561
R4794 spike.n439 spike.n119 15.5561
R4795 spike.n440 spike.n439 15.5561
R4796 spike.n440 spike.n105 15.5561
R4797 spike.n451 spike.n105 15.5561
R4798 spike.n452 spike.n451 15.5561
R4799 spike.n452 spike.n94 15.5561
R4800 spike.n465 spike.n94 15.5561
R4801 spike.n465 spike.n49 15.5561
R4802 spike.n545 spike.n49 15.5561
R4803 spike.n545 spike.n50 15.5561
R4804 spike.n541 spike.n50 15.5561
R4805 spike.n541 spike.n56 15.5561
R4806 spike.n75 spike.n56 15.5561
R4807 spike.n528 spike.n75 15.5561
R4808 spike.n528 spike.n76 15.5561
R4809 spike.n524 spike.n76 15.5561
R4810 spike.n524 spike.n9 15.5561
R4811 spike.n576 spike.n9 15.5561
R4812 spike.n576 spike.n10 15.5561
R4813 spike.n571 spike.n10 15.5561
R4814 spike.n571 spike.n14 15.5561
R4815 spike.n510 spike.n14 15.5561
R4816 spike.n510 spike.n503 15.5561
R4817 spike.n503 spike.n29 15.5561
R4818 spike.n557 spike.n29 15.5561
R4819 spike.n557 spike.n30 15.5561
R4820 spike.n325 spike.n216 15.5561
R4821 spike.n266 spike.n216 15.5561
R4822 spike.n266 spike.n227 15.5561
R4823 spike.n228 spike.n227 15.5561
R4824 spike.n229 spike.n228 15.5561
R4825 spike.n263 spike.n229 15.5561
R4826 spike.n263 spike.n237 15.5561
R4827 spike.n238 spike.n237 15.5561
R4828 spike.n239 spike.n238 15.5561
R4829 spike.n260 spike.n239 15.5561
R4830 spike.n260 spike.n248 15.5561
R4831 spike.n249 spike.n248 15.5561
R4832 spike.n250 spike.n249 15.5561
R4833 spike.n257 spike.n250 15.5561
R4834 spike.n289 spike.n257 15.5561
R4835 spike.n289 spike.n206 15.5561
R4836 spike.n335 spike.n206 15.5561
R4837 spike.n335 spike.n207 15.5561
R4838 spike.n207 spike.n196 15.5561
R4839 spike.n348 spike.n196 15.5561
R4840 spike.n348 spike.n187 15.5561
R4841 spike.n358 spike.n187 15.5561
R4842 spike.n358 spike.n188 15.5561
R4843 spike.n188 spike.n175 15.5561
R4844 spike.n372 spike.n175 15.5561
R4845 spike.n372 spike.n167 15.5561
R4846 spike.n382 spike.n167 15.5561
R4847 spike.n382 spike.n155 15.5561
R4848 spike.n397 spike.n155 15.5561
R4849 spike.n398 spike.n397 15.5561
R4850 spike.n398 spike.n147 15.5561
R4851 spike.n408 spike.n147 15.5561
R4852 spike.n408 spike.n137 15.5561
R4853 spike.n418 spike.n137 15.5561
R4854 spike.n418 spike.n138 15.5561
R4855 spike.n138 spike.n125 15.5561
R4856 spike.n432 spike.n125 15.5561
R4857 spike.n432 spike.n115 15.5561
R4858 spike.n442 spike.n115 15.5561
R4859 spike.n442 spike.n116 15.5561
R4860 spike.n116 spike.n103 15.5561
R4861 spike.n454 spike.n103 15.5561
R4862 spike.n454 spike.n92 15.5561
R4863 spike.n467 spike.n92 15.5561
R4864 spike.n468 spike.n467 15.5561
R4865 spike.n468 spike.n47 15.5561
R4866 spike.n471 spike.n47 15.5561
R4867 spike.n471 spike.n58 15.5561
R4868 spike.n477 spike.n58 15.5561
R4869 spike.n478 spike.n477 15.5561
R4870 spike.n478 spike.n73 15.5561
R4871 spike.n84 spike.n73 15.5561
R4872 spike.n521 spike.n84 15.5561
R4873 spike.n521 spike.n85 15.5561
R4874 spike.n85 spike.n7 15.5561
R4875 spike.n516 spike.n7 15.5561
R4876 spike.n516 spike.n16 15.5561
R4877 spike.n513 spike.n16 15.5561
R4878 spike.n513 spike.n512 15.5561
R4879 spike.n512 spike.n500 15.5561
R4880 spike.n500 spike.n490 15.5561
R4881 spike.n490 spike.n27 15.5561
R4882 spike.n35 spike.n27 15.5561
R4883 spike.n70 spike.n59 15.5561
R4884 spike.n538 spike.n62 15.5561
R4885 spike.n567 spike.n6 15.5561
R4886 spike.n540 spike.n539 14.453
R4887 spike.n71 spike.n60 14.453
R4888 spike.n511 spike.n44 12.6464
R4889 spike.n463 spike.n462 12.5005
R4890 spike.n458 spike.n96 12.5005
R4891 spike.n457 spike.n456 12.5005
R4892 spike.n449 spike.n98 12.5005
R4893 spike.n111 spike.n107 12.5005
R4894 spike.n444 spike.n112 12.5005
R4895 spike.n437 spike.n436 12.5005
R4896 spike.n435 spike.n434 12.5005
R4897 spike.n427 spike.n122 12.5005
R4898 spike.n133 spike.n129 12.5005
R4899 spike.n420 spike.n134 12.5005
R4900 spike.n413 spike.n412 12.5005
R4901 spike.n411 spike.n410 12.5005
R4902 spike.n403 spike.n402 12.5005
R4903 spike.n401 spike.n400 12.5005
R4904 spike.n393 spike.n152 12.5005
R4905 spike.n163 spike.n159 12.5005
R4906 spike.n384 spike.n164 12.5005
R4907 spike.n377 spike.n376 12.5005
R4908 spike.n375 spike.n374 12.5005
R4909 spike.n367 spike.n172 12.5005
R4910 spike.n183 spike.n179 12.5005
R4911 spike.n360 spike.n184 12.5005
R4912 spike.n353 spike.n352 12.5005
R4913 spike.n351 spike.n350 12.5005
R4914 spike.n343 spike.n193 12.5005
R4915 spike.n342 spike.n341 12.5005
R4916 spike.n635 spike.n581 12.0394
R4917 spike.n341 spike.n340 11.7031
R4918 spike.n462 spike.n461 11.545
R4919 spike.n553 spike.n33 10.9121
R4920 spike.n331 spike.n330 7.89186
R4921 spike.n330 spike.n329 7.73533
R4922 spike.n212 spike.n211 7.57378
R4923 spike.n616 spike.n615 6.37187
R4924 spike.n616 spike.n603 6.37187
R4925 spike.n599 spike.n598 6.37187
R4926 spike.n599 spike.n586 6.37187
R4927 spike.n633 spike.n632 6.37187
R4928 spike.n633 spike.n620 6.37187
R4929 spike.n611 spike.n610 6.3005
R4930 spike.n607 spike.n606 6.3005
R4931 spike.n594 spike.n593 6.3005
R4932 spike.n590 spike.n589 6.3005
R4933 spike.n628 spike.n627 6.3005
R4934 spike.n624 spike.n623 6.3005
R4935 spike.n341 spike.n193 5.61588
R4936 spike.n351 spike.n193 5.61588
R4937 spike.n352 spike.n351 5.61588
R4938 spike.n352 spike.n184 5.61588
R4939 spike.n184 spike.n183 5.61588
R4940 spike.n183 spike.n172 5.61588
R4941 spike.n375 spike.n172 5.61588
R4942 spike.n376 spike.n375 5.61588
R4943 spike.n376 spike.n164 5.61588
R4944 spike.n164 spike.n163 5.61588
R4945 spike.n163 spike.n152 5.61588
R4946 spike.n401 spike.n152 5.61588
R4947 spike.n402 spike.n401 5.61588
R4948 spike.n412 spike.n411 5.61588
R4949 spike.n412 spike.n134 5.61588
R4950 spike.n134 spike.n133 5.61588
R4951 spike.n133 spike.n122 5.61588
R4952 spike.n435 spike.n122 5.61588
R4953 spike.n436 spike.n435 5.61588
R4954 spike.n436 spike.n112 5.61588
R4955 spike.n112 spike.n111 5.61588
R4956 spike.n111 spike.n98 5.61588
R4957 spike.n457 spike.n98 5.61588
R4958 spike.n458 spike.n457 5.61588
R4959 spike.n462 spike.n458 5.61588
R4960 spike.n74 spike.n45 5.42018
R4961 spike.n220 spike.n219 5.35452
R4962 spike.n608 spike.n602 5.20101
R4963 spike.n609 spike.n601 5.20101
R4964 spike.n591 spike.n585 5.20101
R4965 spike.n592 spike.n584 5.20101
R4966 spike.n625 spike.n583 5.20101
R4967 spike.n626 spike.n582 5.20101
R4968 spike.n38 spike.n20 5.20101
R4969 spike.n67 spike.n66 5.20101
R4970 spike.n469 spike.n468 5.2005
R4971 spike.n468 spike.n46 5.2005
R4972 spike.n467 spike.n90 5.2005
R4973 spike.n467 spike.n466 5.2005
R4974 spike.n102 spike.n92 5.2005
R4975 spike.n93 spike.n92 5.2005
R4976 spike.n455 spike.n454 5.2005
R4977 spike.n454 spike.n453 5.2005
R4978 spike.n103 spike.n101 5.2005
R4979 spike.n104 spike.n103 5.2005
R4980 spike.n116 spike.n114 5.2005
R4981 spike.n118 spike.n116 5.2005
R4982 spike.n443 spike.n442 5.2005
R4983 spike.n442 spike.n441 5.2005
R4984 spike.n115 spike.n113 5.2005
R4985 spike.n117 spike.n115 5.2005
R4986 spike.n433 spike.n432 5.2005
R4987 spike.n432 spike.n431 5.2005
R4988 spike.n125 spike.n124 5.2005
R4989 spike.n430 spike.n125 5.2005
R4990 spike.n138 spike.n136 5.2005
R4991 spike.n138 spike.n126 5.2005
R4992 spike.n419 spike.n418 5.2005
R4993 spike.n418 spike.n417 5.2005
R4994 spike.n137 spike.n135 5.2005
R4995 spike.n139 spike.n137 5.2005
R4996 spike.n409 spike.n408 5.2005
R4997 spike.n408 spike.n407 5.2005
R4998 spike.n147 spike.n146 5.2005
R4999 spike.n406 spike.n147 5.2005
R5000 spike.n399 spike.n398 5.2005
R5001 spike.n398 spike.n148 5.2005
R5002 spike.n397 spike.n154 5.2005
R5003 spike.n397 spike.n396 5.2005
R5004 spike.n166 spike.n155 5.2005
R5005 spike.n156 spike.n155 5.2005
R5006 spike.n383 spike.n382 5.2005
R5007 spike.n382 spike.n381 5.2005
R5008 spike.n167 spike.n165 5.2005
R5009 spike.n168 spike.n167 5.2005
R5010 spike.n373 spike.n372 5.2005
R5011 spike.n372 spike.n371 5.2005
R5012 spike.n175 spike.n174 5.2005
R5013 spike.n370 spike.n175 5.2005
R5014 spike.n188 spike.n186 5.2005
R5015 spike.n188 spike.n176 5.2005
R5016 spike.n359 spike.n358 5.2005
R5017 spike.n358 spike.n357 5.2005
R5018 spike.n187 spike.n185 5.2005
R5019 spike.n189 spike.n187 5.2005
R5020 spike.n349 spike.n348 5.2005
R5021 spike.n348 spike.n347 5.2005
R5022 spike.n196 spike.n195 5.2005
R5023 spike.n346 spike.n196 5.2005
R5024 spike.n207 spike.n201 5.2005
R5025 spike.n207 spike.n197 5.2005
R5026 spike.n335 spike.n334 5.2005
R5027 spike.n336 spike.n335 5.2005
R5028 spike.n208 spike.n206 5.2005
R5029 spike.n206 spike.n205 5.2005
R5030 spike.n289 spike.n288 5.2005
R5031 spike.n290 spike.n289 5.2005
R5032 spike.n258 spike.n257 5.2005
R5033 spike.n257 spike.n251 5.2005
R5034 spike.n284 spike.n250 5.2005
R5035 spike.n296 spike.n250 5.2005
R5036 spike.n283 spike.n249 5.2005
R5037 spike.n297 spike.n249 5.2005
R5038 spike.n282 spike.n248 5.2005
R5039 spike.n298 spike.n248 5.2005
R5040 spike.n261 spike.n260 5.2005
R5041 spike.n260 spike.n240 5.2005
R5042 spike.n278 spike.n239 5.2005
R5043 spike.n304 spike.n239 5.2005
R5044 spike.n277 spike.n238 5.2005
R5045 spike.n305 spike.n238 5.2005
R5046 spike.n276 spike.n237 5.2005
R5047 spike.n306 spike.n237 5.2005
R5048 spike.n264 spike.n263 5.2005
R5049 spike.n263 spike.n230 5.2005
R5050 spike.n272 spike.n229 5.2005
R5051 spike.n312 spike.n229 5.2005
R5052 spike.n271 spike.n228 5.2005
R5053 spike.n313 spike.n228 5.2005
R5054 spike.n270 spike.n227 5.2005
R5055 spike.n314 spike.n227 5.2005
R5056 spike.n267 spike.n266 5.2005
R5057 spike.n266 spike.n226 5.2005
R5058 spike.n216 spike.n214 5.2005
R5059 spike.n217 spike.n216 5.2005
R5060 spike.n326 spike.n325 5.2005
R5061 spike.n325 spike.n324 5.2005
R5062 spike.n51 spike.n49 5.2005
R5063 spike.n49 spike.n46 5.2005
R5064 spike.n465 spike.n464 5.2005
R5065 spike.n466 spike.n465 5.2005
R5066 spike.n95 spike.n94 5.2005
R5067 spike.n94 spike.n93 5.2005
R5068 spike.n452 spike.n100 5.2005
R5069 spike.n453 spike.n452 5.2005
R5070 spike.n451 spike.n450 5.2005
R5071 spike.n451 spike.n104 5.2005
R5072 spike.n106 spike.n105 5.2005
R5073 spike.n118 spike.n105 5.2005
R5074 spike.n440 spike.n110 5.2005
R5075 spike.n441 spike.n440 5.2005
R5076 spike.n439 spike.n438 5.2005
R5077 spike.n439 spike.n117 5.2005
R5078 spike.n120 spike.n119 5.2005
R5079 spike.n431 spike.n119 5.2005
R5080 spike.n429 spike.n428 5.2005
R5081 spike.n430 spike.n429 5.2005
R5082 spike.n128 spike.n127 5.2005
R5083 spike.n127 spike.n126 5.2005
R5084 spike.n416 spike.n132 5.2005
R5085 spike.n417 spike.n416 5.2005
R5086 spike.n415 spike.n414 5.2005
R5087 spike.n415 spike.n139 5.2005
R5088 spike.n141 spike.n140 5.2005
R5089 spike.n407 spike.n140 5.2005
R5090 spike.n405 spike.n404 5.2005
R5091 spike.n406 spike.n405 5.2005
R5092 spike.n150 spike.n149 5.2005
R5093 spike.n149 spike.n148 5.2005
R5094 spike.n395 spike.n394 5.2005
R5095 spike.n396 spike.n395 5.2005
R5096 spike.n158 spike.n157 5.2005
R5097 spike.n157 spike.n156 5.2005
R5098 spike.n380 spike.n162 5.2005
R5099 spike.n381 spike.n380 5.2005
R5100 spike.n379 spike.n378 5.2005
R5101 spike.n379 spike.n168 5.2005
R5102 spike.n170 spike.n169 5.2005
R5103 spike.n371 spike.n169 5.2005
R5104 spike.n369 spike.n368 5.2005
R5105 spike.n370 spike.n369 5.2005
R5106 spike.n178 spike.n177 5.2005
R5107 spike.n177 spike.n176 5.2005
R5108 spike.n356 spike.n182 5.2005
R5109 spike.n357 spike.n356 5.2005
R5110 spike.n355 spike.n354 5.2005
R5111 spike.n355 spike.n189 5.2005
R5112 spike.n191 spike.n190 5.2005
R5113 spike.n347 spike.n190 5.2005
R5114 spike.n345 spike.n344 5.2005
R5115 spike.n346 spike.n345 5.2005
R5116 spike.n199 spike.n198 5.2005
R5117 spike.n198 spike.n197 5.2005
R5118 spike.n338 spike.n337 5.2005
R5119 spike.n337 spike.n336 5.2005
R5120 spike.n204 spike.n203 5.2005
R5121 spike.n205 spike.n204 5.2005
R5122 spike.n292 spike.n291 5.2005
R5123 spike.n291 spike.n290 5.2005
R5124 spike.n293 spike.n252 5.2005
R5125 spike.n252 spike.n251 5.2005
R5126 spike.n295 spike.n294 5.2005
R5127 spike.n296 spike.n295 5.2005
R5128 spike.n247 spike.n246 5.2005
R5129 spike.n297 spike.n247 5.2005
R5130 spike.n300 spike.n299 5.2005
R5131 spike.n299 spike.n298 5.2005
R5132 spike.n301 spike.n241 5.2005
R5133 spike.n241 spike.n240 5.2005
R5134 spike.n303 spike.n302 5.2005
R5135 spike.n304 spike.n303 5.2005
R5136 spike.n236 spike.n235 5.2005
R5137 spike.n305 spike.n236 5.2005
R5138 spike.n308 spike.n307 5.2005
R5139 spike.n307 spike.n306 5.2005
R5140 spike.n309 spike.n231 5.2005
R5141 spike.n231 spike.n230 5.2005
R5142 spike.n311 spike.n310 5.2005
R5143 spike.n312 spike.n311 5.2005
R5144 spike.n225 spike.n223 5.2005
R5145 spike.n313 spike.n225 5.2005
R5146 spike.n316 spike.n315 5.2005
R5147 spike.n315 spike.n314 5.2005
R5148 spike.n224 spike.n221 5.2005
R5149 spike.n226 spike.n224 5.2005
R5150 spike.n320 spike.n218 5.2005
R5151 spike.n218 spike.n217 5.2005
R5152 spike.n322 spike.n321 5.2005
R5153 spike.n40 spike.n37 5.2005
R5154 spike.n37 spike.n28 5.2005
R5155 spike.n39 spike.n26 5.2005
R5156 spike.n559 spike.n26 5.2005
R5157 spike.n24 spike.n22 5.2005
R5158 spike.n28 spike.n24 5.2005
R5159 spike.n561 spike.n560 5.2005
R5160 spike.n560 spike.n559 5.2005
R5161 spike.n496 spike.n35 5.2005
R5162 spike.n36 spike.n35 5.2005
R5163 spike.n497 spike.n27 5.2005
R5164 spike.n558 spike.n27 5.2005
R5165 spike.n498 spike.n490 5.2005
R5166 spike.n490 spike.n25 5.2005
R5167 spike.n500 spike.n499 5.2005
R5168 spike.n502 spike.n500 5.2005
R5169 spike.n512 spike.n489 5.2005
R5170 spike.n512 spike.n511 5.2005
R5171 spike.n514 spike.n513 5.2005
R5172 spike.n513 spike.n17 5.2005
R5173 spike.n515 spike.n16 5.2005
R5174 spike.n570 spike.n16 5.2005
R5175 spike.n517 spike.n516 5.2005
R5176 spike.n516 spike.n15 5.2005
R5177 spike.n518 spike.n7 5.2005
R5178 spike.n577 spike.n7 5.2005
R5179 spike.n519 spike.n85 5.2005
R5180 spike.n85 spike.n5 5.2005
R5181 spike.n521 spike.n520 5.2005
R5182 spike.n523 spike.n521 5.2005
R5183 spike.n86 spike.n84 5.2005
R5184 spike.n84 spike.n74 5.2005
R5185 spike.n480 spike.n73 5.2005
R5186 spike.n529 spike.n73 5.2005
R5187 spike.n479 spike.n478 5.2005
R5188 spike.n478 spike.n72 5.2005
R5189 spike.n477 spike.n476 5.2005
R5190 spike.n477 spike.n60 5.2005
R5191 spike.n88 spike.n58 5.2005
R5192 spike.n540 spike.n58 5.2005
R5193 spike.n472 spike.n471 5.2005
R5194 spike.n471 spike.n57 5.2005
R5195 spike.n470 spike.n47 5.2005
R5196 spike.n546 spike.n47 5.2005
R5197 spike.n555 spike.n30 5.2005
R5198 spike.n36 spike.n30 5.2005
R5199 spike.n557 spike.n556 5.2005
R5200 spike.n558 spike.n557 5.2005
R5201 spike.n31 spike.n29 5.2005
R5202 spike.n29 spike.n25 5.2005
R5203 spike.n508 spike.n503 5.2005
R5204 spike.n503 spike.n502 5.2005
R5205 spike.n510 spike.n509 5.2005
R5206 spike.n511 spike.n510 5.2005
R5207 spike.n14 spike.n13 5.2005
R5208 spike.n17 spike.n14 5.2005
R5209 spike.n572 spike.n571 5.2005
R5210 spike.n571 spike.n570 5.2005
R5211 spike.n573 spike.n10 5.2005
R5212 spike.n15 spike.n10 5.2005
R5213 spike.n576 spike.n575 5.2005
R5214 spike.n577 spike.n576 5.2005
R5215 spike.n11 spike.n9 5.2005
R5216 spike.n9 spike.n5 5.2005
R5217 spike.n525 spike.n524 5.2005
R5218 spike.n524 spike.n523 5.2005
R5219 spike.n526 spike.n76 5.2005
R5220 spike.n76 spike.n74 5.2005
R5221 spike.n528 spike.n527 5.2005
R5222 spike.n529 spike.n528 5.2005
R5223 spike.n77 spike.n75 5.2005
R5224 spike.n75 spike.n72 5.2005
R5225 spike.n56 spike.n55 5.2005
R5226 spike.n60 spike.n56 5.2005
R5227 spike.n542 spike.n541 5.2005
R5228 spike.n541 spike.n540 5.2005
R5229 spike.n543 spike.n50 5.2005
R5230 spike.n57 spike.n50 5.2005
R5231 spike.n545 spike.n544 5.2005
R5232 spike.n546 spike.n545 5.2005
R5233 spike.n70 spike.n69 5.2005
R5234 spike.n71 spike.n70 5.2005
R5235 spike.n68 spike.n59 5.2005
R5236 spike.n539 spike.n59 5.2005
R5237 spike.n63 spike.n62 5.2005
R5238 spike.n71 spike.n62 5.2005
R5239 spike.n538 spike.n537 5.2005
R5240 spike.n539 spike.n538 5.2005
R5241 spike.n567 spike.n566 5.2005
R5242 spike.n567 spike.n8 5.2005
R5243 spike.n18 spike.n6 5.2005
R5244 spike.n578 spike.n6 5.2005
R5245 spike.n8 spike.n3 5.2005
R5246 spike.n579 spike.n578 5.2005
R5247 spike.n42 spike.n41 5.19319
R5248 spike.n532 spike.n65 5.19319
R5249 spike.n219 spike.n212 5.14053
R5250 spike.n553 spike.n552 5.12952
R5251 spike.n581 spike.n1 5.12001
R5252 spike.n581 spike.n0 5.11219
R5253 spike.n495 spike.n34 5.04833
R5254 spike.n617 spike.n602 4.98321
R5255 spike.n600 spike.n585 4.98321
R5256 spike.n634 spike.n583 4.98321
R5257 spike.n42 spike.n33 4.98321
R5258 spike.n563 spike.n20 4.98321
R5259 spike.n534 spike.n532 4.98321
R5260 spike.n66 spike.n64 4.98321
R5261 spike.n533 spike.n1 4.98321
R5262 spike.n564 spike.n0 4.98321
R5263 spike.n617 spike.n601 4.97539
R5264 spike.n600 spike.n584 4.97539
R5265 spike.n634 spike.n582 4.97539
R5266 spike.n329 spike.n34 4.7183
R5267 spike.n610 spike.n609 4.5005
R5268 spike.n608 spike.n607 4.5005
R5269 spike.n593 spike.n592 4.5005
R5270 spike.n591 spike.n590 4.5005
R5271 spike.n627 spike.n626 4.5005
R5272 spike.n625 spike.n624 4.5005
R5273 spike.n41 spike.n40 4.5005
R5274 spike.n39 spike.n38 4.5005
R5275 spike.n22 spike.n21 4.5005
R5276 spike.n562 spike.n561 4.5005
R5277 spike.n342 spike.n199 4.5005
R5278 spike.n344 spike.n343 4.5005
R5279 spike.n350 spike.n191 4.5005
R5280 spike.n354 spike.n353 4.5005
R5281 spike.n360 spike.n182 4.5005
R5282 spike.n179 spike.n178 4.5005
R5283 spike.n368 spike.n367 4.5005
R5284 spike.n374 spike.n170 4.5005
R5285 spike.n378 spike.n377 4.5005
R5286 spike.n384 spike.n162 4.5005
R5287 spike.n159 spike.n158 4.5005
R5288 spike.n394 spike.n393 4.5005
R5289 spike.n400 spike.n150 4.5005
R5290 spike.n404 spike.n403 4.5005
R5291 spike.n410 spike.n141 4.5005
R5292 spike.n414 spike.n413 4.5005
R5293 spike.n420 spike.n132 4.5005
R5294 spike.n129 spike.n128 4.5005
R5295 spike.n428 spike.n427 4.5005
R5296 spike.n434 spike.n120 4.5005
R5297 spike.n438 spike.n437 4.5005
R5298 spike.n444 spike.n110 4.5005
R5299 spike.n107 spike.n106 4.5005
R5300 spike.n450 spike.n449 4.5005
R5301 spike.n456 spike.n100 4.5005
R5302 spike.n96 spike.n95 4.5005
R5303 spike.n464 spike.n463 4.5005
R5304 spike.n459 spike.n51 4.5005
R5305 spike.n544 spike.n52 4.5005
R5306 spike.n543 spike.n53 4.5005
R5307 spike.n542 spike.n54 4.5005
R5308 spike.n78 spike.n55 4.5005
R5309 spike.n79 spike.n77 4.5005
R5310 spike.n527 spike.n80 4.5005
R5311 spike.n526 spike.n81 4.5005
R5312 spike.n525 spike.n83 4.5005
R5313 spike.n82 spike.n11 4.5005
R5314 spike.n572 spike.n12 4.5005
R5315 spike.n504 spike.n13 4.5005
R5316 spike.n509 spike.n505 4.5005
R5317 spike.n508 spike.n507 4.5005
R5318 spike.n506 spike.n31 4.5005
R5319 spike.n556 spike.n32 4.5005
R5320 spike.n555 spike.n554 4.5005
R5321 spike.n320 spike.n319 4.5005
R5322 spike.n318 spike.n221 4.5005
R5323 spike.n317 spike.n316 4.5005
R5324 spike.n223 spike.n222 4.5005
R5325 spike.n310 spike.n232 4.5005
R5326 spike.n309 spike.n233 4.5005
R5327 spike.n308 spike.n234 4.5005
R5328 spike.n242 spike.n235 4.5005
R5329 spike.n302 spike.n243 4.5005
R5330 spike.n301 spike.n244 4.5005
R5331 spike.n300 spike.n245 4.5005
R5332 spike.n253 spike.n246 4.5005
R5333 spike.n294 spike.n254 4.5005
R5334 spike.n293 spike.n255 4.5005
R5335 spike.n292 spike.n256 4.5005
R5336 spike.n203 spike.n202 4.5005
R5337 spike.n339 spike.n338 4.5005
R5338 spike.n321 spike.n220 4.5005
R5339 spike.n214 spike.n213 4.5005
R5340 spike.n268 spike.n267 4.5005
R5341 spike.n270 spike.n269 4.5005
R5342 spike.n271 spike.n265 4.5005
R5343 spike.n273 spike.n272 4.5005
R5344 spike.n274 spike.n264 4.5005
R5345 spike.n276 spike.n275 4.5005
R5346 spike.n277 spike.n262 4.5005
R5347 spike.n279 spike.n278 4.5005
R5348 spike.n280 spike.n261 4.5005
R5349 spike.n282 spike.n281 4.5005
R5350 spike.n283 spike.n259 4.5005
R5351 spike.n285 spike.n284 4.5005
R5352 spike.n286 spike.n258 4.5005
R5353 spike.n288 spike.n287 4.5005
R5354 spike.n209 spike.n208 4.5005
R5355 spike.n334 spike.n333 4.5005
R5356 spike.n342 spike.n201 4.5005
R5357 spike.n343 spike.n195 4.5005
R5358 spike.n350 spike.n349 4.5005
R5359 spike.n353 spike.n185 4.5005
R5360 spike.n360 spike.n359 4.5005
R5361 spike.n186 spike.n179 4.5005
R5362 spike.n367 spike.n174 4.5005
R5363 spike.n374 spike.n373 4.5005
R5364 spike.n377 spike.n165 4.5005
R5365 spike.n384 spike.n383 4.5005
R5366 spike.n166 spike.n159 4.5005
R5367 spike.n393 spike.n154 4.5005
R5368 spike.n400 spike.n399 4.5005
R5369 spike.n403 spike.n146 4.5005
R5370 spike.n410 spike.n409 4.5005
R5371 spike.n413 spike.n135 4.5005
R5372 spike.n420 spike.n419 4.5005
R5373 spike.n136 spike.n129 4.5005
R5374 spike.n427 spike.n124 4.5005
R5375 spike.n434 spike.n433 4.5005
R5376 spike.n437 spike.n113 4.5005
R5377 spike.n444 spike.n443 4.5005
R5378 spike.n114 spike.n107 4.5005
R5379 spike.n449 spike.n101 4.5005
R5380 spike.n456 spike.n455 4.5005
R5381 spike.n102 spike.n96 4.5005
R5382 spike.n463 spike.n90 4.5005
R5383 spike.n469 spike.n91 4.5005
R5384 spike.n470 spike.n89 4.5005
R5385 spike.n473 spike.n472 4.5005
R5386 spike.n474 spike.n88 4.5005
R5387 spike.n476 spike.n475 4.5005
R5388 spike.n479 spike.n87 4.5005
R5389 spike.n481 spike.n480 4.5005
R5390 spike.n482 spike.n86 4.5005
R5391 spike.n520 spike.n483 4.5005
R5392 spike.n519 spike.n484 4.5005
R5393 spike.n518 spike.n485 4.5005
R5394 spike.n517 spike.n486 4.5005
R5395 spike.n515 spike.n487 4.5005
R5396 spike.n514 spike.n488 4.5005
R5397 spike.n491 spike.n489 4.5005
R5398 spike.n499 spike.n492 4.5005
R5399 spike.n498 spike.n493 4.5005
R5400 spike.n497 spike.n494 4.5005
R5401 spike.n496 spike.n495 4.5005
R5402 spike.n327 spike.n326 4.5005
R5403 spike.n69 spike.n65 4.5005
R5404 spike.n68 spike.n67 4.5005
R5405 spike.n535 spike.n63 4.5005
R5406 spike.n537 spike.n536 4.5005
R5407 spike.n566 spike.n565 4.5005
R5408 spike.n19 spike.n18 4.5005
R5409 spike.n578 spike.n577 3.61362
R5410 spike.n15 spike.n8 3.61362
R5411 spike.n612 spike.n611 3.31679
R5412 spike.n612 spike.n606 3.31679
R5413 spike.n614 spike.n603 3.31679
R5414 spike.n615 spike.n614 3.31679
R5415 spike.n594 spike.n588 3.31679
R5416 spike.n589 spike.n588 3.31679
R5417 spike.n597 spike.n586 3.31679
R5418 spike.n598 spike.n597 3.31679
R5419 spike.n629 spike.n628 3.31679
R5420 spike.n629 spike.n623 3.31679
R5421 spike.n631 spike.n620 3.31679
R5422 spike.n632 spike.n631 3.31679
R5423 spike.n581 spike.n580 3.28078
R5424 spike.n324 spike.n323 3.26114
R5425 spike.n580 spike.n579 3.14293
R5426 spike.n580 spike.n3 3.14293
R5427 spike.n402 spike.n144 2.80819
R5428 spike.n411 spike.n144 2.80819
R5429 spike.n329 spike.n328 2.6735
R5430 spike.n332 spike.n331 2.4683
R5431 spike.n600 spike.n599 2.21557
R5432 spike.n574 spike.n2 2.21557
R5433 spike.n634 spike.n633 2.21557
R5434 spike.n617 spike.n616 2.21557
R5435 spike.n323 spike.n322 1.82789
R5436 spike.n461 spike.n2 1.23277
R5437 spike.n618 Vss 1.0868
R5438 spike.n604 spike.n601 0.9005
R5439 spike.n613 spike.n604 0.9005
R5440 spike.n605 spike.n602 0.9005
R5441 spike.n613 spike.n605 0.9005
R5442 spike.n595 spike.n584 0.9005
R5443 spike.n596 spike.n595 0.9005
R5444 spike.n587 spike.n585 0.9005
R5445 spike.n596 spike.n587 0.9005
R5446 spike.n621 spike.n582 0.9005
R5447 spike.n630 spike.n621 0.9005
R5448 spike.n622 spike.n583 0.9005
R5449 spike.n630 spike.n622 0.9005
R5450 spike.n23 spike.n20 0.743357
R5451 spike.n501 spike.n23 0.743357
R5452 spike.n43 spike.n42 0.743357
R5453 spike.n550 spike.n43 0.743357
R5454 spike.n532 spike.n531 0.743357
R5455 spike.n531 spike.n530 0.743357
R5456 spike.n66 spike.n61 0.743357
R5457 spike.n61 spike.n48 0.743357
R5458 spike.n568 spike.n0 0.743357
R5459 spike.n569 spike.n568 0.743357
R5460 spike.n4 spike.n1 0.743357
R5461 spike.n522 spike.n4 0.743357
R5462 spike.n332 spike.n200 0.573125
R5463 spike.n460 spike.n97 0.483125
R5464 spike.n340 spike.n200 0.483125
R5465 spike.n219 spike.n215 0.473227
R5466 spike.n552 spike.n551 0.473227
R5467 spike.n551 spike.n550 0.473227
R5468 spike.n328 spike.n91 0.44735
R5469 spike.n328 spike.n97 0.393125
R5470 spike.n619 spike.n600 0.316383
R5471 spike.n552 spike.n34 0.29887
R5472 spike.n447 spike.n99 0.28625
R5473 spike.n448 spike.n447 0.28175
R5474 spike.n446 spike.n445 0.28175
R5475 spike.n109 spike.n108 0.28175
R5476 spike.n423 spike.n121 0.28175
R5477 spike.n424 spike.n123 0.28175
R5478 spike.n426 spike.n425 0.28175
R5479 spike.n422 spike.n421 0.28175
R5480 spike.n131 spike.n130 0.28175
R5481 spike.n387 spike.n142 0.28175
R5482 spike.n388 spike.n145 0.28175
R5483 spike.n389 spike.n151 0.28175
R5484 spike.n390 spike.n153 0.28175
R5485 spike.n392 spike.n391 0.28175
R5486 spike.n386 spike.n385 0.28175
R5487 spike.n161 spike.n160 0.28175
R5488 spike.n363 spike.n171 0.28175
R5489 spike.n364 spike.n173 0.28175
R5490 spike.n366 spike.n365 0.28175
R5491 spike.n362 spike.n361 0.28175
R5492 spike.n181 spike.n180 0.28175
R5493 spike.n210 spike.n192 0.28175
R5494 spike.n211 spike.n194 0.28175
R5495 spike.n460 spike.n459 0.26735
R5496 spike.n554 spike.n553 0.2255
R5497 spike.n461 spike.n460 0.219838
R5498 spike.n340 spike.n339 0.20615
R5499 spike.n333 spike.n332 0.20615
R5500 spike.n564 spike.n563 0.2057
R5501 spike.n534 spike.n533 0.2057
R5502 spike.n619 spike.n618 0.2057
R5503 spike.n97 spike.n64 0.1841
R5504 spike.n144 spike.n143 0.1684
R5505 spike.n610 spike.n607 0.1445
R5506 spike.n609 spike.n608 0.1445
R5507 spike.n593 spike.n590 0.1445
R5508 spike.n592 spike.n591 0.1445
R5509 spike.n627 spike.n624 0.1445
R5510 spike.n626 spike.n625 0.1445
R5511 spike.n566 spike.n18 0.1445
R5512 spike.n537 spike.n63 0.1445
R5513 spike.n459 spike.n52 0.1445
R5514 spike.n53 spike.n52 0.1445
R5515 spike.n54 spike.n53 0.1445
R5516 spike.n78 spike.n54 0.1445
R5517 spike.n79 spike.n78 0.1445
R5518 spike.n80 spike.n79 0.1445
R5519 spike.n81 spike.n80 0.1445
R5520 spike.n83 spike.n81 0.1445
R5521 spike.n83 spike.n82 0.1445
R5522 spike.n561 spike.n22 0.1445
R5523 spike.n40 spike.n39 0.1445
R5524 spike.n41 spike.n38 0.1445
R5525 spike.n504 spike.n12 0.1445
R5526 spike.n505 spike.n504 0.1445
R5527 spike.n507 spike.n505 0.1445
R5528 spike.n507 spike.n506 0.1445
R5529 spike.n506 spike.n32 0.1445
R5530 spike.n554 spike.n32 0.1445
R5531 spike.n91 spike.n89 0.1445
R5532 spike.n473 spike.n89 0.1445
R5533 spike.n474 spike.n473 0.1445
R5534 spike.n475 spike.n474 0.1445
R5535 spike.n475 spike.n87 0.1445
R5536 spike.n481 spike.n87 0.1445
R5537 spike.n482 spike.n481 0.1445
R5538 spike.n483 spike.n482 0.1445
R5539 spike.n484 spike.n483 0.1445
R5540 spike.n485 spike.n484 0.1445
R5541 spike.n486 spike.n485 0.1445
R5542 spike.n487 spike.n486 0.1445
R5543 spike.n488 spike.n487 0.1445
R5544 spike.n491 spike.n488 0.1445
R5545 spike.n492 spike.n491 0.1445
R5546 spike.n493 spike.n492 0.1445
R5547 spike.n494 spike.n493 0.1445
R5548 spike.n495 spike.n494 0.1445
R5549 spike.n321 spike.n320 0.1445
R5550 spike.n320 spike.n221 0.1445
R5551 spike.n316 spike.n221 0.1445
R5552 spike.n316 spike.n223 0.1445
R5553 spike.n310 spike.n223 0.1445
R5554 spike.n310 spike.n309 0.1445
R5555 spike.n309 spike.n308 0.1445
R5556 spike.n308 spike.n235 0.1445
R5557 spike.n302 spike.n235 0.1445
R5558 spike.n302 spike.n301 0.1445
R5559 spike.n301 spike.n300 0.1445
R5560 spike.n300 spike.n246 0.1445
R5561 spike.n294 spike.n246 0.1445
R5562 spike.n294 spike.n293 0.1445
R5563 spike.n293 spike.n292 0.1445
R5564 spike.n292 spike.n203 0.1445
R5565 spike.n338 spike.n203 0.1445
R5566 spike.n338 spike.n199 0.1445
R5567 spike.n344 spike.n199 0.1445
R5568 spike.n344 spike.n191 0.1445
R5569 spike.n354 spike.n191 0.1445
R5570 spike.n354 spike.n182 0.1445
R5571 spike.n182 spike.n178 0.1445
R5572 spike.n368 spike.n178 0.1445
R5573 spike.n368 spike.n170 0.1445
R5574 spike.n378 spike.n170 0.1445
R5575 spike.n378 spike.n162 0.1445
R5576 spike.n162 spike.n158 0.1445
R5577 spike.n394 spike.n158 0.1445
R5578 spike.n394 spike.n150 0.1445
R5579 spike.n404 spike.n150 0.1445
R5580 spike.n404 spike.n141 0.1445
R5581 spike.n414 spike.n141 0.1445
R5582 spike.n414 spike.n132 0.1445
R5583 spike.n132 spike.n128 0.1445
R5584 spike.n428 spike.n128 0.1445
R5585 spike.n428 spike.n120 0.1445
R5586 spike.n438 spike.n120 0.1445
R5587 spike.n438 spike.n110 0.1445
R5588 spike.n110 spike.n106 0.1445
R5589 spike.n450 spike.n106 0.1445
R5590 spike.n450 spike.n100 0.1445
R5591 spike.n100 spike.n95 0.1445
R5592 spike.n464 spike.n95 0.1445
R5593 spike.n464 spike.n51 0.1445
R5594 spike.n544 spike.n51 0.1445
R5595 spike.n544 spike.n543 0.1445
R5596 spike.n543 spike.n542 0.1445
R5597 spike.n542 spike.n55 0.1445
R5598 spike.n77 spike.n55 0.1445
R5599 spike.n527 spike.n77 0.1445
R5600 spike.n527 spike.n526 0.1445
R5601 spike.n526 spike.n525 0.1445
R5602 spike.n525 spike.n11 0.1445
R5603 spike.n575 spike.n11 0.1445
R5604 spike.n573 spike.n572 0.1445
R5605 spike.n572 spike.n13 0.1445
R5606 spike.n509 spike.n13 0.1445
R5607 spike.n509 spike.n508 0.1445
R5608 spike.n508 spike.n31 0.1445
R5609 spike.n556 spike.n31 0.1445
R5610 spike.n556 spike.n555 0.1445
R5611 spike.n319 spike.n220 0.1445
R5612 spike.n319 spike.n318 0.1445
R5613 spike.n318 spike.n317 0.1445
R5614 spike.n317 spike.n222 0.1445
R5615 spike.n232 spike.n222 0.1445
R5616 spike.n233 spike.n232 0.1445
R5617 spike.n234 spike.n233 0.1445
R5618 spike.n242 spike.n234 0.1445
R5619 spike.n243 spike.n242 0.1445
R5620 spike.n244 spike.n243 0.1445
R5621 spike.n245 spike.n244 0.1445
R5622 spike.n253 spike.n245 0.1445
R5623 spike.n254 spike.n253 0.1445
R5624 spike.n255 spike.n254 0.1445
R5625 spike.n256 spike.n255 0.1445
R5626 spike.n256 spike.n202 0.1445
R5627 spike.n339 spike.n202 0.1445
R5628 spike.n327 spike.n213 0.1445
R5629 spike.n268 spike.n213 0.1445
R5630 spike.n269 spike.n268 0.1445
R5631 spike.n269 spike.n265 0.1445
R5632 spike.n273 spike.n265 0.1445
R5633 spike.n274 spike.n273 0.1445
R5634 spike.n275 spike.n274 0.1445
R5635 spike.n275 spike.n262 0.1445
R5636 spike.n279 spike.n262 0.1445
R5637 spike.n280 spike.n279 0.1445
R5638 spike.n281 spike.n280 0.1445
R5639 spike.n281 spike.n259 0.1445
R5640 spike.n285 spike.n259 0.1445
R5641 spike.n286 spike.n285 0.1445
R5642 spike.n287 spike.n286 0.1445
R5643 spike.n287 spike.n209 0.1445
R5644 spike.n333 spike.n209 0.1445
R5645 spike.n326 spike.n214 0.1445
R5646 spike.n267 spike.n214 0.1445
R5647 spike.n270 spike.n267 0.1445
R5648 spike.n271 spike.n270 0.1445
R5649 spike.n272 spike.n271 0.1445
R5650 spike.n272 spike.n264 0.1445
R5651 spike.n276 spike.n264 0.1445
R5652 spike.n277 spike.n276 0.1445
R5653 spike.n278 spike.n277 0.1445
R5654 spike.n278 spike.n261 0.1445
R5655 spike.n282 spike.n261 0.1445
R5656 spike.n283 spike.n282 0.1445
R5657 spike.n284 spike.n283 0.1445
R5658 spike.n284 spike.n258 0.1445
R5659 spike.n288 spike.n258 0.1445
R5660 spike.n288 spike.n208 0.1445
R5661 spike.n334 spike.n208 0.1445
R5662 spike.n334 spike.n201 0.1445
R5663 spike.n201 spike.n195 0.1445
R5664 spike.n349 spike.n195 0.1445
R5665 spike.n349 spike.n185 0.1445
R5666 spike.n359 spike.n185 0.1445
R5667 spike.n359 spike.n186 0.1445
R5668 spike.n186 spike.n174 0.1445
R5669 spike.n373 spike.n174 0.1445
R5670 spike.n373 spike.n165 0.1445
R5671 spike.n383 spike.n165 0.1445
R5672 spike.n383 spike.n166 0.1445
R5673 spike.n166 spike.n154 0.1445
R5674 spike.n399 spike.n154 0.1445
R5675 spike.n399 spike.n146 0.1445
R5676 spike.n409 spike.n146 0.1445
R5677 spike.n409 spike.n135 0.1445
R5678 spike.n419 spike.n135 0.1445
R5679 spike.n419 spike.n136 0.1445
R5680 spike.n136 spike.n124 0.1445
R5681 spike.n433 spike.n124 0.1445
R5682 spike.n433 spike.n113 0.1445
R5683 spike.n443 spike.n113 0.1445
R5684 spike.n443 spike.n114 0.1445
R5685 spike.n114 spike.n101 0.1445
R5686 spike.n455 spike.n101 0.1445
R5687 spike.n455 spike.n102 0.1445
R5688 spike.n102 spike.n90 0.1445
R5689 spike.n469 spike.n90 0.1445
R5690 spike.n470 spike.n469 0.1445
R5691 spike.n472 spike.n470 0.1445
R5692 spike.n472 spike.n88 0.1445
R5693 spike.n476 spike.n88 0.1445
R5694 spike.n479 spike.n476 0.1445
R5695 spike.n480 spike.n479 0.1445
R5696 spike.n480 spike.n86 0.1445
R5697 spike.n520 spike.n86 0.1445
R5698 spike.n520 spike.n519 0.1445
R5699 spike.n519 spike.n518 0.1445
R5700 spike.n518 spike.n517 0.1445
R5701 spike.n517 spike.n515 0.1445
R5702 spike.n515 spike.n514 0.1445
R5703 spike.n514 spike.n489 0.1445
R5704 spike.n499 spike.n489 0.1445
R5705 spike.n499 spike.n498 0.1445
R5706 spike.n498 spike.n497 0.1445
R5707 spike.n497 spike.n496 0.1445
R5708 spike.n69 spike.n68 0.1445
R5709 spike.n67 spike.n65 0.1445
R5710 spike.n634 spike.n619 0.111183
R5711 spike.n618 spike.n617 0.111183
R5712 spike.n581 spike.n2 0.107176
R5713 spike.n575 spike.n574 0.0718661
R5714 spike.n574 spike.n573 0.0718661
R5715 spike.n12 spike.n2 0.0671
R5716 spike.n82 spike.n2 0.0599
R5717 Vss spike.n327 0.0599
R5718 spike.n617 Vss 0.0577669
R5719 Vss spike.n635 0.0507793
R5720 Vss spike.n212 0.0490611
R5721 spike.n331 Vss 0.0455
R5722 spike.n563 spike.n562 0.0298531
R5723 spike.n33 spike.n21 0.0298531
R5724 spike.n536 spike.n64 0.0298531
R5725 spike.n535 spike.n534 0.0298531
R5726 spike.n533 spike.n19 0.0298531
R5727 spike.n565 spike.n564 0.0298531
R5728 spike.n562 spike.n21 0.019907
R5729 spike.n536 spike.n535 0.019907
R5730 spike.n565 spike.n19 0.019907
R5731 spike.n635 spike.n634 0.00748758
R5732 spike.n211 spike.n210 0.005
R5733 spike.n210 spike.n180 0.005
R5734 spike.n362 spike.n180 0.005
R5735 spike.n365 spike.n362 0.005
R5736 spike.n365 spike.n364 0.005
R5737 spike.n364 spike.n363 0.005
R5738 spike.n363 spike.n160 0.005
R5739 spike.n386 spike.n160 0.005
R5740 spike.n391 spike.n386 0.005
R5741 spike.n391 spike.n390 0.005
R5742 spike.n390 spike.n389 0.005
R5743 spike.n389 spike.n388 0.005
R5744 spike.n388 spike.n387 0.005
R5745 spike.n387 spike.n130 0.005
R5746 spike.n422 spike.n130 0.005
R5747 spike.n425 spike.n422 0.005
R5748 spike.n425 spike.n424 0.005
R5749 spike.n424 spike.n423 0.005
R5750 spike.n423 spike.n108 0.005
R5751 spike.n446 spike.n108 0.005
R5752 spike.n447 spike.n446 0.005
R5753 spike.n343 spike.n342 0.00389783
R5754 spike.n456 spike.n96 0.00389783
R5755 spike.n463 spike.n96 0.00389783
R5756 spike.n343 spike.n194 0.00317579
R5757 spike.n350 spike.n192 0.00317579
R5758 spike.n353 spike.n181 0.00317579
R5759 spike.n361 spike.n360 0.00317579
R5760 spike.n366 spike.n179 0.00317579
R5761 spike.n367 spike.n173 0.00317579
R5762 spike.n374 spike.n171 0.00317579
R5763 spike.n377 spike.n161 0.00317579
R5764 spike.n385 spike.n384 0.00317579
R5765 spike.n392 spike.n159 0.00317579
R5766 spike.n393 spike.n153 0.00317579
R5767 spike.n400 spike.n151 0.00317579
R5768 spike.n410 spike.n142 0.00317579
R5769 spike.n413 spike.n131 0.00317579
R5770 spike.n421 spike.n420 0.00317579
R5771 spike.n426 spike.n129 0.00317579
R5772 spike.n427 spike.n123 0.00317579
R5773 spike.n434 spike.n121 0.00317579
R5774 spike.n437 spike.n109 0.00317579
R5775 spike.n445 spike.n444 0.00317579
R5776 spike.n448 spike.n107 0.00317579
R5777 spike.n449 spike.n99 0.00317579
R5778 spike.n403 Vss 0.00219891
R5779 spike.n342 spike.n200 0.0020715
R5780 Vss spike.n145 0.00147688
R5781 spike.n350 spike.n194 0.00122204
R5782 spike.n353 spike.n192 0.00122204
R5783 spike.n360 spike.n181 0.00122204
R5784 spike.n361 spike.n179 0.00122204
R5785 spike.n367 spike.n366 0.00122204
R5786 spike.n374 spike.n173 0.00122204
R5787 spike.n377 spike.n171 0.00122204
R5788 spike.n384 spike.n161 0.00122204
R5789 spike.n385 spike.n159 0.00122204
R5790 spike.n393 spike.n392 0.00122204
R5791 spike.n400 spike.n153 0.00122204
R5792 spike.n403 spike.n151 0.00122204
R5793 spike.n410 spike.n145 0.00122204
R5794 spike.n413 spike.n142 0.00122204
R5795 spike.n420 spike.n131 0.00122204
R5796 spike.n421 spike.n129 0.00122204
R5797 spike.n427 spike.n426 0.00122204
R5798 spike.n434 spike.n123 0.00122204
R5799 spike.n437 spike.n121 0.00122204
R5800 spike.n444 spike.n109 0.00122204
R5801 spike.n445 spike.n107 0.00122204
R5802 spike.n449 spike.n448 0.00122204
R5803 spike.n456 spike.n99 0.00122204
R5804 spike.n463 spike.n97 0.000627419
C0 Unnamed_f25afa91_2/a_64_n131# Unnamed_f25afa91_2/a_n64_n339# 0.72052f
C1 spike.n0 Vss 0.00191f
C2 spike.n1 Vss 0.00112f
C3 spike.n2 Vss 0.01f
C4 spike.n3 Vss 0
C5 spike.n4 Vss 0
C6 spike.n5 Vss 0.00605f
C7 spike.n6 Vss 0
C8 spike.n7 Vss 0
C9 spike.n8 Vss 0.00348f
C10 spike.n9 Vss 0
C11 spike.n10 Vss 0
C12 spike.n11 Vss 0
C13 spike.n12 Vss 0
C14 spike.n13 Vss 0
C15 spike.n14 Vss 0
C16 spike.n15 Vss 0.00357f
C17 spike.n16 Vss 0
C18 spike.n17 Vss 0.00418f
C19 spike.n18 Vss 0
C20 spike.n19 Vss 0.00181f
C21 spike.n20 Vss 0.00113f
C22 spike.n21 Vss 0.00181f
C23 spike.n22 Vss 0
C24 spike.n23 Vss 0
C25 spike.n24 Vss 0
C26 spike.n25 Vss 0.00605f
C27 spike.n26 Vss 0
C28 spike.n27 Vss 0
C29 spike.n28 Vss 0.00348f
C30 spike.n29 Vss 0
C31 spike.n30 Vss 0
C32 spike.n31 Vss 0
C33 spike.n32 Vss 0
C34 spike.n33 Vss 0.00372f
C35 spike.n34 Vss 0
C36 spike.n35 Vss 0
C37 spike.n36 Vss 0.00605f
C38 spike.n37 Vss 0
C39 spike.n38 Vss 0
C40 spike.n39 Vss 0
C41 spike.n40 Vss 0
C42 spike.n41 Vss 0
C43 spike.n42 Vss 0.00192f
C44 spike.n43 Vss 0
C45 spike.n44 Vss 0.00484f
C46 spike.n45 Vss 0.00484f
C47 spike.n46 Vss 0.00955f
C48 spike.n47 Vss 0
C49 spike.n48 Vss 0.00348f
C50 spike.n49 Vss 0
C51 spike.n50 Vss 0
C52 spike.n51 Vss 0
C53 spike.n52 Vss 0
C54 spike.n53 Vss 0
C55 spike.n54 Vss 0
C56 spike.n55 Vss 0
C57 spike.n56 Vss 0
C58 spike.n57 Vss 0.00571f
C59 spike.n58 Vss 0
C60 spike.n59 Vss 0
C61 spike.n60 Vss 0.00348f
C62 spike.n61 Vss 0
C63 spike.n62 Vss 0
C64 spike.n63 Vss 0
C65 spike.n64 Vss 0.00171f
C66 spike.n65 Vss 0
C67 spike.n66 Vss 0.00113f
C68 spike.n67 Vss 0
C69 spike.n68 Vss 0
C70 spike.n69 Vss 0
C71 spike.n70 Vss 0
C72 spike.n71 Vss 0.00348f
C73 spike.n72 Vss 0.00605f
C74 spike.n73 Vss 0
C75 spike.n74 Vss 0.00362f
C76 spike.n75 Vss 0
C77 spike.n76 Vss 0
C78 spike.n77 Vss 0
C79 spike.n78 Vss 0
C80 spike.n79 Vss 0
C81 spike.n80 Vss 0
C82 spike.n81 Vss 0
C83 spike.n82 Vss 0
C84 spike.n83 Vss 0
C85 spike.n84 Vss 0
C86 spike.n85 Vss 0
C87 spike.n86 Vss 0
C88 spike.n87 Vss 0
C89 spike.n88 Vss 0
C90 spike.n89 Vss 0
C91 spike.n90 Vss 0
C92 spike.n91 Vss -0
C93 spike.n92 Vss 0
C94 spike.n93 Vss 0.01069f
C95 spike.n94 Vss 0
C96 spike.n95 Vss 0
C97 spike.n96 Vss 0.00829f
C98 spike.n97 Vss 0.00102f
C99 spike.n98 Vss 0
C100 spike.n99 Vss 0.00442f
C101 spike.n100 Vss 0
C102 spike.n101 Vss 0
C103 spike.n102 Vss 0
C104 spike.n103 Vss 0
C105 spike.n104 Vss 0.01069f
C106 spike.n105 Vss 0
C107 spike.n106 Vss 0
C108 spike.n107 Vss 0.00418f
C109 spike.n108 Vss 0.0062f
C110 spike.n109 Vss 0.0041f
C111 spike.n110 Vss 0
C112 spike.n111 Vss 0
C113 spike.n112 Vss 0
C114 spike.n113 Vss 0
C115 spike.n114 Vss 0
C116 spike.n115 Vss 0
C117 spike.n116 Vss 0
C118 spike.n117 Vss 0.01069f
C119 spike.n118 Vss 0.01069f
C120 spike.n119 Vss 0
C121 spike.n120 Vss 0
C122 spike.n121 Vss 0.0041f
C123 spike.n122 Vss 0
C124 spike.n123 Vss 0.0041f
C125 spike.n124 Vss 0
C126 spike.n125 Vss 0
C127 spike.n126 Vss 0.01069f
C128 spike.n127 Vss 0
C129 spike.n128 Vss 0
C130 spike.n129 Vss 0.00418f
C131 spike.n130 Vss 0.0062f
C132 spike.n131 Vss 0.0041f
C133 spike.n132 Vss 0
C134 spike.n133 Vss 0
C135 spike.n134 Vss 0
C136 spike.n135 Vss 0
C137 spike.n136 Vss 0
C138 spike.n137 Vss 0
C139 spike.n138 Vss 0
C140 spike.n139 Vss 0.01069f
C141 spike.n140 Vss 0
C142 spike.n141 Vss 0
C143 spike.n142 Vss 0.0041f
C144 spike.n143 Vss 0.03595f
C145 spike.n144 Vss 0.01412f
C146 spike.n145 Vss 0.00205f
C147 spike.n146 Vss 0
C148 spike.n147 Vss 0
C149 spike.n148 Vss 0.01069f
C150 spike.n149 Vss 0
C151 spike.n150 Vss 0
C152 spike.n151 Vss 0.0041f
C153 spike.n152 Vss 0
C154 spike.n153 Vss 0.0041f
C155 spike.n154 Vss 0
C156 spike.n155 Vss 0
C157 spike.n156 Vss 0.01069f
C158 spike.n157 Vss 0
C159 spike.n158 Vss 0
C160 spike.n159 Vss 0.00418f
C161 spike.n160 Vss 0.0062f
C162 spike.n161 Vss 0.0041f
C163 spike.n162 Vss 0
C164 spike.n163 Vss 0
C165 spike.n164 Vss 0
C166 spike.n165 Vss 0
C167 spike.n166 Vss 0
C168 spike.n167 Vss 0
C169 spike.n168 Vss 0.01069f
C170 spike.n169 Vss 0
C171 spike.n170 Vss 0
C172 spike.n171 Vss 0.0041f
C173 spike.n172 Vss 0
C174 spike.n173 Vss 0.0041f
C175 spike.n174 Vss 0
C176 spike.n175 Vss 0
C177 spike.n176 Vss 0.01069f
C178 spike.n177 Vss 0
C179 spike.n178 Vss 0
C180 spike.n179 Vss 0.00418f
C181 spike.n180 Vss 0.0062f
C182 spike.n181 Vss 0.0041f
C183 spike.n182 Vss 0
C184 spike.n183 Vss 0
C185 spike.n184 Vss 0
C186 spike.n185 Vss 0
C187 spike.n186 Vss 0
C188 spike.n187 Vss 0
C189 spike.n188 Vss 0
C190 spike.n189 Vss 0.01069f
C191 spike.n190 Vss 0
C192 spike.n191 Vss 0
C193 spike.n192 Vss 0.0041f
C194 spike.n193 Vss 0
C195 spike.n194 Vss 0.0041f
C196 spike.n195 Vss 0
C197 spike.n196 Vss 0
C198 spike.n197 Vss 0.01069f
C199 spike.n198 Vss 0
C200 spike.n199 Vss 0
C201 spike.n200 Vss -0.00731f
C202 spike.n201 Vss 0
C203 spike.n202 Vss 0
C204 spike.n203 Vss 0
C205 spike.n204 Vss 0
C206 spike.n205 Vss 0.01069f
C207 spike.n206 Vss 0
C208 spike.n207 Vss 0
C209 spike.n208 Vss 0
C210 spike.n209 Vss 0
C211 spike.n210 Vss 0.0062f
C212 spike.n211 Vss 0.02348f
C213 spike.n212 Vss 0.00133f
C214 spike.n213 Vss 0
C215 spike.n214 Vss 0
C216 spike.n215 Vss 0.04199f
C217 spike.n216 Vss 0
C218 spike.n217 Vss 0.01069f
C219 spike.n218 Vss 0
C220 spike.n219 Vss 0.00148f
C221 spike.n220 Vss 0
C222 spike.n221 Vss 0
C223 spike.n222 Vss 0
C224 spike.n223 Vss 0
C225 spike.n224 Vss 0
C226 spike.n225 Vss 0
C227 spike.n226 Vss 0.01069f
C228 spike.n227 Vss 0
C229 spike.n228 Vss 0
C230 spike.n229 Vss 0
C231 spike.n230 Vss 0.01069f
C232 spike.n231 Vss 0
C233 spike.n232 Vss 0
C234 spike.n233 Vss 0
C235 spike.n234 Vss 0
C236 spike.n235 Vss 0
C237 spike.n236 Vss 0
C238 spike.n237 Vss 0
C239 spike.n238 Vss 0
C240 spike.n239 Vss 0
C241 spike.n240 Vss 0.01069f
C242 spike.n241 Vss 0
C243 spike.n242 Vss 0
C244 spike.n243 Vss 0
C245 spike.n244 Vss 0
C246 spike.n245 Vss 0
C247 spike.n246 Vss 0
C248 spike.n247 Vss 0
C249 spike.n248 Vss 0
C250 spike.n249 Vss 0
C251 spike.n250 Vss 0
C252 spike.n251 Vss 0.01069f
C253 spike.n252 Vss 0
C254 spike.n253 Vss 0
C255 spike.n254 Vss 0
C256 spike.n255 Vss 0
C257 spike.n256 Vss 0
C258 spike.n257 Vss 0
C259 spike.n258 Vss 0
C260 spike.n259 Vss 0
C261 spike.n260 Vss 0
C262 spike.n261 Vss 0
C263 spike.n262 Vss 0
C264 spike.n263 Vss 0
C265 spike.n264 Vss 0
C266 spike.n265 Vss 0
C267 spike.n266 Vss 0
C268 spike.n267 Vss 0
C269 spike.n268 Vss 0
C270 spike.n269 Vss 0
C271 spike.n270 Vss 0
C272 spike.n271 Vss 0
C273 spike.n272 Vss 0
C274 spike.n273 Vss 0
C275 spike.n274 Vss 0
C276 spike.n275 Vss 0
C277 spike.n276 Vss 0
C278 spike.n277 Vss 0
C279 spike.n278 Vss 0
C280 spike.n279 Vss 0
C281 spike.n280 Vss 0
C282 spike.n281 Vss 0
C283 spike.n282 Vss 0
C284 spike.n283 Vss 0
C285 spike.n284 Vss 0
C286 spike.n285 Vss 0
C287 spike.n286 Vss 0
C288 spike.n287 Vss 0
C289 spike.n288 Vss 0
C290 spike.n289 Vss 0
C291 spike.n290 Vss 0.01069f
C292 spike.n291 Vss 0
C293 spike.n292 Vss 0
C294 spike.n293 Vss 0
C295 spike.n294 Vss 0
C296 spike.n295 Vss 0
C297 spike.n296 Vss 0.01069f
C298 spike.n297 Vss 0.01069f
C299 spike.n298 Vss 0.01069f
C300 spike.n299 Vss 0
C301 spike.n300 Vss 0
C302 spike.n301 Vss 0
C303 spike.n302 Vss 0
C304 spike.n303 Vss 0
C305 spike.n304 Vss 0.01069f
C306 spike.n305 Vss 0.01069f
C307 spike.n306 Vss 0.01069f
C308 spike.n307 Vss 0
C309 spike.n308 Vss 0
C310 spike.n309 Vss 0
C311 spike.n310 Vss 0
C312 spike.n311 Vss 0
C313 spike.n312 Vss 0.01069f
C314 spike.n313 Vss 0.01069f
C315 spike.n314 Vss 0.01069f
C316 spike.n315 Vss 0
C317 spike.n316 Vss 0
C318 spike.n317 Vss 0
C319 spike.n318 Vss 0
C320 spike.n319 Vss 0
C321 spike.n320 Vss 0
C322 spike.n321 Vss 0
C323 spike.n322 Vss 0
C324 spike.n324 Vss 0.01396f
C325 spike.n325 Vss 0
C326 spike.n326 Vss 0
C327 spike.n327 Vss 0
C328 spike.n328 Vss 0
C329 spike.n329 Vss 0.00262f
C330 spike.n330 Vss 0.00272f
C331 spike.n331 Vss 0.00224f
C332 spike.n332 Vss -0
C333 spike.n333 Vss 0.00105f
C334 spike.n334 Vss 0
C335 spike.n335 Vss 0
C336 spike.n336 Vss 0.01069f
C337 spike.n337 Vss 0
C338 spike.n338 Vss 0
C339 spike.n339 Vss 0.00112f
C340 spike.n340 Vss 0.01196f
C341 spike.n341 Vss 0.00107f
C342 spike.n342 Vss 0.00608f
C343 spike.n343 Vss 0.00741f
C344 spike.n344 Vss 0
C345 spike.n345 Vss 0
C346 spike.n346 Vss 0.01069f
C347 spike.n347 Vss 0.01069f
C348 spike.n348 Vss 0
C349 spike.n349 Vss 0
C350 spike.n350 Vss 0.00418f
C351 spike.n351 Vss 0
C352 spike.n352 Vss 0
C353 spike.n353 Vss 0.00418f
C354 spike.n354 Vss 0
C355 spike.n355 Vss 0
C356 spike.n356 Vss 0
C357 spike.n357 Vss 0.01069f
C358 spike.n358 Vss 0
C359 spike.n359 Vss 0
C360 spike.n360 Vss 0.00418f
C361 spike.n361 Vss 0.0041f
C362 spike.n362 Vss 0.0062f
C363 spike.n363 Vss 0.0062f
C364 spike.n364 Vss 0.0062f
C365 spike.n365 Vss 0.0062f
C366 spike.n366 Vss 0.0041f
C367 spike.n367 Vss 0.00418f
C368 spike.n368 Vss 0
C369 spike.n369 Vss 0
C370 spike.n370 Vss 0.01069f
C371 spike.n371 Vss 0.01069f
C372 spike.n372 Vss 0
C373 spike.n373 Vss 0
C374 spike.n374 Vss 0.00418f
C375 spike.n375 Vss 0
C376 spike.n376 Vss 0
C377 spike.n377 Vss 0.00418f
C378 spike.n378 Vss 0
C379 spike.n379 Vss 0
C380 spike.n380 Vss 0
C381 spike.n381 Vss 0.01069f
C382 spike.n382 Vss 0
C383 spike.n383 Vss 0
C384 spike.n384 Vss 0.00418f
C385 spike.n385 Vss 0.0041f
C386 spike.n386 Vss 0.0062f
C387 spike.n387 Vss 0.0062f
C388 spike.n388 Vss 0.0062f
C389 spike.n389 Vss 0.0062f
C390 spike.n390 Vss 0.0062f
C391 spike.n391 Vss 0.0062f
C392 spike.n392 Vss 0.0041f
C393 spike.n393 Vss 0.00418f
C394 spike.n394 Vss 0
C395 spike.n395 Vss 0
C396 spike.n396 Vss 0.01069f
C397 spike.n397 Vss 0
C398 spike.n398 Vss 0
C399 spike.n399 Vss 0
C400 spike.n400 Vss 0.00418f
C401 spike.n401 Vss 0
C402 spike.n402 Vss 0
C403 spike.n403 Vss 0.003f
C404 spike.n404 Vss 0
C405 spike.n405 Vss 0
C406 spike.n406 Vss 0.01069f
C407 spike.n407 Vss 0.01069f
C408 spike.n408 Vss 0
C409 spike.n409 Vss 0
C410 spike.n410 Vss 0.00418f
C411 spike.n411 Vss 0
C412 spike.n412 Vss 0
C413 spike.n413 Vss 0.00418f
C414 spike.n414 Vss 0
C415 spike.n415 Vss 0
C416 spike.n416 Vss 0
C417 spike.n417 Vss 0.01069f
C418 spike.n418 Vss 0
C419 spike.n419 Vss 0
C420 spike.n420 Vss 0.00418f
C421 spike.n421 Vss 0.0041f
C422 spike.n422 Vss 0.0062f
C423 spike.n423 Vss 0.0062f
C424 spike.n424 Vss 0.0062f
C425 spike.n425 Vss 0.0062f
C426 spike.n426 Vss 0.0041f
C427 spike.n427 Vss 0.00418f
C428 spike.n428 Vss 0
C429 spike.n429 Vss 0
C430 spike.n430 Vss 0.01069f
C431 spike.n431 Vss 0.01069f
C432 spike.n432 Vss 0
C433 spike.n433 Vss 0
C434 spike.n434 Vss 0.00418f
C435 spike.n435 Vss 0
C436 spike.n436 Vss 0
C437 spike.n437 Vss 0.00418f
C438 spike.n438 Vss 0
C439 spike.n439 Vss 0
C440 spike.n440 Vss 0
C441 spike.n441 Vss 0.01069f
C442 spike.n442 Vss 0
C443 spike.n443 Vss 0
C444 spike.n444 Vss 0.00418f
C445 spike.n445 Vss 0.0041f
C446 spike.n446 Vss 0.0062f
C447 spike.n447 Vss 0.02603f
C448 spike.n448 Vss 0.0041f
C449 spike.n449 Vss 0.00418f
C450 spike.n450 Vss 0
C451 spike.n451 Vss 0
C452 spike.n452 Vss 0
C453 spike.n453 Vss 0.01069f
C454 spike.n454 Vss 0
C455 spike.n455 Vss 0
C456 spike.n456 Vss 0.00505f
C457 spike.n457 Vss 0
C458 spike.n458 Vss 0
C459 spike.n459 Vss 0
C460 spike.n460 Vss 0
C461 spike.n461 Vss 0.00363f
C462 spike.n462 Vss 0
C463 spike.n463 Vss 0.00434f
C464 spike.n464 Vss 0
C465 spike.n465 Vss 0
C466 spike.n466 Vss 0.01069f
C467 spike.n467 Vss 0
C468 spike.n468 Vss 0
C469 spike.n469 Vss 0
C470 spike.n470 Vss 0
C471 spike.n471 Vss 0
C472 spike.n472 Vss 0
C473 spike.n473 Vss 0
C474 spike.n474 Vss 0
C475 spike.n475 Vss 0
C476 spike.n476 Vss 0
C477 spike.n477 Vss 0
C478 spike.n478 Vss 0
C479 spike.n479 Vss 0
C480 spike.n480 Vss 0
C481 spike.n481 Vss 0
C482 spike.n482 Vss 0
C483 spike.n483 Vss 0
C484 spike.n484 Vss 0
C485 spike.n485 Vss 0
C486 spike.n486 Vss 0
C487 spike.n487 Vss 0
C488 spike.n488 Vss 0
C489 spike.n489 Vss 0
C490 spike.n490 Vss 0
C491 spike.n491 Vss 0
C492 spike.n492 Vss 0
C493 spike.n493 Vss 0
C494 spike.n494 Vss 0
C495 spike.n495 Vss 0
C496 spike.n496 Vss 0
C497 spike.n497 Vss 0
C498 spike.n498 Vss 0
C499 spike.n499 Vss 0
C500 spike.n500 Vss 0
C501 spike.n501 Vss 0.00348f
C502 spike.n502 Vss 0.00388f
C503 spike.n503 Vss 0
C504 spike.n504 Vss 0
C505 spike.n505 Vss 0
C506 spike.n506 Vss 0
C507 spike.n507 Vss 0
C508 spike.n508 Vss 0
C509 spike.n509 Vss 0
C510 spike.n510 Vss 0
C511 spike.n511 Vss 0.00379f
C512 spike.n512 Vss 0
C513 spike.n513 Vss 0
C514 spike.n514 Vss 0
C515 spike.n515 Vss 0
C516 spike.n516 Vss 0
C517 spike.n517 Vss 0
C518 spike.n518 Vss 0
C519 spike.n519 Vss 0
C520 spike.n520 Vss 0
C521 spike.n521 Vss 0
C522 spike.n522 Vss 0.00348f
C523 spike.n523 Vss 0.00418f
C524 spike.n524 Vss 0
C525 spike.n525 Vss 0
C526 spike.n526 Vss 0
C527 spike.n527 Vss 0
C528 spike.n528 Vss 0
C529 spike.n529 Vss 0.00405f
C530 spike.n530 Vss 0.00348f
C531 spike.n531 Vss 0
C532 spike.n532 Vss 0.00192f
C533 spike.n533 Vss 0.00177f
C534 spike.n534 Vss 0.00177f
C535 spike.n535 Vss 0.00181f
C536 spike.n536 Vss 0.00181f
C537 spike.n537 Vss 0
C538 spike.n538 Vss 0
C539 spike.n539 Vss 0.00348f
C540 spike.n540 Vss 0.00383f
C541 spike.n541 Vss 0
C542 spike.n542 Vss 0
C543 spike.n543 Vss 0
C544 spike.n544 Vss 0
C545 spike.n545 Vss 0
C546 spike.n546 Vss 0.002f
C547 spike.n547 Vss 0.00979f
C548 spike.n548 Vss 0.01152f
C549 spike.n549 Vss 0.0197f
C550 spike.n550 Vss 0.03293f
C551 spike.n551 Vss 0
C552 spike.n552 Vss 0
C553 spike.n553 Vss 0.00164f
C554 spike.n554 Vss 0
C555 spike.n555 Vss 0
C556 spike.n556 Vss 0
C557 spike.n557 Vss 0
C558 spike.n558 Vss 0.00348f
C559 spike.n559 Vss 0.00348f
C560 spike.n560 Vss 0
C561 spike.n561 Vss 0
C562 spike.n562 Vss 0.00181f
C563 spike.n563 Vss 0.00177f
C564 spike.n564 Vss 0.00177f
C565 spike.n565 Vss 0.00181f
C566 spike.n566 Vss 0
C567 spike.n567 Vss 0
C568 spike.n568 Vss 0
C569 spike.n569 Vss 0.00348f
C570 spike.n570 Vss 0.00597f
C571 spike.n571 Vss 0
C572 spike.n572 Vss 0
C573 spike.n573 Vss 0
C574 spike.n575 Vss 0
C575 spike.n576 Vss 0
C576 spike.n577 Vss 0.00348f
C577 spike.n578 Vss 0.00348f
C578 spike.n579 Vss 0
C579 spike.n580 Vss 0
C580 spike.n581 Vss 0.00489f
C581 spike.n582 Vss 0.00192f
C582 spike.n583 Vss 0.00113f
C583 spike.n584 Vss 0.00192f
C584 spike.n585 Vss 0.00113f
C585 spike.n586 Vss 0
C586 spike.n587 Vss 0
C587 spike.n588 Vss 0.00354f
C588 spike.n589 Vss 0
C589 spike.n590 Vss 0
C590 spike.n591 Vss 0
C591 spike.n592 Vss 0
C592 spike.n593 Vss 0
C593 spike.n594 Vss 0
C594 spike.n595 Vss 0
C595 spike.n596 Vss 0.00512f
C596 spike.n597 Vss 0.00354f
C597 spike.n598 Vss 0
C598 spike.n599 Vss 0
C599 spike.n600 Vss 0.00579f
C600 spike.n601 Vss 0.00192f
C601 spike.n602 Vss 0.00113f
C602 spike.n603 Vss 0
C603 spike.n604 Vss 0
C604 spike.n605 Vss 0
C605 spike.n606 Vss 0
C606 spike.n607 Vss 0
C607 spike.n608 Vss 0
C608 spike.n609 Vss 0
C609 spike.n610 Vss 0
C610 spike.n611 Vss 0
C611 spike.n612 Vss 0.00354f
C612 spike.n613 Vss 0.00512f
C613 spike.n614 Vss 0.00354f
C614 spike.n615 Vss 0
C615 spike.n616 Vss 0
C616 spike.n617 Vss 0.00855f
C617 spike.n618 Vss 0.00734f
C618 spike.n619 Vss 0.00607f
C619 spike.n620 Vss 0
C620 spike.n621 Vss 0
C621 spike.n622 Vss 0
C622 spike.n623 Vss 0
C623 spike.n624 Vss 0
C624 spike.n625 Vss 0
C625 spike.n626 Vss 0
C626 spike.n627 Vss 0
C627 spike.n628 Vss 0
C628 spike.n629 Vss 0.00354f
C629 spike.n630 Vss 0.00512f
C630 spike.n631 Vss 0.00354f
C631 spike.n632 Vss 0
C632 spike.n633 Vss 0
C633 spike.n634 Vss 0.00356f
C634 spike.n635 Vss 0.00288f
C635 spike_neg.n0 Vss 0.00105f
C636 spike_neg.n1 Vss 0
C637 spike_neg.n2 Vss 0.00105f
C638 spike_neg.n3 Vss 0
C639 spike_neg.n4 Vss 0
C640 spike_neg.n5 Vss 0
C641 spike_neg.n6 Vss 0.00194f
C642 spike_neg.n7 Vss 0
C643 spike_neg.n8 Vss 0
C644 spike_neg.n9 Vss 0
C645 spike_neg.n10 Vss 0
C646 spike_neg.n11 Vss 0
C647 spike_neg.n12 Vss 0
C648 spike_neg.n13 Vss 0
C649 spike_neg.n14 Vss 0.0028f
C650 spike_neg.n15 Vss 0.00194f
C651 spike_neg.n16 Vss 0
C652 spike_neg.n17 Vss 0
C653 spike_neg.n18 Vss 0.00317f
C654 spike_neg.n19 Vss 0.00105f
C655 spike_neg.n20 Vss 0
C656 spike_neg.n21 Vss 0
C657 spike_neg.n22 Vss 0
C658 spike_neg.n23 Vss 0
C659 spike_neg.n24 Vss 0
C660 spike_neg.n25 Vss 0
C661 spike_neg.n26 Vss 0
C662 spike_neg.n27 Vss 0
C663 spike_neg.n28 Vss 0
C664 spike_neg.n29 Vss 0
C665 spike_neg.n30 Vss 0.00194f
C666 spike_neg.n31 Vss 0.0028f
C667 spike_neg.n32 Vss 0.00194f
C668 spike_neg.n33 Vss 0
C669 spike_neg.n34 Vss 0
C670 spike_neg.n35 Vss 0.00105f
C671 spike_neg.n36 Vss 0
C672 spike_neg.n37 Vss 0.00548f
C673 spike_neg.n38 Vss 0
C674 spike_neg.n39 Vss 0
C675 spike_neg.n40 Vss 0.00332f
C676 spike_neg.n41 Vss 0
C677 spike_neg.n42 Vss 0
C678 spike_neg.n43 Vss 0.00191f
C679 spike_neg.n44 Vss 0
C680 spike_neg.n45 Vss 0
C681 spike_neg.n46 Vss 0
C682 spike_neg.n47 Vss 0
C683 spike_neg.n48 Vss 0
C684 spike_neg.n49 Vss 0
C685 spike_neg.n50 Vss 0.00196f
C686 spike_neg.n51 Vss 0
C687 spike_neg.n52 Vss 0.00229f
C688 spike_neg.n53 Vss 0
C689 spike_neg.n54 Vss 0
C690 spike_neg.n55 Vss 0
C691 spike_neg.n56 Vss 0
C692 spike_neg.n57 Vss 0
C693 spike_neg.n58 Vss 0
C694 spike_neg.n59 Vss 0
C695 spike_neg.n60 Vss 0.00332f
C696 spike_neg.n61 Vss 0
C697 spike_neg.n62 Vss 0
C698 spike_neg.n63 Vss 0.00191f
C699 spike_neg.n64 Vss 0
C700 spike_neg.n65 Vss 0
C701 spike_neg.n66 Vss 0
C702 spike_neg.n67 Vss 0
C703 spike_neg.n68 Vss 0.00204f
C704 spike_neg.n69 Vss 0
C705 spike_neg.n70 Vss 0
C706 spike_neg.n71 Vss 0.00332f
C707 spike_neg.n72 Vss 0
C708 spike_neg.n73 Vss 0
C709 spike_neg.n74 Vss 0
C710 spike_neg.n75 Vss 0
C711 spike_neg.n76 Vss 0
C712 spike_neg.n77 Vss 0.00105f
C713 spike_neg.n78 Vss 0
C714 spike_neg.n79 Vss 0.00265f
C715 spike_neg.n80 Vss 0.00265f
C716 spike_neg.n81 Vss 0.00523f
C717 spike_neg.n82 Vss 0
C718 spike_neg.n83 Vss 0.00191f
C719 spike_neg.n84 Vss 0
C720 spike_neg.n85 Vss 0
C721 spike_neg.n86 Vss 0
C722 spike_neg.n87 Vss 0
C723 spike_neg.n88 Vss 0
C724 spike_neg.n89 Vss 0
C725 spike_neg.n90 Vss 0
C726 spike_neg.n91 Vss 0
C727 spike_neg.n92 Vss 0.00313f
C728 spike_neg.n93 Vss 0
C729 spike_neg.n94 Vss 0
C730 spike_neg.n95 Vss 0.00191f
C731 spike_neg.n96 Vss 0
C732 spike_neg.n97 Vss 0
C733 spike_neg.n98 Vss 0
C734 spike_neg.n99 Vss 0
C735 spike_neg.n100 Vss 0
C736 spike_neg.n101 Vss 0
C737 spike_neg.n102 Vss 0
C738 spike_neg.n103 Vss 0
C739 spike_neg.n104 Vss 0
C740 spike_neg.n105 Vss 0
C741 spike_neg.n106 Vss 0.00191f
C742 spike_neg.n107 Vss 0.00332f
C743 spike_neg.n108 Vss 0
C744 spike_neg.n109 Vss 0.00198f
C745 spike_neg.n110 Vss 0
C746 spike_neg.n111 Vss 0
C747 spike_neg.n112 Vss 0
C748 spike_neg.n113 Vss 0
C749 spike_neg.n114 Vss 0
C750 spike_neg.n115 Vss 0
C751 spike_neg.n116 Vss 0
C752 spike_neg.n117 Vss 0
C753 spike_neg.n118 Vss 0
C754 spike_neg.n119 Vss 0
C755 spike_neg.n120 Vss 0
C756 spike_neg.n121 Vss 0
C757 spike_neg.n122 Vss 0
C758 spike_neg.n123 Vss 0
C759 spike_neg.n124 Vss 0
C760 spike_neg.n125 Vss 0
C761 spike_neg.n126 Vss -0
C762 spike_neg.n127 Vss 0
C763 spike_neg.n128 Vss 0.00585f
C764 spike_neg.n129 Vss 0
C765 spike_neg.n130 Vss 0
C766 spike_neg.n131 Vss 0.00454f
C767 spike_neg.n132 Vss 0
C768 spike_neg.n133 Vss 0
C769 spike_neg.n134 Vss 0.00242f
C770 spike_neg.n135 Vss 0
C771 spike_neg.n136 Vss 0
C772 spike_neg.n137 Vss 0
C773 spike_neg.n138 Vss 0
C774 spike_neg.n139 Vss 0.00585f
C775 spike_neg.n140 Vss 0
C776 spike_neg.n141 Vss 0
C777 spike_neg.n142 Vss 0.00229f
C778 spike_neg.n143 Vss 0.0034f
C779 spike_neg.n144 Vss 0.00225f
C780 spike_neg.n145 Vss 0
C781 spike_neg.n146 Vss 0
C782 spike_neg.n147 Vss 0
C783 spike_neg.n148 Vss 0
C784 spike_neg.n149 Vss 0
C785 spike_neg.n150 Vss 0
C786 spike_neg.n151 Vss 0
C787 spike_neg.n152 Vss 0.00585f
C788 spike_neg.n153 Vss 0.00585f
C789 spike_neg.n154 Vss 0
C790 spike_neg.n155 Vss 0
C791 spike_neg.n156 Vss 0.00225f
C792 spike_neg.n157 Vss 0
C793 spike_neg.n158 Vss 0.00225f
C794 spike_neg.n159 Vss 0
C795 spike_neg.n160 Vss 0
C796 spike_neg.n161 Vss 0.00585f
C797 spike_neg.n162 Vss 0
C798 spike_neg.n163 Vss 0
C799 spike_neg.n164 Vss 0.00229f
C800 spike_neg.n165 Vss 0.0034f
C801 spike_neg.n166 Vss 0.00225f
C802 spike_neg.n167 Vss 0
C803 spike_neg.n168 Vss 0
C804 spike_neg.n169 Vss 0
C805 spike_neg.n170 Vss 0
C806 spike_neg.n171 Vss 0
C807 spike_neg.n172 Vss 0
C808 spike_neg.n173 Vss 0
C809 spike_neg.n174 Vss 0.00585f
C810 spike_neg.n175 Vss 0
C811 spike_neg.n176 Vss 0
C812 spike_neg.n177 Vss 0.00225f
C813 spike_neg.n178 Vss 0.01969f
C814 spike_neg.n179 Vss 0.00774f
C815 spike_neg.n180 Vss 0.00112f
C816 spike_neg.n181 Vss 0
C817 spike_neg.n182 Vss 0
C818 spike_neg.n183 Vss 0.00585f
C819 spike_neg.n184 Vss 0
C820 spike_neg.n185 Vss 0
C821 spike_neg.n186 Vss 0.00225f
C822 spike_neg.n187 Vss 0
C823 spike_neg.n188 Vss 0.00225f
C824 spike_neg.n189 Vss 0
C825 spike_neg.n190 Vss 0
C826 spike_neg.n191 Vss 0.00585f
C827 spike_neg.n192 Vss 0
C828 spike_neg.n193 Vss 0
C829 spike_neg.n194 Vss 0.00229f
C830 spike_neg.n195 Vss 0.0034f
C831 spike_neg.n196 Vss 0.00225f
C832 spike_neg.n197 Vss 0
C833 spike_neg.n198 Vss 0
C834 spike_neg.n199 Vss 0
C835 spike_neg.n200 Vss 0
C836 spike_neg.n201 Vss 0
C837 spike_neg.n202 Vss 0
C838 spike_neg.n203 Vss 0.00585f
C839 spike_neg.n204 Vss 0
C840 spike_neg.n205 Vss 0
C841 spike_neg.n206 Vss 0.00225f
C842 spike_neg.n207 Vss 0
C843 spike_neg.n208 Vss 0.00225f
C844 spike_neg.n209 Vss 0
C845 spike_neg.n210 Vss 0
C846 spike_neg.n211 Vss 0.00585f
C847 spike_neg.n212 Vss 0
C848 spike_neg.n213 Vss 0
C849 spike_neg.n214 Vss 0.00229f
C850 spike_neg.n215 Vss 0.0034f
C851 spike_neg.n216 Vss 0.00225f
C852 spike_neg.n217 Vss 0
C853 spike_neg.n218 Vss 0
C854 spike_neg.n219 Vss 0
C855 spike_neg.n220 Vss 0
C856 spike_neg.n221 Vss 0
C857 spike_neg.n222 Vss 0
C858 spike_neg.n223 Vss 0
C859 spike_neg.n224 Vss 0.00585f
C860 spike_neg.n225 Vss 0
C861 spike_neg.n226 Vss 0
C862 spike_neg.n227 Vss 0.00225f
C863 spike_neg.n228 Vss 0
C864 spike_neg.n229 Vss 0.00225f
C865 spike_neg.n230 Vss 0
C866 spike_neg.n231 Vss 0
C867 spike_neg.n232 Vss 0.00585f
C868 spike_neg.n233 Vss 0
C869 spike_neg.n234 Vss 0
C870 spike_neg.n235 Vss -0.004f
C871 spike_neg.n236 Vss 0
C872 spike_neg.n237 Vss 0
C873 spike_neg.n238 Vss 0
C874 spike_neg.n239 Vss 0
C875 spike_neg.n240 Vss 0.00585f
C876 spike_neg.n241 Vss 0
C877 spike_neg.n242 Vss 0
C878 spike_neg.n243 Vss 0
C879 spike_neg.n244 Vss 0
C880 spike_neg.n245 Vss 0.0034f
C881 spike_neg.n246 Vss 0.01286f
C882 spike_neg.n247 Vss 0
C883 spike_neg.n248 Vss 0
C884 spike_neg.n249 Vss 0
C885 spike_neg.n250 Vss 0.023f
C886 spike_neg.n251 Vss 0
C887 spike_neg.n252 Vss 0.00585f
C888 spike_neg.n253 Vss 0
C889 spike_neg.n254 Vss 0
C890 spike_neg.n255 Vss 0
C891 spike_neg.n256 Vss 0
C892 spike_neg.n257 Vss 0
C893 spike_neg.n258 Vss 0
C894 spike_neg.n259 Vss 0
C895 spike_neg.n260 Vss 0
C896 spike_neg.n261 Vss 0.00585f
C897 spike_neg.n262 Vss 0
C898 spike_neg.n263 Vss 0
C899 spike_neg.n264 Vss 0
C900 spike_neg.n265 Vss 0.00585f
C901 spike_neg.n266 Vss 0
C902 spike_neg.n267 Vss 0
C903 spike_neg.n268 Vss 0
C904 spike_neg.n269 Vss 0
C905 spike_neg.n270 Vss 0
C906 spike_neg.n271 Vss 0
C907 spike_neg.n272 Vss 0
C908 spike_neg.n273 Vss 0
C909 spike_neg.n274 Vss 0
C910 spike_neg.n275 Vss 0.00585f
C911 spike_neg.n276 Vss 0
C912 spike_neg.n277 Vss 0
C913 spike_neg.n278 Vss 0
C914 spike_neg.n279 Vss 0
C915 spike_neg.n280 Vss 0
C916 spike_neg.n281 Vss 0
C917 spike_neg.n282 Vss 0
C918 spike_neg.n283 Vss 0
C919 spike_neg.n284 Vss 0
C920 spike_neg.n285 Vss 0
C921 spike_neg.n286 Vss 0.00585f
C922 spike_neg.n287 Vss 0
C923 spike_neg.n288 Vss 0
C924 spike_neg.n289 Vss 0
C925 spike_neg.n290 Vss 0
C926 spike_neg.n291 Vss 0
C927 spike_neg.n292 Vss 0
C928 spike_neg.n293 Vss 0
C929 spike_neg.n294 Vss 0
C930 spike_neg.n295 Vss 0
C931 spike_neg.n296 Vss 0
C932 spike_neg.n297 Vss 0
C933 spike_neg.n298 Vss 0
C934 spike_neg.n299 Vss 0
C935 spike_neg.n300 Vss 0
C936 spike_neg.n301 Vss 0
C937 spike_neg.n302 Vss 0
C938 spike_neg.n303 Vss 0
C939 spike_neg.n304 Vss 0
C940 spike_neg.n305 Vss 0
C941 spike_neg.n306 Vss 0
C942 spike_neg.n307 Vss 0
C943 spike_neg.n308 Vss 0
C944 spike_neg.n309 Vss 0
C945 spike_neg.n310 Vss 0
C946 spike_neg.n311 Vss 0
C947 spike_neg.n312 Vss 0
C948 spike_neg.n313 Vss 0
C949 spike_neg.n314 Vss 0
C950 spike_neg.n315 Vss 0
C951 spike_neg.n316 Vss 0
C952 spike_neg.n317 Vss 0
C953 spike_neg.n318 Vss 0
C954 spike_neg.n319 Vss 0
C955 spike_neg.n320 Vss 0
C956 spike_neg.n321 Vss 0
C957 spike_neg.n322 Vss 0
C958 spike_neg.n323 Vss 0
C959 spike_neg.n324 Vss 0
C960 spike_neg.n325 Vss 0.00585f
C961 spike_neg.n326 Vss 0
C962 spike_neg.n327 Vss 0
C963 spike_neg.n328 Vss 0
C964 spike_neg.n329 Vss 0
C965 spike_neg.n330 Vss 0
C966 spike_neg.n331 Vss 0.00585f
C967 spike_neg.n332 Vss 0.00585f
C968 spike_neg.n333 Vss 0.00585f
C969 spike_neg.n334 Vss 0
C970 spike_neg.n335 Vss 0
C971 spike_neg.n336 Vss 0
C972 spike_neg.n337 Vss 0
C973 spike_neg.n338 Vss 0
C974 spike_neg.n339 Vss 0.00585f
C975 spike_neg.n340 Vss 0.00585f
C976 spike_neg.n341 Vss 0.00585f
C977 spike_neg.n342 Vss 0
C978 spike_neg.n343 Vss 0
C979 spike_neg.n344 Vss 0
C980 spike_neg.n345 Vss 0
C981 spike_neg.n346 Vss 0
C982 spike_neg.n347 Vss 0.00585f
C983 spike_neg.n348 Vss 0.00585f
C984 spike_neg.n349 Vss 0.00585f
C985 spike_neg.n350 Vss 0
C986 spike_neg.n351 Vss 0
C987 spike_neg.n352 Vss 0
C988 spike_neg.n353 Vss 0
C989 spike_neg.n354 Vss 0
C990 spike_neg.n355 Vss 0
C991 spike_neg.n356 Vss 0
C992 spike_neg.n357 Vss 0
C993 spike_neg.n359 Vss 0.00765f
C994 spike_neg.n360 Vss 0
C995 spike_neg.n361 Vss 0
C996 spike_neg.n362 Vss 0
C997 spike_neg.n363 Vss 0
C998 spike_neg.n364 Vss 0.00144f
C999 spike_neg.n365 Vss 0.00149f
C1000 spike_neg.n366 Vss 0.00123f
C1001 spike_neg.n367 Vss -0
C1002 spike_neg.n368 Vss 0
C1003 spike_neg.n369 Vss 0
C1004 spike_neg.n370 Vss 0
C1005 spike_neg.n371 Vss 0.00585f
C1006 spike_neg.n372 Vss 0
C1007 spike_neg.n373 Vss 0
C1008 spike_neg.n374 Vss 0
C1009 spike_neg.n375 Vss 0.00655f
C1010 spike_neg.n376 Vss 0
C1011 spike_neg.n377 Vss 0.00333f
C1012 spike_neg.n378 Vss 0.00406f
C1013 spike_neg.n379 Vss 0
C1014 spike_neg.n380 Vss 0
C1015 spike_neg.n381 Vss 0.00585f
C1016 spike_neg.n382 Vss 0.00585f
C1017 spike_neg.n383 Vss 0
C1018 spike_neg.n384 Vss 0
C1019 spike_neg.n385 Vss 0.00229f
C1020 spike_neg.n386 Vss 0
C1021 spike_neg.n387 Vss 0
C1022 spike_neg.n388 Vss 0.00229f
C1023 spike_neg.n389 Vss 0
C1024 spike_neg.n390 Vss 0
C1025 spike_neg.n391 Vss 0
C1026 spike_neg.n392 Vss 0.00585f
C1027 spike_neg.n393 Vss 0
C1028 spike_neg.n394 Vss 0
C1029 spike_neg.n395 Vss 0.00229f
C1030 spike_neg.n396 Vss 0.00225f
C1031 spike_neg.n397 Vss 0.0034f
C1032 spike_neg.n398 Vss 0.0034f
C1033 spike_neg.n399 Vss 0.0034f
C1034 spike_neg.n400 Vss 0.0034f
C1035 spike_neg.n401 Vss 0.00225f
C1036 spike_neg.n402 Vss 0.00229f
C1037 spike_neg.n403 Vss 0
C1038 spike_neg.n404 Vss 0
C1039 spike_neg.n405 Vss 0.00585f
C1040 spike_neg.n406 Vss 0.00585f
C1041 spike_neg.n407 Vss 0
C1042 spike_neg.n408 Vss 0
C1043 spike_neg.n409 Vss 0.00229f
C1044 spike_neg.n410 Vss 0
C1045 spike_neg.n411 Vss 0
C1046 spike_neg.n412 Vss 0.00229f
C1047 spike_neg.n413 Vss 0
C1048 spike_neg.n414 Vss 0
C1049 spike_neg.n415 Vss 0
C1050 spike_neg.n416 Vss 0.00585f
C1051 spike_neg.n417 Vss 0
C1052 spike_neg.n418 Vss 0
C1053 spike_neg.n419 Vss 0.00229f
C1054 spike_neg.n420 Vss 0.00225f
C1055 spike_neg.n421 Vss 0.0034f
C1056 spike_neg.n422 Vss 0.0034f
C1057 spike_neg.n423 Vss 0.0034f
C1058 spike_neg.n424 Vss 0.0034f
C1059 spike_neg.n425 Vss 0.0034f
C1060 spike_neg.n426 Vss 0.0034f
C1061 spike_neg.n427 Vss 0.00225f
C1062 spike_neg.n428 Vss 0.00229f
C1063 spike_neg.n429 Vss 0
C1064 spike_neg.n430 Vss 0
C1065 spike_neg.n431 Vss 0.00585f
C1066 spike_neg.n432 Vss 0
C1067 spike_neg.n433 Vss 0
C1068 spike_neg.n434 Vss 0
C1069 spike_neg.n435 Vss 0.00229f
C1070 spike_neg.n436 Vss 0
C1071 spike_neg.n437 Vss 0
C1072 spike_neg.n438 Vss 0.00164f
C1073 spike_neg.n439 Vss 0
C1074 spike_neg.n440 Vss 0
C1075 spike_neg.n441 Vss 0.00585f
C1076 spike_neg.n442 Vss 0.00585f
C1077 spike_neg.n443 Vss 0
C1078 spike_neg.n444 Vss 0
C1079 spike_neg.n445 Vss 0.00229f
C1080 spike_neg.n446 Vss 0
C1081 spike_neg.n447 Vss 0
C1082 spike_neg.n448 Vss 0.00229f
C1083 spike_neg.n449 Vss 0
C1084 spike_neg.n450 Vss 0
C1085 spike_neg.n451 Vss 0
C1086 spike_neg.n452 Vss 0.00585f
C1087 spike_neg.n453 Vss 0
C1088 spike_neg.n454 Vss 0
C1089 spike_neg.n455 Vss 0.00229f
C1090 spike_neg.n456 Vss 0.00225f
C1091 spike_neg.n457 Vss 0.0034f
C1092 spike_neg.n458 Vss 0.0034f
C1093 spike_neg.n459 Vss 0.0034f
C1094 spike_neg.n460 Vss 0.0034f
C1095 spike_neg.n461 Vss 0.00225f
C1096 spike_neg.n462 Vss 0.00229f
C1097 spike_neg.n463 Vss 0
C1098 spike_neg.n464 Vss 0
C1099 spike_neg.n465 Vss 0.00585f
C1100 spike_neg.n466 Vss 0.00585f
C1101 spike_neg.n467 Vss 0
C1102 spike_neg.n468 Vss 0
C1103 spike_neg.n469 Vss 0.00229f
C1104 spike_neg.n470 Vss 0
C1105 spike_neg.n471 Vss 0
C1106 spike_neg.n472 Vss 0.00229f
C1107 spike_neg.n473 Vss 0
C1108 spike_neg.n474 Vss 0
C1109 spike_neg.n475 Vss 0
C1110 spike_neg.n476 Vss 0.00585f
C1111 spike_neg.n477 Vss 0
C1112 spike_neg.n478 Vss 0
C1113 spike_neg.n479 Vss 0.00229f
C1114 spike_neg.n480 Vss 0.00225f
C1115 spike_neg.n481 Vss 0.0034f
C1116 spike_neg.n482 Vss 0.01426f
C1117 spike_neg.n483 Vss 0.00225f
C1118 spike_neg.n484 Vss 0.00229f
C1119 spike_neg.n485 Vss 0
C1120 spike_neg.n486 Vss 0
C1121 spike_neg.n487 Vss 0
C1122 spike_neg.n488 Vss 0.00585f
C1123 spike_neg.n489 Vss 0
C1124 spike_neg.n490 Vss 0
C1125 spike_neg.n491 Vss 0.00277f
C1126 spike_neg.n492 Vss 0
C1127 spike_neg.n493 Vss 0
C1128 spike_neg.n494 Vss 0
C1129 spike_neg.n495 Vss 0
C1130 spike_neg.n496 Vss 0.00199f
C1131 spike_neg.n497 Vss 0
C1132 spike_neg.n498 Vss 0.00237f
C1133 spike_neg.n499 Vss 0
C1134 spike_neg.n500 Vss 0
C1135 spike_neg.n501 Vss 0.00585f
C1136 spike_neg.n502 Vss 0
C1137 spike_neg.n503 Vss 0
C1138 spike_neg.n504 Vss 0
C1139 spike_neg.n505 Vss 0
C1140 spike_neg.n506 Vss 0
C1141 spike_neg.n507 Vss 0
C1142 spike_neg.n508 Vss 0
C1143 spike_neg.n509 Vss 0
C1144 spike_neg.n510 Vss 0
C1145 spike_neg.n511 Vss 0
C1146 spike_neg.n512 Vss 0
C1147 spike_neg.n513 Vss 0
C1148 spike_neg.n514 Vss 0
C1149 spike_neg.n515 Vss 0
C1150 spike_neg.n516 Vss 0
C1151 spike_neg.n517 Vss 0
C1152 spike_neg.n518 Vss 0
C1153 spike_neg.n519 Vss 0
C1154 spike_neg.n520 Vss 0
C1155 spike_neg.n521 Vss 0
C1156 spike_neg.n522 Vss 0
C1157 spike_neg.n523 Vss 0
C1158 spike_neg.n524 Vss 0
C1159 spike_neg.n525 Vss 0
C1160 spike_neg.n526 Vss 0
C1161 spike_neg.n527 Vss 0
C1162 spike_neg.n528 Vss 0
C1163 spike_neg.n529 Vss 0
C1164 spike_neg.n530 Vss 0
C1165 spike_neg.n531 Vss 0
C1166 spike_neg.n532 Vss 0
C1167 spike_neg.n533 Vss 0
C1168 spike_neg.n534 Vss 0
C1169 spike_neg.n535 Vss 0
C1170 spike_neg.n536 Vss 0.00191f
C1171 spike_neg.n537 Vss 0.00212f
C1172 spike_neg.n538 Vss 0
C1173 spike_neg.n539 Vss 0
C1174 spike_neg.n540 Vss 0
C1175 spike_neg.n541 Vss 0
C1176 spike_neg.n542 Vss 0
C1177 spike_neg.n543 Vss 0
C1178 spike_neg.n544 Vss 0
C1179 spike_neg.n545 Vss 0
C1180 spike_neg.n546 Vss 0.00208f
C1181 spike_neg.n547 Vss 0
C1182 spike_neg.n548 Vss 0
C1183 spike_neg.n549 Vss 0
C1184 spike_neg.n550 Vss 0
C1185 spike_neg.n551 Vss 0
C1186 spike_neg.n552 Vss 0
C1187 spike_neg.n553 Vss 0
C1188 spike_neg.n554 Vss 0
C1189 spike_neg.n555 Vss 0
C1190 spike_neg.n556 Vss 0
C1191 spike_neg.n557 Vss 0.00191f
C1192 spike_neg.n558 Vss 0.00229f
C1193 spike_neg.n559 Vss 0
C1194 spike_neg.n560 Vss 0
C1195 spike_neg.n561 Vss 0
C1196 spike_neg.n562 Vss 0
C1197 spike_neg.n563 Vss 0
C1198 spike_neg.n564 Vss 0.00222f
C1199 spike_neg.n565 Vss 0.00191f
C1200 spike_neg.n566 Vss 0
C1201 spike_neg.n567 Vss 0.00105f
C1202 spike_neg.n568 Vss 0
C1203 spike_neg.n569 Vss 0
C1204 spike_neg.n570 Vss 0
C1205 spike_neg.n571 Vss 0
C1206 spike_neg.n572 Vss 0
C1207 spike_neg.n573 Vss 0
C1208 spike_neg.n574 Vss 0.00191f
C1209 spike_neg.n575 Vss 0.0021f
C1210 spike_neg.n576 Vss 0
C1211 spike_neg.n577 Vss 0
C1212 spike_neg.n578 Vss 0
C1213 spike_neg.n579 Vss 0
C1214 spike_neg.n580 Vss 0
C1215 spike_neg.n581 Vss 0.0011f
C1216 spike_neg.n582 Vss 0.00536f
C1217 spike_neg.n583 Vss 0.00631f
C1218 spike_neg.n584 Vss 0.01079f
C1219 spike_neg.n585 Vss 0.01803f
C1220 spike_neg.n586 Vss 0
C1221 spike_neg.n587 Vss 0
C1222 spike_neg.n588 Vss 0
C1223 spike_neg.n589 Vss 0
C1224 spike_neg.n590 Vss 0
C1225 spike_neg.n591 Vss 0
C1226 spike_neg.n592 Vss 0
C1227 spike_neg.n593 Vss 0.00191f
C1228 spike_neg.n594 Vss 0.00191f
C1229 spike_neg.n595 Vss 0
C1230 spike_neg.n596 Vss 0
C1231 spike_neg.n597 Vss 0
C1232 spike_neg.n598 Vss 0
C1233 spike_neg.n599 Vss 0
C1234 spike_neg.n600 Vss 0
C1235 spike_neg.n601 Vss 0
C1236 spike_neg.n602 Vss 0
C1237 spike_neg.n603 Vss 0
C1238 spike_neg.n604 Vss 0.00191f
C1239 spike_neg.n605 Vss 0.00327f
C1240 spike_neg.n606 Vss 0
C1241 spike_neg.n607 Vss 0
C1242 spike_neg.n608 Vss 0
C1243 spike_neg.n610 Vss 0
C1244 spike_neg.n611 Vss 0
C1245 spike_neg.n612 Vss 0.00191f
C1246 spike_neg.n613 Vss 0.00191f
C1247 spike_neg.n614 Vss 0
C1248 spike_neg.n615 Vss 0
C1249 spike_neg.n616 Vss 0.00268f
C1250 spike_neg.n617 Vss 0.00158f
C1251 spike_neg.n618 Vss 0.00195f
C1252 spike_neg.n619 Vss 0.00333f
C1253 spike_neg.n620 Vss 0.00402f
C1254 spike_neg.n621 Vss 0
C1255 spike_neg.n622 Vss 0
C1256 spike_neg.n623 Vss 0
C1257 spike_neg.n624 Vss 0
C1258 spike_neg.n625 Vss 0
C1259 spike_neg.n626 Vss 0
C1260 spike_neg.n627 Vss 0
C1261 spike_neg.n628 Vss 0
C1262 spike_neg.n629 Vss 0
C1263 spike_neg.n630 Vss 0.00194f
C1264 spike_neg.n631 Vss 0.0028f
C1265 spike_neg.n632 Vss 0.00194f
C1266 spike_neg.n633 Vss 0
C1267 spike_neg.n634 Vss 0
C1268 spike_neg.n635 Vss 0.00468f
C1269 Iin.n0 Vss 0
C1270 Iin.n1 Vss 0
C1271 Iin.n2 Vss 0
C1272 Iin.n3 Vss 0
C1273 Iin.n4 Vss 0
C1274 Iin.n5 Vss 0
C1275 Iin.n6 Vss 0
C1276 Iin.n7 Vss 0
C1277 Iin.n8 Vss 0
C1278 Iin.n9 Vss 0
C1279 Iin.n10 Vss 0
C1280 Iin.n11 Vss 0
C1281 Iin.n12 Vss 0
C1282 Iin.n13 Vss 0
C1283 Iin.n14 Vss 0
C1284 Iin.n15 Vss 0
C1285 Iin.n16 Vss 0
C1286 Iin.n17 Vss 0
C1287 Iin.n18 Vss 0
C1288 Iin.n19 Vss 0
C1289 Iin.n20 Vss 0
C1290 Iin.n21 Vss 0
C1291 Iin.n22 Vss 0
C1292 Iin.n23 Vss 0
C1293 Iin.n24 Vss 0
C1294 Iin.n25 Vss 0
C1295 Iin.n26 Vss 0
C1296 Iin.n27 Vss 0
C1297 Iin.n28 Vss 0
C1298 Iin.n29 Vss 0
C1299 Iin.n30 Vss 0
C1300 Iin.n31 Vss 0
C1301 Iin.n32 Vss 0
C1302 Iin.n33 Vss 0
C1303 Iin.n34 Vss 0
C1304 Iin.n35 Vss 0
C1305 Iin.n36 Vss 0
C1306 Iin.n37 Vss 0
C1307 Iin.n38 Vss 0
C1308 Iin.n39 Vss 0.00112f
C1309 Iin.n40 Vss 0
C1310 Iin.n41 Vss 0
C1311 Iin.n42 Vss 0
C1312 Iin.n43 Vss 0
C1313 Iin.n44 Vss 0
C1314 Iin.n45 Vss 0
C1315 Iin.n46 Vss 0
C1316 Iin.n47 Vss 0
C1317 Iin.n48 Vss 0.00144f
C1318 Iin.n49 Vss 0
C1319 Iin.n50 Vss 0
C1320 Iin.n51 Vss 0
C1321 Iin.n52 Vss 0
C1322 Iin.n53 Vss 0
C1323 Iin.n54 Vss 0
C1324 Iin.n55 Vss 0
C1325 Iin.n56 Vss 0
C1326 Iin.n57 Vss 0
C1327 Iin.n58 Vss 0
C1328 Iin.n59 Vss 0
C1329 Iin.n60 Vss 0
C1330 Iin.n61 Vss 0
C1331 Iin.n62 Vss 0
C1332 Iin.n63 Vss 0
C1333 Iin.n64 Vss 0
C1334 Iin.n65 Vss 0
C1335 Iin.n66 Vss 0
C1336 Iin.n67 Vss 0
C1337 Iin.n68 Vss 0
C1338 Iin.n69 Vss 0
C1339 Iin.n70 Vss 0
C1340 Iin.n71 Vss 0
C1341 Iin.n72 Vss 0
C1342 Iin.n73 Vss 0
C1343 Iin.n74 Vss 0
C1344 Iin.n75 Vss 0
C1345 Iin.n76 Vss 0
C1346 Iin.n77 Vss 0
C1347 Iin.n78 Vss 0
C1348 Iin.n79 Vss 0
C1349 Iin.n80 Vss 0
C1350 Iin.n81 Vss 0
C1351 Iin.n82 Vss 0
C1352 Iin.n83 Vss 0
C1353 Iin.n84 Vss 0
C1354 Iin.n85 Vss 0
C1355 Iin.n86 Vss 0
C1356 Iin.n87 Vss 0
C1357 Iin.n88 Vss 0
C1358 Iin.n89 Vss 0
C1359 Iin.n90 Vss 0
C1360 Iin.n91 Vss 0
C1361 Iin.n92 Vss 0
C1362 Iin.n93 Vss 0
C1363 Iin.n94 Vss 0
C1364 Iin.n95 Vss 0
C1365 Iin.n96 Vss 0
C1366 Iin.n97 Vss 0
C1367 Iin.n98 Vss 0
C1368 Iin.n99 Vss 0
C1369 Iin.n100 Vss 0
C1370 Iin.n101 Vss 0
C1371 Iin.n102 Vss 0
C1372 Iin.n103 Vss 0
C1373 Iin.n104 Vss 0
C1374 Iin.n105 Vss 0
C1375 Iin.n106 Vss 0
C1376 Iin.n107 Vss 0
C1377 Iin.n108 Vss 0
C1378 Iin.n109 Vss 0
C1379 Iin.n110 Vss 0
C1380 Iin.n111 Vss 0
C1381 Iin.n112 Vss 0
C1382 Iin.n113 Vss 0
C1383 Iin.n114 Vss 0
C1384 Iin.n115 Vss 0
C1385 Iin.n116 Vss 0
C1386 Iin.n117 Vss 0
C1387 Iin.n118 Vss 0
C1388 Iin.n119 Vss 0
C1389 Iin.n120 Vss 0
C1390 Iin.n121 Vss 0
C1391 Iin.n122 Vss 0
C1392 Iin.n123 Vss 0.00115f
C1393 Iin.n124 Vss 0
C1394 Iin.n125 Vss 0
C1395 Iin.n126 Vss 0
C1396 Iin.n127 Vss 0
C1397 Iin.n128 Vss 0
C1398 Iin.n129 Vss 0
C1399 Iin.n130 Vss 0
C1400 Iin.n131 Vss 0
C1401 Iin.n132 Vss 0
C1402 Iin.n133 Vss 0
C1403 Iin.n134 Vss 0
C1404 Iin.n135 Vss 0
C1405 Iin.n136 Vss 0
C1406 Iin.n137 Vss 0
C1407 Iin.n138 Vss 0
C1408 Iin.n139 Vss 0
C1409 Iin.n140 Vss 0
C1410 Iin.n141 Vss 0
C1411 Iin.n142 Vss 0
C1412 Iin.n143 Vss 0
C1413 Iin.n144 Vss 0
C1414 Iin.n145 Vss 0
C1415 Iin.n146 Vss 0
C1416 Iin.n147 Vss 0
C1417 Iin.n148 Vss 0
C1418 Iin.n149 Vss 0
C1419 Iin.n150 Vss 0
C1420 Iin.n151 Vss 0
C1421 Iin.n152 Vss 0
C1422 Iin.n153 Vss 0
C1423 Iin.n154 Vss 0
C1424 Iin.n155 Vss 0
C1425 Iin.n156 Vss 0
C1426 Iin.n157 Vss 0
C1427 Iin.n158 Vss 0
C1428 Iin.n159 Vss 0
C1429 Iin.n160 Vss 0
C1430 Iin.n161 Vss 0
C1431 Iin.n162 Vss 0
C1432 Iin.n163 Vss 0
C1433 Iin.n164 Vss 0
C1434 Iin.n165 Vss 0
C1435 Iin.n166 Vss 0
C1436 Iin.n167 Vss 0
C1437 Iin.n168 Vss 0
C1438 Iin.n169 Vss 0
C1439 Iin.n170 Vss 0
C1440 Iin.n171 Vss 0
C1441 Iin.n172 Vss 0
C1442 Iin.n173 Vss 0
C1443 Iin.n174 Vss 0
C1444 Iin.n175 Vss 0
C1445 Iin.n176 Vss 0
C1446 Iin.n177 Vss 0
C1447 Iin.n178 Vss 0
C1448 Iin.n179 Vss 0
C1449 Iin.n180 Vss 0
C1450 Iin.n181 Vss 0
C1451 Iin.n182 Vss 0.00162f
C1452 Iin.n183 Vss 0
C1453 Iin.n184 Vss 0.001f
C1454 Iin.n185 Vss 0
C1455 Iin.n186 Vss 0
C1456 Iin.n187 Vss 0
C1457 Iin.n188 Vss 0
C1458 Iin.n189 Vss 0
C1459 Iin.n190 Vss 0
C1460 Iin.n191 Vss 0
C1461 Iin.n192 Vss 0
C1462 Iin.n193 Vss 0
C1463 Iin.n194 Vss 0
C1464 Iin.n195 Vss 0
C1465 Iin.n196 Vss 0
C1466 Iin.n197 Vss 0
C1467 Iin.n198 Vss 0
C1468 Iin.n199 Vss 0
C1469 Iin.n200 Vss 0
C1470 Iin.n201 Vss 0
C1471 Iin.n202 Vss 0
C1472 Iin.n203 Vss 0
C1473 Iin.n204 Vss 0
C1474 Iin.n205 Vss 0
C1475 Iin.n206 Vss 0
C1476 Iin.n207 Vss 0
C1477 Iin.n208 Vss 0
C1478 Iin.n209 Vss 0
C1479 Iin.n210 Vss 0
C1480 Iin.n211 Vss 0
C1481 Iin.n212 Vss 0
C1482 Iin.n213 Vss 0
C1483 Iin.n214 Vss 0
C1484 Iin.n215 Vss 0
C1485 Iin.n216 Vss 0
C1486 Iin.n217 Vss 0
C1487 Iin.n218 Vss 0
C1488 Iin.n219 Vss 0
C1489 Iin.n220 Vss 0
C1490 Iin.n221 Vss 0
C1491 Iin.n222 Vss 0
C1492 Iin.n223 Vss 0.00486f
C1493 Iin.n224 Vss 0
C1494 Iin.n225 Vss 0.00191f
C1495 Iin.n226 Vss 0
C1496 Iin.n227 Vss 0
C1497 Iin.n228 Vss 0
C1498 Iin.n229 Vss 0
C1499 Iin.n230 Vss 0
C1500 Iin.n231 Vss 0
C1501 Iin.n232 Vss 0
C1502 Iin.n233 Vss 0.00144f
C1503 Iin.n234 Vss 0
C1504 Iin.n235 Vss 0.00144f
C1505 Iin.n236 Vss 0
C1506 Iin.n237 Vss 0.00144f
C1507 Iin.n238 Vss 0
C1508 Iin.n239 Vss 0.00144f
C1509 Iin.n240 Vss 0
C1510 Iin.n241 Vss 0
C1511 Iin.n242 Vss 0.00144f
C1512 Iin.n243 Vss 0
C1513 Iin.n244 Vss 0
C1514 Iin.n245 Vss 0
C1515 Iin.n246 Vss 0
C1516 Iin.n247 Vss 0
C1517 Iin.n248 Vss 0.00144f
C1518 Iin.n249 Vss 0
C1519 Iin.n250 Vss 0
C1520 Iin.n251 Vss 0
C1521 Iin.n252 Vss 0
C1522 Iin.n253 Vss 0
C1523 Iin.n254 Vss 0.00144f
C1524 Iin.n255 Vss 0
C1525 Iin.n256 Vss 0
C1526 Iin.n257 Vss 0
C1527 Iin.n258 Vss 0
C1528 Iin.n259 Vss 0
C1529 Iin.n260 Vss 0.00144f
C1530 Iin.n261 Vss 0
C1531 Iin.n262 Vss 0
C1532 Iin.n263 Vss 0
C1533 Iin.n264 Vss 0
C1534 Iin.n265 Vss 0
C1535 Iin.n266 Vss 0.00144f
C1536 Iin.n267 Vss 0
C1537 Iin.n268 Vss 0
C1538 Iin.n269 Vss 0
C1539 Iin.n270 Vss 0
C1540 Iin.n271 Vss 0
C1541 Iin.n272 Vss 0.00144f
C1542 Iin.n273 Vss 0
C1543 Iin.n274 Vss 0
C1544 Iin.n275 Vss 0
C1545 Iin.n276 Vss 0
C1546 Iin.n277 Vss 0
C1547 Iin.n278 Vss 0.00144f
C1548 Iin.n279 Vss 0
C1549 Iin.n280 Vss 0
C1550 Iin.n281 Vss 0
C1551 Iin.n282 Vss 0
C1552 Iin.n283 Vss 0
C1553 Iin.n284 Vss 0.00144f
C1554 Iin.n285 Vss 0
C1555 Iin.n286 Vss 0
C1556 Iin.n287 Vss 0.00567f
C1557 Iin.n288 Vss 0.00317f
C1558 Iin.n289 Vss 0
C1559 Iin.n290 Vss 0
C1560 Iin.n291 Vss 0
C1561 Iin.n292 Vss 0
C1562 Iin.n293 Vss 0
C1563 Iin.n294 Vss 0.00189f
C1564 Iin.n296 Vss 0
C1565 Iin.n297 Vss 0
C1566 Iin.n298 Vss 0
C1567 Iin.n299 Vss 0
C1568 Iin.n300 Vss 0
C1569 Iin.n301 Vss 0
C1570 Iin.n302 Vss 0
C1571 Iin.n303 Vss 0.00144f
C1572 Iin.n304 Vss 0
C1573 Iin.n305 Vss 0
C1574 Iin.n306 Vss 0
C1575 Iin.n307 Vss 0
C1576 Iin.n308 Vss 0
C1577 Iin.n309 Vss 0
C1578 Iin.n310 Vss 0
C1579 Iin.n311 Vss 0.00144f
C1580 Iin.n312 Vss 0
C1581 Iin.n313 Vss 0
C1582 Iin.n314 Vss 0
C1583 Iin.n315 Vss 0
C1584 Iin.n316 Vss 0
C1585 Iin.n317 Vss 0
C1586 Iin.n318 Vss 0
C1587 Iin.n319 Vss 0.00144f
C1588 Iin.n320 Vss 0
C1589 Iin.n321 Vss 0
C1590 Iin.n322 Vss 0
C1591 Iin.n323 Vss 0
C1592 Iin.n324 Vss 0
C1593 Iin.n325 Vss 0
C1594 Iin.n326 Vss 0
C1595 Iin.n327 Vss 0.00144f
C1596 Iin.n328 Vss 0
C1597 Iin.n329 Vss 0
C1598 Iin.n330 Vss 0
C1599 Iin.n331 Vss 0
C1600 Iin.n332 Vss 0
C1601 Iin.n333 Vss 0
C1602 Iin.n334 Vss 0
C1603 Iin.n335 Vss 0
C1604 Iin.n336 Vss 0
C1605 Iin.n337 Vss 0.00144f
C1606 Iin.n338 Vss 0
C1607 Iin.n339 Vss 0
C1608 Iin.n340 Vss 0
C1609 Iin.n341 Vss 0
C1610 Iin.n342 Vss 0
C1611 Iin.n343 Vss 0
C1612 Iin.n344 Vss 0
C1613 Iin.n345 Vss 0.00144f
C1614 Iin.n346 Vss 0
C1615 Iin.n347 Vss 0
C1616 Iin.n348 Vss 0
C1617 Iin.n349 Vss 0
C1618 Iin.n350 Vss 0
C1619 Iin.n351 Vss 0
C1620 Iin.n352 Vss 0
C1621 Iin.n353 Vss 0
C1622 Iin.n354 Vss 0
C1623 Iin.n355 Vss 0
C1624 Iin.n356 Vss 0.00144f
C1625 Iin.n357 Vss 0.00144f
C1626 Iin.n358 Vss 0
C1627 Iin.n359 Vss 0
C1628 Iin.n360 Vss 0
C1629 Iin.n361 Vss 0
C1630 Iin.n362 Vss 0
C1631 Iin.n363 Vss 0
C1632 Iin.n364 Vss 0
C1633 Iin.n365 Vss 0
C1634 Iin.n366 Vss 0
C1635 Iin.n367 Vss 0.00144f
C1636 Iin.n368 Vss 0
C1637 Iin.n369 Vss 0
C1638 Iin.n370 Vss 0
C1639 Iin.n371 Vss 0
C1640 Iin.n372 Vss 0.00144f
C1641 Iin.n373 Vss 0.00144f
C1642 Iin.n374 Vss 0
C1643 Iin.n375 Vss 0
C1644 Iin.n376 Vss 0.00144f
C1645 Iin.n377 Vss 0
C1646 Iin.n378 Vss 0
C1647 Iin.n379 Vss 0
C1648 Iin.n380 Vss 0
C1649 Iin.n381 Vss 0.00144f
C1650 Iin.n382 Vss 0.00144f
C1651 Iin.n383 Vss 0
C1652 Iin.n384 Vss 0
C1653 Iin.n385 Vss 0.00144f
C1654 Iin.n386 Vss 0
C1655 Iin.n387 Vss 0
C1656 Iin.n388 Vss 0
C1657 Iin.n389 Vss 0
C1658 Iin.n390 Vss 0.00144f
C1659 Iin.n391 Vss 0.00144f
C1660 Iin.n392 Vss 0
C1661 Iin.n393 Vss 0.00144f
C1662 Iin.n394 Vss 0
C1663 Iin.n395 Vss 0
C1664 Iin.n396 Vss 0
C1665 Iin.n397 Vss 0
C1666 Iin.n398 Vss 0
C1667 Iin.n399 Vss 0
C1668 Iin.n400 Vss 0
C1669 Iin.n401 Vss 0
C1670 Iin.n402 Vss 0
C1671 Iin.n403 Vss 0
C1672 Iin.n404 Vss 0
C1673 Iin.n405 Vss 0
C1674 Iin.n406 Vss 0
C1675 Iin.n407 Vss 0
C1676 Iin.n408 Vss 0
C1677 Iin.n409 Vss 0
C1678 Iin.n410 Vss 0
C1679 Iin.n411 Vss 0
C1680 Iin.n412 Vss 0
C1681 Iin.n413 Vss 0
C1682 Iin.n414 Vss 0
C1683 Iin.n415 Vss 0
C1684 Iin.n416 Vss 0.00144f
C1685 Iin.n417 Vss 0.00144f
C1686 Iin.n418 Vss 0.00144f
C1687 Iin.n419 Vss 0.00144f
C1688 Iin.n420 Vss 0
C1689 Iin.n421 Vss 0
C1690 Iin.n422 Vss 0.00144f
C1691 Iin.n423 Vss 0.00144f
C1692 Iin.n424 Vss 0.00144f
C1693 Iin.n425 Vss 0.00144f
C1694 Iin.n426 Vss 0
C1695 Iin.n427 Vss 0
C1696 Iin.n428 Vss 0.00144f
C1697 Iin.n429 Vss 0.00144f
C1698 Iin.n430 Vss 0.00144f
C1699 Iin.n431 Vss 0.00144f
C1700 Iin.n432 Vss 0.00144f
C1701 Iin.n433 Vss 0
C1702 Iin.n434 Vss 0
C1703 Iin.n435 Vss 0
C1704 Iin.n436 Vss 0
C1705 Iin.n437 Vss 0
C1706 Iin.n438 Vss 0
C1707 Iin.n439 Vss 0
C1708 Iin.n440 Vss 0
C1709 Iin.n441 Vss 0
C1710 Iin.n442 Vss 0
C1711 Iin.n443 Vss 0
C1712 Iin.n444 Vss 0
C1713 Iin.n445 Vss 0
C1714 Iin.n446 Vss 0
C1715 Iin.n447 Vss 0
C1716 Iin.n448 Vss 0
C1717 Iin.n449 Vss 0
C1718 Iin.n450 Vss 0
C1719 Iin.n451 Vss 0
C1720 Iin.n452 Vss 0
C1721 Iin.n453 Vss 0
C1722 Iin.n454 Vss 0
C1723 Iin.n455 Vss 0
C1724 Iin.n456 Vss 0
C1725 Iin.n457 Vss 0
C1726 Iin.n458 Vss 0
C1727 Iin.n459 Vss 0
C1728 Iin.n460 Vss 0
C1729 Iin.n461 Vss 0
C1730 Iin.n462 Vss 0
C1731 Iin.n463 Vss 0
C1732 Iin.n464 Vss 0
C1733 Iin.n465 Vss 0
C1734 Iin.n466 Vss 0
C1735 Iin.n467 Vss 0
C1736 Iin.n468 Vss 0
C1737 Iin.n469 Vss 0
C1738 Iin.n470 Vss -0
C1739 Iin.n471 Vss -0
C1740 Iin.n472 Vss 0
C1741 Iin.n473 Vss 0
C1742 Iin.n474 Vss 0
C1743 Iin.n475 Vss 0
C1744 Iin.n476 Vss -0
C1745 Iin.n477 Vss 0
C1746 Iin.n478 Vss 0
C1747 Iin.n479 Vss 0
C1748 Iin.n480 Vss 0
C1749 Iin.n481 Vss 0
C1750 Iin.n482 Vss 0
C1751 Iin.n483 Vss 0
C1752 Iin.n484 Vss 0
C1753 Iin.n485 Vss 0
C1754 Iin.n486 Vss 0
C1755 Iin.n487 Vss 0
C1756 Iin.n488 Vss 0
C1757 Iin.n489 Vss 0
C1758 Iin.n490 Vss 0
C1759 Iin.n491 Vss 0
C1760 Iin.n492 Vss 0
C1761 Iin.n493 Vss 0
C1762 Iin.n494 Vss 0
C1763 Iin.n495 Vss 0
C1764 Iin.n496 Vss 0
C1765 Iin.n497 Vss 0
C1766 Iin.n498 Vss 0
C1767 Iin.n499 Vss 0
C1768 Iin.n500 Vss 0
C1769 Iin.n501 Vss 0
C1770 Iin.n502 Vss 0
C1771 Iin.n503 Vss 0
C1772 Iin.n504 Vss 0
C1773 Iin.n505 Vss 0
C1774 Iin.n506 Vss 0
C1775 Iin.n507 Vss 0
C1776 Iin.n508 Vss 0
C1777 Iin.n509 Vss 0
C1778 Iin.n510 Vss 0
C1779 Iin.n511 Vss 0
C1780 Iin.n512 Vss 0
C1781 Iin.n513 Vss 0
C1782 Iin.n514 Vss 0
C1783 Iin.n515 Vss 0
C1784 Iin.n516 Vss 0
C1785 Iin.n517 Vss 0
C1786 Iin.n518 Vss 0
C1787 Iin.n519 Vss 0
C1788 Iin.n520 Vss 0
C1789 Iin.n521 Vss 0
C1790 Iin.n522 Vss 0
C1791 Iin.n523 Vss 0
C1792 Iin.n524 Vss 0
C1793 Iin.n525 Vss 0
C1794 Iin.n526 Vss 0
C1795 Iin.n527 Vss 0
C1796 Iin.n528 Vss 0
C1797 Iin.n529 Vss 0
C1798 Iin.n530 Vss 0
C1799 Iin.n531 Vss 0
C1800 Iin.n532 Vss 0
C1801 Iin.n533 Vss 0
C1802 Iin.n534 Vss 0
C1803 Iin.n535 Vss 0
C1804 Iin.n536 Vss 0
C1805 Iin.n537 Vss 0
C1806 Iin.n538 Vss 0
C1807 Iin.n539 Vss 0
C1808 Iin.n540 Vss 0
C1809 Iin.n541 Vss 0
C1810 Iin.n542 Vss 0
C1811 Iin.n543 Vss 0
C1812 Iin.n544 Vss 0
C1813 Iin.n546 Vss 0.00135f
C1814 Iin.n547 Vss 0
C1815 Iin.n548 Vss 0
C1816 Iin.n549 Vss 0
C1817 Iin.n550 Vss 0
C1818 Iin.n551 Vss 0
C1819 Iin.n552 Vss 0
C1820 Iin.n553 Vss 0
C1821 Iin.n554 Vss 0
C1822 Iin.n555 Vss 0
C1823 Iin.n556 Vss 0
C1824 Iin.n557 Vss 0
C1825 Iin.n558 Vss 0
C1826 Iin.n559 Vss 0
C1827 Iin.n560 Vss 0
C1828 Iin.n561 Vss 0
C1829 Iin.n562 Vss 0
C1830 Iin.n563 Vss 0
C1831 Iin.n564 Vss 0
C1832 Iin.n565 Vss 0
C1833 Iin.n566 Vss 0
C1834 Iin.n567 Vss 0
C1835 Iin.n568 Vss 0
C1836 Iin.n569 Vss 0
C1837 Iin.n570 Vss 0
C1838 Iin.n571 Vss 0
C1839 Iin.n572 Vss 0
C1840 Iin.n573 Vss 0
C1841 Iin.n574 Vss 0
C1842 Iin.n575 Vss 0
C1843 Iin.n576 Vss 0
C1844 Iin.n577 Vss 0
C1845 Iin.n578 Vss 0
C1846 Iin.n579 Vss 0
C1847 Iin.n580 Vss 0
C1848 Iin.n581 Vss 0
C1849 Iin.n582 Vss 0
C1850 Iin.n583 Vss 0
C1851 Iin.n584 Vss 0
C1852 Iin.n585 Vss 0
C1853 Iin.n586 Vss 0
C1854 Iin.n587 Vss 0
C1855 Iin.n588 Vss 0
C1856 Iin.n589 Vss 0
C1857 Iin.n590 Vss 0
C1858 Iin.n591 Vss 0
C1859 Iin.n592 Vss 0
C1860 Iin.n593 Vss 0
C1861 Iin.n594 Vss 0.00445f
C1862 Iin.n595 Vss 0.00266f
C1863 Iin.n596 Vss 0.00156f
C1864 Iin.n597 Vss 0.00132f
C1865 Iin.n598 Vss 0.00129f
C1866 Iin.n599 Vss 0
C1867 Iin.n600 Vss 0
C1868 Iin.n601 Vss 0
C1869 Iin.n602 Vss 0
C1870 Iin.n603 Vss 0
C1871 Iin.n604 Vss 0
C1872 Iin.n605 Vss 0
C1873 Iin.n606 Vss 0
C1874 Iin.n607 Vss 0
C1875 Iin.n608 Vss 0
C1876 Iin.n609 Vss 0
C1877 Iin.n610 Vss 0
C1878 Iin.n611 Vss 0.00352f
C1879 Iin.n612 Vss 0
C1880 Iin.n613 Vss 0
C1881 Iin.n614 Vss 0
C1882 Iin.n615 Vss 0
C1883 Iin.n616 Vss 0
C1884 Iin.n617 Vss 0
C1885 Iin.n618 Vss 0
C1886 Iin.n619 Vss 0
C1887 Iin.n620 Vss 0
C1888 Iin.n621 Vss 0
C1889 Iin.n622 Vss 0
C1890 Iin.n623 Vss 0
C1891 Iin.n624 Vss 0
C1892 Iin.n625 Vss 0
C1893 Iin.n626 Vss 0
C1894 Iin.n627 Vss 0
C1895 Iin.n628 Vss 0
C1896 Iin.n629 Vss 0
C1897 Iin.n630 Vss 0
C1898 Iin.n631 Vss 0
C1899 Iin.n632 Vss 0
C1900 Iin.n633 Vss 0
C1901 Iin.n634 Vss 0
C1902 Iin.n635 Vss 0
C1903 Vdd.n0 Vss 0
C1904 Vdd.n1 Vss 0
C1905 Vdd.n2 Vss 0
C1906 Vdd.n3 Vss 0
C1907 Vdd.n4 Vss 0
C1908 Vdd.n5 Vss 0
C1909 Vdd.n6 Vss 0
C1910 Vdd.n7 Vss 0
C1911 Vdd.n8 Vss 0
C1912 Vdd.n9 Vss 0
C1913 Vdd.n10 Vss 0
C1914 Vdd.n11 Vss 0
C1915 Vdd.n12 Vss 0
C1916 Vdd.n13 Vss 0
C1917 Vdd.n14 Vss 0
C1918 Vdd.n15 Vss 0
C1919 Vdd.n16 Vss 0
C1920 Vdd.n17 Vss 0
C1921 Vdd.n18 Vss 0
C1922 Vdd.n19 Vss 0
C1923 Vdd.n20 Vss 0
C1924 Vdd.n21 Vss 0
C1925 Vdd.n22 Vss 0
C1926 Vdd.n23 Vss 0
C1927 Vdd.n24 Vss 0
C1928 Vdd.n25 Vss 0
C1929 Vdd.n26 Vss 0
C1930 Vdd.n27 Vss 0
C1931 Vdd.n28 Vss 0
C1932 Vdd.n29 Vss 0
C1933 Vdd.n30 Vss 0
C1934 Vdd.n31 Vss 0
C1935 Vdd.n32 Vss 0
C1936 Vdd.n33 Vss 0
C1937 Vdd.n34 Vss 0
C1938 Vdd.n35 Vss 0
C1939 Vdd.n36 Vss 0
C1940 Vdd.n37 Vss 0
C1941 Vdd.n38 Vss 0
C1942 Vdd.n39 Vss 0
C1943 Vdd.n40 Vss 0
C1944 Vdd.n41 Vss 0
C1945 Vdd.n42 Vss 0
C1946 Vdd.n43 Vss 0
C1947 Vdd.n44 Vss 0
C1948 Vdd.n45 Vss 0
C1949 Vdd.n46 Vss 0
C1950 Vdd.n47 Vss 0
C1951 Vdd.n48 Vss 0
C1952 Vdd.n49 Vss 0
C1953 Vdd.n50 Vss 0
C1954 Vdd.n51 Vss 0
C1955 Vdd.n52 Vss 0
C1956 Vdd.n53 Vss 0
C1957 Vdd.n54 Vss 0
C1958 Vdd.n55 Vss 0
C1959 Vdd.n56 Vss 0
C1960 Vdd.n57 Vss 0
C1961 Vdd.n58 Vss 0
C1962 Vdd.n59 Vss 0
C1963 Vdd.n60 Vss 0
C1964 Vdd.n61 Vss 0
C1965 Vdd.n62 Vss 0
C1966 Vdd.n63 Vss 0
C1967 Vdd.n64 Vss 0
C1968 Vdd.n65 Vss 0
C1969 Vdd.n66 Vss 0
C1970 Vdd.n67 Vss 0
C1971 Vdd.n68 Vss 0
C1972 Vdd.n69 Vss 0
C1973 Vdd.n70 Vss 0
C1974 Vdd.n71 Vss 0
C1975 Vdd.n72 Vss 0
C1976 Vdd.n73 Vss 0
C1977 Vdd.n74 Vss 0
C1978 Vdd.n75 Vss 0
C1979 Vdd.n76 Vss 0
C1980 Vdd.n77 Vss 0
C1981 Vdd.n78 Vss 0
C1982 Vdd.n79 Vss 0
C1983 Vdd.n80 Vss 0
C1984 Vdd.n81 Vss 0
C1985 Vdd.n82 Vss 0
C1986 Vdd.n83 Vss 0
C1987 Vdd.n84 Vss 0
C1988 Vdd.n85 Vss 0
C1989 Vdd.n86 Vss 0
C1990 Vdd.n87 Vss 0
C1991 Vdd.n88 Vss 0
C1992 Vdd.n89 Vss 0
C1993 Vdd.n90 Vss 0
C1994 Vdd.n91 Vss 0
C1995 Vdd.n92 Vss 0
C1996 Vdd.n93 Vss 0
C1997 Vdd.n94 Vss 0
C1998 Vdd.n95 Vss 0
C1999 Vdd.n96 Vss 0
C2000 Vdd.n97 Vss 0
C2001 Vdd.n98 Vss 0
C2002 Vdd.n99 Vss 0
C2003 Vdd.n100 Vss 0
C2004 Vdd.n101 Vss 0
C2005 Vdd.n102 Vss 0
C2006 Vdd.n103 Vss 0
C2007 Vdd.n104 Vss 0
C2008 Vdd.n105 Vss 0
C2009 Vdd.n106 Vss 0
C2010 Vdd.n107 Vss 0
C2011 Vdd.n108 Vss 0
C2012 Vdd.n109 Vss 0
C2013 Vdd.n110 Vss 0
C2014 Vdd.n111 Vss 0
C2015 Vdd.n112 Vss 0
C2016 Vdd.n113 Vss 0
C2017 Vdd.n114 Vss 0
C2018 Vdd.n115 Vss 0
C2019 Vdd.n116 Vss 0
C2020 Vdd.n117 Vss 0
C2021 Vdd.n118 Vss 0
C2022 Vdd.n119 Vss 0
C2023 Vdd.n120 Vss 0
C2024 Vdd.n121 Vss 0
C2025 Vdd.n122 Vss 0
C2026 Vdd.n123 Vss 0
C2027 Vdd.n124 Vss 0
C2028 Vdd.n125 Vss 0
C2029 Vdd.n126 Vss -0
C2030 Vdd.n127 Vss 0
C2031 Vdd.n128 Vss 0
C2032 Vdd.n129 Vss 0
C2033 Vdd.n130 Vss 0
C2034 Vdd.n131 Vss 0
C2035 Vdd.n132 Vss 0
C2036 Vdd.n133 Vss 0
C2037 Vdd.n134 Vss 0
C2038 Vdd.n135 Vss 0
C2039 Vdd.n136 Vss 0
C2040 Vdd.n137 Vss 0
C2041 Vdd.n138 Vss 0
C2042 Vdd.n139 Vss 0
C2043 Vdd.n140 Vss 0
C2044 Vdd.n141 Vss 0
C2045 Vdd.n142 Vss 0
C2046 Vdd.n143 Vss 0
C2047 Vdd.n144 Vss 0
C2048 Vdd.n145 Vss 0
C2049 Vdd.n146 Vss 0
C2050 Vdd.n147 Vss 0
C2051 Vdd.n148 Vss 0
C2052 Vdd.n149 Vss 0
C2053 Vdd.n150 Vss 0
C2054 Vdd.n151 Vss 0
C2055 Vdd.n152 Vss 0
C2056 Vdd.n153 Vss 0
C2057 Vdd.n154 Vss 0
C2058 Vdd.n155 Vss 0
C2059 Vdd.n156 Vss 0
C2060 Vdd.n157 Vss 0
C2061 Vdd.n158 Vss 0
C2062 Vdd.n159 Vss 0
C2063 Vdd.n160 Vss 0
C2064 Vdd.n161 Vss 0
C2065 Vdd.n162 Vss 0
C2066 Vdd.n163 Vss 0
C2067 Vdd.n164 Vss 0
C2068 Vdd.n165 Vss 0
C2069 Vdd.n166 Vss 0
C2070 Vdd.n167 Vss 0
C2071 Vdd.n168 Vss 0
C2072 Vdd.n169 Vss 0
C2073 Vdd.n170 Vss 0
C2074 Vdd.n171 Vss 0
C2075 Vdd.n172 Vss 0
C2076 Vdd.n173 Vss 0
C2077 Vdd.n174 Vss 0
C2078 Vdd.n175 Vss 0
C2079 Vdd.n176 Vss 0
C2080 Vdd.n177 Vss 0
C2081 Vdd.n178 Vss 0.0028f
C2082 Vdd.n179 Vss 0.0011f
C2083 Vdd.n180 Vss 0
C2084 Vdd.n181 Vss 0
C2085 Vdd.n182 Vss 0
C2086 Vdd.n183 Vss 0
C2087 Vdd.n184 Vss 0
C2088 Vdd.n185 Vss 0
C2089 Vdd.n186 Vss 0
C2090 Vdd.n187 Vss 0
C2091 Vdd.n188 Vss 0
C2092 Vdd.n189 Vss 0
C2093 Vdd.n190 Vss 0
C2094 Vdd.n191 Vss 0
C2095 Vdd.n192 Vss 0
C2096 Vdd.n193 Vss 0
C2097 Vdd.n194 Vss 0
C2098 Vdd.n195 Vss 0
C2099 Vdd.n196 Vss 0
C2100 Vdd.n197 Vss 0
C2101 Vdd.n198 Vss 0
C2102 Vdd.n199 Vss 0
C2103 Vdd.n200 Vss 0
C2104 Vdd.n201 Vss 0
C2105 Vdd.n202 Vss 0
C2106 Vdd.n203 Vss 0
C2107 Vdd.n204 Vss 0
C2108 Vdd.n205 Vss 0
C2109 Vdd.n206 Vss 0
C2110 Vdd.n207 Vss 0
C2111 Vdd.n208 Vss 0
C2112 Vdd.n209 Vss 0
C2113 Vdd.n210 Vss 0
C2114 Vdd.n211 Vss 0
C2115 Vdd.n212 Vss 0
C2116 Vdd.n213 Vss 0
C2117 Vdd.n214 Vss 0
C2118 Vdd.n215 Vss 0
C2119 Vdd.n216 Vss 0
C2120 Vdd.n217 Vss 0
C2121 Vdd.n218 Vss 0
C2122 Vdd.n219 Vss 0
C2123 Vdd.n220 Vss 0
C2124 Vdd.n221 Vss 0
C2125 Vdd.n222 Vss 0
C2126 Vdd.n223 Vss 0
C2127 Vdd.n224 Vss 0
C2128 Vdd.n225 Vss 0
C2129 Vdd.n226 Vss 0
C2130 Vdd.n227 Vss 0
C2131 Vdd.n228 Vss 0
C2132 Vdd.n229 Vss 0
C2133 Vdd.n230 Vss 0
C2134 Vdd.n231 Vss 0
C2135 Vdd.n232 Vss 0
C2136 Vdd.n233 Vss 0
C2137 Vdd.n234 Vss 0
C2138 Vdd.n235 Vss -0
C2139 Vdd.n236 Vss 0
C2140 Vdd.n237 Vss 0
C2141 Vdd.n238 Vss 0
C2142 Vdd.n239 Vss 0
C2143 Vdd.n240 Vss 0
C2144 Vdd.n241 Vss 0
C2145 Vdd.n242 Vss 0
C2146 Vdd.n243 Vss 0
C2147 Vdd.n244 Vss 0
C2148 Vdd.n245 Vss 0
C2149 Vdd.n246 Vss 0.00183f
C2150 Vdd.n247 Vss 0
C2151 Vdd.n248 Vss 0
C2152 Vdd.n249 Vss 0
C2153 Vdd.n250 Vss 0.00327f
C2154 Vdd.n251 Vss 0
C2155 Vdd.n252 Vss 0
C2156 Vdd.n253 Vss 0
C2157 Vdd.n254 Vss 0
C2158 Vdd.n255 Vss 0
C2159 Vdd.n256 Vss 0
C2160 Vdd.n257 Vss 0
C2161 Vdd.n258 Vss 0
C2162 Vdd.n259 Vss 0
C2163 Vdd.n260 Vss 0
C2164 Vdd.n261 Vss 0
C2165 Vdd.n262 Vss 0
C2166 Vdd.n263 Vss 0
C2167 Vdd.n264 Vss 0
C2168 Vdd.n265 Vss 0
C2169 Vdd.n266 Vss 0
C2170 Vdd.n267 Vss 0
C2171 Vdd.n268 Vss 0
C2172 Vdd.n269 Vss 0
C2173 Vdd.n270 Vss 0
C2174 Vdd.n271 Vss 0
C2175 Vdd.n272 Vss 0
C2176 Vdd.n273 Vss 0
C2177 Vdd.n274 Vss 0
C2178 Vdd.n275 Vss 0
C2179 Vdd.n276 Vss 0
C2180 Vdd.n277 Vss 0
C2181 Vdd.n278 Vss 0
C2182 Vdd.n279 Vss 0
C2183 Vdd.n280 Vss 0
C2184 Vdd.n281 Vss 0
C2185 Vdd.n282 Vss 0
C2186 Vdd.n283 Vss 0
C2187 Vdd.n284 Vss 0
C2188 Vdd.n285 Vss 0
C2189 Vdd.n286 Vss 0
C2190 Vdd.n287 Vss 0
C2191 Vdd.n288 Vss 0
C2192 Vdd.n289 Vss 0
C2193 Vdd.n290 Vss 0
C2194 Vdd.n291 Vss 0
C2195 Vdd.n292 Vss 0
C2196 Vdd.n293 Vss 0
C2197 Vdd.n294 Vss 0
C2198 Vdd.n295 Vss 0
C2199 Vdd.n296 Vss 0
C2200 Vdd.n297 Vss 0
C2201 Vdd.n298 Vss 0
C2202 Vdd.n299 Vss 0
C2203 Vdd.n300 Vss 0
C2204 Vdd.n301 Vss 0
C2205 Vdd.n302 Vss 0
C2206 Vdd.n303 Vss 0
C2207 Vdd.n304 Vss 0
C2208 Vdd.n305 Vss 0
C2209 Vdd.n306 Vss 0
C2210 Vdd.n307 Vss 0
C2211 Vdd.n308 Vss 0
C2212 Vdd.n309 Vss 0
C2213 Vdd.n310 Vss 0
C2214 Vdd.n311 Vss 0
C2215 Vdd.n312 Vss 0
C2216 Vdd.n313 Vss 0
C2217 Vdd.n314 Vss 0
C2218 Vdd.n315 Vss 0
C2219 Vdd.n316 Vss 0
C2220 Vdd.n317 Vss 0
C2221 Vdd.n318 Vss 0
C2222 Vdd.n319 Vss 0
C2223 Vdd.n320 Vss 0
C2224 Vdd.n321 Vss 0
C2225 Vdd.n322 Vss 0
C2226 Vdd.n323 Vss 0
C2227 Vdd.n324 Vss 0
C2228 Vdd.n325 Vss 0
C2229 Vdd.n326 Vss 0
C2230 Vdd.n327 Vss 0
C2231 Vdd.n328 Vss 0
C2232 Vdd.n329 Vss 0
C2233 Vdd.n330 Vss 0
C2234 Vdd.n331 Vss 0
C2235 Vdd.n332 Vss 0
C2236 Vdd.n333 Vss 0
C2237 Vdd.n334 Vss 0
C2238 Vdd.n335 Vss 0
C2239 Vdd.n336 Vss 0
C2240 Vdd.n337 Vss 0
C2241 Vdd.n338 Vss 0
C2242 Vdd.n339 Vss 0
C2243 Vdd.n340 Vss 0
C2244 Vdd.n341 Vss 0
C2245 Vdd.n342 Vss 0
C2246 Vdd.n343 Vss 0
C2247 Vdd.n344 Vss 0
C2248 Vdd.n345 Vss 0
C2249 Vdd.n346 Vss 0
C2250 Vdd.n347 Vss 0
C2251 Vdd.n348 Vss 0
C2252 Vdd.n349 Vss 0
C2253 Vdd.n350 Vss 0
C2254 Vdd.n351 Vss 0
C2255 Vdd.n352 Vss 0
C2256 Vdd.n353 Vss 0
C2257 Vdd.n354 Vss 0
C2258 Vdd.n355 Vss 0
C2259 Vdd.n356 Vss 0
C2260 Vdd.n357 Vss 0
C2261 Vdd.n359 Vss 0.00109f
C2262 Vdd.n360 Vss 0
C2263 Vdd.n361 Vss 0
C2264 Vdd.n362 Vss 0
C2265 Vdd.n363 Vss 0
C2266 Vdd.n364 Vss 0
C2267 Vdd.n365 Vss 0
C2268 Vdd.n366 Vss 0
C2269 Vdd.n367 Vss -0
C2270 Vdd.n368 Vss 0
C2271 Vdd.n369 Vss 0
C2272 Vdd.n370 Vss 0
C2273 Vdd.n371 Vss 0
C2274 Vdd.n372 Vss 0
C2275 Vdd.n373 Vss 0
C2276 Vdd.n374 Vss 0
C2277 Vdd.n375 Vss 0
C2278 Vdd.n376 Vss 0
C2279 Vdd.n377 Vss 0
C2280 Vdd.n378 Vss 0
C2281 Vdd.n379 Vss 0
C2282 Vdd.n380 Vss 0
C2283 Vdd.n381 Vss 0
C2284 Vdd.n382 Vss 0
C2285 Vdd.n383 Vss 0
C2286 Vdd.n384 Vss 0
C2287 Vdd.n385 Vss 0
C2288 Vdd.n386 Vss 0
C2289 Vdd.n387 Vss 0
C2290 Vdd.n388 Vss 0
C2291 Vdd.n389 Vss 0
C2292 Vdd.n390 Vss 0
C2293 Vdd.n391 Vss 0
C2294 Vdd.n392 Vss 0
C2295 Vdd.n393 Vss 0
C2296 Vdd.n394 Vss 0
C2297 Vdd.n395 Vss 0
C2298 Vdd.n396 Vss 0
C2299 Vdd.n397 Vss 0
C2300 Vdd.n398 Vss 0
C2301 Vdd.n399 Vss 0
C2302 Vdd.n400 Vss 0
C2303 Vdd.n401 Vss 0
C2304 Vdd.n402 Vss 0
C2305 Vdd.n403 Vss 0
C2306 Vdd.n404 Vss 0
C2307 Vdd.n405 Vss 0
C2308 Vdd.n406 Vss 0
C2309 Vdd.n407 Vss 0
C2310 Vdd.n408 Vss 0
C2311 Vdd.n409 Vss 0
C2312 Vdd.n410 Vss 0
C2313 Vdd.n411 Vss 0
C2314 Vdd.n412 Vss 0
C2315 Vdd.n413 Vss 0
C2316 Vdd.n414 Vss 0
C2317 Vdd.n415 Vss 0
C2318 Vdd.n416 Vss 0
C2319 Vdd.n417 Vss 0
C2320 Vdd.n418 Vss 0
C2321 Vdd.n419 Vss 0
C2322 Vdd.n420 Vss 0
C2323 Vdd.n421 Vss 0
C2324 Vdd.n422 Vss 0
C2325 Vdd.n423 Vss 0
C2326 Vdd.n424 Vss 0
C2327 Vdd.n425 Vss 0
C2328 Vdd.n426 Vss 0
C2329 Vdd.n427 Vss 0
C2330 Vdd.n428 Vss 0
C2331 Vdd.n429 Vss 0
C2332 Vdd.n430 Vss 0
C2333 Vdd.n431 Vss 0
C2334 Vdd.n432 Vss 0
C2335 Vdd.n433 Vss 0
C2336 Vdd.n434 Vss 0
C2337 Vdd.n435 Vss 0
C2338 Vdd.n436 Vss 0
C2339 Vdd.n437 Vss 0
C2340 Vdd.n438 Vss 0
C2341 Vdd.n439 Vss 0
C2342 Vdd.n440 Vss 0
C2343 Vdd.n441 Vss 0
C2344 Vdd.n442 Vss 0
C2345 Vdd.n443 Vss 0
C2346 Vdd.n444 Vss 0
C2347 Vdd.n445 Vss 0
C2348 Vdd.n446 Vss 0
C2349 Vdd.n447 Vss 0
C2350 Vdd.n448 Vss 0
C2351 Vdd.n449 Vss 0
C2352 Vdd.n450 Vss 0
C2353 Vdd.n451 Vss 0
C2354 Vdd.n452 Vss 0
C2355 Vdd.n453 Vss 0
C2356 Vdd.n454 Vss 0
C2357 Vdd.n455 Vss 0
C2358 Vdd.n456 Vss 0
C2359 Vdd.n457 Vss 0
C2360 Vdd.n458 Vss 0
C2361 Vdd.n459 Vss 0
C2362 Vdd.n460 Vss 0
C2363 Vdd.n461 Vss 0
C2364 Vdd.n462 Vss 0
C2365 Vdd.n463 Vss 0
C2366 Vdd.n464 Vss 0
C2367 Vdd.n465 Vss 0
C2368 Vdd.n466 Vss 0
C2369 Vdd.n467 Vss 0
C2370 Vdd.n468 Vss 0
C2371 Vdd.n469 Vss 0
C2372 Vdd.n470 Vss 0
C2373 Vdd.n471 Vss 0
C2374 Vdd.n472 Vss 0
C2375 Vdd.n473 Vss 0
C2376 Vdd.n474 Vss 0
C2377 Vdd.n475 Vss 0
C2378 Vdd.n476 Vss 0
C2379 Vdd.n477 Vss 0
C2380 Vdd.n478 Vss 0
C2381 Vdd.n479 Vss 0
C2382 Vdd.n480 Vss 0
C2383 Vdd.n481 Vss 0
C2384 Vdd.n482 Vss 0.00203f
C2385 Vdd.n483 Vss 0
C2386 Vdd.n484 Vss 0
C2387 Vdd.n485 Vss 0
C2388 Vdd.n486 Vss 0
C2389 Vdd.n487 Vss 0
C2390 Vdd.n488 Vss 0
C2391 Vdd.n489 Vss 0
C2392 Vdd.n490 Vss 0
C2393 Vdd.n491 Vss 0
C2394 Vdd.n492 Vss 0
C2395 Vdd.n493 Vss 0
C2396 Vdd.n494 Vss 0
C2397 Vdd.n495 Vss 0
C2398 Vdd.n496 Vss 0
C2399 Vdd.n497 Vss 0
C2400 Vdd.n498 Vss 0
C2401 Vdd.n499 Vss 0
C2402 Vdd.n500 Vss 0
C2403 Vdd.n501 Vss 0
C2404 Vdd.n502 Vss 0
C2405 Vdd.n503 Vss 0
C2406 Vdd.n504 Vss 0
C2407 Vdd.n505 Vss 0
C2408 Vdd.n506 Vss 0
C2409 Vdd.n507 Vss 0
C2410 Vdd.n508 Vss 0
C2411 Vdd.n509 Vss 0
C2412 Vdd.n510 Vss 0
C2413 Vdd.n511 Vss 0
C2414 Vdd.n512 Vss 0
C2415 Vdd.n513 Vss 0
C2416 Vdd.n514 Vss 0
C2417 Vdd.n515 Vss 0
C2418 Vdd.n516 Vss 0
C2419 Vdd.n517 Vss 0
C2420 Vdd.n518 Vss 0
C2421 Vdd.n519 Vss 0
C2422 Vdd.n520 Vss 0
C2423 Vdd.n521 Vss 0
C2424 Vdd.n522 Vss 0
C2425 Vdd.n523 Vss 0
C2426 Vdd.n524 Vss 0
C2427 Vdd.n525 Vss 0
C2428 Vdd.n526 Vss 0
C2429 Vdd.n527 Vss 0
C2430 Vdd.n528 Vss 0
C2431 Vdd.n529 Vss 0
C2432 Vdd.n530 Vss 0
C2433 Vdd.n531 Vss 0
C2434 Vdd.n532 Vss 0
C2435 Vdd.n533 Vss 0
C2436 Vdd.n534 Vss 0
C2437 Vdd.n535 Vss 0
C2438 Vdd.n536 Vss 0
C2439 Vdd.n537 Vss 0
C2440 Vdd.n538 Vss 0
C2441 Vdd.n539 Vss 0
C2442 Vdd.n540 Vss 0
C2443 Vdd.n541 Vss 0
C2444 Vdd.n542 Vss 0
C2445 Vdd.n543 Vss 0
C2446 Vdd.n544 Vss 0
C2447 Vdd.n545 Vss 0
C2448 Vdd.n546 Vss 0
C2449 Vdd.n547 Vss 0
C2450 Vdd.n548 Vss 0
C2451 Vdd.n549 Vss 0
C2452 Vdd.n550 Vss 0
C2453 Vdd.n551 Vss 0
C2454 Vdd.n552 Vss 0
C2455 Vdd.n553 Vss 0
C2456 Vdd.n554 Vss 0
C2457 Vdd.n555 Vss 0
C2458 Vdd.n556 Vss 0
C2459 Vdd.n557 Vss 0
C2460 Vdd.n558 Vss 0
C2461 Vdd.n559 Vss 0
C2462 Vdd.n560 Vss 0
C2463 Vdd.n561 Vss 0
C2464 Vdd.n562 Vss 0
C2465 Vdd.n563 Vss 0
C2466 Vdd.n564 Vss 0
C2467 Vdd.n565 Vss 0
C2468 Vdd.n566 Vss 0
C2469 Vdd.n567 Vss 0
C2470 Vdd.n568 Vss 0
C2471 Vdd.n569 Vss 0
C2472 Vdd.n570 Vss 0
C2473 Vdd.n571 Vss 0
C2474 Vdd.n572 Vss 0
C2475 Vdd.n573 Vss 0
C2476 Vdd.n574 Vss 0
C2477 Vdd.n575 Vss 0
C2478 Vdd.n576 Vss 0
C2479 Vdd.n577 Vss 0
C2480 Vdd.n578 Vss 0
C2481 Vdd.n579 Vss 0
C2482 Vdd.n580 Vss 0
C2483 Vdd.n581 Vss 0
C2484 Vdd.n582 Vss 0
C2485 Vdd.n583 Vss 0
C2486 Vdd.n584 Vss 0.00153f
C2487 Vdd.n585 Vss 0.00256f
C2488 Vdd.n586 Vss 0
C2489 Vdd.n587 Vss 0
C2490 Vdd.n588 Vss 0
C2491 Vdd.n589 Vss 0
C2492 Vdd.n590 Vss 0
C2493 Vdd.n591 Vss 0
C2494 Vdd.n592 Vss 0
C2495 Vdd.n593 Vss 0
C2496 Vdd.n594 Vss 0
C2497 Vdd.n595 Vss 0
C2498 Vdd.n596 Vss 0
C2499 Vdd.n597 Vss 0
C2500 Vdd.n598 Vss 0
C2501 Vdd.n599 Vss 0
C2502 Vdd.n600 Vss 0
C2503 Vdd.n601 Vss 0
C2504 Vdd.n602 Vss 0
C2505 Vdd.n603 Vss 0
C2506 Vdd.n604 Vss 0
C2507 Vdd.n605 Vss 0
C2508 Vdd.n606 Vss 0
C2509 Vdd.n607 Vss 0
C2510 Vdd.n608 Vss 0
C2511 Vdd.n610 Vss 0
C2512 Vdd.n611 Vss 0
C2513 Vdd.n612 Vss 0
C2514 Vdd.n613 Vss 0
C2515 Vdd.n614 Vss 0
C2516 Vdd.n615 Vss 0
C2517 Vdd.n616 Vss 0
C2518 Vdd.n617 Vss 0
C2519 Vdd.n618 Vss 0
C2520 Vdd.n619 Vss 0
C2521 Vdd.n620 Vss 0
C2522 Vdd.n621 Vss 0
C2523 Vdd.n622 Vss 0
C2524 Vdd.n623 Vss 0
C2525 Vdd.n624 Vss 0
C2526 Vdd.n625 Vss 0
C2527 Vdd.n626 Vss 0
C2528 Vdd.n627 Vss 0
C2529 Vdd.n628 Vss 0
C2530 Vdd.n629 Vss 0
C2531 Vdd.n630 Vss 0
C2532 Vdd.n631 Vss 0
C2533 Vdd.n632 Vss 0
C2534 Vdd.n633 Vss 0
C2535 Vdd.n634 Vss 0
C2536 Vdd.n635 Vss 0
C2537 Vss.n0 Vss 0.00175f
C2538 Vss.n1 Vss 0.00103f
C2539 Vss.n2 Vss 0.00175f
C2540 Vss.n3 Vss 0.00103f
C2541 Vss.n4 Vss 0
C2542 Vss.n5 Vss 0
C2543 Vss.n6 Vss 0.00323f
C2544 Vss.n7 Vss 0
C2545 Vss.n8 Vss 0
C2546 Vss.n9 Vss 0
C2547 Vss.n10 Vss 0
C2548 Vss.n11 Vss 0
C2549 Vss.n12 Vss 0
C2550 Vss.n13 Vss 0
C2551 Vss.n14 Vss 0.00467f
C2552 Vss.n15 Vss 0.00323f
C2553 Vss.n16 Vss 0
C2554 Vss.n17 Vss 0
C2555 Vss.n18 Vss 0.00528f
C2556 Vss.n19 Vss 0.00175f
C2557 Vss.n20 Vss 0.00103f
C2558 Vss.n21 Vss 0
C2559 Vss.n22 Vss 0
C2560 Vss.n23 Vss 0
C2561 Vss.n24 Vss 0
C2562 Vss.n25 Vss 0
C2563 Vss.n26 Vss 0
C2564 Vss.n27 Vss 0
C2565 Vss.n28 Vss 0
C2566 Vss.n29 Vss 0
C2567 Vss.n30 Vss 0.00323f
C2568 Vss.n31 Vss 0.00467f
C2569 Vss.n32 Vss 0.00323f
C2570 Vss.n33 Vss 0
C2571 Vss.n34 Vss 0
C2572 Vss.n35 Vss 0.00779f
C2573 Vss.n36 Vss 0.00669f
C2574 Vss.n37 Vss 0.00554f
C2575 Vss.n38 Vss 0
C2576 Vss.n39 Vss 0
C2577 Vss.n40 Vss 0
C2578 Vss.n41 Vss 0
C2579 Vss.n42 Vss 0
C2580 Vss.n43 Vss 0
C2581 Vss.n44 Vss 0
C2582 Vss.n45 Vss 0
C2583 Vss.n46 Vss 0
C2584 Vss.n47 Vss 0.00323f
C2585 Vss.n48 Vss 0.00467f
C2586 Vss.n49 Vss 0.00323f
C2587 Vss.n50 Vss 0
C2588 Vss.n51 Vss 0
C2589 Vss.n52 Vss 0.00325f
C2590 Vss.n53 Vss 0.00175f
C2591 Vss.n54 Vss 0.00102f
C2592 Vss.n55 Vss 0.00912f
C2593 Vss.n56 Vss 0
C2594 Vss.n57 Vss 0
C2595 Vss.n58 Vss 0.00552f
C2596 Vss.n59 Vss 0
C2597 Vss.n60 Vss 0
C2598 Vss.n61 Vss 0.00318f
C2599 Vss.n62 Vss 0
C2600 Vss.n63 Vss 0
C2601 Vss.n64 Vss 0
C2602 Vss.n65 Vss 0
C2603 Vss.n66 Vss 0
C2604 Vss.n67 Vss 0
C2605 Vss.n68 Vss 0
C2606 Vss.n69 Vss 0
C2607 Vss.n70 Vss 0
C2608 Vss.n71 Vss 0
C2609 Vss.n72 Vss 0
C2610 Vss.n73 Vss 0
C2611 Vss.n74 Vss 0
C2612 Vss.n75 Vss 0
C2613 Vss.n76 Vss 0
C2614 Vss.n77 Vss 0
C2615 Vss.n78 Vss 0
C2616 Vss.n79 Vss 0.0109f
C2617 Vss.n80 Vss 0
C2618 Vss.n81 Vss 0.00676f
C2619 Vss.n82 Vss 0
C2620 Vss.n83 Vss 0
C2621 Vss.n84 Vss 0
C2622 Vss.n85 Vss 0
C2623 Vss.n86 Vss 0
C2624 Vss.n87 Vss 0
C2625 Vss.n88 Vss 0.00374f
C2626 Vss.n89 Vss 0
C2627 Vss.n90 Vss 0.00374f
C2628 Vss.n91 Vss 0
C2629 Vss.n92 Vss 0
C2630 Vss.n93 Vss 0
C2631 Vss.n94 Vss 0.00381f
C2632 Vss.n95 Vss 0.00565f
C2633 Vss.n96 Vss 0.00565f
C2634 Vss.n97 Vss 0
C2635 Vss.n98 Vss 0.00374f
C2636 Vss.n99 Vss 0
C2637 Vss.n100 Vss 0
C2638 Vss.n101 Vss 0
C2639 Vss.n102 Vss 0
C2640 Vss.n103 Vss 0
C2641 Vss.n104 Vss 0
C2642 Vss.n105 Vss 0.00374f
C2643 Vss.n106 Vss 0
C2644 Vss.n107 Vss 0
C2645 Vss.n108 Vss 0.00381f
C2646 Vss.n109 Vss 0.00565f
C2647 Vss.n110 Vss 0.00565f
C2648 Vss.n111 Vss 0
C2649 Vss.n112 Vss 0.00374f
C2650 Vss.n113 Vss 0
C2651 Vss.n114 Vss 0
C2652 Vss.n115 Vss 0
C2653 Vss.n116 Vss 0
C2654 Vss.n117 Vss 0
C2655 Vss.n118 Vss 0
C2656 Vss.n119 Vss 0.00374f
C2657 Vss.n120 Vss 0
C2658 Vss.n121 Vss 0
C2659 Vss.n122 Vss 0.00381f
C2660 Vss.n123 Vss 0.00565f
C2661 Vss.n124 Vss 0.00565f
C2662 Vss.n125 Vss 0
C2663 Vss.n126 Vss 0
C2664 Vss.n127 Vss 0
C2665 Vss.n128 Vss 0
C2666 Vss.n129 Vss 0
C2667 Vss.n130 Vss 0
C2668 Vss.n131 Vss 0.00187f
C2669 Vss.n132 Vss 0
C2670 Vss.n133 Vss 0.00374f
C2671 Vss.n134 Vss 0.03278f
C2672 Vss.n135 Vss 0.01288f
C2673 Vss.n136 Vss 0
C2674 Vss.n137 Vss 0
C2675 Vss.n138 Vss 0.00381f
C2676 Vss.n139 Vss 0.00565f
C2677 Vss.n140 Vss 0.00565f
C2678 Vss.n141 Vss 0
C2679 Vss.n142 Vss 0.00374f
C2680 Vss.n143 Vss 0
C2681 Vss.n144 Vss 0
C2682 Vss.n145 Vss 0
C2683 Vss.n146 Vss 0
C2684 Vss.n147 Vss 0
C2685 Vss.n148 Vss 0
C2686 Vss.n149 Vss 0.00374f
C2687 Vss.n150 Vss 0
C2688 Vss.n151 Vss 0
C2689 Vss.n152 Vss 0.00381f
C2690 Vss.n153 Vss 0.00565f
C2691 Vss.n154 Vss 0.00565f
C2692 Vss.n155 Vss 0
C2693 Vss.n156 Vss 0.00374f
C2694 Vss.n157 Vss 0
C2695 Vss.n158 Vss 0
C2696 Vss.n159 Vss 0
C2697 Vss.n160 Vss 0
C2698 Vss.n161 Vss 0
C2699 Vss.n162 Vss 0
C2700 Vss.n163 Vss 0.00374f
C2701 Vss.n164 Vss 0
C2702 Vss.n165 Vss 0
C2703 Vss.n166 Vss 0
C2704 Vss.n167 Vss 0.00756f
C2705 Vss.n168 Vss 0
C2706 Vss.n169 Vss 0
C2707 Vss.n170 Vss 0
C2708 Vss.n171 Vss 0
C2709 Vss.n172 Vss 0
C2710 Vss.n173 Vss 0
C2711 Vss.n174 Vss 0
C2712 Vss.n175 Vss 0
C2713 Vss.n176 Vss 0
C2714 Vss.n177 Vss 0
C2715 Vss.n178 Vss 0
C2716 Vss.n179 Vss 0.00893f
C2717 Vss.n180 Vss 0.00318f
C2718 Vss.n181 Vss 0
C2719 Vss.n182 Vss 0.00975f
C2720 Vss.n183 Vss 0
C2721 Vss.n184 Vss 0.00975f
C2722 Vss.n185 Vss 0
C2723 Vss.n186 Vss 0.00975f
C2724 Vss.n187 Vss 0
C2725 Vss.n188 Vss 0.00975f
C2726 Vss.n189 Vss 0
C2727 Vss.n190 Vss 0.00975f
C2728 Vss.n191 Vss 0
C2729 Vss.n192 Vss 0.00975f
C2730 Vss.n193 Vss 0
C2731 Vss.n194 Vss 0.00975f
C2732 Vss.n195 Vss 0
C2733 Vss.n196 Vss 0
C2734 Vss.n197 Vss 0.00975f
C2735 Vss.n198 Vss 0
C2736 Vss.n199 Vss 0
C2737 Vss.n200 Vss 0
C2738 Vss.n201 Vss 0
C2739 Vss.n202 Vss 0
C2740 Vss.n203 Vss 0.00975f
C2741 Vss.n204 Vss 0.00975f
C2742 Vss.n205 Vss 0
C2743 Vss.n206 Vss 0
C2744 Vss.n207 Vss 0
C2745 Vss.n208 Vss 0
C2746 Vss.n209 Vss 0
C2747 Vss.n210 Vss 0
C2748 Vss.n211 Vss 0
C2749 Vss.n212 Vss 0.00975f
C2750 Vss.n213 Vss 0
C2751 Vss.n214 Vss 0
C2752 Vss.n215 Vss 0
C2753 Vss.n216 Vss 0
C2754 Vss.n217 Vss 0
C2755 Vss.n218 Vss 0.00975f
C2756 Vss.n219 Vss 0
C2757 Vss.n220 Vss 0
C2758 Vss.n221 Vss 0
C2759 Vss.n222 Vss 0
C2760 Vss.n223 Vss 0
C2761 Vss.n224 Vss 0.00975f
C2762 Vss.n225 Vss 0
C2763 Vss.n226 Vss 0
C2764 Vss.n227 Vss 0
C2765 Vss.n228 Vss 0
C2766 Vss.n229 Vss 0
C2767 Vss.n230 Vss 0.00975f
C2768 Vss.n231 Vss 0
C2769 Vss.n232 Vss 0
C2770 Vss.n233 Vss 0
C2771 Vss.n234 Vss 0
C2772 Vss.n235 Vss 0
C2773 Vss.n236 Vss 0.00975f
C2774 Vss.n237 Vss 0
C2775 Vss.n238 Vss 0
C2776 Vss.n239 Vss 0
C2777 Vss.n240 Vss 0
C2778 Vss.n241 Vss 0
C2779 Vss.n242 Vss 0.00975f
C2780 Vss.n243 Vss 0
C2781 Vss.n244 Vss 0
C2782 Vss.n245 Vss 0.03829f
C2783 Vss.n246 Vss 0.02141f
C2784 Vss.n247 Vss 0.00121f
C2785 Vss.n248 Vss 0.00135f
C2786 Vss.n249 Vss 0
C2787 Vss.n250 Vss 0
C2788 Vss.n251 Vss 0
C2789 Vss.n253 Vss 0.01273f
C2790 Vss.n254 Vss 0
C2791 Vss.n255 Vss 0
C2792 Vss.n256 Vss 0
C2793 Vss.n257 Vss 0
C2794 Vss.n258 Vss 0
C2795 Vss.n259 Vss 0
C2796 Vss.n260 Vss 0
C2797 Vss.n261 Vss 0.00975f
C2798 Vss.n262 Vss 0
C2799 Vss.n263 Vss 0
C2800 Vss.n264 Vss 0
C2801 Vss.n265 Vss 0
C2802 Vss.n266 Vss 0
C2803 Vss.n267 Vss 0
C2804 Vss.n268 Vss 0
C2805 Vss.n269 Vss 0.00975f
C2806 Vss.n270 Vss 0
C2807 Vss.n271 Vss 0
C2808 Vss.n272 Vss 0
C2809 Vss.n273 Vss 0
C2810 Vss.n274 Vss 0
C2811 Vss.n275 Vss 0
C2812 Vss.n276 Vss 0
C2813 Vss.n277 Vss 0.00975f
C2814 Vss.n278 Vss 0
C2815 Vss.n279 Vss 0
C2816 Vss.n280 Vss 0
C2817 Vss.n281 Vss 0
C2818 Vss.n282 Vss 0
C2819 Vss.n283 Vss 0
C2820 Vss.n284 Vss 0
C2821 Vss.n285 Vss 0.00975f
C2822 Vss.n286 Vss 0
C2823 Vss.n287 Vss 0
C2824 Vss.n288 Vss 0
C2825 Vss.n289 Vss 0
C2826 Vss.n290 Vss 0
C2827 Vss.n291 Vss 0
C2828 Vss.n292 Vss 0
C2829 Vss.n293 Vss 0.00975f
C2830 Vss.n294 Vss 0
C2831 Vss.n295 Vss 0
C2832 Vss.n296 Vss 0
C2833 Vss.n297 Vss 0
C2834 Vss.n298 Vss 0
C2835 Vss.n299 Vss 0
C2836 Vss.n300 Vss 0
C2837 Vss.n301 Vss 0.00975f
C2838 Vss.n302 Vss 0
C2839 Vss.n303 Vss 0
C2840 Vss.n304 Vss 0
C2841 Vss.n305 Vss 0
C2842 Vss.n306 Vss 0
C2843 Vss.n307 Vss 0
C2844 Vss.n308 Vss 0
C2845 Vss.n309 Vss 0
C2846 Vss.n310 Vss 0
C2847 Vss.n311 Vss 0
C2848 Vss.n312 Vss 0.00975f
C2849 Vss.n313 Vss 0
C2850 Vss.n314 Vss 0
C2851 Vss.n315 Vss 0
C2852 Vss.n316 Vss 0
C2853 Vss.n317 Vss 0.00103f
C2854 Vss.n318 Vss 0
C2855 Vss.n319 Vss 0
C2856 Vss.n320 Vss 0
C2857 Vss.n321 Vss 0
C2858 Vss.n322 Vss 0.00975f
C2859 Vss.n323 Vss 0
C2860 Vss.n324 Vss 0
C2861 Vss.n325 Vss 0
C2862 Vss.n326 Vss 0
C2863 Vss.n327 Vss 0.00975f
C2864 Vss.n328 Vss 0.00975f
C2865 Vss.n329 Vss 0
C2866 Vss.n330 Vss 0
C2867 Vss.n331 Vss 0.00975f
C2868 Vss.n332 Vss 0
C2869 Vss.n333 Vss 0
C2870 Vss.n334 Vss 0
C2871 Vss.n335 Vss 0
C2872 Vss.n336 Vss 0.00975f
C2873 Vss.n337 Vss 0.00975f
C2874 Vss.n338 Vss 0
C2875 Vss.n339 Vss 0
C2876 Vss.n340 Vss 0.00975f
C2877 Vss.n341 Vss 0
C2878 Vss.n342 Vss 0
C2879 Vss.n343 Vss 0
C2880 Vss.n344 Vss 0
C2881 Vss.n345 Vss 0.00975f
C2882 Vss.n346 Vss 0.00975f
C2883 Vss.n347 Vss 0
C2884 Vss.n348 Vss 0
C2885 Vss.n349 Vss 0.00975f
C2886 Vss.n350 Vss 0
C2887 Vss.n351 Vss 0
C2888 Vss.n352 Vss 0
C2889 Vss.n353 Vss 0
C2890 Vss.n354 Vss 0.00975f
C2891 Vss.n355 Vss 0.00975f
C2892 Vss.n356 Vss 0
C2893 Vss.n357 Vss 0
C2894 Vss.n358 Vss 0.00975f
C2895 Vss.n359 Vss 0
C2896 Vss.n360 Vss 0
C2897 Vss.n361 Vss 0
C2898 Vss.n362 Vss 0
C2899 Vss.n363 Vss 0.00975f
C2900 Vss.n364 Vss 0.00975f
C2901 Vss.n365 Vss 0
C2902 Vss.n366 Vss 0
C2903 Vss.n367 Vss 0.00975f
C2904 Vss.n368 Vss 0
C2905 Vss.n369 Vss 0
C2906 Vss.n370 Vss 0
C2907 Vss.n371 Vss 0
C2908 Vss.n372 Vss 0.00975f
C2909 Vss.n373 Vss 0.00975f
C2910 Vss.n374 Vss 0
C2911 Vss.n375 Vss 0.00975f
C2912 Vss.n376 Vss 0
C2913 Vss.n377 Vss 0
C2914 Vss.n378 Vss 0
C2915 Vss.n379 Vss 0
C2916 Vss.n380 Vss 0.00975f
C2917 Vss.n381 Vss 0.00975f
C2918 Vss.n382 Vss 0.00871f
C2919 Vss.n383 Vss 0
C2920 Vss.n384 Vss 0
C2921 Vss.n385 Vss 0
C2922 Vss.n386 Vss 0
C2923 Vss.n387 Vss -0
C2924 Vss.n388 Vss 0
C2925 Vss.n389 Vss 0
C2926 Vss.n390 Vss 0
C2927 Vss.n391 Vss 0
C2928 Vss.n392 Vss 0
C2929 Vss.n393 Vss 0
C2930 Vss.n394 Vss 0
C2931 Vss.n395 Vss 0.00441f
C2932 Vss.n396 Vss 0
C2933 Vss.n397 Vss 0
C2934 Vss.n398 Vss 0
C2935 Vss.n399 Vss 0
C2936 Vss.n400 Vss 0
C2937 Vss.n401 Vss 0
C2938 Vss.n402 Vss 0
C2939 Vss.n403 Vss 0.00381f
C2940 Vss.n404 Vss 0
C2941 Vss.n405 Vss 0.00175f
C2942 Vss.n406 Vss 0.00165f
C2943 Vss.n407 Vss 0
C2944 Vss.n408 Vss 0
C2945 Vss.n409 Vss 0
C2946 Vss.n410 Vss 0.00318f
C2947 Vss.n411 Vss 0.00552f
C2948 Vss.n412 Vss 0.0052f
C2949 Vss.n413 Vss 0
C2950 Vss.n414 Vss 0
C2951 Vss.n415 Vss 0
C2952 Vss.n416 Vss 0
C2953 Vss.n417 Vss 0
C2954 Vss.n418 Vss 0
C2955 Vss.n419 Vss 0
C2956 Vss.n420 Vss 0.00318f
C2957 Vss.n421 Vss 0.0033f
C2958 Vss.n422 Vss 0
C2959 Vss.n423 Vss 0.00369f
C2960 Vss.n424 Vss 0
C2961 Vss.n425 Vss 0
C2962 Vss.n426 Vss 0
C2963 Vss.n427 Vss 0
C2964 Vss.n428 Vss 0
C2965 Vss.n429 Vss 0
C2966 Vss.n430 Vss 0.0035f
C2967 Vss.n431 Vss 0.00318f
C2968 Vss.n432 Vss 0
C2969 Vss.n433 Vss 0
C2970 Vss.n434 Vss 0.00156f
C2971 Vss.n435 Vss 0
C2972 Vss.n436 Vss 0.00103f
C2973 Vss.n437 Vss 0
C2974 Vss.n438 Vss 0
C2975 Vss.n439 Vss 0
C2976 Vss.n440 Vss 0
C2977 Vss.n441 Vss 0.00318f
C2978 Vss.n442 Vss 0
C2979 Vss.n443 Vss 0
C2980 Vss.n444 Vss 0.00165f
C2981 Vss.n445 Vss 0.00161f
C2982 Vss.n446 Vss 0.00161f
C2983 Vss.n447 Vss 0.00165f
C2984 Vss.n448 Vss 0.00165f
C2985 Vss.n449 Vss 0
C2986 Vss.n450 Vss 0
C2987 Vss.n451 Vss 0
C2988 Vss.n452 Vss 0
C2989 Vss.n453 Vss 0.00353f
C2990 Vss.n454 Vss 0
C2991 Vss.n455 Vss 0
C2992 Vss.n456 Vss 0
C2993 Vss.n457 Vss 0.00552f
C2994 Vss.n458 Vss 0
C2995 Vss.n459 Vss 0
C2996 Vss.n460 Vss 0
C2997 Vss.n461 Vss 0
C2998 Vss.n462 Vss 0
C2999 Vss.n463 Vss 0
C3000 Vss.n464 Vss 0
C3001 Vss.n465 Vss 0
C3002 Vss.n466 Vss 0
C3003 Vss.n467 Vss 0
C3004 Vss.n468 Vss 0
C3005 Vss.n469 Vss 0
C3006 Vss.n470 Vss 0
C3007 Vss.n471 Vss 0
C3008 Vss.n472 Vss 0
C3009 Vss.n473 Vss 0
C3010 Vss.n474 Vss 0.00346f
C3011 Vss.n475 Vss 0.00441f
C3012 Vss.n476 Vss 0.01051f
C3013 Vss.n477 Vss 0.01796f
C3014 Vss.n478 Vss 0.03002f
C3015 Vss.n479 Vss 0
C3016 Vss.n480 Vss 0
C3017 Vss.n481 Vss 0
C3018 Vss.n482 Vss 0
C3019 Vss.n483 Vss 0.00149f
C3020 Vss.n484 Vss 0
C3021 Vss.n485 Vss 0
C3022 Vss.n486 Vss 0
C3023 Vss.n487 Vss 0.00175f
C3024 Vss.n488 Vss 0.00339f
C3025 Vss.n489 Vss 0.00165f
C3026 Vss.n490 Vss 0
C3027 Vss.n491 Vss 0
C3028 Vss.n492 Vss 0.00318f
C3029 Vss.n493 Vss 0.00318f
C3030 Vss.n494 Vss 0.00318f
C3031 Vss.n495 Vss 0.00552f
C3032 Vss.n496 Vss 0.00318f
C3033 Vss.n497 Vss 0
C3034 Vss.n498 Vss 0.00103f
C3035 Vss.n499 Vss 0.00161f
C3036 Vss.n500 Vss 0.00161f
C3037 Vss.n501 Vss 0.00165f
C3038 Vss.n502 Vss 0
C3039 Vss.n503 Vss 0
C3040 Vss.n504 Vss 0
C3041 Vss.n505 Vss 0.00318f
C3042 Vss.n506 Vss 0.00544f
C3043 Vss.n507 Vss 0.00326f
C3044 Vss.n508 Vss 0
C3045 Vss.n509 Vss 0
C3046 Vss.n511 Vss 0
C3047 Vss.n512 Vss 0
C3048 Vss.n513 Vss 0
C3049 Vss.n514 Vss 0
C3050 Vss.n515 Vss 0.00318f
C3051 Vss.n516 Vss 0.00381f
C3052 Vss.n517 Vss 0
C3053 Vss.n518 Vss 0
C3054 Vss.n519 Vss 0
C3055 Vss.n520 Vss 0
C3056 Vss.n521 Vss 0
C3057 Vss.n522 Vss 0
C3058 Vss.n523 Vss 0
C3059 Vss.n524 Vss 0
C3060 Vss.n525 Vss 0
C3061 Vss.n526 Vss 0
C3062 Vss.n527 Vss 0
C3063 Vss.n528 Vss 0
C3064 Vss.n529 Vss 0
C3065 Vss.n530 Vss 0
C3066 Vss.n531 Vss 0.00183f
C3067 Vss.n532 Vss 0
C3068 Vss.n533 Vss 0
C3069 Vss.n534 Vss 0
C3070 Vss.n535 Vss 0
C3071 Vss.n536 Vss 0
C3072 Vss.n537 Vss 0.00331f
C3073 Vss.n538 Vss 0
C3074 Vss.n539 Vss 0.00395f
C3075 Vss.n540 Vss 0
C3076 Vss.n541 Vss 0
C3077 Vss.n542 Vss 0
C3078 Vss.n543 Vss 0.00461f
C3079 Vss.n544 Vss 0.02373f
C3080 Vss.n545 Vss 0.00403f
C3081 Vss.n546 Vss 0.00381f
C3082 Vss.n547 Vss 0
C3083 Vss.n548 Vss 0
C3084 Vss.n549 Vss 0.00381f
C3085 Vss.n550 Vss 0
C3086 Vss.n551 Vss 0
C3087 Vss.n552 Vss 0.00381f
C3088 Vss.n553 Vss 0.00374f
C3089 Vss.n554 Vss 0.00565f
C3090 Vss.n555 Vss 0.00565f
C3091 Vss.n556 Vss 0.00374f
C3092 Vss.n557 Vss 0.00381f
C3093 Vss.n558 Vss 0
C3094 Vss.n559 Vss 0
C3095 Vss.n560 Vss 0.00381f
C3096 Vss.n561 Vss 0
C3097 Vss.n562 Vss 0
C3098 Vss.n563 Vss 0.00381f
C3099 Vss.n564 Vss 0.00374f
C3100 Vss.n565 Vss 0.00565f
C3101 Vss.n566 Vss 0.00565f
C3102 Vss.n567 Vss 0.00374f
C3103 Vss.n568 Vss 0.00381f
C3104 Vss.n569 Vss 0
C3105 Vss.n570 Vss 0
C3106 Vss.n571 Vss 0.00381f
C3107 Vss.n572 Vss 0
C3108 Vss.n573 Vss 0
C3109 Vss.n574 Vss 0.00274f
C3110 Vss.n575 Vss 0.00374f
C3111 Vss.n576 Vss 0.00565f
C3112 Vss.n577 Vss 0.00565f
C3113 Vss.n578 Vss 0.00374f
C3114 Vss.n579 Vss 0.00381f
C3115 Vss.n580 Vss 0
C3116 Vss.n581 Vss 0
C3117 Vss.n582 Vss 0.00381f
C3118 Vss.n583 Vss 0
C3119 Vss.n584 Vss 0
C3120 Vss.n585 Vss 0.00381f
C3121 Vss.n586 Vss 0.00374f
C3122 Vss.n587 Vss 0.00565f
C3123 Vss.n588 Vss 0.00565f
C3124 Vss.n589 Vss 0.00374f
C3125 Vss.n590 Vss 0.00381f
C3126 Vss.n591 Vss 0
C3127 Vss.n592 Vss 0
C3128 Vss.n593 Vss 0.00381f
C3129 Vss.n594 Vss 0
C3130 Vss.n595 Vss 0
C3131 Vss.n596 Vss 0.00381f
C3132 Vss.n597 Vss 0.00374f
C3133 Vss.n598 Vss 0.00565f
C3134 Vss.n599 Vss 0.00565f
C3135 Vss.n600 Vss 0.00374f
C3136 Vss.n601 Vss 0.00381f
C3137 Vss.n602 Vss 0
C3138 Vss.n603 Vss 0
C3139 Vss.n604 Vss 0.00381f
C3140 Vss.n605 Vss 0
C3141 Vss.n606 Vss 0
C3142 Vss.n607 Vss 0
C3143 Vss.n608 Vss 0.00554f
C3144 Vss.n609 Vss -0.00667f
C3145 Vss.n610 Vss -0
C3146 Vss.n611 Vss 0.00204f
C3147 Vss.n612 Vss 0.00248f
C3148 Vss.n613 Vss 0.00239f
C3149 Vss.n614 Vss 0
C3150 Vss.n615 Vss 0
C3151 Vss.n616 Vss 0
C3152 Vss.n617 Vss 0
C3153 Vss.n618 Vss 0
C3154 Vss.n619 Vss 0
C3155 Vss.n620 Vss 0
C3156 Vss.n621 Vss 0
C3157 Vss.n622 Vss 0
C3158 Vss.n623 Vss 0
C3159 Vss.n624 Vss 0
C3160 Vss.n625 Vss 0
C3161 Vss.n626 Vss 0
C3162 Vss.n627 Vss 0
C3163 Vss.n628 Vss 0
C3164 Vss.n629 Vss 0
C3165 Vss.n630 Vss 0.00318f
C3166 Vss.n631 Vss 0.00318f
C3167 Vss.n632 Vss 0
C3168 Vss.n633 Vss 0
C3169 Vss.n634 Vss 0.00446f
C3170 Vss.n635 Vss 0.00263f
C3171 Unnamed_f25afa91_2/a_64_n131# Vss 0.70845f
C3172 Unnamed_f25afa91_2/a_n64_n339# Vss -0.15477f
.ends
