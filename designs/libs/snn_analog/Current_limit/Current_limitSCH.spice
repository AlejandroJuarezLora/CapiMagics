** sch_path: /foss/designs/CapiMagics/sch/Current_limit/Current-limit.sch
.subckt Current-limit i_SUM avdd ifwd avss
*.PININFO avdd:B ifwd:B i_SUM:B avss:B
M4 net1 net1 i_SUM avdd pfet_03v3 L=5u W=0.5u nf=1
M6 ifwd ifwd net1 avdd pfet_03v3 L=5u W=0.5u nf=1
M1 avss avss avss avss nfet_03v3 L=0.28u W=0.5u nf=1
.ends
