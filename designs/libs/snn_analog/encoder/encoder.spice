* NGSPICE file created from encoder.ext - technology: gf180mcuD

.subckt xm5 a_n306_n173# a_186_n173# w_n572_n603# a_n186_n382# VSUBS
X0 a_186_n173# a_n186_n382# a_n306_n173# w_n572_n603# pfet_03v3 ad=0.558p pd=3.06u as=0.558p ps=3.06u w=0.93u l=1.86u
C0 a_n306_n173# a_n186_n382# 0.11626f
C1 w_n572_n603# a_186_n173# 0.66931f
C2 a_n186_n382# a_186_n173# 0.05372f
C3 a_n306_n173# a_186_n173# 0.38397f
C4 a_n186_n382# w_n572_n603# 0.94238f
C5 a_n306_n173# w_n572_n603# 0.29685f
C6 a_186_n173# VSUBS 0.04839f
C7 a_n306_n173# VSUBS 0.04832f
C8 a_n186_n382# VSUBS 0.07458f
C9 w_n572_n603# VSUBS 5.08511f
.ends

.subckt xm3 a_28_n281# a_n178_n281# w_n444_n709# a_n50_n489# VSUBS
X0 a_28_n281# a_n50_n489# a_n178_n281# w_n444_n709# pfet_03v3 ad=1.5p pd=5.5u as=1.5p ps=5.5u w=2u l=0.28u
C0 a_n178_n281# a_n50_n489# 0.0391f
C1 w_n444_n709# a_28_n281# 0.6139f
C2 a_n50_n489# a_28_n281# 0.02705f
C3 a_n178_n281# a_28_n281# 0.53377f
C4 a_n50_n489# w_n444_n709# 0.38939f
C5 a_n178_n281# w_n444_n709# 0.35562f
C6 a_28_n281# VSUBS 0.08168f
C7 a_n178_n281# VSUBS 0.08054f
C8 a_n50_n489# VSUBS 0.0484f
C9 w_n444_n709# VSUBS 4.62248f
.ends

.subckt xm11 a_n178_n131# a_n50_n339# w_n444_n560# a_28_n131# VSUBS
X0 a_28_n131# a_n50_n339# a_n178_n131# w_n444_n560# pfet_03v3 ad=0.375p pd=2.5u as=0.375p ps=2.5u w=0.5u l=0.28u
C0 a_n178_n131# a_n50_n339# 0.02611f
C1 w_n444_n560# a_28_n131# 0.48499f
C2 a_n50_n339# a_28_n131# 0.01004f
C3 a_n178_n131# a_28_n131# 0.34063f
C4 a_n50_n339# w_n444_n560# 0.39308f
C5 a_n178_n131# w_n444_n560# 0.22952f
C6 a_28_n131# VSUBS 0.04441f
C7 a_n178_n131# VSUBS 0.04328f
C8 a_n50_n339# VSUBS 0.04859f
C9 w_n444_n560# VSUBS 3.73985f
.ends

.subckt xm1 a_n1120_n131# a_n1330_n504# a_1000_n131# a_n1000_n339#
X0 a_1000_n131# a_n1000_n339# a_n1120_n131# a_n1330_n504# nfet_03v3 ad=0.3p pd=2.2u as=0.3p ps=2.2u w=0.5u l=10u
C0 a_n1120_n131# a_1000_n131# 1.01551f
C1 a_1000_n131# a_n1000_n339# 0.06176f
C2 a_n1120_n131# a_n1000_n339# 0.42273f
C3 a_1000_n131# a_n1330_n504# 1.43795f
C4 a_n1120_n131# a_n1330_n504# 0.4423f
C5 a_n1000_n339# a_n1330_n504# 4.53847f
.ends

.subckt xm8 a_n306_n173# a_186_n173# w_n572_n603# a_n186_n382# VSUBS
X0 a_186_n173# a_n186_n382# a_n306_n173# w_n572_n603# pfet_03v3 ad=0.558p pd=3.06u as=0.558p ps=3.06u w=0.93u l=1.86u
C0 a_n186_n382# a_n306_n173# 0.11626f
C1 w_n572_n603# a_186_n173# 0.66931f
C2 a_n306_n173# a_186_n173# 0.38397f
C3 a_n186_n382# a_186_n173# 0.05372f
C4 a_n306_n173# w_n572_n603# 0.29685f
C5 a_n186_n382# w_n572_n603# 0.94238f
C6 a_186_n173# VSUBS 0.04839f
C7 a_n306_n173# VSUBS 0.04832f
C8 a_n186_n382# VSUBS 0.07458f
C9 w_n572_n603# VSUBS 5.08511f
.ends

.subckt xm6 a_n306_n173# a_186_n173# w_n572_n603# a_n186_n382# VSUBS
X0 a_186_n173# a_n186_n382# a_n306_n173# w_n572_n603# pfet_03v3 ad=0.558p pd=3.06u as=0.558p ps=3.06u w=0.93u l=1.86u
C0 a_n186_n382# a_n306_n173# 0.11626f
C1 w_n572_n603# a_186_n173# 0.66931f
C2 a_n306_n173# a_186_n173# 0.38397f
C3 a_n186_n382# a_186_n173# 0.05372f
C4 a_n306_n173# w_n572_n603# 0.29685f
C5 a_n186_n382# w_n572_n603# 0.94238f
C6 a_186_n173# VSUBS 0.04839f
C7 a_n306_n173# VSUBS 0.04832f
C8 a_n186_n382# VSUBS 0.07458f
C9 w_n572_n603# VSUBS 5.08511f
.ends

.subckt xm4 a_28_n281# a_n178_n281# w_n444_n709# a_n50_n489# VSUBS
X0 a_28_n281# a_n50_n489# a_n178_n281# w_n444_n709# pfet_03v3 ad=1.5p pd=5.5u as=1.5p ps=5.5u w=2u l=0.28u
C0 a_n178_n281# a_n50_n489# 0.0391f
C1 w_n444_n709# a_28_n281# 0.6139f
C2 a_n50_n489# a_28_n281# 0.02705f
C3 a_n178_n281# a_28_n281# 0.53377f
C4 a_n50_n489# w_n444_n709# 0.38939f
C5 a_n178_n281# w_n444_n709# 0.35562f
C6 a_28_n281# VSUBS 0.08168f
C7 a_n178_n281# VSUBS 0.08054f
C8 a_n50_n489# VSUBS 0.0484f
C9 w_n444_n709# VSUBS 4.62248f
.ends

.subckt xm2 a_n1120_n131# a_n1330_n504# a_1000_n131# a_n1000_n339#
X0 a_1000_n131# a_n1000_n339# a_n1120_n131# a_n1330_n504# nfet_03v3 ad=0.3p pd=2.2u as=0.3p ps=2.2u w=0.5u l=10u
C0 a_1000_n131# a_n1120_n131# 1.01551f
C1 a_n1120_n131# a_n1000_n339# 0.42273f
C2 a_1000_n131# a_n1000_n339# 0.06176f
C3 a_1000_n131# a_n1330_n504# 1.43795f
C4 a_n1120_n131# a_n1330_n504# 0.4423f
C5 a_n1000_n339# a_n1330_n504# 4.53847f
.ends

.subckt xm10 a_n178_n131# a_n50_n339# a_n388_n504# a_28_n131#
X0 a_28_n131# a_n50_n339# a_n178_n131# a_n388_n504# nfet_03v3 ad=0.375p pd=2.5u as=0.375p ps=2.5u w=0.5u l=0.28u
C0 a_28_n131# a_n178_n131# 0.34063f
C1 a_n178_n131# a_n50_n339# 0.02611f
C2 a_28_n131# a_n50_n339# 0.01004f
C3 a_28_n131# a_n388_n504# 0.52938f
C4 a_n178_n131# a_n388_n504# 0.27279f
C5 a_n50_n339# a_n388_n504# 0.44167f
.ends

.subckt xm9 a_n178_n131# a_n50_n339# a_n388_n504# a_28_n131#
X0 a_28_n131# a_n50_n339# a_n178_n131# a_n388_n504# nfet_03v3 ad=0.375p pd=2.5u as=0.375p ps=2.5u w=0.5u l=0.28u
C0 a_n178_n131# a_28_n131# 0.34063f
C1 a_28_n131# a_n50_n339# 0.01004f
C2 a_n178_n131# a_n50_n339# 0.02611f
C3 a_28_n131# a_n388_n504# 0.52938f
C4 a_n178_n131# a_n388_n504# 0.27279f
C5 a_n50_n339# a_n388_n504# 0.44167f
.ends

.subckt xm7 a_n306_n173# a_186_n173# w_n572_n603# a_n186_n382# VSUBS
X0 a_186_n173# a_n186_n382# a_n306_n173# w_n572_n603# pfet_03v3 ad=0.558p pd=3.06u as=0.558p ps=3.06u w=0.93u l=1.86u
C0 a_n306_n173# a_n186_n382# 0.11626f
C1 w_n572_n603# a_186_n173# 0.66931f
C2 a_n186_n382# a_186_n173# 0.05372f
C3 a_n306_n173# a_186_n173# 0.38397f
C4 a_n186_n382# w_n572_n603# 0.94238f
C5 a_n306_n173# w_n572_n603# 0.29685f
C6 a_186_n173# VSUBS 0.04839f
C7 a_n306_n173# VSUBS 0.04832f
C8 a_n186_n382# VSUBS 0.07458f
C9 w_n572_n603# VSUBS 5.08511f
.ends

.subckt encoder Vdd Vss
Xxm5_0 Vdd xm5_0/a_186_n173# Vdd xm3_0/a_28_n281# Vss xm5
Xxm3_0 xm3_0/a_28_n281# Vdd Vdd xm3_0/a_28_n281# Vss xm3
Xxm11_0 Vdd xm9_0/a_n50_n339# Vdd xm9_0/a_n50_n339# Vss xm11
Xxm1_0 xm9_0/a_28_n131# Vss xm3_0/a_28_n281# xm1_0/a_n1000_n339# xm1
Xxm8_0 Vdd xm8_0/a_186_n173# Vdd xm3_0/a_28_n281# Vss xm8
Xxm6_0 Vdd xm6_0/a_186_n173# Vdd xm4_0/a_28_n281# Vss xm6
Xxm4_0 xm4_0/a_28_n281# Vdd Vdd xm4_0/a_28_n281# Vss xm4
Xxm2_0 xm9_0/a_28_n131# Vss xm4_0/a_28_n281# xm2_0/a_n1000_n339# xm2
Xxm10_0 Vss xm9_0/a_n50_n339# Vss xm9_0/a_n50_n339# xm10
Xxm9_0 Vss xm9_0/a_n50_n339# Vss xm9_0/a_28_n131# xm9
Xxm7_0 Vdd xm7_0/a_186_n173# Vdd xm4_0/a_28_n281# Vss xm7
R0 Vss.n164 Vss.n163 16629.2
R1 Vss.n163 Vss.n44 15075
R2 Vss.n162 Vss.n65 15075
R3 Vss.n161 Vss.n66 14000
R4 Vss.n160 Vss.n67 14000
R5 Vss.n160 Vss.n159 12326.2
R6 Vss.n163 Vss.n162 4508.89
R7 Vss.n162 Vss.n161 4476.19
R8 Vss.n161 Vss.n160 3398
R9 Vss.n255 Vss.n254 411.228
R10 Vss.n159 Vss.n68 235.252
R11 Vss.n256 Vss.n255 235.252
R12 Vss.n254 Vss.n8 235.252
R13 Vss.n215 Vss.n164 235.252
R14 Vss.n77 Vss.n68 148.19
R15 Vss.n151 Vss.n77 148.19
R16 Vss.n151 Vss.n150 148.19
R17 Vss.n144 Vss.n91 148.19
R18 Vss.n144 Vss.n92 148.19
R19 Vss.n138 Vss.n92 148.19
R20 Vss.n138 Vss.n137 148.19
R21 Vss.n137 Vss.n136 148.19
R22 Vss.n136 Vss.n106 148.19
R23 Vss.n130 Vss.n6 148.19
R24 Vss.n256 Vss.n6 148.19
R25 Vss.n246 Vss.n17 148.19
R26 Vss.n246 Vss.n18 148.19
R27 Vss.n194 Vss.n42 148.19
R28 Vss.n224 Vss.n53 148.19
R29 Vss.n240 Vss.n29 146.339
R30 Vss.n91 Vss.n67 144.487
R31 Vss.n65 Vss.n17 144.487
R32 Vss.n61 Vss.n55 131.519
R33 Vss.n216 Vss.n62 131.519
R34 Vss.n223 Vss.n55 120.406
R35 Vss.n130 Vss.n66 118.552
R36 Vss.n230 Vss.n44 118.552
R37 Vss.n240 Vss.n239 105.587
R38 Vss.n188 Vss.n32 105.587
R39 Vss.n231 Vss.n230 87.0623
R40 Vss.n63 Vss.n60 68.4449
R41 Vss.n217 Vss.n60 68.4449
R42 Vss.n222 Vss.n57 68.4449
R43 Vss.n222 Vss.n56 68.4449
R44 Vss.n33 Vss.n31 68.4449
R45 Vss.n238 Vss.n33 68.4449
R46 Vss.n232 Vss.n41 68.4449
R47 Vss.n232 Vss.n34 68.4449
R48 Vss.n253 Vss.n9 66.6949
R49 Vss.n214 Vss.n166 66.6949
R50 Vss.n166 Vss.n64 66.6949
R51 Vss.n253 Vss.n10 66.6949
R52 Vss.n7 Vss.n5 66.6949
R53 Vss.n257 Vss.n5 66.6949
R54 Vss.n158 Vss.n70 66.6949
R55 Vss.n158 Vss.n69 66.6949
R56 Vss.n231 Vss.n42 61.129
R57 Vss.n239 Vss.n32 42.6052
R58 Vss.n194 Vss.n188 42.6052
R59 Vss.n106 Vss.n66 29.6386
R60 Vss.n53 Vss.n44 29.6386
R61 Vss.n224 Vss.n223 27.7862
R62 Vss.n62 Vss.n61 16.6719
R63 Vss.n216 Vss.n215 16.6719
R64 Vss.n19 Vss.n9 15.5561
R65 Vss.n245 Vss.n19 15.5561
R66 Vss.n245 Vss.n20 15.5561
R67 Vss.n241 Vss.n20 15.5561
R68 Vss.n241 Vss.n28 15.5561
R69 Vss.n193 Vss.n28 15.5561
R70 Vss.n193 Vss.n45 15.5561
R71 Vss.n229 Vss.n45 15.5561
R72 Vss.n229 Vss.n46 15.5561
R73 Vss.n225 Vss.n46 15.5561
R74 Vss.n225 Vss.n52 15.5561
R75 Vss.n165 Vss.n52 15.5561
R76 Vss.n214 Vss.n165 15.5561
R77 Vss.n13 Vss.n10 15.5561
R78 Vss.n247 Vss.n13 15.5561
R79 Vss.n247 Vss.n16 15.5561
R80 Vss.n30 Vss.n16 15.5561
R81 Vss.n187 Vss.n30 15.5561
R82 Vss.n195 Vss.n187 15.5561
R83 Vss.n196 Vss.n195 15.5561
R84 Vss.n196 Vss.n43 15.5561
R85 Vss.n199 Vss.n43 15.5561
R86 Vss.n199 Vss.n54 15.5561
R87 Vss.n205 Vss.n54 15.5561
R88 Vss.n206 Vss.n205 15.5561
R89 Vss.n206 Vss.n64 15.5561
R90 Vss.n73 Vss.n70 15.5561
R91 Vss.n152 Vss.n73 15.5561
R92 Vss.n152 Vss.n76 15.5561
R93 Vss.n93 Vss.n76 15.5561
R94 Vss.n143 Vss.n93 15.5561
R95 Vss.n143 Vss.n94 15.5561
R96 Vss.n139 Vss.n94 15.5561
R97 Vss.n139 Vss.n102 15.5561
R98 Vss.n135 Vss.n102 15.5561
R99 Vss.n135 Vss.n107 15.5561
R100 Vss.n131 Vss.n107 15.5561
R101 Vss.n131 Vss.n4 15.5561
R102 Vss.n257 Vss.n4 15.5561
R103 Vss.n82 Vss.n69 15.5561
R104 Vss.n82 Vss.n78 15.5561
R105 Vss.n149 Vss.n78 15.5561
R106 Vss.n149 Vss.n79 15.5561
R107 Vss.n145 Vss.n79 15.5561
R108 Vss.n145 Vss.n90 15.5561
R109 Vss.n103 Vss.n90 15.5561
R110 Vss.n104 Vss.n103 15.5561
R111 Vss.n105 Vss.n104 15.5561
R112 Vss.n112 Vss.n105 15.5561
R113 Vss.n129 Vss.n112 15.5561
R114 Vss.n129 Vss.n113 15.5561
R115 Vss.n113 Vss.n7 15.5561
R116 Vss.n217 Vss.n57 15.5561
R117 Vss.n63 Vss.n56 15.5561
R118 Vss.n41 Vss.n31 15.5561
R119 Vss.n238 Vss.n34 15.5561
R120 Vss.n261 Vss.n260 6.37289
R121 Vss.n170 Vss.n0 5.53949
R122 Vss.n173 Vss.n63 5.2005
R123 Vss.n216 Vss.n63 5.2005
R124 Vss.n172 Vss.n56 5.2005
R125 Vss.n61 Vss.n56 5.2005
R126 Vss.n218 Vss.n217 5.2005
R127 Vss.n217 Vss.n216 5.2005
R128 Vss.n219 Vss.n57 5.2005
R129 Vss.n61 Vss.n57 5.2005
R130 Vss.n126 Vss.n7 5.2005
R131 Vss.n256 Vss.n7 5.2005
R132 Vss.n127 Vss.n113 5.2005
R133 Vss.n113 Vss.n6 5.2005
R134 Vss.n129 Vss.n128 5.2005
R135 Vss.n130 Vss.n129 5.2005
R136 Vss.n114 Vss.n112 5.2005
R137 Vss.n112 Vss.n106 5.2005
R138 Vss.n120 Vss.n105 5.2005
R139 Vss.n136 Vss.n105 5.2005
R140 Vss.n119 Vss.n104 5.2005
R141 Vss.n137 Vss.n104 5.2005
R142 Vss.n118 Vss.n103 5.2005
R143 Vss.n138 Vss.n103 5.2005
R144 Vss.n90 Vss.n89 5.2005
R145 Vss.n92 Vss.n90 5.2005
R146 Vss.n146 Vss.n145 5.2005
R147 Vss.n145 Vss.n144 5.2005
R148 Vss.n147 Vss.n79 5.2005
R149 Vss.n91 Vss.n79 5.2005
R150 Vss.n149 Vss.n148 5.2005
R151 Vss.n150 Vss.n149 5.2005
R152 Vss.n80 Vss.n78 5.2005
R153 Vss.n151 Vss.n78 5.2005
R154 Vss.n83 Vss.n82 5.2005
R155 Vss.n82 Vss.n77 5.2005
R156 Vss.n81 Vss.n69 5.2005
R157 Vss.n69 Vss.n68 5.2005
R158 Vss.n258 Vss.n257 5.2005
R159 Vss.n257 Vss.n256 5.2005
R160 Vss.n4 Vss.n3 5.2005
R161 Vss.n6 Vss.n4 5.2005
R162 Vss.n132 Vss.n131 5.2005
R163 Vss.n131 Vss.n130 5.2005
R164 Vss.n133 Vss.n107 5.2005
R165 Vss.n107 Vss.n106 5.2005
R166 Vss.n135 Vss.n134 5.2005
R167 Vss.n136 Vss.n135 5.2005
R168 Vss.n102 Vss.n101 5.2005
R169 Vss.n137 Vss.n102 5.2005
R170 Vss.n140 Vss.n139 5.2005
R171 Vss.n139 Vss.n138 5.2005
R172 Vss.n141 Vss.n94 5.2005
R173 Vss.n94 Vss.n92 5.2005
R174 Vss.n143 Vss.n142 5.2005
R175 Vss.n144 Vss.n143 5.2005
R176 Vss.n95 Vss.n93 5.2005
R177 Vss.n93 Vss.n91 5.2005
R178 Vss.n76 Vss.n75 5.2005
R179 Vss.n150 Vss.n76 5.2005
R180 Vss.n153 Vss.n152 5.2005
R181 Vss.n152 Vss.n151 5.2005
R182 Vss.n154 Vss.n73 5.2005
R183 Vss.n77 Vss.n73 5.2005
R184 Vss.n155 Vss.n70 5.2005
R185 Vss.n70 Vss.n68 5.2005
R186 Vss.n208 Vss.n64 5.2005
R187 Vss.n215 Vss.n64 5.2005
R188 Vss.n207 Vss.n206 5.2005
R189 Vss.n206 Vss.n62 5.2005
R190 Vss.n205 Vss.n204 5.2005
R191 Vss.n205 Vss.n55 5.2005
R192 Vss.n177 Vss.n54 5.2005
R193 Vss.n224 Vss.n54 5.2005
R194 Vss.n200 Vss.n199 5.2005
R195 Vss.n199 Vss.n53 5.2005
R196 Vss.n198 Vss.n43 5.2005
R197 Vss.n230 Vss.n43 5.2005
R198 Vss.n197 Vss.n196 5.2005
R199 Vss.n196 Vss.n42 5.2005
R200 Vss.n195 Vss.n179 5.2005
R201 Vss.n195 Vss.n194 5.2005
R202 Vss.n187 Vss.n186 5.2005
R203 Vss.n187 Vss.n32 5.2005
R204 Vss.n181 Vss.n30 5.2005
R205 Vss.n240 Vss.n30 5.2005
R206 Vss.n16 Vss.n15 5.2005
R207 Vss.n18 Vss.n16 5.2005
R208 Vss.n248 Vss.n247 5.2005
R209 Vss.n247 Vss.n246 5.2005
R210 Vss.n249 Vss.n13 5.2005
R211 Vss.n17 Vss.n13 5.2005
R212 Vss.n250 Vss.n10 5.2005
R213 Vss.n10 Vss.n8 5.2005
R214 Vss.n21 Vss.n9 5.2005
R215 Vss.n9 Vss.n8 5.2005
R216 Vss.n22 Vss.n19 5.2005
R217 Vss.n19 Vss.n17 5.2005
R218 Vss.n245 Vss.n244 5.2005
R219 Vss.n246 Vss.n245 5.2005
R220 Vss.n243 Vss.n20 5.2005
R221 Vss.n20 Vss.n18 5.2005
R222 Vss.n242 Vss.n241 5.2005
R223 Vss.n241 Vss.n240 5.2005
R224 Vss.n28 Vss.n27 5.2005
R225 Vss.n32 Vss.n28 5.2005
R226 Vss.n193 Vss.n192 5.2005
R227 Vss.n194 Vss.n193 5.2005
R228 Vss.n47 Vss.n45 5.2005
R229 Vss.n45 Vss.n42 5.2005
R230 Vss.n229 Vss.n228 5.2005
R231 Vss.n230 Vss.n229 5.2005
R232 Vss.n227 Vss.n46 5.2005
R233 Vss.n53 Vss.n46 5.2005
R234 Vss.n226 Vss.n225 5.2005
R235 Vss.n225 Vss.n224 5.2005
R236 Vss.n52 Vss.n51 5.2005
R237 Vss.n55 Vss.n52 5.2005
R238 Vss.n167 Vss.n165 5.2005
R239 Vss.n165 Vss.n62 5.2005
R240 Vss.n214 Vss.n213 5.2005
R241 Vss.n215 Vss.n214 5.2005
R242 Vss.n41 Vss.n40 5.2005
R243 Vss.n188 Vss.n41 5.2005
R244 Vss.n39 Vss.n31 5.2005
R245 Vss.n239 Vss.n31 5.2005
R246 Vss.n35 Vss.n34 5.2005
R247 Vss.n188 Vss.n34 5.2005
R248 Vss.n238 Vss.n237 5.2005
R249 Vss.n239 Vss.n238 5.2005
R250 Vss.n221 Vss.n220 5.19561
R251 Vss.n236 Vss.n36 5.19561
R252 Vss.n233 Vss.n37 5.19561
R253 Vss.n221 Vss.n58 5.18779
R254 Vss.n38 Vss.n36 5.18779
R255 Vss.n125 Vss.n1 5.17941
R256 Vss.n157 Vss.n156 5.17941
R257 Vss.n157 Vss.n71 5.17941
R258 Vss.n252 Vss.n251 5.17941
R259 Vss.n252 Vss.n11 5.17941
R260 Vss.n212 Vss.n211 5.17941
R261 Vss.n234 Vss.n0 5.02289
R262 Vss.n170 Vss.n59 4.7417
R263 Vss.n175 Vss.n174 4.7417
R264 Vss.n235 Vss.n234 4.7417
R265 Vss.n260 Vss.n259 4.7255
R266 Vss.n210 Vss.n209 4.7255
R267 Vss.n154 Vss.n72 4.5005
R268 Vss.n153 Vss.n74 4.5005
R269 Vss.n96 Vss.n75 4.5005
R270 Vss.n97 Vss.n95 4.5005
R271 Vss.n142 Vss.n98 4.5005
R272 Vss.n141 Vss.n99 4.5005
R273 Vss.n140 Vss.n100 4.5005
R274 Vss.n108 Vss.n101 4.5005
R275 Vss.n134 Vss.n109 4.5005
R276 Vss.n133 Vss.n110 4.5005
R277 Vss.n132 Vss.n111 4.5005
R278 Vss.n3 Vss.n2 4.5005
R279 Vss.n259 Vss.n258 4.5005
R280 Vss.n156 Vss.n155 4.5005
R281 Vss.n84 Vss.n83 4.5005
R282 Vss.n85 Vss.n80 4.5005
R283 Vss.n148 Vss.n86 4.5005
R284 Vss.n147 Vss.n87 4.5005
R285 Vss.n146 Vss.n88 4.5005
R286 Vss.n116 Vss.n89 4.5005
R287 Vss.n118 Vss.n117 4.5005
R288 Vss.n119 Vss.n115 4.5005
R289 Vss.n121 Vss.n120 4.5005
R290 Vss.n122 Vss.n114 4.5005
R291 Vss.n128 Vss.n123 4.5005
R292 Vss.n127 Vss.n124 4.5005
R293 Vss.n126 Vss.n125 4.5005
R294 Vss.n81 Vss.n71 4.5005
R295 Vss.n249 Vss.n12 4.5005
R296 Vss.n248 Vss.n14 4.5005
R297 Vss.n182 Vss.n15 4.5005
R298 Vss.n183 Vss.n181 4.5005
R299 Vss.n186 Vss.n185 4.5005
R300 Vss.n184 Vss.n179 4.5005
R301 Vss.n197 Vss.n180 4.5005
R302 Vss.n198 Vss.n178 4.5005
R303 Vss.n201 Vss.n200 4.5005
R304 Vss.n202 Vss.n177 4.5005
R305 Vss.n204 Vss.n203 4.5005
R306 Vss.n207 Vss.n176 4.5005
R307 Vss.n209 Vss.n208 4.5005
R308 Vss.n251 Vss.n250 4.5005
R309 Vss.n21 Vss.n11 4.5005
R310 Vss.n23 Vss.n22 4.5005
R311 Vss.n244 Vss.n24 4.5005
R312 Vss.n243 Vss.n25 4.5005
R313 Vss.n242 Vss.n26 4.5005
R314 Vss.n189 Vss.n27 4.5005
R315 Vss.n192 Vss.n191 4.5005
R316 Vss.n190 Vss.n47 4.5005
R317 Vss.n228 Vss.n48 4.5005
R318 Vss.n227 Vss.n49 4.5005
R319 Vss.n226 Vss.n50 4.5005
R320 Vss.n168 Vss.n51 4.5005
R321 Vss.n169 Vss.n167 4.5005
R322 Vss.n213 Vss.n212 4.5005
R323 Vss.n218 Vss.n59 4.5005
R324 Vss.n220 Vss.n219 4.5005
R325 Vss.n174 Vss.n173 4.5005
R326 Vss.n172 Vss.n58 4.5005
R327 Vss.n235 Vss.n35 4.5005
R328 Vss.n237 Vss.n236 4.5005
R329 Vss.n40 Vss.n37 4.5005
R330 Vss.n39 Vss.n38 4.5005
R331 Vss.n150 Vss.n67 3.70526
R332 Vss.n65 Vss.n8 3.70526
R333 Vss.n29 Vss.n18 1.85288
R334 Vss.n261 Vss.n0 0.8483
R335 Vss.n222 Vss.n221 0.743357
R336 Vss.n223 Vss.n222 0.743357
R337 Vss.n171 Vss.n60 0.743357
R338 Vss.n164 Vss.n60 0.743357
R339 Vss.n158 Vss.n157 0.743357
R340 Vss.n159 Vss.n158 0.743357
R341 Vss.n5 Vss.n1 0.743357
R342 Vss.n255 Vss.n5 0.743357
R343 Vss.n253 Vss.n252 0.743357
R344 Vss.n254 Vss.n253 0.743357
R345 Vss.n211 Vss.n166 0.743357
R346 Vss.n166 Vss.n164 0.743357
R347 Vss.n36 Vss.n33 0.743357
R348 Vss.n33 Vss.n29 0.743357
R349 Vss.n233 Vss.n232 0.743357
R350 Vss.n232 Vss.n231 0.743357
R351 Vss Vss.n261 0.5729
R352 Vss.n260 Vss.n1 0.454413
R353 Vss.n211 Vss.n210 0.454413
R354 Vss.n175 Vss.n171 0.454413
R355 Vss.n171 Vss.n170 0.454413
R356 Vss.n234 Vss.n233 0.454413
R357 Vss.n210 Vss.n175 0.427022
R358 Vss.n155 Vss.n154 0.1445
R359 Vss.n154 Vss.n153 0.1445
R360 Vss.n153 Vss.n75 0.1445
R361 Vss.n95 Vss.n75 0.1445
R362 Vss.n142 Vss.n95 0.1445
R363 Vss.n142 Vss.n141 0.1445
R364 Vss.n141 Vss.n140 0.1445
R365 Vss.n140 Vss.n101 0.1445
R366 Vss.n134 Vss.n101 0.1445
R367 Vss.n134 Vss.n133 0.1445
R368 Vss.n133 Vss.n132 0.1445
R369 Vss.n132 Vss.n3 0.1445
R370 Vss.n258 Vss.n3 0.1445
R371 Vss.n156 Vss.n72 0.1445
R372 Vss.n74 Vss.n72 0.1445
R373 Vss.n96 Vss.n74 0.1445
R374 Vss.n97 Vss.n96 0.1445
R375 Vss.n98 Vss.n97 0.1445
R376 Vss.n99 Vss.n98 0.1445
R377 Vss.n100 Vss.n99 0.1445
R378 Vss.n108 Vss.n100 0.1445
R379 Vss.n109 Vss.n108 0.1445
R380 Vss.n110 Vss.n109 0.1445
R381 Vss.n111 Vss.n110 0.1445
R382 Vss.n111 Vss.n2 0.1445
R383 Vss.n259 Vss.n2 0.1445
R384 Vss.n84 Vss.n71 0.1445
R385 Vss.n85 Vss.n84 0.1445
R386 Vss.n86 Vss.n85 0.1445
R387 Vss.n87 Vss.n86 0.1445
R388 Vss.n88 Vss.n87 0.1445
R389 Vss.n116 Vss.n88 0.1445
R390 Vss.n117 Vss.n116 0.1445
R391 Vss.n117 Vss.n115 0.1445
R392 Vss.n121 Vss.n115 0.1445
R393 Vss.n122 Vss.n121 0.1445
R394 Vss.n123 Vss.n122 0.1445
R395 Vss.n124 Vss.n123 0.1445
R396 Vss.n125 Vss.n124 0.1445
R397 Vss.n83 Vss.n81 0.1445
R398 Vss.n83 Vss.n80 0.1445
R399 Vss.n148 Vss.n80 0.1445
R400 Vss.n148 Vss.n147 0.1445
R401 Vss.n147 Vss.n146 0.1445
R402 Vss.n146 Vss.n89 0.1445
R403 Vss.n118 Vss.n89 0.1445
R404 Vss.n119 Vss.n118 0.1445
R405 Vss.n120 Vss.n119 0.1445
R406 Vss.n120 Vss.n114 0.1445
R407 Vss.n128 Vss.n114 0.1445
R408 Vss.n128 Vss.n127 0.1445
R409 Vss.n127 Vss.n126 0.1445
R410 Vss.n219 Vss.n218 0.1445
R411 Vss.n22 Vss.n21 0.1445
R412 Vss.n244 Vss.n22 0.1445
R413 Vss.n244 Vss.n243 0.1445
R414 Vss.n243 Vss.n242 0.1445
R415 Vss.n242 Vss.n27 0.1445
R416 Vss.n192 Vss.n27 0.1445
R417 Vss.n192 Vss.n47 0.1445
R418 Vss.n228 Vss.n47 0.1445
R419 Vss.n228 Vss.n227 0.1445
R420 Vss.n227 Vss.n226 0.1445
R421 Vss.n226 Vss.n51 0.1445
R422 Vss.n167 Vss.n51 0.1445
R423 Vss.n213 Vss.n167 0.1445
R424 Vss.n250 Vss.n249 0.1445
R425 Vss.n249 Vss.n248 0.1445
R426 Vss.n248 Vss.n15 0.1445
R427 Vss.n181 Vss.n15 0.1445
R428 Vss.n186 Vss.n181 0.1445
R429 Vss.n186 Vss.n179 0.1445
R430 Vss.n197 Vss.n179 0.1445
R431 Vss.n198 Vss.n197 0.1445
R432 Vss.n200 Vss.n198 0.1445
R433 Vss.n200 Vss.n177 0.1445
R434 Vss.n204 Vss.n177 0.1445
R435 Vss.n207 Vss.n204 0.1445
R436 Vss.n208 Vss.n207 0.1445
R437 Vss.n251 Vss.n12 0.1445
R438 Vss.n14 Vss.n12 0.1445
R439 Vss.n182 Vss.n14 0.1445
R440 Vss.n183 Vss.n182 0.1445
R441 Vss.n185 Vss.n183 0.1445
R442 Vss.n185 Vss.n184 0.1445
R443 Vss.n184 Vss.n180 0.1445
R444 Vss.n180 Vss.n178 0.1445
R445 Vss.n201 Vss.n178 0.1445
R446 Vss.n202 Vss.n201 0.1445
R447 Vss.n203 Vss.n202 0.1445
R448 Vss.n203 Vss.n176 0.1445
R449 Vss.n209 Vss.n176 0.1445
R450 Vss.n23 Vss.n11 0.1445
R451 Vss.n24 Vss.n23 0.1445
R452 Vss.n25 Vss.n24 0.1445
R453 Vss.n26 Vss.n25 0.1445
R454 Vss.n189 Vss.n26 0.1445
R455 Vss.n191 Vss.n189 0.1445
R456 Vss.n191 Vss.n190 0.1445
R457 Vss.n190 Vss.n48 0.1445
R458 Vss.n49 Vss.n48 0.1445
R459 Vss.n50 Vss.n49 0.1445
R460 Vss.n168 Vss.n50 0.1445
R461 Vss.n169 Vss.n168 0.1445
R462 Vss.n212 Vss.n169 0.1445
R463 Vss.n220 Vss.n59 0.1445
R464 Vss.n174 Vss.n58 0.1445
R465 Vss.n173 Vss.n172 0.1445
R466 Vss.n40 Vss.n39 0.1445
R467 Vss.n237 Vss.n35 0.1445
R468 Vss.n236 Vss.n235 0.1445
R469 Vss.n38 Vss.n37 0.1445
R470 Vdd.n106 Vdd.n95 696.312
R471 Vdd.n106 Vdd.n105 696.312
R472 Vdd.n15 Vdd.n4 696.312
R473 Vdd.n7 Vdd.n4 696.312
R474 Vdd.n199 Vdd.n188 528.52
R475 Vdd.n191 Vdd.n188 528.52
R476 Vdd.n142 Vdd.n117 446.678
R477 Vdd.n127 Vdd.n117 446.678
R478 Vdd.n178 Vdd.n153 446.678
R479 Vdd.n163 Vdd.n153 446.678
R480 Vdd.n86 Vdd.n61 446.678
R481 Vdd.n71 Vdd.n61 446.678
R482 Vdd.n50 Vdd.n25 446.678
R483 Vdd.n35 Vdd.n25 446.678
R484 Vdd.n108 Vdd.n107 74.638
R485 Vdd.n107 Vdd.n96 74.638
R486 Vdd.n104 Vdd.n98 74.638
R487 Vdd.n98 Vdd.n97 74.638
R488 Vdd.n16 Vdd.n3 74.638
R489 Vdd.n8 Vdd.n3 74.638
R490 Vdd.n13 Vdd.n5 74.638
R491 Vdd.n14 Vdd.n13 74.638
R492 Vdd.n143 Vdd.n116 62.563
R493 Vdd.n129 Vdd.n116 62.563
R494 Vdd.n123 Vdd.n119 62.563
R495 Vdd.n141 Vdd.n119 62.563
R496 Vdd.n179 Vdd.n152 62.563
R497 Vdd.n165 Vdd.n152 62.563
R498 Vdd.n159 Vdd.n155 62.563
R499 Vdd.n177 Vdd.n155 62.563
R500 Vdd.n87 Vdd.n60 62.563
R501 Vdd.n73 Vdd.n60 62.563
R502 Vdd.n67 Vdd.n63 62.563
R503 Vdd.n85 Vdd.n63 62.563
R504 Vdd.n51 Vdd.n24 62.563
R505 Vdd.n37 Vdd.n24 62.563
R506 Vdd.n31 Vdd.n27 62.563
R507 Vdd.n49 Vdd.n27 62.563
R508 Vdd.n200 Vdd.n187 61.6005
R509 Vdd.n192 Vdd.n187 61.6005
R510 Vdd.n197 Vdd.n189 61.6005
R511 Vdd.n198 Vdd.n197 61.6005
R512 Vdd.n125 Vdd.n124 14.0005
R513 Vdd.n141 Vdd.n120 14.0005
R514 Vdd.n143 Vdd.n115 14.0005
R515 Vdd.n161 Vdd.n160 14.0005
R516 Vdd.n177 Vdd.n156 14.0005
R517 Vdd.n179 Vdd.n151 14.0005
R518 Vdd.n69 Vdd.n68 14.0005
R519 Vdd.n85 Vdd.n64 14.0005
R520 Vdd.n87 Vdd.n59 14.0005
R521 Vdd.n33 Vdd.n32 14.0005
R522 Vdd.n49 Vdd.n28 14.0005
R523 Vdd.n51 Vdd.n23 14.0005
R524 Vdd.n99 Vdd.n96 6.3005
R525 Vdd.n104 Vdd.n103 6.3005
R526 Vdd.n97 Vdd.n94 6.3005
R527 Vdd.n109 Vdd.n108 6.3005
R528 Vdd.n130 Vdd.n129 6.3005
R529 Vdd.n133 Vdd.n125 6.3005
R530 Vdd.n134 Vdd.n124 6.3005
R531 Vdd.n135 Vdd.n123 6.3005
R532 Vdd.n144 Vdd.n143 6.3005
R533 Vdd.n143 Vdd.n142 6.3005
R534 Vdd.n115 Vdd.n114 6.3005
R535 Vdd.n121 Vdd.n120 6.3005
R536 Vdd.n141 Vdd.n140 6.3005
R537 Vdd.n142 Vdd.n141 6.3005
R538 Vdd.n166 Vdd.n165 6.3005
R539 Vdd.n169 Vdd.n161 6.3005
R540 Vdd.n170 Vdd.n160 6.3005
R541 Vdd.n171 Vdd.n159 6.3005
R542 Vdd.n180 Vdd.n179 6.3005
R543 Vdd.n179 Vdd.n178 6.3005
R544 Vdd.n151 Vdd.n150 6.3005
R545 Vdd.n157 Vdd.n156 6.3005
R546 Vdd.n177 Vdd.n176 6.3005
R547 Vdd.n178 Vdd.n177 6.3005
R548 Vdd.n193 Vdd.n192 6.3005
R549 Vdd.n194 Vdd.n189 6.3005
R550 Vdd.n201 Vdd.n200 6.3005
R551 Vdd.n198 Vdd.n186 6.3005
R552 Vdd.n74 Vdd.n73 6.3005
R553 Vdd.n77 Vdd.n69 6.3005
R554 Vdd.n78 Vdd.n68 6.3005
R555 Vdd.n79 Vdd.n67 6.3005
R556 Vdd.n88 Vdd.n87 6.3005
R557 Vdd.n87 Vdd.n86 6.3005
R558 Vdd.n59 Vdd.n58 6.3005
R559 Vdd.n65 Vdd.n64 6.3005
R560 Vdd.n85 Vdd.n84 6.3005
R561 Vdd.n86 Vdd.n85 6.3005
R562 Vdd.n38 Vdd.n37 6.3005
R563 Vdd.n41 Vdd.n33 6.3005
R564 Vdd.n42 Vdd.n32 6.3005
R565 Vdd.n43 Vdd.n31 6.3005
R566 Vdd.n52 Vdd.n51 6.3005
R567 Vdd.n51 Vdd.n50 6.3005
R568 Vdd.n23 Vdd.n22 6.3005
R569 Vdd.n29 Vdd.n28 6.3005
R570 Vdd.n49 Vdd.n48 6.3005
R571 Vdd.n50 Vdd.n49 6.3005
R572 Vdd.n9 Vdd.n8 6.3005
R573 Vdd.n10 Vdd.n5 6.3005
R574 Vdd.n17 Vdd.n16 6.3005
R575 Vdd.n14 Vdd.n2 6.3005
R576 Vdd.n55 Vdd.n19 5.85034
R577 Vdd.n147 Vdd.n111 5.73514
R578 Vdd.n204 Vdd.n203 5.51007
R579 Vdd.n147 Vdd.n146 5.42593
R580 Vdd.n183 Vdd.n182 5.42593
R581 Vdd.n91 Vdd.n90 5.42593
R582 Vdd.n55 Vdd.n54 5.42593
R583 Vdd.n102 Vdd.n100 5.34137
R584 Vdd.n101 Vdd.n92 5.34137
R585 Vdd.n12 Vdd.n11 5.34137
R586 Vdd.n6 Vdd.n0 5.34137
R587 Vdd.n100 Vdd.n93 5.33355
R588 Vdd.n12 Vdd.n1 5.33355
R589 Vdd.n137 Vdd.n136 5.20888
R590 Vdd.n131 Vdd.n112 5.20888
R591 Vdd.n173 Vdd.n172 5.20888
R592 Vdd.n167 Vdd.n148 5.20888
R593 Vdd.n81 Vdd.n80 5.20888
R594 Vdd.n75 Vdd.n56 5.20888
R595 Vdd.n45 Vdd.n44 5.20888
R596 Vdd.n39 Vdd.n20 5.20888
R597 Vdd.n139 Vdd.n137 5.20105
R598 Vdd.n175 Vdd.n173 5.20105
R599 Vdd.n83 Vdd.n81 5.20105
R600 Vdd.n47 Vdd.n45 5.20105
R601 Vdd.n196 Vdd.n195 5.19561
R602 Vdd.n190 Vdd.n184 5.19561
R603 Vdd.n196 Vdd.n185 5.18779
R604 Vdd.n111 Vdd.n110 4.7417
R605 Vdd.n203 Vdd.n202 4.7417
R606 Vdd.n19 Vdd.n18 4.7417
R607 Vdd.n146 Vdd.n145 4.7129
R608 Vdd.n182 Vdd.n181 4.7129
R609 Vdd.n90 Vdd.n89 4.7129
R610 Vdd.n54 Vdd.n53 4.7129
R611 Vdd.n94 Vdd.n93 4.5005
R612 Vdd.n110 Vdd.n109 4.5005
R613 Vdd.n101 Vdd.n99 4.5005
R614 Vdd.n103 Vdd.n102 4.5005
R615 Vdd.n138 Vdd.n121 4.5005
R616 Vdd.n114 Vdd.n113 4.5005
R617 Vdd.n145 Vdd.n144 4.5005
R618 Vdd.n140 Vdd.n139 4.5005
R619 Vdd.n134 Vdd.n122 4.5005
R620 Vdd.n133 Vdd.n132 4.5005
R621 Vdd.n131 Vdd.n130 4.5005
R622 Vdd.n136 Vdd.n135 4.5005
R623 Vdd.n174 Vdd.n157 4.5005
R624 Vdd.n150 Vdd.n149 4.5005
R625 Vdd.n181 Vdd.n180 4.5005
R626 Vdd.n176 Vdd.n175 4.5005
R627 Vdd.n170 Vdd.n158 4.5005
R628 Vdd.n169 Vdd.n168 4.5005
R629 Vdd.n167 Vdd.n166 4.5005
R630 Vdd.n172 Vdd.n171 4.5005
R631 Vdd.n202 Vdd.n201 4.5005
R632 Vdd.n186 Vdd.n185 4.5005
R633 Vdd.n193 Vdd.n190 4.5005
R634 Vdd.n195 Vdd.n194 4.5005
R635 Vdd.n82 Vdd.n65 4.5005
R636 Vdd.n58 Vdd.n57 4.5005
R637 Vdd.n89 Vdd.n88 4.5005
R638 Vdd.n84 Vdd.n83 4.5005
R639 Vdd.n78 Vdd.n66 4.5005
R640 Vdd.n77 Vdd.n76 4.5005
R641 Vdd.n75 Vdd.n74 4.5005
R642 Vdd.n80 Vdd.n79 4.5005
R643 Vdd.n46 Vdd.n29 4.5005
R644 Vdd.n22 Vdd.n21 4.5005
R645 Vdd.n53 Vdd.n52 4.5005
R646 Vdd.n48 Vdd.n47 4.5005
R647 Vdd.n42 Vdd.n30 4.5005
R648 Vdd.n41 Vdd.n40 4.5005
R649 Vdd.n39 Vdd.n38 4.5005
R650 Vdd.n44 Vdd.n43 4.5005
R651 Vdd.n18 Vdd.n17 4.5005
R652 Vdd.n2 Vdd.n1 4.5005
R653 Vdd.n9 Vdd.n6 4.5005
R654 Vdd.n11 Vdd.n10 4.5005
R655 Vdd.n105 Vdd.n104 3.31679
R656 Vdd.n105 Vdd.n96 3.31679
R657 Vdd.n108 Vdd.n95 3.31679
R658 Vdd.n97 Vdd.n95 3.31679
R659 Vdd.n126 Vdd.n123 3.31679
R660 Vdd.n128 Vdd.n125 3.31679
R661 Vdd.n129 Vdd.n128 3.31679
R662 Vdd.n126 Vdd.n124 3.31679
R663 Vdd.n118 Vdd.n115 3.31679
R664 Vdd.n120 Vdd.n118 3.31679
R665 Vdd.n162 Vdd.n159 3.31679
R666 Vdd.n164 Vdd.n161 3.31679
R667 Vdd.n165 Vdd.n164 3.31679
R668 Vdd.n162 Vdd.n160 3.31679
R669 Vdd.n154 Vdd.n151 3.31679
R670 Vdd.n156 Vdd.n154 3.31679
R671 Vdd.n191 Vdd.n189 3.31679
R672 Vdd.n192 Vdd.n191 3.31679
R673 Vdd.n199 Vdd.n198 3.31679
R674 Vdd.n200 Vdd.n199 3.31679
R675 Vdd.n70 Vdd.n67 3.31679
R676 Vdd.n72 Vdd.n69 3.31679
R677 Vdd.n73 Vdd.n72 3.31679
R678 Vdd.n70 Vdd.n68 3.31679
R679 Vdd.n62 Vdd.n59 3.31679
R680 Vdd.n64 Vdd.n62 3.31679
R681 Vdd.n34 Vdd.n31 3.31679
R682 Vdd.n36 Vdd.n33 3.31679
R683 Vdd.n37 Vdd.n36 3.31679
R684 Vdd.n34 Vdd.n32 3.31679
R685 Vdd.n26 Vdd.n23 3.31679
R686 Vdd.n28 Vdd.n26 3.31679
R687 Vdd.n7 Vdd.n5 3.31679
R688 Vdd.n8 Vdd.n7 3.31679
R689 Vdd.n15 Vdd.n14 3.31679
R690 Vdd.n16 Vdd.n15 3.31679
R691 Vdd.n128 Vdd.n127 1.49311
R692 Vdd.n127 Vdd.n126 1.49311
R693 Vdd.n142 Vdd.n118 1.49311
R694 Vdd.n164 Vdd.n163 1.49311
R695 Vdd.n163 Vdd.n162 1.49311
R696 Vdd.n178 Vdd.n154 1.49311
R697 Vdd.n72 Vdd.n71 1.49311
R698 Vdd.n71 Vdd.n70 1.49311
R699 Vdd.n86 Vdd.n62 1.49311
R700 Vdd.n36 Vdd.n35 1.49311
R701 Vdd.n35 Vdd.n34 1.49311
R702 Vdd.n50 Vdd.n26 1.49311
R703 Vdd.n197 Vdd.n196 0.9005
R704 Vdd.n197 Vdd.n188 0.9005
R705 Vdd.n187 Vdd.n184 0.9005
R706 Vdd.n188 Vdd.n187 0.9005
R707 Vdd.n137 Vdd.n119 0.788
R708 Vdd.n119 Vdd.n117 0.788
R709 Vdd.n116 Vdd.n112 0.788
R710 Vdd.n117 Vdd.n116 0.788
R711 Vdd.n173 Vdd.n155 0.788
R712 Vdd.n155 Vdd.n153 0.788
R713 Vdd.n152 Vdd.n148 0.788
R714 Vdd.n153 Vdd.n152 0.788
R715 Vdd.n81 Vdd.n63 0.788
R716 Vdd.n63 Vdd.n61 0.788
R717 Vdd.n60 Vdd.n56 0.788
R718 Vdd.n61 Vdd.n60 0.788
R719 Vdd.n45 Vdd.n27 0.788
R720 Vdd.n27 Vdd.n25 0.788
R721 Vdd.n24 Vdd.n20 0.788
R722 Vdd.n25 Vdd.n24 0.788
R723 Vdd.n91 Vdd.n55 0.6323
R724 Vdd.n204 Vdd.n183 0.6323
R725 Vdd.n183 Vdd.n147 0.6323
R726 Vdd.n100 Vdd.n98 0.6305
R727 Vdd.n106 Vdd.n98 0.6305
R728 Vdd.n107 Vdd.n92 0.6305
R729 Vdd.n107 Vdd.n106 0.6305
R730 Vdd.n13 Vdd.n12 0.6305
R731 Vdd.n13 Vdd.n4 0.6305
R732 Vdd.n3 Vdd.n0 0.6305
R733 Vdd.n4 Vdd.n3 0.6305
R734 Vdd.n111 Vdd.n92 0.600174
R735 Vdd.n19 Vdd.n0 0.600174
R736 Vdd.n146 Vdd.n112 0.496478
R737 Vdd.n182 Vdd.n148 0.496478
R738 Vdd.n90 Vdd.n56 0.496478
R739 Vdd.n54 Vdd.n20 0.496478
R740 Vdd.n203 Vdd.n184 0.454413
R741 Vdd Vdd.n91 0.3569
R742 Vdd Vdd.n204 0.1571
R743 Vdd.n103 Vdd.n99 0.1445
R744 Vdd.n109 Vdd.n94 0.1445
R745 Vdd.n110 Vdd.n93 0.1445
R746 Vdd.n102 Vdd.n101 0.1445
R747 Vdd.n135 Vdd.n134 0.1445
R748 Vdd.n134 Vdd.n133 0.1445
R749 Vdd.n133 Vdd.n130 0.1445
R750 Vdd.n140 Vdd.n121 0.1445
R751 Vdd.n121 Vdd.n114 0.1445
R752 Vdd.n144 Vdd.n114 0.1445
R753 Vdd.n139 Vdd.n138 0.1445
R754 Vdd.n138 Vdd.n113 0.1445
R755 Vdd.n145 Vdd.n113 0.1445
R756 Vdd.n136 Vdd.n122 0.1445
R757 Vdd.n132 Vdd.n122 0.1445
R758 Vdd.n132 Vdd.n131 0.1445
R759 Vdd.n171 Vdd.n170 0.1445
R760 Vdd.n170 Vdd.n169 0.1445
R761 Vdd.n169 Vdd.n166 0.1445
R762 Vdd.n176 Vdd.n157 0.1445
R763 Vdd.n157 Vdd.n150 0.1445
R764 Vdd.n180 Vdd.n150 0.1445
R765 Vdd.n175 Vdd.n174 0.1445
R766 Vdd.n174 Vdd.n149 0.1445
R767 Vdd.n181 Vdd.n149 0.1445
R768 Vdd.n172 Vdd.n158 0.1445
R769 Vdd.n168 Vdd.n158 0.1445
R770 Vdd.n168 Vdd.n167 0.1445
R771 Vdd.n194 Vdd.n193 0.1445
R772 Vdd.n201 Vdd.n186 0.1445
R773 Vdd.n202 Vdd.n185 0.1445
R774 Vdd.n195 Vdd.n190 0.1445
R775 Vdd.n79 Vdd.n78 0.1445
R776 Vdd.n78 Vdd.n77 0.1445
R777 Vdd.n77 Vdd.n74 0.1445
R778 Vdd.n84 Vdd.n65 0.1445
R779 Vdd.n65 Vdd.n58 0.1445
R780 Vdd.n88 Vdd.n58 0.1445
R781 Vdd.n83 Vdd.n82 0.1445
R782 Vdd.n82 Vdd.n57 0.1445
R783 Vdd.n89 Vdd.n57 0.1445
R784 Vdd.n80 Vdd.n66 0.1445
R785 Vdd.n76 Vdd.n66 0.1445
R786 Vdd.n76 Vdd.n75 0.1445
R787 Vdd.n43 Vdd.n42 0.1445
R788 Vdd.n42 Vdd.n41 0.1445
R789 Vdd.n41 Vdd.n38 0.1445
R790 Vdd.n48 Vdd.n29 0.1445
R791 Vdd.n29 Vdd.n22 0.1445
R792 Vdd.n52 Vdd.n22 0.1445
R793 Vdd.n47 Vdd.n46 0.1445
R794 Vdd.n46 Vdd.n21 0.1445
R795 Vdd.n53 Vdd.n21 0.1445
R796 Vdd.n44 Vdd.n30 0.1445
R797 Vdd.n40 Vdd.n30 0.1445
R798 Vdd.n40 Vdd.n39 0.1445
R799 Vdd.n10 Vdd.n9 0.1445
R800 Vdd.n17 Vdd.n2 0.1445
R801 Vdd.n18 Vdd.n1 0.1445
R802 Vdd.n11 Vdd.n6 0.1445
C0 xm5_0/a_186_n173# xm8_0/a_186_n173# 0.00537f
C1 xm1_0/a_n1000_n339# xm9_0/a_n50_n339# 0.00623f
C2 xm7_0/a_186_n173# xm4_0/a_28_n281# 0.03921f
C3 xm1_0/a_n1000_n339# xm5_0/a_186_n173# 0
C4 Vdd xm8_0/a_186_n173# 0.02568f
C5 xm2_0/a_n1000_n339# xm9_0/a_28_n131# 0
C6 xm2_0/a_n1000_n339# xm4_0/a_28_n281# 0.01456f
C7 xm6_0/a_186_n173# xm4_0/a_28_n281# 0.03327f
C8 Vdd xm9_0/a_28_n131# 0.0222f
C9 Vdd xm4_0/a_28_n281# 1.9143f
C10 xm1_0/a_n1000_n339# xm2_0/a_n1000_n339# 0.0071f
C11 xm1_0/a_n1000_n339# Vdd 0.01265f
C12 xm3_0/a_28_n281# xm9_0/a_28_n131# 0.14297f
C13 xm2_0/a_n1000_n339# xm9_0/a_n50_n339# 0.13259f
C14 xm6_0/a_186_n173# xm9_0/a_n50_n339# 0.00387f
C15 xm3_0/a_28_n281# xm4_0/a_28_n281# 0.00537f
C16 Vdd xm9_0/a_n50_n339# 0.73605f
C17 xm1_0/a_n1000_n339# xm3_0/a_28_n281# 0.00485f
C18 xm6_0/a_186_n173# xm7_0/a_186_n173# 0.00537f
C19 xm3_0/a_28_n281# xm9_0/a_n50_n339# 0.00953f
C20 xm7_0/a_186_n173# Vdd 0.01325f
C21 xm5_0/a_186_n173# Vdd 0.01306f
C22 xm3_0/a_28_n281# xm5_0/a_186_n173# 0.03693f
C23 Vdd xm2_0/a_n1000_n339# 0.01176f
C24 xm6_0/a_186_n173# Vdd 0.01169f
C25 xm3_0/a_28_n281# xm2_0/a_n1000_n339# 0
C26 xm9_0/a_28_n131# xm4_0/a_28_n281# 0
C27 xm3_0/a_28_n281# Vdd 1.77819f
C28 xm8_0/a_186_n173# xm9_0/a_n50_n339# 0.00234f
C29 xm1_0/a_n1000_n339# xm9_0/a_28_n131# 0.05282f
C30 xm9_0/a_n50_n339# xm9_0/a_28_n131# 0.12927f
C31 xm9_0/a_n50_n339# xm4_0/a_28_n281# 0.0992f
C32 Vdd.n0 Vss 0.00879f
C33 Vdd.n1 Vss 0.00472f
C34 Vdd.n2 Vss 0.00131f
C35 Vdd.n3 Vss 0.00634f
C36 Vdd.n4 Vss 0.05527f
C37 Vdd.n5 Vss 0.00385f
C38 Vdd.n6 Vss 0.0043f
C39 Vdd.n7 Vss 0.0357f
C40 Vdd.n8 Vss 0.00385f
C41 Vdd.n9 Vss 0.00131f
C42 Vdd.n10 Vss 0.00131f
C43 Vdd.n11 Vss 0.0043f
C44 Vdd.n12 Vss 0.01985f
C45 Vdd.n13 Vss 0.00634f
C46 Vdd.n14 Vss 0.00385f
C47 Vdd.n15 Vss 0.0357f
C48 Vdd.n16 Vss 0.00385f
C49 Vdd.n17 Vss 0.00131f
C50 Vdd.n18 Vss 0.00391f
C51 Vdd.n19 Vss 0.01329f
C52 Vdd.n20 Vss 0.00741f
C53 Vdd.n21 Vss 0.00161f
C54 Vdd.n22 Vss 0.00161f
C55 Vdd.n23 Vss 0.00116f
C56 Vdd.n24 Vss 0.00535f
C57 Vdd.n25 Vss 0.0588f
C58 Vdd.n27 Vss 0.00535f
C59 Vdd.n28 Vss 0.00116f
C60 Vdd.n29 Vss 0.00161f
C61 Vdd.n30 Vss 0.00161f
C62 Vdd.n31 Vss 0.00334f
C63 Vdd.n32 Vss 0.00116f
C64 Vdd.n33 Vss 0.00116f
C65 Vdd.n35 Vss 0.03999f
C66 Vdd.n37 Vss 0.00334f
C67 Vdd.n38 Vss 0.00131f
C68 Vdd.n39 Vss 0.00389f
C69 Vdd.n40 Vss 0.00161f
C70 Vdd.n41 Vss 0.00161f
C71 Vdd.n42 Vss 0.00161f
C72 Vdd.n43 Vss 0.00131f
C73 Vdd.n44 Vss 0.00389f
C74 Vdd.n45 Vss 0.01712f
C75 Vdd.n46 Vss 0.00161f
C76 Vdd.n47 Vss 0.00412f
C77 Vdd.n48 Vss 0.00131f
C78 Vdd.n49 Vss 0.00334f
C79 Vdd.n50 Vss 0.03999f
C80 Vdd.n51 Vss 0.00334f
C81 Vdd.n52 Vss 0.00131f
C82 Vdd.n53 Vss 0.00361f
C83 Vdd.n54 Vss 0.01029f
C84 Vdd.n55 Vss 0.06344f
C85 Vdd.n56 Vss 0.00741f
C86 Vdd.n57 Vss 0.00161f
C87 Vdd.n58 Vss 0.00161f
C88 Vdd.n59 Vss 0.00116f
C89 Vdd.n60 Vss 0.00535f
C90 Vdd.n61 Vss 0.0588f
C91 Vdd.n63 Vss 0.00535f
C92 Vdd.n64 Vss 0.00116f
C93 Vdd.n65 Vss 0.00161f
C94 Vdd.n66 Vss 0.00161f
C95 Vdd.n67 Vss 0.00334f
C96 Vdd.n68 Vss 0.00116f
C97 Vdd.n69 Vss 0.00116f
C98 Vdd.n71 Vss 0.03999f
C99 Vdd.n73 Vss 0.00334f
C100 Vdd.n74 Vss 0.00131f
C101 Vdd.n75 Vss 0.00389f
C102 Vdd.n76 Vss 0.00161f
C103 Vdd.n77 Vss 0.00161f
C104 Vdd.n78 Vss 0.00161f
C105 Vdd.n79 Vss 0.00131f
C106 Vdd.n80 Vss 0.00389f
C107 Vdd.n81 Vss 0.01712f
C108 Vdd.n82 Vss 0.00161f
C109 Vdd.n83 Vss 0.00412f
C110 Vdd.n84 Vss 0.00131f
C111 Vdd.n85 Vss 0.00334f
C112 Vdd.n86 Vss 0.03999f
C113 Vdd.n87 Vss 0.00334f
C114 Vdd.n88 Vss 0.00131f
C115 Vdd.n89 Vss 0.00361f
C116 Vdd.n90 Vss 0.01029f
C117 Vdd.n91 Vss 0.02278f
C118 Vdd.n92 Vss 0.00879f
C119 Vdd.n93 Vss 0.00472f
C120 Vdd.n94 Vss 0.00131f
C121 Vdd.n95 Vss 0.0357f
C122 Vdd.n96 Vss 0.00385f
C123 Vdd.n97 Vss 0.00385f
C124 Vdd.n98 Vss 0.00634f
C125 Vdd.n99 Vss 0.00131f
C126 Vdd.n100 Vss 0.01985f
C127 Vdd.n101 Vss 0.0043f
C128 Vdd.n102 Vss 0.0043f
C129 Vdd.n103 Vss 0.00131f
C130 Vdd.n104 Vss 0.00385f
C131 Vdd.n105 Vss 0.0357f
C132 Vdd.n106 Vss 0.05527f
C133 Vdd.n107 Vss 0.00634f
C134 Vdd.n108 Vss 0.00385f
C135 Vdd.n109 Vss 0.00131f
C136 Vdd.n110 Vss 0.00391f
C137 Vdd.n111 Vss 0.01109f
C138 Vdd.n112 Vss 0.00741f
C139 Vdd.n113 Vss 0.00161f
C140 Vdd.n114 Vss 0.00161f
C141 Vdd.n115 Vss 0.00116f
C142 Vdd.n116 Vss 0.00535f
C143 Vdd.n117 Vss 0.0588f
C144 Vdd.n119 Vss 0.00535f
C145 Vdd.n120 Vss 0.00116f
C146 Vdd.n121 Vss 0.00161f
C147 Vdd.n122 Vss 0.00161f
C148 Vdd.n123 Vss 0.00334f
C149 Vdd.n124 Vss 0.00116f
C150 Vdd.n125 Vss 0.00116f
C151 Vdd.n127 Vss 0.03999f
C152 Vdd.n129 Vss 0.00334f
C153 Vdd.n130 Vss 0.00131f
C154 Vdd.n131 Vss 0.00389f
C155 Vdd.n132 Vss 0.00161f
C156 Vdd.n133 Vss 0.00161f
C157 Vdd.n134 Vss 0.00161f
C158 Vdd.n135 Vss 0.00131f
C159 Vdd.n136 Vss 0.00389f
C160 Vdd.n137 Vss 0.01712f
C161 Vdd.n138 Vss 0.00161f
C162 Vdd.n139 Vss 0.00412f
C163 Vdd.n140 Vss 0.00131f
C164 Vdd.n141 Vss 0.00334f
C165 Vdd.n142 Vss 0.03999f
C166 Vdd.n143 Vss 0.00334f
C167 Vdd.n144 Vss 0.00131f
C168 Vdd.n145 Vss 0.00361f
C169 Vdd.n146 Vss 0.01029f
C170 Vdd.n147 Vss 0.04633f
C171 Vdd.n148 Vss 0.00741f
C172 Vdd.n149 Vss 0.00161f
C173 Vdd.n150 Vss 0.00161f
C174 Vdd.n151 Vss 0.00116f
C175 Vdd.n152 Vss 0.00535f
C176 Vdd.n153 Vss 0.0588f
C177 Vdd.n155 Vss 0.00535f
C178 Vdd.n156 Vss 0.00116f
C179 Vdd.n157 Vss 0.00161f
C180 Vdd.n158 Vss 0.00161f
C181 Vdd.n159 Vss 0.00334f
C182 Vdd.n160 Vss 0.00116f
C183 Vdd.n161 Vss 0.00116f
C184 Vdd.n163 Vss 0.03999f
C185 Vdd.n165 Vss 0.00334f
C186 Vdd.n166 Vss 0.00131f
C187 Vdd.n167 Vss 0.00389f
C188 Vdd.n168 Vss 0.00161f
C189 Vdd.n169 Vss 0.00161f
C190 Vdd.n170 Vss 0.00161f
C191 Vdd.n171 Vss 0.00131f
C192 Vdd.n172 Vss 0.00389f
C193 Vdd.n173 Vss 0.01712f
C194 Vdd.n174 Vss 0.00161f
C195 Vdd.n175 Vss 0.00412f
C196 Vdd.n176 Vss 0.00131f
C197 Vdd.n177 Vss 0.00334f
C198 Vdd.n178 Vss 0.03999f
C199 Vdd.n179 Vss 0.00334f
C200 Vdd.n180 Vss 0.00131f
C201 Vdd.n181 Vss 0.00361f
C202 Vdd.n182 Vss 0.01029f
C203 Vdd.n183 Vss 0.02893f
C204 Vdd.n184 Vss 0.00687f
C205 Vdd.n185 Vss 0.0043f
C206 Vdd.n186 Vss 0.00131f
C207 Vdd.n187 Vss 0.0053f
C208 Vdd.n188 Vss 0.04197f
C209 Vdd.n189 Vss 0.00329f
C210 Vdd.n190 Vss 0.00416f
C211 Vdd.n191 Vss 0.02904f
C212 Vdd.n192 Vss 0.00329f
C213 Vdd.n193 Vss 0.00131f
C214 Vdd.n194 Vss 0.00131f
C215 Vdd.n195 Vss 0.00416f
C216 Vdd.n196 Vss 0.01555f
C217 Vdd.n197 Vss 0.0053f
C218 Vdd.n198 Vss 0.00329f
C219 Vdd.n199 Vss 0.02904f
C220 Vdd.n200 Vss 0.00329f
C221 Vdd.n201 Vss 0.00131f
C222 Vdd.n202 Vss 0.00391f
C223 Vdd.n203 Vss 0.01079f
C224 Vdd.n204 Vss 0.01844f
C225 Vss.n0 Vss 0.00626f
C226 Vss.n1 Vss 0
C227 Vss.n2 Vss 0
C228 Vss.n3 Vss 0
C229 Vss.n4 Vss 0
C230 Vss.n5 Vss 0
C231 Vss.n6 Vss 0.00701f
C232 Vss.n7 Vss 0
C233 Vss.n8 Vss 0.00565f
C234 Vss.n9 Vss 0
C235 Vss.n10 Vss 0
C236 Vss.n11 Vss 0
C237 Vss.n12 Vss 0
C238 Vss.n13 Vss 0
C239 Vss.n14 Vss 0
C240 Vss.n15 Vss 0
C241 Vss.n16 Vss 0
C242 Vss.n17 Vss 0.00692f
C243 Vss.n18 Vss 0.00355f
C244 Vss.n19 Vss 0
C245 Vss.n20 Vss 0
C246 Vss.n21 Vss 0
C247 Vss.n22 Vss 0
C248 Vss.n23 Vss 0
C249 Vss.n24 Vss 0
C250 Vss.n25 Vss 0
C251 Vss.n26 Vss 0
C252 Vss.n27 Vss 0
C253 Vss.n28 Vss 0
C254 Vss.n29 Vss 0.0035f
C255 Vss.n30 Vss 0
C256 Vss.n31 Vss 0
C257 Vss.n32 Vss 0.0035f
C258 Vss.n33 Vss 0
C259 Vss.n34 Vss 0
C260 Vss.n35 Vss 0
C261 Vss.n36 Vss 0.00193f
C262 Vss.n37 Vss 0
C263 Vss.n38 Vss 0
C264 Vss.n39 Vss 0
C265 Vss.n40 Vss 0
C266 Vss.n41 Vss 0
C267 Vss.n42 Vss 0.00495f
C268 Vss.n43 Vss 0
C269 Vss.n44 Vss 0.00546f
C270 Vss.n45 Vss 0
C271 Vss.n46 Vss 0
C272 Vss.n47 Vss 0
C273 Vss.n48 Vss 0
C274 Vss.n49 Vss 0
C275 Vss.n50 Vss 0
C276 Vss.n51 Vss 0
C277 Vss.n52 Vss 0
C278 Vss.n53 Vss 0.00421f
C279 Vss.n54 Vss 0
C280 Vss.n55 Vss 0.00596f
C281 Vss.n56 Vss 0
C282 Vss.n57 Vss 0
C283 Vss.n58 Vss 0
C284 Vss.n59 Vss 0
C285 Vss.n60 Vss 0
C286 Vss.n61 Vss 0.0035f
C287 Vss.n62 Vss 0.0035f
C288 Vss.n63 Vss 0
C289 Vss.n64 Vss 0
C290 Vss.n65 Vss 0.00546f
C291 Vss.n66 Vss 0.00532f
C292 Vss.n67 Vss 0.00532f
C293 Vss.n68 Vss 0.00907f
C294 Vss.n69 Vss 0
C295 Vss.n70 Vss 0
C296 Vss.n71 Vss 0
C297 Vss.n72 Vss 0
C298 Vss.n73 Vss 0
C299 Vss.n74 Vss 0
C300 Vss.n75 Vss 0
C301 Vss.n76 Vss 0
C302 Vss.n77 Vss 0.00701f
C303 Vss.n78 Vss 0
C304 Vss.n79 Vss 0
C305 Vss.n80 Vss 0
C306 Vss.n81 Vss 0
C307 Vss.n82 Vss 0
C308 Vss.n83 Vss 0
C309 Vss.n84 Vss 0
C310 Vss.n85 Vss 0
C311 Vss.n86 Vss 0
C312 Vss.n87 Vss 0
C313 Vss.n88 Vss 0
C314 Vss.n89 Vss 0
C315 Vss.n90 Vss 0
C316 Vss.n91 Vss 0.00692f
C317 Vss.n92 Vss 0.00701f
C318 Vss.n93 Vss 0
C319 Vss.n94 Vss 0
C320 Vss.n95 Vss 0
C321 Vss.n96 Vss 0
C322 Vss.n97 Vss 0
C323 Vss.n98 Vss 0
C324 Vss.n99 Vss 0
C325 Vss.n100 Vss 0
C326 Vss.n101 Vss 0
C327 Vss.n102 Vss 0
C328 Vss.n103 Vss 0
C329 Vss.n104 Vss 0
C330 Vss.n105 Vss 0
C331 Vss.n106 Vss 0.00421f
C332 Vss.n107 Vss 0
C333 Vss.n108 Vss 0
C334 Vss.n109 Vss 0
C335 Vss.n110 Vss 0
C336 Vss.n111 Vss 0
C337 Vss.n112 Vss 0
C338 Vss.n113 Vss 0
C339 Vss.n114 Vss 0
C340 Vss.n115 Vss 0
C341 Vss.n116 Vss 0
C342 Vss.n117 Vss 0
C343 Vss.n118 Vss 0
C344 Vss.n119 Vss 0
C345 Vss.n120 Vss 0
C346 Vss.n121 Vss 0
C347 Vss.n122 Vss 0
C348 Vss.n123 Vss 0
C349 Vss.n124 Vss 0
C350 Vss.n125 Vss 0
C351 Vss.n126 Vss 0
C352 Vss.n127 Vss 0
C353 Vss.n128 Vss 0
C354 Vss.n129 Vss 0
C355 Vss.n130 Vss 0.00631f
C356 Vss.n131 Vss 0
C357 Vss.n132 Vss 0
C358 Vss.n133 Vss 0
C359 Vss.n134 Vss 0
C360 Vss.n135 Vss 0
C361 Vss.n136 Vss 0.00701f
C362 Vss.n137 Vss 0.00701f
C363 Vss.n138 Vss 0.00701f
C364 Vss.n139 Vss 0
C365 Vss.n140 Vss 0
C366 Vss.n141 Vss 0
C367 Vss.n142 Vss 0
C368 Vss.n143 Vss 0
C369 Vss.n144 Vss 0.00701f
C370 Vss.n145 Vss 0
C371 Vss.n146 Vss 0
C372 Vss.n147 Vss 0
C373 Vss.n148 Vss 0
C374 Vss.n149 Vss 0
C375 Vss.n150 Vss 0.00359f
C376 Vss.n151 Vss 0.00701f
C377 Vss.n152 Vss 0
C378 Vss.n153 Vss 0
C379 Vss.n154 Vss 0
C380 Vss.n155 Vss 0
C381 Vss.n156 Vss 0
C382 Vss.n157 Vss 0.00117f
C383 Vss.n158 Vss 0
C384 Vss.n159 Vss 0.17646f
C385 Vss.n160 Vss 0.05661f
C386 Vss.n161 Vss 0.01875f
C387 Vss.n162 Vss 0.01964f
C388 Vss.n163 Vss 0.02583f
C389 Vss.n164 Vss 0.0337f
C390 Vss.n165 Vss 0
C391 Vss.n166 Vss 0
C392 Vss.n167 Vss 0
C393 Vss.n168 Vss 0
C394 Vss.n169 Vss 0
C395 Vss.n170 Vss 0.00109f
C396 Vss.n171 Vss 0
C397 Vss.n172 Vss 0
C398 Vss.n173 Vss 0
C399 Vss.n174 Vss 0
C400 Vss.n175 Vss 0
C401 Vss.n176 Vss 0
C402 Vss.n177 Vss 0
C403 Vss.n178 Vss 0
C404 Vss.n179 Vss 0
C405 Vss.n180 Vss 0
C406 Vss.n181 Vss 0
C407 Vss.n182 Vss 0
C408 Vss.n183 Vss 0
C409 Vss.n184 Vss 0
C410 Vss.n185 Vss 0
C411 Vss.n186 Vss 0
C412 Vss.n187 Vss 0
C413 Vss.n188 Vss 0.0035f
C414 Vss.n189 Vss 0
C415 Vss.n190 Vss 0
C416 Vss.n191 Vss 0
C417 Vss.n192 Vss 0
C418 Vss.n193 Vss 0
C419 Vss.n194 Vss 0.00451f
C420 Vss.n195 Vss 0
C421 Vss.n196 Vss 0
C422 Vss.n197 Vss 0
C423 Vss.n198 Vss 0
C424 Vss.n199 Vss 0
C425 Vss.n200 Vss 0
C426 Vss.n201 Vss 0
C427 Vss.n202 Vss 0
C428 Vss.n203 Vss 0
C429 Vss.n204 Vss 0
C430 Vss.n205 Vss 0
C431 Vss.n206 Vss 0
C432 Vss.n207 Vss 0
C433 Vss.n208 Vss 0
C434 Vss.n209 Vss 0
C435 Vss.n210 Vss 0
C436 Vss.n211 Vss 0
C437 Vss.n212 Vss 0
C438 Vss.n213 Vss 0
C439 Vss.n214 Vss 0
C440 Vss.n215 Vss 0.00596f
C441 Vss.n216 Vss 0.0035f
C442 Vss.n217 Vss 0
C443 Vss.n218 Vss 0
C444 Vss.n219 Vss 0
C445 Vss.n220 Vss 0
C446 Vss.n221 Vss 0.00193f
C447 Vss.n222 Vss 0
C448 Vss.n223 Vss 0.0035f
C449 Vss.n224 Vss 0.00416f
C450 Vss.n225 Vss 0
C451 Vss.n226 Vss 0
C452 Vss.n227 Vss 0
C453 Vss.n228 Vss 0
C454 Vss.n229 Vss 0
C455 Vss.n230 Vss 0.00486f
C456 Vss.n231 Vss 0.0035f
C457 Vss.n232 Vss 0
C458 Vss.n233 Vss 0
C459 Vss.n234 Vss 0
C460 Vss.n235 Vss 0
C461 Vss.n236 Vss 0
C462 Vss.n237 Vss 0
C463 Vss.n238 Vss 0
C464 Vss.n239 Vss 0.0035f
C465 Vss.n240 Vss 0.00596f
C466 Vss.n241 Vss 0
C467 Vss.n242 Vss 0
C468 Vss.n243 Vss 0
C469 Vss.n244 Vss 0
C470 Vss.n245 Vss 0
C471 Vss.n246 Vss 0.00701f
C472 Vss.n247 Vss 0
C473 Vss.n248 Vss 0
C474 Vss.n249 Vss 0
C475 Vss.n250 Vss 0
C476 Vss.n251 Vss 0
C477 Vss.n252 Vss 0.00117f
C478 Vss.n253 Vss 0
C479 Vss.n254 Vss 0.01529f
C480 Vss.n255 Vss 0.01529f
C481 Vss.n256 Vss 0.00907f
C482 Vss.n257 Vss 0
C483 Vss.n258 Vss 0
C484 Vss.n259 Vss 0
C485 Vss.n260 Vss 0.00214f
C486 Vss.n261 Vss 0.00425f
C487 xm2_0/a_n1000_n339# Vss -0.06378f
C488 xm8_0/a_186_n173# Vss -0.09894f
C489 xm9_0/a_n50_n339# Vss -0.4215f
C490 xm9_0/a_28_n131# Vss 0.0316f
C491 xm5_0/a_186_n173# Vss -0.10422f
C492 xm4_0/a_28_n281# Vss -1.84603f
C493 Vdd Vss -13.83054f
C494 xm6_0/a_186_n173# Vss -0.10334f
C495 xm3_0/a_28_n281# Vss -1.45827f
C496 xm7_0/a_186_n173# Vss -0.10434f
C497 xm1_0/a_n1000_n339# Vss -0.05828f
.ends
