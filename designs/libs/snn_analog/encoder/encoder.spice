* NGSPICE file created from encoder.ext - technology: gf180mcuD

.subckt xm5 a_n306_n173# a_186_n173# w_n572_n603# a_n186_n382# VSUBS
X0 a_186_n173# a_n186_n382# a_n306_n173# w_n572_n603# pfet_03v3 ad=0.558p pd=3.06u as=0.558p ps=3.06u w=0.93u l=1.86u
C0 a_n186_n382# a_n306_n173# 0.11626f
C1 a_n306_n173# w_n572_n603# 0.29685f
C2 a_186_n173# a_n186_n382# 0.05372f
C3 a_186_n173# w_n572_n603# 0.66931f
C4 a_n186_n382# w_n572_n603# 0.94238f
C5 a_186_n173# a_n306_n173# 0.38397f
C6 a_186_n173# VSUBS 0.04839f
C7 a_n306_n173# VSUBS 0.04832f
C8 a_n186_n382# VSUBS 0.07458f
C9 w_n572_n603# VSUBS 5.08511f
.ends

.subckt xm3 a_28_n281# a_n178_n281# w_n444_n709# a_n50_n489# VSUBS
X0 a_28_n281# a_n50_n489# a_n178_n281# w_n444_n709# pfet_03v3 ad=1.5p pd=5.5u as=1.5p ps=5.5u w=2u l=0.28u
C0 a_n50_n489# a_n178_n281# 0.0391f
C1 a_n178_n281# w_n444_n709# 0.35562f
C2 a_28_n281# a_n50_n489# 0.02705f
C3 a_28_n281# w_n444_n709# 0.6139f
C4 a_n50_n489# w_n444_n709# 0.38939f
C5 a_28_n281# a_n178_n281# 0.53377f
C6 a_28_n281# VSUBS 0.08168f
C7 a_n178_n281# VSUBS 0.08054f
C8 a_n50_n489# VSUBS 0.0484f
C9 w_n444_n709# VSUBS 4.62248f
.ends

.subckt xm11 a_n178_n131# a_n50_n339# w_n444_n560# a_28_n131# VSUBS
X0 a_28_n131# a_n50_n339# a_n178_n131# w_n444_n560# pfet_03v3 ad=0.375p pd=2.5u as=0.375p ps=2.5u w=0.5u l=0.28u
C0 a_n50_n339# a_n178_n131# 0.02611f
C1 a_n178_n131# w_n444_n560# 0.22952f
C2 a_28_n131# a_n50_n339# 0.01004f
C3 a_28_n131# w_n444_n560# 0.48499f
C4 a_n50_n339# w_n444_n560# 0.39308f
C5 a_28_n131# a_n178_n131# 0.34063f
C6 a_28_n131# VSUBS 0.04441f
C7 a_n178_n131# VSUBS 0.04328f
C8 a_n50_n339# VSUBS 0.04859f
C9 w_n444_n560# VSUBS 3.73985f
.ends

.subckt xm1 a_n1120_n131# a_n1330_n504# a_1000_n131# a_n1000_n339#
X0 a_1000_n131# a_n1000_n339# a_n1120_n131# a_n1330_n504# nfet_03v3 ad=0.3p pd=2.2u as=0.3p ps=2.2u w=0.5u l=10u
C0 a_n1120_n131# a_1000_n131# 1.01551f
C1 a_1000_n131# a_n1000_n339# 0.06176f
C2 a_n1120_n131# a_n1000_n339# 0.42273f
C3 a_1000_n131# a_n1330_n504# 1.43795f
C4 a_n1120_n131# a_n1330_n504# 0.4423f
C5 a_n1000_n339# a_n1330_n504# 4.53847f
.ends

.subckt xm8 a_n306_n173# a_186_n173# w_n572_n603# a_n186_n382# VSUBS
X0 a_186_n173# a_n186_n382# a_n306_n173# w_n572_n603# pfet_03v3 ad=0.558p pd=3.06u as=0.558p ps=3.06u w=0.93u l=1.86u
C0 a_n186_n382# a_n306_n173# 0.11626f
C1 a_n306_n173# w_n572_n603# 0.29685f
C2 a_186_n173# a_n186_n382# 0.05372f
C3 a_186_n173# w_n572_n603# 0.66931f
C4 a_n186_n382# w_n572_n603# 0.94238f
C5 a_186_n173# a_n306_n173# 0.38397f
C6 a_186_n173# VSUBS 0.04839f
C7 a_n306_n173# VSUBS 0.04832f
C8 a_n186_n382# VSUBS 0.07458f
C9 w_n572_n603# VSUBS 5.08511f
.ends

.subckt xm6 a_n306_n173# a_186_n173# w_n572_n603# a_n186_n382# VSUBS
X0 a_186_n173# a_n186_n382# a_n306_n173# w_n572_n603# pfet_03v3 ad=0.558p pd=3.06u as=0.558p ps=3.06u w=0.93u l=1.86u
C0 a_n186_n382# a_n306_n173# 0.11626f
C1 a_n306_n173# w_n572_n603# 0.29685f
C2 a_186_n173# a_n186_n382# 0.05372f
C3 a_186_n173# w_n572_n603# 0.66931f
C4 a_n186_n382# w_n572_n603# 0.94238f
C5 a_186_n173# a_n306_n173# 0.38397f
C6 a_186_n173# VSUBS 0.04839f
C7 a_n306_n173# VSUBS 0.04832f
C8 a_n186_n382# VSUBS 0.07458f
C9 w_n572_n603# VSUBS 5.08511f
.ends

.subckt xm4 a_28_n281# a_n178_n281# w_n444_n709# a_n50_n489# VSUBS
X0 a_28_n281# a_n50_n489# a_n178_n281# w_n444_n709# pfet_03v3 ad=1.5p pd=5.5u as=1.5p ps=5.5u w=2u l=0.28u
C0 a_n50_n489# a_n178_n281# 0.0391f
C1 a_n178_n281# w_n444_n709# 0.35562f
C2 a_28_n281# a_n50_n489# 0.02705f
C3 a_28_n281# w_n444_n709# 0.6139f
C4 a_n50_n489# w_n444_n709# 0.38939f
C5 a_28_n281# a_n178_n281# 0.53377f
C6 a_28_n281# VSUBS 0.08168f
C7 a_n178_n281# VSUBS 0.08054f
C8 a_n50_n489# VSUBS 0.0484f
C9 w_n444_n709# VSUBS 4.62248f
.ends

.subckt xm2 a_n1120_n131# a_n1330_n504# a_1000_n131# a_n1000_n339#
X0 a_1000_n131# a_n1000_n339# a_n1120_n131# a_n1330_n504# nfet_03v3 ad=0.3p pd=2.2u as=0.3p ps=2.2u w=0.5u l=10u
C0 a_n1120_n131# a_1000_n131# 1.01551f
C1 a_1000_n131# a_n1000_n339# 0.06176f
C2 a_n1120_n131# a_n1000_n339# 0.42273f
C3 a_1000_n131# a_n1330_n504# 1.43795f
C4 a_n1120_n131# a_n1330_n504# 0.4423f
C5 a_n1000_n339# a_n1330_n504# 4.53847f
.ends

.subckt xm10 a_n178_n131# a_n50_n339# a_n388_n504# a_28_n131#
X0 a_28_n131# a_n50_n339# a_n178_n131# a_n388_n504# nfet_03v3 ad=0.375p pd=2.5u as=0.375p ps=2.5u w=0.5u l=0.28u
C0 a_n178_n131# a_28_n131# 0.34063f
C1 a_28_n131# a_n50_n339# 0.01004f
C2 a_n178_n131# a_n50_n339# 0.02611f
C3 a_28_n131# a_n388_n504# 0.52938f
C4 a_n178_n131# a_n388_n504# 0.27279f
C5 a_n50_n339# a_n388_n504# 0.44167f
.ends

.subckt xm9 a_n178_n131# a_n50_n339# a_n388_n504# a_28_n131#
X0 a_28_n131# a_n50_n339# a_n178_n131# a_n388_n504# nfet_03v3 ad=0.375p pd=2.5u as=0.375p ps=2.5u w=0.5u l=0.28u
C0 a_n178_n131# a_28_n131# 0.34063f
C1 a_28_n131# a_n50_n339# 0.01004f
C2 a_n178_n131# a_n50_n339# 0.02611f
C3 a_28_n131# a_n388_n504# 0.52938f
C4 a_n178_n131# a_n388_n504# 0.27279f
C5 a_n50_n339# a_n388_n504# 0.44167f
.ends

.subckt xm7 a_n306_n173# a_186_n173# w_n572_n603# a_n186_n382# VSUBS
X0 a_186_n173# a_n186_n382# a_n306_n173# w_n572_n603# pfet_03v3 ad=0.558p pd=3.06u as=0.558p ps=3.06u w=0.93u l=1.86u
C0 a_n186_n382# a_n306_n173# 0.11626f
C1 a_n306_n173# w_n572_n603# 0.29685f
C2 a_186_n173# a_n186_n382# 0.05372f
C3 a_186_n173# w_n572_n603# 0.66931f
C4 a_n186_n382# w_n572_n603# 0.94238f
C5 a_186_n173# a_n306_n173# 0.38397f
C6 a_186_n173# VSUBS 0.04839f
C7 a_n306_n173# VSUBS 0.04832f
C8 a_n186_n382# VSUBS 0.07458f
C9 w_n572_n603# VSUBS 5.08511f
.ends

.subckt encoder_pex Vdd Vss Vin Vin_neg Iex_1_i Iex_2_i Iex_3_i Iex_4_i
Xxm5_0 Vdd Iex_2_i Vdd xm3_0/a_28_n281# Vss xm5
Xxm3_0 xm3_0/a_28_n281# Vdd Vdd xm3_0/a_28_n281# Vss xm3
Xxm11_0 Vdd xm9_0/a_n50_n339# Vdd xm9_0/a_n50_n339# Vss xm11
Xxm1_0 xm9_0/a_28_n131# Vss xm3_0/a_28_n281# Vin xm1
Xxm8_0 Vdd Iex_1_i Vdd xm3_0/a_28_n281# Vss xm8
Xxm6_0 Vdd Iex_4_i Vdd xm4_0/a_28_n281# Vss xm6
Xxm4_0 xm4_0/a_28_n281# Vdd Vdd xm4_0/a_28_n281# Vss xm4
Xxm2_0 xm9_0/a_28_n131# Vss xm4_0/a_28_n281# Vin_neg xm2
Xxm10_0 Vss xm9_0/a_n50_n339# Vss xm9_0/a_n50_n339# xm10
Xxm9_0 Vss xm9_0/a_n50_n339# Vss xm9_0/a_28_n131# xm9
Xxm7_0 Vdd Iex_3_i Vdd xm4_0/a_28_n281# Vss xm7
R0 Vin_neg Vin_neg.n0 14.3423
R1 Vin Vin.n0 14.3423
R2 Vdd.n106 Vdd.n95 696.312
R3 Vdd.n106 Vdd.n105 696.312
R4 Vdd.n15 Vdd.n4 696.312
R5 Vdd.n7 Vdd.n4 696.312
R6 Vdd.n199 Vdd.n188 528.52
R7 Vdd.n191 Vdd.n188 528.52
R8 Vdd.n142 Vdd.n117 446.678
R9 Vdd.n127 Vdd.n117 446.678
R10 Vdd.n178 Vdd.n153 446.678
R11 Vdd.n163 Vdd.n153 446.678
R12 Vdd.n86 Vdd.n61 446.678
R13 Vdd.n71 Vdd.n61 446.678
R14 Vdd.n50 Vdd.n25 446.678
R15 Vdd.n35 Vdd.n25 446.678
R16 Vdd.n108 Vdd.n107 74.638
R17 Vdd.n107 Vdd.n96 74.638
R18 Vdd.n104 Vdd.n98 74.638
R19 Vdd.n98 Vdd.n97 74.638
R20 Vdd.n16 Vdd.n3 74.638
R21 Vdd.n8 Vdd.n3 74.638
R22 Vdd.n13 Vdd.n5 74.638
R23 Vdd.n14 Vdd.n13 74.638
R24 Vdd.n143 Vdd.n116 62.563
R25 Vdd.n129 Vdd.n116 62.563
R26 Vdd.n123 Vdd.n119 62.563
R27 Vdd.n141 Vdd.n119 62.563
R28 Vdd.n179 Vdd.n152 62.563
R29 Vdd.n165 Vdd.n152 62.563
R30 Vdd.n159 Vdd.n155 62.563
R31 Vdd.n177 Vdd.n155 62.563
R32 Vdd.n87 Vdd.n60 62.563
R33 Vdd.n73 Vdd.n60 62.563
R34 Vdd.n67 Vdd.n63 62.563
R35 Vdd.n85 Vdd.n63 62.563
R36 Vdd.n51 Vdd.n24 62.563
R37 Vdd.n37 Vdd.n24 62.563
R38 Vdd.n31 Vdd.n27 62.563
R39 Vdd.n49 Vdd.n27 62.563
R40 Vdd.n200 Vdd.n187 61.6005
R41 Vdd.n192 Vdd.n187 61.6005
R42 Vdd.n197 Vdd.n189 61.6005
R43 Vdd.n198 Vdd.n197 61.6005
R44 Vdd.n125 Vdd.n124 14.0005
R45 Vdd.n141 Vdd.n120 14.0005
R46 Vdd.n143 Vdd.n115 14.0005
R47 Vdd.n161 Vdd.n160 14.0005
R48 Vdd.n177 Vdd.n156 14.0005
R49 Vdd.n179 Vdd.n151 14.0005
R50 Vdd.n69 Vdd.n68 14.0005
R51 Vdd.n85 Vdd.n64 14.0005
R52 Vdd.n87 Vdd.n59 14.0005
R53 Vdd.n33 Vdd.n32 14.0005
R54 Vdd.n49 Vdd.n28 14.0005
R55 Vdd.n51 Vdd.n23 14.0005
R56 Vdd Vdd.n205 13.5005
R57 Vdd.n55 Vdd.n19 6.62106
R58 Vdd.n147 Vdd.n111 6.39066
R59 Vdd.n99 Vdd.n96 6.3005
R60 Vdd.n104 Vdd.n103 6.3005
R61 Vdd.n97 Vdd.n94 6.3005
R62 Vdd.n109 Vdd.n108 6.3005
R63 Vdd.n130 Vdd.n129 6.3005
R64 Vdd.n133 Vdd.n125 6.3005
R65 Vdd.n134 Vdd.n124 6.3005
R66 Vdd.n135 Vdd.n123 6.3005
R67 Vdd.n144 Vdd.n143 6.3005
R68 Vdd.n143 Vdd.n142 6.3005
R69 Vdd.n115 Vdd.n114 6.3005
R70 Vdd.n121 Vdd.n120 6.3005
R71 Vdd.n141 Vdd.n140 6.3005
R72 Vdd.n142 Vdd.n141 6.3005
R73 Vdd.n166 Vdd.n165 6.3005
R74 Vdd.n169 Vdd.n161 6.3005
R75 Vdd.n170 Vdd.n160 6.3005
R76 Vdd.n171 Vdd.n159 6.3005
R77 Vdd.n180 Vdd.n179 6.3005
R78 Vdd.n179 Vdd.n178 6.3005
R79 Vdd.n151 Vdd.n150 6.3005
R80 Vdd.n157 Vdd.n156 6.3005
R81 Vdd.n177 Vdd.n176 6.3005
R82 Vdd.n178 Vdd.n177 6.3005
R83 Vdd.n193 Vdd.n192 6.3005
R84 Vdd.n194 Vdd.n189 6.3005
R85 Vdd.n201 Vdd.n200 6.3005
R86 Vdd.n198 Vdd.n186 6.3005
R87 Vdd.n74 Vdd.n73 6.3005
R88 Vdd.n77 Vdd.n69 6.3005
R89 Vdd.n78 Vdd.n68 6.3005
R90 Vdd.n79 Vdd.n67 6.3005
R91 Vdd.n88 Vdd.n87 6.3005
R92 Vdd.n87 Vdd.n86 6.3005
R93 Vdd.n59 Vdd.n58 6.3005
R94 Vdd.n65 Vdd.n64 6.3005
R95 Vdd.n85 Vdd.n84 6.3005
R96 Vdd.n86 Vdd.n85 6.3005
R97 Vdd.n38 Vdd.n37 6.3005
R98 Vdd.n41 Vdd.n33 6.3005
R99 Vdd.n42 Vdd.n32 6.3005
R100 Vdd.n43 Vdd.n31 6.3005
R101 Vdd.n52 Vdd.n51 6.3005
R102 Vdd.n51 Vdd.n50 6.3005
R103 Vdd.n23 Vdd.n22 6.3005
R104 Vdd.n29 Vdd.n28 6.3005
R105 Vdd.n49 Vdd.n48 6.3005
R106 Vdd.n50 Vdd.n49 6.3005
R107 Vdd.n9 Vdd.n8 6.3005
R108 Vdd.n10 Vdd.n5 6.3005
R109 Vdd.n17 Vdd.n16 6.3005
R110 Vdd.n14 Vdd.n2 6.3005
R111 Vdd.n204 Vdd.n203 5.55898
R112 Vdd.n147 Vdd.n146 5.47485
R113 Vdd.n183 Vdd.n182 5.47485
R114 Vdd.n91 Vdd.n90 5.47485
R115 Vdd.n55 Vdd.n54 5.47485
R116 Vdd.n102 Vdd.n100 5.34137
R117 Vdd.n101 Vdd.n92 5.34137
R118 Vdd.n12 Vdd.n11 5.34137
R119 Vdd.n6 Vdd.n0 5.34137
R120 Vdd.n100 Vdd.n93 5.33355
R121 Vdd.n12 Vdd.n1 5.33355
R122 Vdd.n137 Vdd.n136 5.20888
R123 Vdd.n131 Vdd.n112 5.20888
R124 Vdd.n173 Vdd.n172 5.20888
R125 Vdd.n167 Vdd.n148 5.20888
R126 Vdd.n81 Vdd.n80 5.20888
R127 Vdd.n75 Vdd.n56 5.20888
R128 Vdd.n45 Vdd.n44 5.20888
R129 Vdd.n39 Vdd.n20 5.20888
R130 Vdd.n139 Vdd.n137 5.20105
R131 Vdd.n175 Vdd.n173 5.20105
R132 Vdd.n83 Vdd.n81 5.20105
R133 Vdd.n47 Vdd.n45 5.20105
R134 Vdd.n196 Vdd.n195 5.19561
R135 Vdd.n190 Vdd.n184 5.19561
R136 Vdd.n196 Vdd.n185 5.18779
R137 Vdd.n111 Vdd.n110 4.7417
R138 Vdd.n203 Vdd.n202 4.7417
R139 Vdd.n19 Vdd.n18 4.7417
R140 Vdd.n146 Vdd.n145 4.7129
R141 Vdd.n182 Vdd.n181 4.7129
R142 Vdd.n90 Vdd.n89 4.7129
R143 Vdd.n54 Vdd.n53 4.7129
R144 Vdd.n94 Vdd.n93 4.5005
R145 Vdd.n110 Vdd.n109 4.5005
R146 Vdd.n101 Vdd.n99 4.5005
R147 Vdd.n103 Vdd.n102 4.5005
R148 Vdd.n138 Vdd.n121 4.5005
R149 Vdd.n114 Vdd.n113 4.5005
R150 Vdd.n145 Vdd.n144 4.5005
R151 Vdd.n140 Vdd.n139 4.5005
R152 Vdd.n134 Vdd.n122 4.5005
R153 Vdd.n133 Vdd.n132 4.5005
R154 Vdd.n131 Vdd.n130 4.5005
R155 Vdd.n136 Vdd.n135 4.5005
R156 Vdd.n174 Vdd.n157 4.5005
R157 Vdd.n150 Vdd.n149 4.5005
R158 Vdd.n181 Vdd.n180 4.5005
R159 Vdd.n176 Vdd.n175 4.5005
R160 Vdd.n170 Vdd.n158 4.5005
R161 Vdd.n169 Vdd.n168 4.5005
R162 Vdd.n167 Vdd.n166 4.5005
R163 Vdd.n172 Vdd.n171 4.5005
R164 Vdd.n202 Vdd.n201 4.5005
R165 Vdd.n186 Vdd.n185 4.5005
R166 Vdd.n193 Vdd.n190 4.5005
R167 Vdd.n195 Vdd.n194 4.5005
R168 Vdd.n82 Vdd.n65 4.5005
R169 Vdd.n58 Vdd.n57 4.5005
R170 Vdd.n89 Vdd.n88 4.5005
R171 Vdd.n84 Vdd.n83 4.5005
R172 Vdd.n78 Vdd.n66 4.5005
R173 Vdd.n77 Vdd.n76 4.5005
R174 Vdd.n75 Vdd.n74 4.5005
R175 Vdd.n80 Vdd.n79 4.5005
R176 Vdd.n46 Vdd.n29 4.5005
R177 Vdd.n22 Vdd.n21 4.5005
R178 Vdd.n53 Vdd.n52 4.5005
R179 Vdd.n48 Vdd.n47 4.5005
R180 Vdd.n42 Vdd.n30 4.5005
R181 Vdd.n41 Vdd.n40 4.5005
R182 Vdd.n39 Vdd.n38 4.5005
R183 Vdd.n44 Vdd.n43 4.5005
R184 Vdd.n18 Vdd.n17 4.5005
R185 Vdd.n2 Vdd.n1 4.5005
R186 Vdd.n9 Vdd.n6 4.5005
R187 Vdd.n11 Vdd.n10 4.5005
R188 Vdd.n105 Vdd.n104 3.31679
R189 Vdd.n105 Vdd.n96 3.31679
R190 Vdd.n108 Vdd.n95 3.31679
R191 Vdd.n97 Vdd.n95 3.31679
R192 Vdd.n126 Vdd.n123 3.31679
R193 Vdd.n128 Vdd.n125 3.31679
R194 Vdd.n129 Vdd.n128 3.31679
R195 Vdd.n126 Vdd.n124 3.31679
R196 Vdd.n118 Vdd.n115 3.31679
R197 Vdd.n120 Vdd.n118 3.31679
R198 Vdd.n162 Vdd.n159 3.31679
R199 Vdd.n164 Vdd.n161 3.31679
R200 Vdd.n165 Vdd.n164 3.31679
R201 Vdd.n162 Vdd.n160 3.31679
R202 Vdd.n154 Vdd.n151 3.31679
R203 Vdd.n156 Vdd.n154 3.31679
R204 Vdd.n191 Vdd.n189 3.31679
R205 Vdd.n192 Vdd.n191 3.31679
R206 Vdd.n199 Vdd.n198 3.31679
R207 Vdd.n200 Vdd.n199 3.31679
R208 Vdd.n70 Vdd.n67 3.31679
R209 Vdd.n72 Vdd.n69 3.31679
R210 Vdd.n73 Vdd.n72 3.31679
R211 Vdd.n70 Vdd.n68 3.31679
R212 Vdd.n62 Vdd.n59 3.31679
R213 Vdd.n64 Vdd.n62 3.31679
R214 Vdd.n34 Vdd.n31 3.31679
R215 Vdd.n36 Vdd.n33 3.31679
R216 Vdd.n37 Vdd.n36 3.31679
R217 Vdd.n34 Vdd.n32 3.31679
R218 Vdd.n26 Vdd.n23 3.31679
R219 Vdd.n28 Vdd.n26 3.31679
R220 Vdd.n7 Vdd.n5 3.31679
R221 Vdd.n8 Vdd.n7 3.31679
R222 Vdd.n15 Vdd.n14 3.31679
R223 Vdd.n16 Vdd.n15 3.31679
R224 Vdd.n128 Vdd.n127 1.49311
R225 Vdd.n127 Vdd.n126 1.49311
R226 Vdd.n142 Vdd.n118 1.49311
R227 Vdd.n164 Vdd.n163 1.49311
R228 Vdd.n163 Vdd.n162 1.49311
R229 Vdd.n178 Vdd.n154 1.49311
R230 Vdd.n72 Vdd.n71 1.49311
R231 Vdd.n71 Vdd.n70 1.49311
R232 Vdd.n86 Vdd.n62 1.49311
R233 Vdd.n36 Vdd.n35 1.49311
R234 Vdd.n35 Vdd.n34 1.49311
R235 Vdd.n50 Vdd.n26 1.49311
R236 Vdd.n91 Vdd.n55 1.3541
R237 Vdd.n204 Vdd.n183 1.3541
R238 Vdd.n183 Vdd.n147 1.3541
R239 Vdd.n197 Vdd.n196 0.9005
R240 Vdd.n197 Vdd.n188 0.9005
R241 Vdd.n187 Vdd.n184 0.9005
R242 Vdd.n188 Vdd.n187 0.9005
R243 Vdd.n205 Vdd.n91 0.8033
R244 Vdd.n137 Vdd.n119 0.788
R245 Vdd.n119 Vdd.n117 0.788
R246 Vdd.n116 Vdd.n112 0.788
R247 Vdd.n117 Vdd.n116 0.788
R248 Vdd.n173 Vdd.n155 0.788
R249 Vdd.n155 Vdd.n153 0.788
R250 Vdd.n152 Vdd.n148 0.788
R251 Vdd.n153 Vdd.n152 0.788
R252 Vdd.n81 Vdd.n63 0.788
R253 Vdd.n63 Vdd.n61 0.788
R254 Vdd.n60 Vdd.n56 0.788
R255 Vdd.n61 Vdd.n60 0.788
R256 Vdd.n45 Vdd.n27 0.788
R257 Vdd.n27 Vdd.n25 0.788
R258 Vdd.n24 Vdd.n20 0.788
R259 Vdd.n25 Vdd.n24 0.788
R260 Vdd.n100 Vdd.n98 0.6305
R261 Vdd.n106 Vdd.n98 0.6305
R262 Vdd.n107 Vdd.n92 0.6305
R263 Vdd.n107 Vdd.n106 0.6305
R264 Vdd.n13 Vdd.n12 0.6305
R265 Vdd.n13 Vdd.n4 0.6305
R266 Vdd.n3 Vdd.n0 0.6305
R267 Vdd.n4 Vdd.n3 0.6305
R268 Vdd.n111 Vdd.n92 0.600174
R269 Vdd.n19 Vdd.n0 0.600174
R270 Vdd.n146 Vdd.n112 0.496478
R271 Vdd.n182 Vdd.n148 0.496478
R272 Vdd.n90 Vdd.n56 0.496478
R273 Vdd.n54 Vdd.n20 0.496478
R274 Vdd.n203 Vdd.n184 0.454413
R275 Vdd.n205 Vdd.n204 0.3137
R276 Vdd.n103 Vdd.n99 0.1445
R277 Vdd.n109 Vdd.n94 0.1445
R278 Vdd.n110 Vdd.n93 0.1445
R279 Vdd.n102 Vdd.n101 0.1445
R280 Vdd.n135 Vdd.n134 0.1445
R281 Vdd.n134 Vdd.n133 0.1445
R282 Vdd.n133 Vdd.n130 0.1445
R283 Vdd.n140 Vdd.n121 0.1445
R284 Vdd.n121 Vdd.n114 0.1445
R285 Vdd.n144 Vdd.n114 0.1445
R286 Vdd.n139 Vdd.n138 0.1445
R287 Vdd.n138 Vdd.n113 0.1445
R288 Vdd.n145 Vdd.n113 0.1445
R289 Vdd.n136 Vdd.n122 0.1445
R290 Vdd.n132 Vdd.n122 0.1445
R291 Vdd.n132 Vdd.n131 0.1445
R292 Vdd.n171 Vdd.n170 0.1445
R293 Vdd.n170 Vdd.n169 0.1445
R294 Vdd.n169 Vdd.n166 0.1445
R295 Vdd.n176 Vdd.n157 0.1445
R296 Vdd.n157 Vdd.n150 0.1445
R297 Vdd.n180 Vdd.n150 0.1445
R298 Vdd.n175 Vdd.n174 0.1445
R299 Vdd.n174 Vdd.n149 0.1445
R300 Vdd.n181 Vdd.n149 0.1445
R301 Vdd.n172 Vdd.n158 0.1445
R302 Vdd.n168 Vdd.n158 0.1445
R303 Vdd.n168 Vdd.n167 0.1445
R304 Vdd.n194 Vdd.n193 0.1445
R305 Vdd.n201 Vdd.n186 0.1445
R306 Vdd.n202 Vdd.n185 0.1445
R307 Vdd.n195 Vdd.n190 0.1445
R308 Vdd.n79 Vdd.n78 0.1445
R309 Vdd.n78 Vdd.n77 0.1445
R310 Vdd.n77 Vdd.n74 0.1445
R311 Vdd.n84 Vdd.n65 0.1445
R312 Vdd.n65 Vdd.n58 0.1445
R313 Vdd.n88 Vdd.n58 0.1445
R314 Vdd.n83 Vdd.n82 0.1445
R315 Vdd.n82 Vdd.n57 0.1445
R316 Vdd.n89 Vdd.n57 0.1445
R317 Vdd.n80 Vdd.n66 0.1445
R318 Vdd.n76 Vdd.n66 0.1445
R319 Vdd.n76 Vdd.n75 0.1445
R320 Vdd.n43 Vdd.n42 0.1445
R321 Vdd.n42 Vdd.n41 0.1445
R322 Vdd.n41 Vdd.n38 0.1445
R323 Vdd.n48 Vdd.n29 0.1445
R324 Vdd.n29 Vdd.n22 0.1445
R325 Vdd.n52 Vdd.n22 0.1445
R326 Vdd.n47 Vdd.n46 0.1445
R327 Vdd.n46 Vdd.n21 0.1445
R328 Vdd.n53 Vdd.n21 0.1445
R329 Vdd.n44 Vdd.n30 0.1445
R330 Vdd.n40 Vdd.n30 0.1445
R331 Vdd.n40 Vdd.n39 0.1445
R332 Vdd.n10 Vdd.n9 0.1445
R333 Vdd.n17 Vdd.n2 0.1445
R334 Vdd.n18 Vdd.n1 0.1445
R335 Vdd.n11 Vdd.n6 0.1445
R336 Vss.n213 Vss.n173 16945.1
R337 Vss.n123 Vss.n122 11700.7
R338 Vss.n123 Vss.n18 10887.5
R339 Vss.n223 Vss.n173 10887.5
R340 Vss.n172 Vss.n138 10887.5
R341 Vss.n256 Vss.n125 10111.1
R342 Vss.n124 Vss.n17 10111.1
R343 Vss.n173 Vss.n172 4830.04
R344 Vss.n124 Vss.n123 4784.76
R345 Vss.n172 Vss.n125 4784.76
R346 Vss.n125 Vss.n124 3693.99
R347 Vss.n247 Vss.n246 793.182
R348 Vss.n41 Vss.n17 577.389
R349 Vss.n257 Vss.n256 577.389
R350 Vss.n16 Vss.n7 396.591
R351 Vss.n258 Vss.n257 396.591
R352 Vss.n255 Vss.n126 396.591
R353 Vss.n248 Vss.n247 396.591
R354 Vss.n122 Vss.n19 370.346
R355 Vss.n97 Vss.n41 370.346
R356 Vss.n214 Vss.n213 370.346
R357 Vss.n63 Vss.n19 233.288
R358 Vss.n64 Vss.n63 233.288
R359 Vss.n66 Vss.n64 233.288
R360 Vss.n66 Vss.n53 233.288
R361 Vss.n74 Vss.n53 233.288
R362 Vss.n75 Vss.n74 233.288
R363 Vss.n77 Vss.n75 233.288
R364 Vss.n85 Vss.n47 233.288
R365 Vss.n86 Vss.n85 233.288
R366 Vss.n88 Vss.n86 233.288
R367 Vss.n88 Vss.n40 233.288
R368 Vss.n97 Vss.n40 233.288
R369 Vss.n258 Vss.n7 233.288
R370 Vss.n248 Vss.n126 233.288
R371 Vss.n148 Vss.n147 233.288
R372 Vss.n238 Vss.n148 233.288
R373 Vss.n238 Vss.n149 233.288
R374 Vss.n232 Vss.n149 233.288
R375 Vss.n232 Vss.n231 233.288
R376 Vss.n231 Vss.n230 233.288
R377 Vss.n230 Vss.n163 233.288
R378 Vss.n224 Vss.n163 233.288
R379 Vss.n222 Vss.n221 233.288
R380 Vss.n221 Vss.n176 233.288
R381 Vss.n215 Vss.n176 233.288
R382 Vss.n215 Vss.n214 233.288
R383 Vss.n17 Vss.n16 215.792
R384 Vss.n256 Vss.n255 215.792
R385 Vss.n147 Vss.n138 212.876
R386 Vss.n246 Vss.n138 157.47
R387 Vss.n77 Vss.n18 154.554
R388 Vss.n223 Vss.n222 119.561
R389 Vss.n224 Vss.n223 113.728
R390 Vss.n47 Vss.n18 78.7354
R391 Vss.n137 Vss.n131 68.4449
R392 Vss.n249 Vss.n131 68.4449
R393 Vss.n254 Vss.n128 68.4449
R394 Vss.n254 Vss.n127 68.4449
R395 Vss.n8 Vss.n6 68.4449
R396 Vss.n259 Vss.n6 68.4449
R397 Vss.n15 Vss.n5 68.4449
R398 Vss.n15 Vss.n9 68.4449
R399 Vss.n245 Vss.n139 66.6949
R400 Vss.n212 Vss.n183 66.6949
R401 Vss.n212 Vss.n185 66.6949
R402 Vss.n245 Vss.n140 66.6949
R403 Vss.n121 Vss.n20 66.6949
R404 Vss.n121 Vss.n21 66.6949
R405 Vss.n96 Vss.n39 66.6949
R406 Vss.n98 Vss.n39 66.6949
R407 Vss.n150 Vss.n139 15.5561
R408 Vss.n237 Vss.n150 15.5561
R409 Vss.n237 Vss.n151 15.5561
R410 Vss.n233 Vss.n151 15.5561
R411 Vss.n233 Vss.n159 15.5561
R412 Vss.n229 Vss.n159 15.5561
R413 Vss.n229 Vss.n164 15.5561
R414 Vss.n225 Vss.n164 15.5561
R415 Vss.n225 Vss.n170 15.5561
R416 Vss.n220 Vss.n170 15.5561
R417 Vss.n220 Vss.n177 15.5561
R418 Vss.n216 Vss.n177 15.5561
R419 Vss.n216 Vss.n183 15.5561
R420 Vss.n143 Vss.n140 15.5561
R421 Vss.n239 Vss.n143 15.5561
R422 Vss.n239 Vss.n146 15.5561
R423 Vss.n160 Vss.n146 15.5561
R424 Vss.n161 Vss.n160 15.5561
R425 Vss.n162 Vss.n161 15.5561
R426 Vss.n198 Vss.n162 15.5561
R427 Vss.n198 Vss.n171 15.5561
R428 Vss.n174 Vss.n171 15.5561
R429 Vss.n175 Vss.n174 15.5561
R430 Vss.n205 Vss.n175 15.5561
R431 Vss.n205 Vss.n184 15.5561
R432 Vss.n185 Vss.n184 15.5561
R433 Vss.n249 Vss.n128 15.5561
R434 Vss.n137 Vss.n127 15.5561
R435 Vss.n259 Vss.n5 15.5561
R436 Vss.n9 Vss.n8 15.5561
R437 Vss.n62 Vss.n20 15.5561
R438 Vss.n62 Vss.n58 15.5561
R439 Vss.n67 Vss.n58 15.5561
R440 Vss.n67 Vss.n54 15.5561
R441 Vss.n73 Vss.n54 15.5561
R442 Vss.n73 Vss.n52 15.5561
R443 Vss.n78 Vss.n52 15.5561
R444 Vss.n78 Vss.n48 15.5561
R445 Vss.n84 Vss.n48 15.5561
R446 Vss.n84 Vss.n46 15.5561
R447 Vss.n89 Vss.n46 15.5561
R448 Vss.n89 Vss.n42 15.5561
R449 Vss.n96 Vss.n42 15.5561
R450 Vss.n24 Vss.n21 15.5561
R451 Vss.n25 Vss.n24 15.5561
R452 Vss.n65 Vss.n25 15.5561
R453 Vss.n65 Vss.n28 15.5561
R454 Vss.n29 Vss.n28 15.5561
R455 Vss.n30 Vss.n29 15.5561
R456 Vss.n76 Vss.n30 15.5561
R457 Vss.n76 Vss.n33 15.5561
R458 Vss.n34 Vss.n33 15.5561
R459 Vss.n35 Vss.n34 15.5561
R460 Vss.n87 Vss.n35 15.5561
R461 Vss.n87 Vss.n38 15.5561
R462 Vss.n98 Vss.n38 15.5561
R463 Vss Vss.n264 13.5005
R464 Vss.n210 Vss.n1 7.8906
R465 Vss.n264 Vss.n0 5.9862
R466 Vss.n11 Vss.n8 5.2005
R467 Vss.n258 Vss.n8 5.2005
R468 Vss.n12 Vss.n9 5.2005
R469 Vss.n9 Vss.n7 5.2005
R470 Vss.n260 Vss.n259 5.2005
R471 Vss.n259 Vss.n258 5.2005
R472 Vss.n5 Vss.n4 5.2005
R473 Vss.n7 Vss.n5 5.2005
R474 Vss.n137 Vss.n136 5.2005
R475 Vss.n248 Vss.n137 5.2005
R476 Vss.n132 Vss.n127 5.2005
R477 Vss.n127 Vss.n126 5.2005
R478 Vss.n250 Vss.n249 5.2005
R479 Vss.n249 Vss.n248 5.2005
R480 Vss.n251 Vss.n128 5.2005
R481 Vss.n128 Vss.n126 5.2005
R482 Vss.n208 Vss.n185 5.2005
R483 Vss.n214 Vss.n185 5.2005
R484 Vss.n207 Vss.n184 5.2005
R485 Vss.n215 Vss.n184 5.2005
R486 Vss.n206 Vss.n205 5.2005
R487 Vss.n205 Vss.n176 5.2005
R488 Vss.n188 Vss.n175 5.2005
R489 Vss.n221 Vss.n175 5.2005
R490 Vss.n201 Vss.n174 5.2005
R491 Vss.n222 Vss.n174 5.2005
R492 Vss.n200 Vss.n171 5.2005
R493 Vss.n224 Vss.n171 5.2005
R494 Vss.n199 Vss.n198 5.2005
R495 Vss.n198 Vss.n163 5.2005
R496 Vss.n190 Vss.n162 5.2005
R497 Vss.n230 Vss.n162 5.2005
R498 Vss.n194 Vss.n161 5.2005
R499 Vss.n231 Vss.n161 5.2005
R500 Vss.n193 Vss.n160 5.2005
R501 Vss.n232 Vss.n160 5.2005
R502 Vss.n146 Vss.n145 5.2005
R503 Vss.n149 Vss.n146 5.2005
R504 Vss.n240 Vss.n239 5.2005
R505 Vss.n239 Vss.n238 5.2005
R506 Vss.n241 Vss.n143 5.2005
R507 Vss.n148 Vss.n143 5.2005
R508 Vss.n242 Vss.n140 5.2005
R509 Vss.n147 Vss.n140 5.2005
R510 Vss.n152 Vss.n139 5.2005
R511 Vss.n147 Vss.n139 5.2005
R512 Vss.n153 Vss.n150 5.2005
R513 Vss.n150 Vss.n148 5.2005
R514 Vss.n237 Vss.n236 5.2005
R515 Vss.n238 Vss.n237 5.2005
R516 Vss.n235 Vss.n151 5.2005
R517 Vss.n151 Vss.n149 5.2005
R518 Vss.n234 Vss.n233 5.2005
R519 Vss.n233 Vss.n232 5.2005
R520 Vss.n159 Vss.n158 5.2005
R521 Vss.n231 Vss.n159 5.2005
R522 Vss.n229 Vss.n228 5.2005
R523 Vss.n230 Vss.n229 5.2005
R524 Vss.n227 Vss.n164 5.2005
R525 Vss.n164 Vss.n163 5.2005
R526 Vss.n226 Vss.n225 5.2005
R527 Vss.n225 Vss.n224 5.2005
R528 Vss.n170 Vss.n169 5.2005
R529 Vss.n222 Vss.n170 5.2005
R530 Vss.n220 Vss.n219 5.2005
R531 Vss.n221 Vss.n220 5.2005
R532 Vss.n218 Vss.n177 5.2005
R533 Vss.n177 Vss.n176 5.2005
R534 Vss.n217 Vss.n216 5.2005
R535 Vss.n216 Vss.n215 5.2005
R536 Vss.n183 Vss.n182 5.2005
R537 Vss.n214 Vss.n183 5.2005
R538 Vss.n96 Vss.n95 5.2005
R539 Vss.n97 Vss.n96 5.2005
R540 Vss.n43 Vss.n42 5.2005
R541 Vss.n42 Vss.n40 5.2005
R542 Vss.n90 Vss.n89 5.2005
R543 Vss.n89 Vss.n88 5.2005
R544 Vss.n46 Vss.n45 5.2005
R545 Vss.n86 Vss.n46 5.2005
R546 Vss.n84 Vss.n83 5.2005
R547 Vss.n85 Vss.n84 5.2005
R548 Vss.n49 Vss.n48 5.2005
R549 Vss.n48 Vss.n47 5.2005
R550 Vss.n79 Vss.n78 5.2005
R551 Vss.n78 Vss.n77 5.2005
R552 Vss.n52 Vss.n51 5.2005
R553 Vss.n75 Vss.n52 5.2005
R554 Vss.n73 Vss.n72 5.2005
R555 Vss.n74 Vss.n73 5.2005
R556 Vss.n55 Vss.n54 5.2005
R557 Vss.n54 Vss.n53 5.2005
R558 Vss.n68 Vss.n67 5.2005
R559 Vss.n67 Vss.n66 5.2005
R560 Vss.n58 Vss.n57 5.2005
R561 Vss.n64 Vss.n58 5.2005
R562 Vss.n62 Vss.n61 5.2005
R563 Vss.n63 Vss.n62 5.2005
R564 Vss.n59 Vss.n20 5.2005
R565 Vss.n20 Vss.n19 5.2005
R566 Vss.n99 Vss.n98 5.2005
R567 Vss.n98 Vss.n97 5.2005
R568 Vss.n100 Vss.n38 5.2005
R569 Vss.n40 Vss.n38 5.2005
R570 Vss.n87 Vss.n36 5.2005
R571 Vss.n88 Vss.n87 5.2005
R572 Vss.n104 Vss.n35 5.2005
R573 Vss.n86 Vss.n35 5.2005
R574 Vss.n105 Vss.n34 5.2005
R575 Vss.n85 Vss.n34 5.2005
R576 Vss.n106 Vss.n33 5.2005
R577 Vss.n47 Vss.n33 5.2005
R578 Vss.n76 Vss.n31 5.2005
R579 Vss.n77 Vss.n76 5.2005
R580 Vss.n110 Vss.n30 5.2005
R581 Vss.n75 Vss.n30 5.2005
R582 Vss.n111 Vss.n29 5.2005
R583 Vss.n74 Vss.n29 5.2005
R584 Vss.n112 Vss.n28 5.2005
R585 Vss.n53 Vss.n28 5.2005
R586 Vss.n65 Vss.n26 5.2005
R587 Vss.n66 Vss.n65 5.2005
R588 Vss.n116 Vss.n25 5.2005
R589 Vss.n64 Vss.n25 5.2005
R590 Vss.n117 Vss.n24 5.2005
R591 Vss.n63 Vss.n24 5.2005
R592 Vss.n118 Vss.n21 5.2005
R593 Vss.n21 Vss.n19 5.2005
R594 Vss.n135 Vss.n134 5.19561
R595 Vss.n253 Vss.n252 5.19561
R596 Vss.n10 Vss.n2 5.19561
R597 Vss.n14 Vss.n3 5.19561
R598 Vss.n253 Vss.n129 5.18779
R599 Vss.n14 Vss.n13 5.18779
R600 Vss.n244 Vss.n141 5.17941
R601 Vss.n211 Vss.n186 5.17941
R602 Vss.n244 Vss.n243 5.17941
R603 Vss.n120 Vss.n119 5.17941
R604 Vss.n120 Vss.n22 5.17941
R605 Vss.n94 Vss.n93 5.17941
R606 Vss.n133 Vss.n1 5.0718
R607 Vss.n263 Vss.n262 5.0718
R608 Vss.n133 Vss.n130 4.7417
R609 Vss.n262 Vss.n261 4.7417
R610 Vss.n210 Vss.n209 4.7255
R611 Vss.n37 Vss.n0 4.7255
R612 Vss.n152 Vss.n141 4.5005
R613 Vss.n154 Vss.n153 4.5005
R614 Vss.n236 Vss.n155 4.5005
R615 Vss.n235 Vss.n156 4.5005
R616 Vss.n234 Vss.n157 4.5005
R617 Vss.n165 Vss.n158 4.5005
R618 Vss.n228 Vss.n166 4.5005
R619 Vss.n227 Vss.n167 4.5005
R620 Vss.n226 Vss.n168 4.5005
R621 Vss.n178 Vss.n169 4.5005
R622 Vss.n219 Vss.n179 4.5005
R623 Vss.n218 Vss.n180 4.5005
R624 Vss.n217 Vss.n181 4.5005
R625 Vss.n186 Vss.n182 4.5005
R626 Vss.n241 Vss.n142 4.5005
R627 Vss.n240 Vss.n144 4.5005
R628 Vss.n191 Vss.n145 4.5005
R629 Vss.n193 Vss.n192 4.5005
R630 Vss.n195 Vss.n194 4.5005
R631 Vss.n196 Vss.n190 4.5005
R632 Vss.n199 Vss.n197 4.5005
R633 Vss.n200 Vss.n189 4.5005
R634 Vss.n202 Vss.n201 4.5005
R635 Vss.n203 Vss.n188 4.5005
R636 Vss.n206 Vss.n204 4.5005
R637 Vss.n207 Vss.n187 4.5005
R638 Vss.n209 Vss.n208 4.5005
R639 Vss.n243 Vss.n242 4.5005
R640 Vss.n250 Vss.n130 4.5005
R641 Vss.n252 Vss.n251 4.5005
R642 Vss.n136 Vss.n135 4.5005
R643 Vss.n132 Vss.n129 4.5005
R644 Vss.n261 Vss.n260 4.5005
R645 Vss.n4 Vss.n3 4.5005
R646 Vss.n11 Vss.n10 4.5005
R647 Vss.n13 Vss.n12 4.5005
R648 Vss.n117 Vss.n23 4.5005
R649 Vss.n116 Vss.n115 4.5005
R650 Vss.n114 Vss.n26 4.5005
R651 Vss.n113 Vss.n112 4.5005
R652 Vss.n111 Vss.n27 4.5005
R653 Vss.n110 Vss.n109 4.5005
R654 Vss.n108 Vss.n31 4.5005
R655 Vss.n107 Vss.n106 4.5005
R656 Vss.n105 Vss.n32 4.5005
R657 Vss.n104 Vss.n103 4.5005
R658 Vss.n102 Vss.n36 4.5005
R659 Vss.n101 Vss.n100 4.5005
R660 Vss.n99 Vss.n37 4.5005
R661 Vss.n119 Vss.n118 4.5005
R662 Vss.n61 Vss.n60 4.5005
R663 Vss.n57 Vss.n56 4.5005
R664 Vss.n69 Vss.n68 4.5005
R665 Vss.n70 Vss.n55 4.5005
R666 Vss.n72 Vss.n71 4.5005
R667 Vss.n51 Vss.n50 4.5005
R668 Vss.n80 Vss.n79 4.5005
R669 Vss.n81 Vss.n49 4.5005
R670 Vss.n83 Vss.n82 4.5005
R671 Vss.n45 Vss.n44 4.5005
R672 Vss.n91 Vss.n90 4.5005
R673 Vss.n92 Vss.n43 4.5005
R674 Vss.n95 Vss.n94 4.5005
R675 Vss.n59 Vss.n22 4.5005
R676 Vss.n263 Vss.n1 1.1237
R677 Vss.n15 Vss.n14 0.743357
R678 Vss.n16 Vss.n15 0.743357
R679 Vss.n6 Vss.n2 0.743357
R680 Vss.n257 Vss.n6 0.743357
R681 Vss.n254 Vss.n253 0.743357
R682 Vss.n255 Vss.n254 0.743357
R683 Vss.n134 Vss.n131 0.743357
R684 Vss.n247 Vss.n131 0.743357
R685 Vss.n245 Vss.n244 0.743357
R686 Vss.n246 Vss.n245 0.743357
R687 Vss.n212 Vss.n211 0.743357
R688 Vss.n213 Vss.n212 0.743357
R689 Vss.n121 Vss.n120 0.743357
R690 Vss.n122 Vss.n121 0.743357
R691 Vss.n93 Vss.n39 0.743357
R692 Vss.n41 Vss.n39 0.743357
R693 Vss.n211 Vss.n210 0.454413
R694 Vss.n134 Vss.n133 0.454413
R695 Vss.n262 Vss.n2 0.454413
R696 Vss.n93 Vss.n0 0.454413
R697 Vss.n264 Vss.n263 0.2021
R698 Vss.n242 Vss.n241 0.1445
R699 Vss.n241 Vss.n240 0.1445
R700 Vss.n240 Vss.n145 0.1445
R701 Vss.n193 Vss.n145 0.1445
R702 Vss.n194 Vss.n193 0.1445
R703 Vss.n194 Vss.n190 0.1445
R704 Vss.n199 Vss.n190 0.1445
R705 Vss.n200 Vss.n199 0.1445
R706 Vss.n201 Vss.n200 0.1445
R707 Vss.n201 Vss.n188 0.1445
R708 Vss.n206 Vss.n188 0.1445
R709 Vss.n207 Vss.n206 0.1445
R710 Vss.n208 Vss.n207 0.1445
R711 Vss.n153 Vss.n152 0.1445
R712 Vss.n236 Vss.n153 0.1445
R713 Vss.n236 Vss.n235 0.1445
R714 Vss.n235 Vss.n234 0.1445
R715 Vss.n234 Vss.n158 0.1445
R716 Vss.n228 Vss.n158 0.1445
R717 Vss.n228 Vss.n227 0.1445
R718 Vss.n227 Vss.n226 0.1445
R719 Vss.n226 Vss.n169 0.1445
R720 Vss.n219 Vss.n169 0.1445
R721 Vss.n219 Vss.n218 0.1445
R722 Vss.n218 Vss.n217 0.1445
R723 Vss.n217 Vss.n182 0.1445
R724 Vss.n154 Vss.n141 0.1445
R725 Vss.n155 Vss.n154 0.1445
R726 Vss.n156 Vss.n155 0.1445
R727 Vss.n157 Vss.n156 0.1445
R728 Vss.n165 Vss.n157 0.1445
R729 Vss.n166 Vss.n165 0.1445
R730 Vss.n167 Vss.n166 0.1445
R731 Vss.n168 Vss.n167 0.1445
R732 Vss.n178 Vss.n168 0.1445
R733 Vss.n179 Vss.n178 0.1445
R734 Vss.n180 Vss.n179 0.1445
R735 Vss.n181 Vss.n180 0.1445
R736 Vss.n186 Vss.n181 0.1445
R737 Vss.n243 Vss.n142 0.1445
R738 Vss.n144 Vss.n142 0.1445
R739 Vss.n191 Vss.n144 0.1445
R740 Vss.n192 Vss.n191 0.1445
R741 Vss.n195 Vss.n192 0.1445
R742 Vss.n196 Vss.n195 0.1445
R743 Vss.n197 Vss.n196 0.1445
R744 Vss.n197 Vss.n189 0.1445
R745 Vss.n202 Vss.n189 0.1445
R746 Vss.n203 Vss.n202 0.1445
R747 Vss.n204 Vss.n203 0.1445
R748 Vss.n204 Vss.n187 0.1445
R749 Vss.n209 Vss.n187 0.1445
R750 Vss.n251 Vss.n250 0.1445
R751 Vss.n252 Vss.n130 0.1445
R752 Vss.n135 Vss.n129 0.1445
R753 Vss.n136 Vss.n132 0.1445
R754 Vss.n260 Vss.n4 0.1445
R755 Vss.n261 Vss.n3 0.1445
R756 Vss.n13 Vss.n10 0.1445
R757 Vss.n12 Vss.n11 0.1445
R758 Vss.n61 Vss.n59 0.1445
R759 Vss.n61 Vss.n57 0.1445
R760 Vss.n68 Vss.n57 0.1445
R761 Vss.n68 Vss.n55 0.1445
R762 Vss.n72 Vss.n55 0.1445
R763 Vss.n72 Vss.n51 0.1445
R764 Vss.n79 Vss.n51 0.1445
R765 Vss.n79 Vss.n49 0.1445
R766 Vss.n83 Vss.n49 0.1445
R767 Vss.n83 Vss.n45 0.1445
R768 Vss.n90 Vss.n45 0.1445
R769 Vss.n90 Vss.n43 0.1445
R770 Vss.n95 Vss.n43 0.1445
R771 Vss.n118 Vss.n117 0.1445
R772 Vss.n117 Vss.n116 0.1445
R773 Vss.n116 Vss.n26 0.1445
R774 Vss.n112 Vss.n26 0.1445
R775 Vss.n112 Vss.n111 0.1445
R776 Vss.n111 Vss.n110 0.1445
R777 Vss.n110 Vss.n31 0.1445
R778 Vss.n106 Vss.n31 0.1445
R779 Vss.n106 Vss.n105 0.1445
R780 Vss.n105 Vss.n104 0.1445
R781 Vss.n104 Vss.n36 0.1445
R782 Vss.n100 Vss.n36 0.1445
R783 Vss.n100 Vss.n99 0.1445
R784 Vss.n119 Vss.n23 0.1445
R785 Vss.n115 Vss.n23 0.1445
R786 Vss.n115 Vss.n114 0.1445
R787 Vss.n114 Vss.n113 0.1445
R788 Vss.n113 Vss.n27 0.1445
R789 Vss.n109 Vss.n27 0.1445
R790 Vss.n109 Vss.n108 0.1445
R791 Vss.n108 Vss.n107 0.1445
R792 Vss.n107 Vss.n32 0.1445
R793 Vss.n103 Vss.n32 0.1445
R794 Vss.n103 Vss.n102 0.1445
R795 Vss.n102 Vss.n101 0.1445
R796 Vss.n101 Vss.n37 0.1445
R797 Vss.n60 Vss.n22 0.1445
R798 Vss.n60 Vss.n56 0.1445
R799 Vss.n69 Vss.n56 0.1445
R800 Vss.n70 Vss.n69 0.1445
R801 Vss.n71 Vss.n70 0.1445
R802 Vss.n71 Vss.n50 0.1445
R803 Vss.n80 Vss.n50 0.1445
R804 Vss.n81 Vss.n80 0.1445
R805 Vss.n82 Vss.n81 0.1445
R806 Vss.n82 Vss.n44 0.1445
R807 Vss.n91 Vss.n44 0.1445
R808 Vss.n92 Vss.n91 0.1445
R809 Vss.n94 Vss.n92 0.1445
C0 xm9_0/a_28_n131# Iex_1_i 0
C1 Vdd Vin_neg 0.01061f
C2 xm9_0/a_n50_n339# Vin_neg 0.0102f
C3 xm4_0/a_28_n281# Vin_neg 0.00876f
C4 Vdd Iex_4_i 0.07774f
C5 Iex_4_i xm9_0/a_n50_n339# 0.00567f
C6 Iex_4_i xm4_0/a_28_n281# 0.04363f
C7 xm9_0/a_28_n131# xm3_0/a_28_n281# 0.03085f
C8 Iex_2_i Iex_1_i 0.02714f
C9 Vdd xm9_0/a_28_n131# 0.5631f
C10 xm9_0/a_n50_n339# xm9_0/a_28_n131# 0.23849f
C11 xm9_0/a_28_n131# xm4_0/a_28_n281# 0.43354f
C12 Vdd Iex_3_i 0.07772f
C13 Iex_3_i xm4_0/a_28_n281# 0.06045f
C14 xm9_0/a_28_n131# Vin 0.00425f
C15 Iex_1_i xm3_0/a_28_n281# 0.01037f
C16 Vdd Iex_1_i 0.0927f
C17 xm9_0/a_n50_n339# Iex_1_i 0.00845f
C18 Iex_4_i Vin_neg 0
C19 Iex_2_i xm3_0/a_28_n281# 0.0535f
C20 xm9_0/a_28_n131# Vin_neg 0.00933f
C21 Vdd Iex_2_i 0.07665f
C22 Iex_3_i Vin_neg 0
C23 Iex_2_i Vin 0
C24 Vdd xm3_0/a_28_n281# 1.69945f
C25 xm9_0/a_n50_n339# xm3_0/a_28_n281# 0.02036f
C26 Iex_4_i xm9_0/a_28_n131# 0
C27 Vdd xm9_0/a_n50_n339# 0.95938f
C28 Vdd xm4_0/a_28_n281# 1.81868f
C29 Iex_3_i Iex_4_i 0.02714f
C30 xm9_0/a_n50_n339# xm4_0/a_28_n281# 0.03121f
C31 Vin xm3_0/a_28_n281# 0.00764f
C32 Iex_3_i xm9_0/a_28_n131# 0
C33 Vdd Vin 0.0117f
C34 xm9_0/a_n50_n339# Vin 0.00641f
C35 Iex_2_i Vss -0.09835f
C36 Vss.n0 Vss 0.00429f
C37 Vss.n1 Vss 0.01594f
C38 Vss.n2 Vss 0.00331f
C39 Vss.n3 Vss 0.002f
C40 Vss.n4 Vss 0
C41 Vss.n5 Vss 0.00158f
C42 Vss.n6 Vss 0.00255f
C43 Vss.n7 Vss 0.02333f
C44 Vss.n8 Vss 0.00158f
C45 Vss.n9 Vss 0.00158f
C46 Vss.n10 Vss 0.002f
C47 Vss.n11 Vss 0
C48 Vss.n12 Vss 0
C49 Vss.n13 Vss 0.00207f
C50 Vss.n14 Vss 0.00749f
C51 Vss.n15 Vss 0.00255f
C52 Vss.n16 Vss 0.02268f
C53 Vss.n17 Vss 0.03914f
C54 Vss.n18 Vss 0.01916f
C55 Vss.n19 Vss 0.02236f
C56 Vss.n20 Vss 0.00155f
C57 Vss.n21 Vss 0.00155f
C58 Vss.n22 Vss 0.00192f
C59 Vss.n23 Vss 0
C60 Vss.n24 Vss 0
C61 Vss.n25 Vss 0
C62 Vss.n26 Vss 0
C63 Vss.n27 Vss 0
C64 Vss.n28 Vss 0
C65 Vss.n29 Vss 0
C66 Vss.n30 Vss 0
C67 Vss.n31 Vss 0
C68 Vss.n32 Vss 0
C69 Vss.n33 Vss 0
C70 Vss.n34 Vss 0
C71 Vss.n35 Vss 0
C72 Vss.n36 Vss 0
C73 Vss.n37 Vss 0.0018f
C74 Vss.n38 Vss 0
C75 Vss.n39 Vss 0.00249f
C76 Vss.n40 Vss 0.01728f
C77 Vss.n41 Vss 0.0351f
C78 Vss.n42 Vss 0
C79 Vss.n43 Vss 0
C80 Vss.n44 Vss 0
C81 Vss.n45 Vss 0
C82 Vss.n46 Vss 0
C83 Vss.n47 Vss 0.01156f
C84 Vss.n48 Vss 0
C85 Vss.n49 Vss 0
C86 Vss.n50 Vss 0
C87 Vss.n51 Vss 0
C88 Vss.n52 Vss 0
C89 Vss.n53 Vss 0.01728f
C90 Vss.n54 Vss 0
C91 Vss.n55 Vss 0
C92 Vss.n56 Vss 0
C93 Vss.n57 Vss 0
C94 Vss.n58 Vss 0
C95 Vss.n59 Vss 0
C96 Vss.n60 Vss 0
C97 Vss.n61 Vss 0
C98 Vss.n62 Vss 0
C99 Vss.n63 Vss 0.01728f
C100 Vss.n64 Vss 0.01728f
C101 Vss.n65 Vss 0
C102 Vss.n66 Vss 0.01728f
C103 Vss.n67 Vss 0
C104 Vss.n68 Vss 0
C105 Vss.n69 Vss 0
C106 Vss.n70 Vss 0
C107 Vss.n71 Vss 0
C108 Vss.n72 Vss 0
C109 Vss.n73 Vss 0
C110 Vss.n74 Vss 0.01728f
C111 Vss.n75 Vss 0.01728f
C112 Vss.n76 Vss 0
C113 Vss.n77 Vss 0.01436f
C114 Vss.n78 Vss 0
C115 Vss.n79 Vss 0
C116 Vss.n80 Vss 0
C117 Vss.n81 Vss 0
C118 Vss.n82 Vss 0
C119 Vss.n83 Vss 0
C120 Vss.n84 Vss 0
C121 Vss.n85 Vss 0.01728f
C122 Vss.n86 Vss 0.01728f
C123 Vss.n87 Vss 0
C124 Vss.n88 Vss 0.01728f
C125 Vss.n89 Vss 0
C126 Vss.n90 Vss 0
C127 Vss.n91 Vss 0
C128 Vss.n92 Vss 0
C129 Vss.n93 Vss 0.00331f
C130 Vss.n94 Vss 0.00192f
C131 Vss.n95 Vss 0
C132 Vss.n96 Vss 0.00155f
C133 Vss.n97 Vss 0.02236f
C134 Vss.n98 Vss 0.00155f
C135 Vss.n99 Vss 0
C136 Vss.n100 Vss 0
C137 Vss.n101 Vss 0
C138 Vss.n102 Vss 0
C139 Vss.n103 Vss 0
C140 Vss.n104 Vss 0
C141 Vss.n105 Vss 0
C142 Vss.n106 Vss 0
C143 Vss.n107 Vss 0
C144 Vss.n108 Vss 0
C145 Vss.n109 Vss 0
C146 Vss.n110 Vss 0
C147 Vss.n111 Vss 0
C148 Vss.n112 Vss 0
C149 Vss.n113 Vss 0
C150 Vss.n114 Vss 0
C151 Vss.n115 Vss 0
C152 Vss.n116 Vss 0
C153 Vss.n117 Vss 0
C154 Vss.n118 Vss 0
C155 Vss.n119 Vss 0.00192f
C156 Vss.n120 Vss 0.00454f
C157 Vss.n121 Vss 0.00249f
C158 Vss.n122 Vss 0.24917f
C159 Vss.n123 Vss 0.15381f
C160 Vss.n124 Vss 0.08085f
C161 Vss.n125 Vss 0.08085f
C162 Vss.n126 Vss 0.02333f
C163 Vss.n127 Vss 0.00158f
C164 Vss.n128 Vss 0.00158f
C165 Vss.n129 Vss 0.00207f
C166 Vss.n130 Vss 0.00188f
C167 Vss.n131 Vss 0.00255f
C168 Vss.n132 Vss 0
C169 Vss.n133 Vss 0.00386f
C170 Vss.n134 Vss 0.00331f
C171 Vss.n135 Vss 0.002f
C172 Vss.n136 Vss 0
C173 Vss.n137 Vss 0.00158f
C174 Vss.n138 Vss 0.02423f
C175 Vss.n139 Vss 0.00155f
C176 Vss.n140 Vss 0.00155f
C177 Vss.n141 Vss 0.00192f
C178 Vss.n142 Vss 0
C179 Vss.n143 Vss 0
C180 Vss.n144 Vss 0
C181 Vss.n145 Vss 0
C182 Vss.n146 Vss 0
C183 Vss.n147 Vss 0.01652f
C184 Vss.n148 Vss 0.01728f
C185 Vss.n149 Vss 0.01728f
C186 Vss.n150 Vss 0
C187 Vss.n151 Vss 0
C188 Vss.n152 Vss 0
C189 Vss.n153 Vss 0
C190 Vss.n154 Vss 0
C191 Vss.n155 Vss 0
C192 Vss.n156 Vss 0
C193 Vss.n157 Vss 0
C194 Vss.n158 Vss 0
C195 Vss.n159 Vss 0
C196 Vss.n160 Vss 0
C197 Vss.n161 Vss 0
C198 Vss.n162 Vss 0
C199 Vss.n163 Vss 0.01728f
C200 Vss.n164 Vss 0
C201 Vss.n165 Vss 0
C202 Vss.n166 Vss 0
C203 Vss.n167 Vss 0
C204 Vss.n168 Vss 0
C205 Vss.n169 Vss 0
C206 Vss.n170 Vss 0
C207 Vss.n171 Vss 0
C208 Vss.n172 Vss 0.084f
C209 Vss.n173 Vss 0.10774f
C210 Vss.n174 Vss 0
C211 Vss.n175 Vss 0
C212 Vss.n176 Vss 0.01728f
C213 Vss.n177 Vss 0
C214 Vss.n178 Vss 0
C215 Vss.n179 Vss 0
C216 Vss.n180 Vss 0
C217 Vss.n181 Vss 0
C218 Vss.n182 Vss 0
C219 Vss.n183 Vss 0.00155f
C220 Vss.n184 Vss 0
C221 Vss.n185 Vss 0.00155f
C222 Vss.n186 Vss 0.00192f
C223 Vss.n187 Vss 0
C224 Vss.n188 Vss 0
C225 Vss.n189 Vss 0
C226 Vss.n190 Vss 0
C227 Vss.n191 Vss 0
C228 Vss.n192 Vss 0
C229 Vss.n193 Vss 0
C230 Vss.n194 Vss 0
C231 Vss.n195 Vss 0
C232 Vss.n196 Vss 0
C233 Vss.n197 Vss 0
C234 Vss.n198 Vss 0
C235 Vss.n199 Vss 0
C236 Vss.n200 Vss 0
C237 Vss.n201 Vss 0
C238 Vss.n202 Vss 0
C239 Vss.n203 Vss 0
C240 Vss.n204 Vss 0
C241 Vss.n205 Vss 0
C242 Vss.n206 Vss 0
C243 Vss.n207 Vss 0
C244 Vss.n208 Vss 0
C245 Vss.n209 Vss 0.0018f
C246 Vss.n210 Vss 0.00671f
C247 Vss.n211 Vss 0.00331f
C248 Vss.n212 Vss 0.00249f
C249 Vss.n213 Vss 0.09273f
C250 Vss.n214 Vss 0.02236f
C251 Vss.n215 Vss 0.01728f
C252 Vss.n216 Vss 0
C253 Vss.n217 Vss 0
C254 Vss.n218 Vss 0
C255 Vss.n219 Vss 0
C256 Vss.n220 Vss 0
C257 Vss.n221 Vss 0.01728f
C258 Vss.n222 Vss 0.01307f
C259 Vss.n223 Vss 0.01916f
C260 Vss.n224 Vss 0.01285f
C261 Vss.n225 Vss 0
C262 Vss.n226 Vss 0
C263 Vss.n227 Vss 0
C264 Vss.n228 Vss 0
C265 Vss.n229 Vss 0
C266 Vss.n230 Vss 0.01728f
C267 Vss.n231 Vss 0.01728f
C268 Vss.n232 Vss 0.01728f
C269 Vss.n233 Vss 0
C270 Vss.n234 Vss 0
C271 Vss.n235 Vss 0
C272 Vss.n236 Vss 0
C273 Vss.n237 Vss 0
C274 Vss.n238 Vss 0.01728f
C275 Vss.n239 Vss 0
C276 Vss.n240 Vss 0
C277 Vss.n241 Vss 0
C278 Vss.n242 Vss 0
C279 Vss.n243 Vss 0.00192f
C280 Vss.n244 Vss 0.00454f
C281 Vss.n245 Vss 0.00249f
C282 Vss.n246 Vss 0.03521f
C283 Vss.n247 Vss 0.04406f
C284 Vss.n248 Vss 0.02333f
C285 Vss.n249 Vss 0.00158f
C286 Vss.n250 Vss 0
C287 Vss.n251 Vss 0
C288 Vss.n252 Vss 0.002f
C289 Vss.n253 Vss 0.00749f
C290 Vss.n254 Vss 0.00255f
C291 Vss.n255 Vss 0.02268f
C292 Vss.n256 Vss 0.03914f
C293 Vss.n257 Vss 0.03607f
C294 Vss.n258 Vss 0.02333f
C295 Vss.n259 Vss 0.00158f
C296 Vss.n260 Vss 0
C297 Vss.n261 Vss 0.00188f
C298 Vss.n262 Vss 0.00386f
C299 Vss.n263 Vss 0.00374f
C300 Vss.n264 Vss 0.00593f
C301 Vdd.n0 Vss 0.01009f
C302 Vdd.n1 Vss 0.00542f
C303 Vdd.n2 Vss 0.0015f
C304 Vdd.n3 Vss 0.00728f
C305 Vdd.n4 Vss 0.06343f
C306 Vdd.n5 Vss 0.00441f
C307 Vdd.n6 Vss 0.00494f
C308 Vdd.n7 Vss 0.04097f
C309 Vdd.n8 Vss 0.00441f
C310 Vdd.n9 Vss 0.0015f
C311 Vdd.n10 Vss 0.0015f
C312 Vdd.n11 Vss 0.00494f
C313 Vdd.n12 Vss 0.02278f
C314 Vdd.n13 Vss 0.00728f
C315 Vdd.n14 Vss 0.00441f
C316 Vdd.n15 Vss 0.04097f
C317 Vdd.n16 Vss 0.00441f
C318 Vdd.n17 Vss 0.0015f
C319 Vdd.n18 Vss 0.00449f
C320 Vdd.n19 Vss 0.01386f
C321 Vdd.n20 Vss 0.00851f
C322 Vdd.n21 Vss 0.00185f
C323 Vdd.n22 Vss 0.00185f
C324 Vdd.n23 Vss 0.00133f
C325 Vdd.n24 Vss 0.00614f
C326 Vdd.n25 Vss 0.06749f
C327 Vdd.n27 Vss 0.00614f
C328 Vdd.n28 Vss 0.00133f
C329 Vdd.n29 Vss 0.00185f
C330 Vdd.n30 Vss 0.00185f
C331 Vdd.n31 Vss 0.00384f
C332 Vdd.n32 Vss 0.00133f
C333 Vdd.n33 Vss 0.00133f
C334 Vdd.n35 Vss 0.0459f
C335 Vdd.n37 Vss 0.00384f
C336 Vdd.n38 Vss 0.0015f
C337 Vdd.n39 Vss 0.00447f
C338 Vdd.n40 Vss 0.00185f
C339 Vdd.n41 Vss 0.00185f
C340 Vdd.n42 Vss 0.00185f
C341 Vdd.n43 Vss 0.0015f
C342 Vdd.n44 Vss 0.00447f
C343 Vdd.n45 Vss 0.01965f
C344 Vdd.n46 Vss 0.00185f
C345 Vdd.n47 Vss 0.00472f
C346 Vdd.n48 Vss 0.0015f
C347 Vdd.n49 Vss 0.00384f
C348 Vdd.n50 Vss 0.0459f
C349 Vdd.n51 Vss 0.00384f
C350 Vdd.n52 Vss 0.0015f
C351 Vdd.n53 Vss 0.00414f
C352 Vdd.n54 Vss 0.01314f
C353 Vdd.n55 Vss 0.02635f
C354 Vdd.n56 Vss 0.00851f
C355 Vdd.n57 Vss 0.00185f
C356 Vdd.n58 Vss 0.00185f
C357 Vdd.n59 Vss 0.00133f
C358 Vdd.n60 Vss 0.00614f
C359 Vdd.n61 Vss 0.06749f
C360 Vdd.n63 Vss 0.00614f
C361 Vdd.n64 Vss 0.00133f
C362 Vdd.n65 Vss 0.00185f
C363 Vdd.n66 Vss 0.00185f
C364 Vdd.n67 Vss 0.00384f
C365 Vdd.n68 Vss 0.00133f
C366 Vdd.n69 Vss 0.00133f
C367 Vdd.n71 Vss 0.0459f
C368 Vdd.n73 Vss 0.00384f
C369 Vdd.n74 Vss 0.0015f
C370 Vdd.n75 Vss 0.00447f
C371 Vdd.n76 Vss 0.00185f
C372 Vdd.n77 Vss 0.00185f
C373 Vdd.n78 Vss 0.00185f
C374 Vdd.n79 Vss 0.0015f
C375 Vdd.n80 Vss 0.00447f
C376 Vdd.n81 Vss 0.01965f
C377 Vdd.n82 Vss 0.00185f
C378 Vdd.n83 Vss 0.00472f
C379 Vdd.n84 Vss 0.0015f
C380 Vdd.n85 Vss 0.00384f
C381 Vdd.n86 Vss 0.0459f
C382 Vdd.n87 Vss 0.00384f
C383 Vdd.n88 Vss 0.0015f
C384 Vdd.n89 Vss 0.00414f
C385 Vdd.n90 Vss 0.01314f
C386 Vdd.n91 Vss 0.01489f
C387 Vdd.n92 Vss 0.01009f
C388 Vdd.n93 Vss 0.00542f
C389 Vdd.n94 Vss 0.0015f
C390 Vdd.n95 Vss 0.04097f
C391 Vdd.n96 Vss 0.00441f
C392 Vdd.n97 Vss 0.00441f
C393 Vdd.n98 Vss 0.00728f
C394 Vdd.n99 Vss 0.0015f
C395 Vdd.n100 Vss 0.02278f
C396 Vdd.n101 Vss 0.00494f
C397 Vdd.n102 Vss 0.00494f
C398 Vdd.n103 Vss 0.0015f
C399 Vdd.n104 Vss 0.00441f
C400 Vdd.n105 Vss 0.04097f
C401 Vdd.n106 Vss 0.06343f
C402 Vdd.n107 Vss 0.00728f
C403 Vdd.n108 Vss 0.00441f
C404 Vdd.n109 Vss 0.0015f
C405 Vdd.n110 Vss 0.00449f
C406 Vdd.n111 Vss 0.01332f
C407 Vdd.n112 Vss 0.00851f
C408 Vdd.n113 Vss 0.00185f
C409 Vdd.n114 Vss 0.00185f
C410 Vdd.n115 Vss 0.00133f
C411 Vdd.n116 Vss 0.00614f
C412 Vdd.n117 Vss 0.06749f
C413 Vdd.n119 Vss 0.00614f
C414 Vdd.n120 Vss 0.00133f
C415 Vdd.n121 Vss 0.00185f
C416 Vdd.n122 Vss 0.00185f
C417 Vdd.n123 Vss 0.00384f
C418 Vdd.n124 Vss 0.00133f
C419 Vdd.n125 Vss 0.00133f
C420 Vdd.n127 Vss 0.0459f
C421 Vdd.n129 Vss 0.00384f
C422 Vdd.n130 Vss 0.0015f
C423 Vdd.n131 Vss 0.00447f
C424 Vdd.n132 Vss 0.00185f
C425 Vdd.n133 Vss 0.00185f
C426 Vdd.n134 Vss 0.00185f
C427 Vdd.n135 Vss 0.0015f
C428 Vdd.n136 Vss 0.00447f
C429 Vdd.n137 Vss 0.01965f
C430 Vdd.n138 Vss 0.00185f
C431 Vdd.n139 Vss 0.00472f
C432 Vdd.n140 Vss 0.0015f
C433 Vdd.n141 Vss 0.00384f
C434 Vdd.n142 Vss 0.0459f
C435 Vdd.n143 Vss 0.00384f
C436 Vdd.n144 Vss 0.0015f
C437 Vdd.n145 Vss 0.00414f
C438 Vdd.n146 Vss 0.01314f
C439 Vdd.n147 Vss 0.02394f
C440 Vdd.n148 Vss 0.00851f
C441 Vdd.n149 Vss 0.00185f
C442 Vdd.n150 Vss 0.00185f
C443 Vdd.n151 Vss 0.00133f
C444 Vdd.n152 Vss 0.00614f
C445 Vdd.n153 Vss 0.06749f
C446 Vdd.n155 Vss 0.00614f
C447 Vdd.n156 Vss 0.00133f
C448 Vdd.n157 Vss 0.00185f
C449 Vdd.n158 Vss 0.00185f
C450 Vdd.n159 Vss 0.00384f
C451 Vdd.n160 Vss 0.00133f
C452 Vdd.n161 Vss 0.00133f
C453 Vdd.n163 Vss 0.0459f
C454 Vdd.n165 Vss 0.00384f
C455 Vdd.n166 Vss 0.0015f
C456 Vdd.n167 Vss 0.00447f
C457 Vdd.n168 Vss 0.00185f
C458 Vdd.n169 Vss 0.00185f
C459 Vdd.n170 Vss 0.00185f
C460 Vdd.n171 Vss 0.0015f
C461 Vdd.n172 Vss 0.00447f
C462 Vdd.n173 Vss 0.01965f
C463 Vdd.n174 Vss 0.00185f
C464 Vdd.n175 Vss 0.00472f
C465 Vdd.n176 Vss 0.0015f
C466 Vdd.n177 Vss 0.00384f
C467 Vdd.n178 Vss 0.0459f
C468 Vdd.n179 Vss 0.00384f
C469 Vdd.n180 Vss 0.0015f
C470 Vdd.n181 Vss 0.00414f
C471 Vdd.n182 Vss 0.01314f
C472 Vdd.n183 Vss 0.01842f
C473 Vdd.n184 Vss 0.00789f
C474 Vdd.n185 Vss 0.00493f
C475 Vdd.n186 Vss 0.0015f
C476 Vdd.n187 Vss 0.00608f
C477 Vdd.n188 Vss 0.04817f
C478 Vdd.n189 Vss 0.00377f
C479 Vdd.n190 Vss 0.00477f
C480 Vdd.n191 Vss 0.03333f
C481 Vdd.n192 Vss 0.00377f
C482 Vdd.n193 Vss 0.0015f
C483 Vdd.n194 Vss 0.0015f
C484 Vdd.n195 Vss 0.00477f
C485 Vdd.n196 Vss 0.01785f
C486 Vdd.n197 Vss 0.00608f
C487 Vdd.n198 Vss 0.00377f
C488 Vdd.n199 Vss 0.03333f
C489 Vdd.n200 Vss 0.00377f
C490 Vdd.n201 Vss 0.0015f
C491 Vdd.n202 Vss 0.00449f
C492 Vdd.n203 Vss 0.01368f
C493 Vdd.n204 Vss 0.01191f
C494 Vdd.n205 Vss 0.00831f
C495 Vin.n0 Vss 0.08118f
C496 Vin_neg.n0 Vss 0.08836f
C497 Iex_4_i Vss -0.09664f
C498 Vin Vss -0.1329f
C499 xm9_0/a_n50_n339# Vss -0.76926f
C500 Iex_3_i Vss -0.09219f
C501 xm9_0/a_28_n131# Vss -0.38554f
C502 Iex_1_i Vss -0.10798f
C503 Vin_neg Vss -0.14218f
C504 xm3_0/a_28_n281# Vss -1.39273f
C505 Vdd Vss -10.19864f
C506 xm4_0/a_28_n281# Vss -1.98556f
.ends
