** sch_path: /foss/repo/.wt-d14lvs/designs/libs/snn_analog/sch/full_4x2_lvs.sch
.subckt full_4x2_lvs avdd avss Vin Vin_neg vpre1 vpre2 vw11 vw42 vpost1 vpost2
*.PININFO avdd:B avss:B Vin:I Vin_neg:I vpre1:O vpre2:O vpost1:O vpost2:O vw11:O vw42:O
x1 vpre1 vpost1 nvpost1 nvpre1 vpost2 vpre2 nvpre2 nvpost2 avdd vpre3 avss nvpre3 vpre4 A nvpre4 B net1 net2 vw11 vw42
+ stdp_4x2_lvs
x8 avdd avss Vin Vin_neg net3 net4 net5 net6 encoder
x9 avdd B A avss current_mirror
x10 avdd avss net3 vpre1 nvpre1 net4 vpre2 nvpre2 net5 vpre3 nvpre3 vpre4 net6 nvpre4 layer_input
x2 avdd avss net2 vpost1 nvpost1 vpost2 net1 nvpost2 layer_output
.ends

* expanding   symbol:  stdp/stdp_4x2_lvs.sym # of pins=20
** sym_path: /foss/repo/.wt-d14lvs/designs/libs/snn_analog/sch/stdp/stdp_4x2_lvs.sym
** sch_path: /foss/repo/.wt-d14lvs/designs/libs/snn_analog/sch/stdp/stdp_4x2_lvs.sch
.subckt stdp_4x2_lvs vpre1 vpost1 nvpost1 nvpre1 vpost2 vpre2 nvpre2 nvpost2 avdd vpre3 avss nvpre3 vpre4 A nvpre4 B ifwd2 ifwd1
+ vw11 vw42
*.PININFO ifwd1:B ifwd2:B vpre1:I nvpre1:I vpre2:I nvpre2:I vpre3:I nvpre3:I vpre4:I nvpre4:I vpost1:O nvpost1:O vpost2:O
*+ nvpost2:O avdd:B avss:B A:B B:B vw11:O vw42:O
x1 avdd avss nvpre1 nvpost1 vpre1 vpost1 A B B A vw11 net7 stdp_lvs
x2 avdd avss nvpre2 nvpost1 vpre2 vpost1 A B B A net3 net7 stdp_lvs
x3 avdd avss nvpre3 nvpost1 vpre3 vpost1 A B B A net2 net7 stdp_lvs
x4 avdd avss nvpre4 nvpost1 vpre4 vpost1 A B B A net1 net7 stdp_lvs
x5 avdd avss nvpre1 nvpost2 vpre1 vpost2 A B B A net4 net8 stdp_lvs
x6 avdd avss nvpre2 nvpost2 vpre2 vpost2 A B B A net6 net8 stdp_lvs
x7 avdd avss nvpre3 nvpost2 vpre3 vpost2 A B B A net5 net8 stdp_lvs
x8 avdd avss nvpre4 nvpost2 vpre4 vpost2 A B B A vw42 net8 stdp_lvs
x9 net7 avdd ifwd1 avss Current-limit
x10 net8 avdd ifwd2 avss Current-limit
* noconn #net3
* noconn #net4
* noconn #net6
* noconn #net5
* noconn #net2
* noconn #net1
.ends

* expanding   symbol:  encoder/encoder.sym # of pins=8
** sym_path: /foss/repo/.wt-d14lvs/designs/libs/snn_analog/sch/encoder/encoder.sym
** sch_path: /foss/repo/.wt-d14lvs/designs/libs/snn_analog/sch/encoder/encoder.sch
.subckt encoder Vdd Vss Vin Vin_neg Iex_1_i Iex_2_i Iex_3_i Iex_4_i
*.PININFO Vdd:B Vss:B Vin:I Vin_neg:I Iex_1_i:O Iex_4_i:O Iex_2_i:O Iex_3_i:O
XM1 x Vin a Vss nfet_03v3 L=10u W=0.5u nf=1 ad='int((nf+1)/2) * W/nf * 0.18u' as='int((nf+2)/2) * W/nf * 0.18u' pd='2*int((nf+1)/2) * (W/nf + 0.18u)'
+ ps='2*int((nf+2)/2) * (W/nf + 0.18u)' nrd='0.18u / W' nrs='0.18u / W' sa=0 sb=0 sd=0
XM2 y Vin_neg a Vss nfet_03v3 L=10u W=0.5u nf=1 ad='int((nf+1)/2) * W/nf * 0.18u' as='int((nf+2)/2) * W/nf * 0.18u' pd='2*int((nf+1)/2) * (W/nf + 0.18u)'
+ ps='2*int((nf+2)/2) * (W/nf + 0.18u)' nrd='0.18u / W' nrs='0.18u / W' sa=0 sb=0 sd=0
XM3 x x Vdd Vdd pfet_03v3 L=0.28u W=2u nf=1 ad='int((nf+1)/2) * W/nf * 0.18u' as='int((nf+2)/2) * W/nf * 0.18u' pd='2*int((nf+1)/2) * (W/nf + 0.18u)'
+ ps='2*int((nf+2)/2) * (W/nf + 0.18u)' nrd='0.18u / W' nrs='0.18u / W' sa=0 sb=0 sd=0
XM4 y y Vdd Vdd pfet_03v3 L=0.28u W=2u nf=1 ad='int((nf+1)/2) * W/nf * 0.18u' as='int((nf+2)/2) * W/nf * 0.18u' pd='2*int((nf+1)/2) * (W/nf + 0.18u)'
+ ps='2*int((nf+2)/2) * (W/nf + 0.18u)' nrd='0.18u / W' nrs='0.18u / W' sa=0 sb=0 sd=0
XM5 Iex_2_i x Vdd Vdd pfet_03v3 L=1.86u W=0.93u nf=1 ad='int((nf+1)/2) * W/nf * 0.18u' as='int((nf+2)/2) * W/nf * 0.18u' pd='2*int((nf+1)/2) * (W/nf + 0.18u)'
+ ps='2*int((nf+2)/2) * (W/nf + 0.18u)' nrd='0.18u / W' nrs='0.18u / W' sa=0 sb=0 sd=0
XM7 Iex_3_i y Vdd Vdd pfet_03v3 L=1.86u W=0.93u nf=1 ad='int((nf+1)/2) * W/nf * 0.18u' as='int((nf+2)/2) * W/nf * 0.18u' pd='2*int((nf+1)/2) * (W/nf + 0.18u)'
+ ps='2*int((nf+2)/2) * (W/nf + 0.18u)' nrd='0.18u / W' nrs='0.18u / W' sa=0 sb=0 sd=0
XM9 a net1 Vss Vss nfet_03v3 L=0.28u W=0.5u nf=1 ad='int((nf+1)/2) * W/nf * 0.18u' as='int((nf+2)/2) * W/nf * 0.18u' pd='2*int((nf+1)/2) * (W/nf + 0.18u)'
+ ps='2*int((nf+2)/2) * (W/nf + 0.18u)' nrd='0.18u / W' nrs='0.18u / W' sa=0 sb=0 sd=0
XM10 net1 net1 Vss Vss nfet_03v3 L=0.28u W=0.5u nf=1 ad='int((nf+1)/2) * W/nf * 0.18u' as='int((nf+2)/2) * W/nf * 0.18u' pd='2*int((nf+1)/2) * (W/nf + 0.18u)'
+ ps='2*int((nf+2)/2) * (W/nf + 0.18u)' nrd='0.18u / W' nrs='0.18u / W' sa=0 sb=0 sd=0
XM11 net1 net1 Vdd Vdd pfet_03v3 L=0.28u W=0.5u nf=1 ad='int((nf+1)/2) * W/nf * 0.18u' as='int((nf+2)/2) * W/nf * 0.18u' pd='2*int((nf+1)/2) * (W/nf + 0.18u)'
+ ps='2*int((nf+2)/2) * (W/nf + 0.18u)' nrd='0.18u / W' nrs='0.18u / W' sa=0 sb=0 sd=0
XM6 Iex_4_i y Vdd Vdd pfet_03v3 L=1.86u W=0.93u nf=1 ad='int((nf+1)/2) * W/nf * 0.18u' as='int((nf+2)/2) * W/nf * 0.18u' pd='2*int((nf+1)/2) * (W/nf + 0.18u)'
+ ps='2*int((nf+2)/2) * (W/nf + 0.18u)' nrd='0.18u / W' nrs='0.18u / W' sa=0 sb=0 sd=0
XM8 Iex_1_i x Vdd Vdd pfet_03v3 L=1.86u W=0.93u nf=1 ad='int((nf+1)/2) * W/nf * 0.18u' as='int((nf+2)/2) * W/nf * 0.18u' pd='2*int((nf+1)/2) * (W/nf + 0.18u)'
+ ps='2*int((nf+2)/2) * (W/nf + 0.18u)' nrd='0.18u / W' nrs='0.18u / W' sa=0 sb=0 sd=0
.ends

* expanding   symbol:  current_mirror/current_mirror.sym # of pins=4
** sym_path: /foss/repo/.wt-d14lvs/designs/libs/snn_analog/sch/current_mirror/current_mirror.sym
** sch_path: /foss/repo/.wt-d14lvs/designs/libs/snn_analog/sch/current_mirror/current_mirror.sch
.subckt current_mirror Avdd B A Avss
*.PININFO Avdd:B Avss:B B:B A:B
XM1 A A Avss Avss nfet_03v3 L=0.28u W=4u nf=1 ad='int((nf+1)/2) * W/nf * 0.18u' as='int((nf+2)/2) * W/nf * 0.18u' pd='2*int((nf+1)/2) * (W/nf + 0.18u)'
+ ps='2*int((nf+2)/2) * (W/nf + 0.18u)' nrd='0.18u / W' nrs='0.18u / W' sa=0 sb=0 sd=0
XM2 B A Avss Avss nfet_03v3 L=4u W=4u nf=1 ad='int((nf+1)/2) * W/nf * 0.18u' as='int((nf+2)/2) * W/nf * 0.18u' pd='2*int((nf+1)/2) * (W/nf + 0.18u)'
+ ps='2*int((nf+2)/2) * (W/nf + 0.18u)' nrd='0.18u / W' nrs='0.18u / W' sa=0 sb=0 sd=0
XM3 B B Avdd Avdd pfet_03v3 L=0.5u W=8u nf=1 ad='int((nf+1)/2) * W/nf * 0.18u' as='int((nf+2)/2) * W/nf * 0.18u' pd='2*int((nf+1)/2) * (W/nf + 0.18u)'
+ ps='2*int((nf+2)/2) * (W/nf + 0.18u)' nrd='0.18u / W' nrs='0.18u / W' sa=0 sb=0 sd=0
XM4 A A Avdd Avdd pfet_03v3 L=0.5u W=1.6u nf=1 ad='int((nf+1)/2) * W/nf * 0.18u' as='int((nf+2)/2) * W/nf * 0.18u' pd='2*int((nf+1)/2) * (W/nf + 0.18u)'
+ ps='2*int((nf+2)/2) * (W/nf + 0.18u)' nrd='0.18u / W' nrs='0.18u / W' sa=0 sb=0 sd=0
.ends

* expanding   symbol:  lif/layer_input.sym # of pins=14
** sym_path: /foss/repo/.wt-d14lvs/designs/libs/snn_analog/sch/lif/layer_input.sym
** sch_path: /foss/repo/.wt-d14lvs/designs/libs/snn_analog/sch/lif/layer_input.sch
.subckt layer_input avdd avss Iext1 vout_1 nvout_1 Iext2 vout_2 nvout_2 Iext3 vout_3 nvout_3 vout_4 Iext4 nvout_4
*.PININFO avdd:B avss:B Iext1:I Iext2:I Iext3:I Iext4:I vout_1:O nvout_1:O vout_2:O nvout_2:O vout_3:O nvout_3:O vout_4:O
*+ nvout_4:O
x2 Iext1 avdd avss vout_1 nvout_1 neurona_lvs
x3 Iext2 avdd avss vout_2 nvout_2 neurona_lvs
x4 Iext3 avdd avss vout_3 nvout_3 neurona_lvs
x5 Iext4 avdd avss vout_4 nvout_4 neurona_lvs
.ends

* expanding   symbol:  lif/layer_output.sym # of pins=8
** sym_path: /foss/repo/.wt-d14lvs/designs/libs/snn_analog/sch/lif/layer_output.sym
** sch_path: /foss/repo/.wt-d14lvs/designs/libs/snn_analog/sch/lif/layer_output.sch
.subckt layer_output avdd avss Iext1 vout_1 nvout_1 vout_2 Iext2 nvout_2
*.PININFO avdd:B avss:B Iext1:I Iext2:I vout_1:O nvout_1:O vout_2:O nvout_2:O
x6 Iext1 avdd avss vout_1 nvout_1 neurona_lvs
x7 Iext2 avdd avss vout_2 nvout_2 neurona_lvs
.ends

* expanding   symbol:  stdp/stdp_lvs.sym # of pins=12
** sym_path: /foss/repo/.wt-d14lvs/designs/libs/snn_analog/sch/stdp/stdp_lvs.sym
** sch_path: /foss/repo/.wt-d14lvs/designs/libs/snn_analog/sch/stdp/stdp_lvs.sch
.subckt stdp_lvs avdd avss nvpre nvpost vpre vpost vb_itd vb_idep vb_itp vb_pot vw iout
*.PININFO avss:B avdd:B nvpost:B nvpre:B vpost:B vpre:B vb_idep:B vb_itd:B vb_itp:B vb_pot:B vw:B iout:O
XM1 n1 vpot avdd avdd pfet_03v3 L=0.63u W=0.5u nf=1 ad='int((nf+1)/2) * W/nf * 0.18u' as='int((nf+2)/2) * W/nf * 0.18u' pd='2*int((nf+1)/2) * (W/nf + 0.18u)'
+ ps='2*int((nf+2)/2) * (W/nf + 0.18u)' nrd='0.18u / W' nrs='0.18u / W' sa=0 sb=0 sd=0
XM2 vw nvpost n1 avdd pfet_03v3 L=0.63u W=0.5u nf=1 ad='int((nf+1)/2) * W/nf * 0.18u' as='int((nf+2)/2) * W/nf * 0.18u' pd='2*int((nf+1)/2) * (W/nf + 0.18u)'
+ ps='2*int((nf+2)/2) * (W/nf + 0.18u)' nrd='0.18u / W' nrs='0.18u / W' sa=0 sb=0 sd=0
XM3 vw vpre n2 avss nfet_03v3 L=0.63u W=0.5u nf=1 ad='int((nf+1)/2) * W/nf * 0.18u' as='int((nf+2)/2) * W/nf * 0.18u' pd='2*int((nf+1)/2) * (W/nf + 0.18u)'
+ ps='2*int((nf+2)/2) * (W/nf + 0.18u)' nrd='0.18u / W' nrs='0.18u / W' sa=0 sb=0 sd=0
XM4 n2 vdep avss avss nfet_03v3 L=0.63u W=0.5u nf=1 ad='int((nf+1)/2) * W/nf * 0.18u' as='int((nf+2)/2) * W/nf * 0.18u' pd='2*int((nf+1)/2) * (W/nf + 0.18u)'
+ ps='2*int((nf+2)/2) * (W/nf + 0.18u)' nrd='0.18u / W' nrs='0.18u / W' sa=0 sb=0 sd=0
XM7 n4 n3 avdd avdd pfet_03v3 L=0.63u W=0.5u nf=1 ad='int((nf+1)/2) * W/nf * 0.18u' as='int((nf+2)/2) * W/nf * 0.18u' pd='2*int((nf+1)/2) * (W/nf + 0.18u)'
+ ps='2*int((nf+2)/2) * (W/nf + 0.18u)' nrd='0.18u / W' nrs='0.18u / W' sa=0 sb=0 sd=0
XM8 n3 nvpre vpot avdd pfet_03v3 L=0.63u W=0.5u nf=1 ad='int((nf+1)/2) * W/nf * 0.18u' as='int((nf+2)/2) * W/nf * 0.18u' pd='2*int((nf+1)/2) * (W/nf + 0.18u)'
+ ps='2*int((nf+2)/2) * (W/nf + 0.18u)' nrd='0.18u / W' nrs='0.18u / W' sa=0 sb=0 sd=0
XM9 n5 n5 avss avss nfet_03v3 L=0.63u W=0.5u nf=1 ad='int((nf+1)/2) * W/nf * 0.18u' as='int((nf+2)/2) * W/nf * 0.18u' pd='2*int((nf+1)/2) * (W/nf + 0.18u)'
+ ps='2*int((nf+2)/2) * (W/nf + 0.18u)' nrd='0.18u / W' nrs='0.18u / W' sa=0 sb=0 sd=0
XM12 n5 vpost vdep avss nfet_03v3 L=0.63u W=0.5u nf=1 ad='int((nf+1)/2) * W/nf * 0.18u' as='int((nf+2)/2) * W/nf * 0.18u' pd='2*int((nf+1)/2) * (W/nf + 0.18u)'
+ ps='2*int((nf+2)/2) * (W/nf + 0.18u)' nrd='0.18u / W' nrs='0.18u / W' sa=0 sb=0 sd=0
XM17 vpot vb_itp avdd avdd pfet_03v3 L=4.6u W=0.5u nf=1 ad='int((nf+1)/2) * W/nf * 0.18u' as='int((nf+2)/2) * W/nf * 0.18u' pd='2*int((nf+1)/2) * (W/nf + 0.18u)'
+ ps='2*int((nf+2)/2) * (W/nf + 0.18u)' nrd='0.18u / W' nrs='0.18u / W' sa=0 sb=0 sd=0
XMCM_1 n4 vb_pot avss avss nfet_03v3 L=2.8u W=0.61u nf=1 ad='int((nf+1)/2) * W/nf * 0.18u' as='int((nf+2)/2) * W/nf * 0.18u' pd='2*int((nf+1)/2) * (W/nf + 0.18u)'
+ ps='2*int((nf+2)/2) * (W/nf + 0.18u)' nrd='0.18u / W' nrs='0.18u / W' sa=0 sb=0 sd=0
XM16 n5 vb_idep avdd avdd pfet_03v3 L=2.8u W=10.2u nf=1 ad='int((nf+1)/2) * W/nf * 0.18u' as='int((nf+2)/2) * W/nf * 0.18u' pd='2*int((nf+1)/2) * (W/nf + 0.18u)'
+ ps='2*int((nf+2)/2) * (W/nf + 0.18u)' nrd='0.18u / W' nrs='0.18u / W' sa=0 sb=0 sd=0
XMCM_5 vdep vb_itd n6 avss nfet_03v3 L=10u W=0.5u nf=1 ad='int((nf+1)/2) * W/nf * 0.18u' as='int((nf+2)/2) * W/nf * 0.18u' pd='2*int((nf+1)/2) * (W/nf + 0.18u)'
+ ps='2*int((nf+2)/2) * (W/nf + 0.18u)' nrd='0.18u / W' nrs='0.18u / W' sa=0 sb=0 sd=0
XMCM_6 n6 vb_itd n7 avss nfet_03v3 L=10u W=0.5u nf=1 ad='int((nf+1)/2) * W/nf * 0.18u' as='int((nf+2)/2) * W/nf * 0.18u' pd='2*int((nf+1)/2) * (W/nf + 0.18u)'
+ ps='2*int((nf+2)/2) * (W/nf + 0.18u)' nrd='0.18u / W' nrs='0.18u / W' sa=0 sb=0 sd=0
XMCM_7 n7 vb_itd n8 avss nfet_03v3 L=10u W=0.5u nf=1 ad='int((nf+1)/2) * W/nf * 0.18u' as='int((nf+2)/2) * W/nf * 0.18u' pd='2*int((nf+1)/2) * (W/nf + 0.18u)'
+ ps='2*int((nf+2)/2) * (W/nf + 0.18u)' nrd='0.18u / W' nrs='0.18u / W' sa=0 sb=0 sd=0
XMCM_8 n8 vb_itd n9 avss nfet_03v3 L=10u W=0.5u nf=1 ad='int((nf+1)/2) * W/nf * 0.18u' as='int((nf+2)/2) * W/nf * 0.18u' pd='2*int((nf+1)/2) * (W/nf + 0.18u)'
+ ps='2*int((nf+2)/2) * (W/nf + 0.18u)' nrd='0.18u / W' nrs='0.18u / W' sa=0 sb=0 sd=0
XMCM_9 n9 vb_itd avss avss nfet_03v3 L=10u W=0.5u nf=1 ad='int((nf+1)/2) * W/nf * 0.18u' as='int((nf+2)/2) * W/nf * 0.18u' pd='2*int((nf+1)/2) * (W/nf + 0.18u)'
+ ps='2*int((nf+2)/2) * (W/nf + 0.18u)' nrd='0.18u / W' nrs='0.18u / W' sa=0 sb=0 sd=0
x1[0] vdep avss unitcap
x1[1] vdep avss unitcap
x2[0] vw avss unitcap
x2[1] vw avss unitcap
x2[2] vw avss unitcap
x2[3] vw avss unitcap
x2[4] vw avss unitcap
x2[5] vw avss unitcap
x2[6] vw avss unitcap
x2[7] vw avss unitcap
x2[8] vw avss unitcap
x2[9] vw avss unitcap
x3[0] avdd vpot unitcap
x3[1] avdd vpot unitcap
XM5 iout vw avdd avdd pfet_03v3 L=15u W=0.5u nf=1 ad='int((nf+1)/2) * W/nf * 0.18u' as='int((nf+2)/2) * W/nf * 0.18u' pd='2*int((nf+1)/2) * (W/nf + 0.18u)'
+ ps='2*int((nf+2)/2) * (W/nf + 0.18u)' nrd='0.18u / W' nrs='0.18u / W' sa=0 sb=0 sd=0
.ends

* expanding   symbol:  Current_limit/Current-limit.sym # of pins=4
** sym_path: /foss/repo/.wt-d14lvs/designs/libs/snn_analog/sch/Current_limit/Current-limit.sym
** sch_path: /foss/repo/.wt-d14lvs/designs/libs/snn_analog/sch/Current_limit/Current-limit.sch
.subckt Current-limit i_SUM avdd ifwd avss
*.PININFO avdd:B avss:B i_SUM:B ifwd:B
XM1 net1 net1 i_SUM avdd pfet_03v3 L=5.0u W=0.5u nf=1 ad='int((nf+1)/2) * W/nf * 0.18u' as='int((nf+2)/2) * W/nf * 0.18u' pd='2*int((nf+1)/2) * (W/nf + 0.18u)'
+ ps='2*int((nf+2)/2) * (W/nf + 0.18u)' nrd='0.18u / W' nrs='0.18u / W' sa=0 sb=0 sd=0
XM2 ifwd ifwd net1 avdd pfet_03v3 L=5.0u W=0.5u nf=1 ad='int((nf+1)/2) * W/nf * 0.18u' as='int((nf+2)/2) * W/nf * 0.18u' pd='2*int((nf+1)/2) * (W/nf + 0.18u)'
+ ps='2*int((nf+2)/2) * (W/nf + 0.18u)' nrd='0.18u / W' nrs='0.18u / W' sa=0 sb=0 sd=0
XM3 avss avss avss avss nfet_03v3 L=5.0u W=0.5u nf=1 ad='int((nf+1)/2) * W/nf * 0.18u' as='int((nf+2)/2) * W/nf * 0.18u' pd='2*int((nf+1)/2) * (W/nf + 0.18u)'
+ ps='2*int((nf+2)/2) * (W/nf + 0.18u)' nrd='0.18u / W' nrs='0.18u / W' sa=0 sb=0 sd=0
.ends

* expanding   symbol:  lif/neurona_lvs.sym # of pins=5
** sym_path: /foss/repo/.wt-d14lvs/designs/libs/snn_analog/sch/lif/neurona_lvs.sym
** sch_path: /foss/repo/.wt-d14lvs/designs/libs/snn_analog/sch/lif/neurona_lvs.sch
.subckt neurona_lvs Iin Vdd Vss spike spike_neg
*.PININFO Vdd:B Vss:B Iin:I spike:O spike_neg:O
XM1 spike_neg Iin Vdd Vdd pfet_03v3 L=0.28u W=0.5u nf=1 ad='int((nf+1)/2) * W/nf * 0.18u' as='int((nf+2)/2) * W/nf * 0.18u' pd='2*int((nf+1)/2) * (W/nf + 0.18u)'
+ ps='2*int((nf+2)/2) * (W/nf + 0.18u)' nrd='0.18u / W' nrs='0.18u / W' sa=0 sb=0 sd=0
XM2 spike_neg Iin Vss Vss nfet_03v3 L=0.28u W=0.5u nf=1 ad='int((nf+1)/2) * W/nf * 0.18u' as='int((nf+2)/2) * W/nf * 0.18u' pd='2*int((nf+1)/2) * (W/nf + 0.18u)'
+ ps='2*int((nf+2)/2) * (W/nf + 0.18u)' nrd='0.18u / W' nrs='0.18u / W' sa=0 sb=0 sd=0
XM3 spike_reset spike_neg Vdd Vdd pfet_03v3 L=0.28u W=0.5u nf=1 ad='int((nf+1)/2) * W/nf * 0.18u' as='int((nf+2)/2) * W/nf * 0.18u'
+ pd='2*int((nf+1)/2) * (W/nf + 0.18u)' ps='2*int((nf+2)/2) * (W/nf + 0.18u)' nrd='0.18u / W' nrs='0.18u / W' sa=0 sb=0 sd=0
XM4 spike_reset spike_neg Vss Vss nfet_03v3 L=0.28u W=0.5u nf=1 ad='int((nf+1)/2) * W/nf * 0.18u' as='int((nf+2)/2) * W/nf * 0.18u'
+ pd='2*int((nf+1)/2) * (W/nf + 0.18u)' ps='2*int((nf+2)/2) * (W/nf + 0.18u)' nrd='0.18u / W' nrs='0.18u / W' sa=0 sb=0 sd=0
XM7 spike spike_neg Vdd Vdd pfet_03v3 L=0.28u W=0.5u nf=1 ad='int((nf+1)/2) * W/nf * 0.18u' as='int((nf+2)/2) * W/nf * 0.18u' pd='2*int((nf+1)/2) * (W/nf + 0.18u)'
+ ps='2*int((nf+2)/2) * (W/nf + 0.18u)' nrd='0.18u / W' nrs='0.18u / W' sa=0 sb=0 sd=0
XM8 spike spike_neg Vss Vss nfet_03v3 L=0.28u W=0.5u nf=1 ad='int((nf+1)/2) * W/nf * 0.18u' as='int((nf+2)/2) * W/nf * 0.18u' pd='2*int((nf+1)/2) * (W/nf + 0.18u)'
+ ps='2*int((nf+2)/2) * (W/nf + 0.18u)' nrd='0.18u / W' nrs='0.18u / W' sa=0 sb=0 sd=0
XM5 Iin spike_reset Vss Vss nfet_03v3 L=50u W=2.3u nf=1 ad='int((nf+1)/2) * W/nf * 0.18u' as='int((nf+2)/2) * W/nf * 0.18u' pd='2*int((nf+1)/2) * (W/nf + 0.18u)'
+ ps='2*int((nf+2)/2) * (W/nf + 0.18u)' nrd='0.18u / W' nrs='0.18u / W' sa=0 sb=0 sd=0
XC2 Iin Vss cap_mim_2f0fF c_width=28e-6 c_length=5e-6
.ends

* expanding   symbol:  stdp/unitcap.sym # of pins=2
** sym_path: /foss/repo/.wt-d14lvs/designs/libs/snn_analog/sch/stdp/unitcap.sym
** sch_path: /foss/repo/.wt-d14lvs/designs/libs/snn_analog/sch/stdp/unitcap.sch
.subckt unitcap tp bp
*.PININFO tp:B bp:B
XCdep tp bp cap_mim_2f0fF c_width=5e-6 c_length=5e-6
.ends
